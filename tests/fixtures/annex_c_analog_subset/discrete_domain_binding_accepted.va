// §7.2.1: "A discipline with a discrete domain ... is used to declare a net
// which is part of the discrete (digital) portion of a mixed-signal design."
// Binding a net to such a discipline is the ordinary, meaningful way to say so,
// and §7.4.2 is where that net meets discipline resolution.
//
// This file USED to demand the opposite, on Annex C.4 bullet 1: "From 3.6.2.2,
// Domain binding: the domain binding type discrete shall be an error in
// Verilog-A." That clause is real, and it is not this tool's. VerA targets
// Verilog-AMS, where §7.2.1 makes the binding legal, so a fixture demanding a
// diagnostic here demanded one a conforming AMS compiler must NOT emit — it
// would have failed VerA for obeying the standard it implements. Rewritten as
// the positive rule rather than deleted, because the construct still needs a
// fixture; the Verilog-A-only reading is recorded here and nowhere else.
//
// q is driven and sampled as a digital net. The driver uses 1 ns precision:
// its #1.4 rounds to 1 ns, and the following #1.6 rounds to 2 ns, so q changes
// at 1 ns and 3 ns. The parent uses 100 ps precision to sample both sides of
// those ticks. The old fixture left q unused and checked only the unrelated
// electrical bias, which could not observe any discrete-domain behavior.
//
//! lrm 7.2.1
//! lrm 7.2.1:1000
//! lrm 3.6.2.2
//! lrm C.17
//! bias V(p) = 0.75
//! analysis tran
//! time 0, 4n
//! checks 4
`timescale 100ps/100ps
`include "check.vh"
module annex_c_discrete_domain_binding_accepted(p);
    inout p;
    electrical p;
    ddiscrete q;
    annex_c_discrete_tick_driver driver(q);
    initial begin
      #9 `CHECKI("q is low just before the first driver tick", q === 1'b0, 1);
      #2 `CHECKI("q rises at the rounded 1 ns tick, before 1.4 ns", q === 1'b1, 1);
      #18 `CHECKI("q holds its digital value until the next driver tick", q === 1'b1, 1);
      #2 `CHECKI("q falls at the rounded 3 ns tick", q === 1'b0, 1);
    end
    analog I(p) <+ V(p);
endmodule

`timescale 1ns/1ns
module annex_c_discrete_tick_driver(q);
    output q;
    ddiscrete q;
    reg q;
    initial begin
      q = 1'b0;
      #1.4 q = 1'b1;
      #1.6 q = 1'b0;
    end
endmodule
