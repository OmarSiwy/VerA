// §10.2: "The `default_discipline compiler directive can be used to specify a
// default discipline for those nets and undeclared implicit nets which do not
// have a discipline associated with them." The directive is this module's ONLY
// source of a discipline — there is deliberately no `electrical p, n`
// declaration, because with one the directive binds nothing (a net with its own
// declaration keeps it) and the file would pass on a compiler that ignores the
// directive entirely.
//
// WHY THIS FILE USED TO DEMAND A REJECTION, and why that was wrong here. Annex
// C.4 bullet 3 says "the `default_discipline compiler directive is not supported
// in Verilog-A. All Verilog-A modules shall have a discipline defined for each
// module." That clause is normative for the Verilog-A SUBSET. VerA targets
// Verilog-AMS, where §10.2 makes the directive legal and meaningful, so a
// conforming AMS compiler must NOT emit the diagnostic this file used to
// require. Demanding it made the fixture inverted: only a subset-only compiler
// could pass, and VerA closing the gap would have FAILed it.
//
// The C.4 rule is not deleted, only re-scoped: it is a statement about the
// subset, and it belongs to a dialect gate this compiler does not have. If a
// `--std=verilog-a` mode is ever added, this file is where the subset half goes
// back, as a second fixture rather than an inversion of this one.
//
// WHAT IS ASSERTED. Without the directive both ports are natureless and V(p, n)
// is E0337 "net has no declared discipline" — that is exactly what ch10/41
// pins from the other side. With it, §10.2 binds `electrical` to both undeclared
// ports, so the potential access resolves and the branch potential is the node
// difference (§1.3.1): 0.75 - 0.25 = 0.5 V, exact in binary because both
// operands are. A compiler that parses the directive and then discards it
// reaches E0337 and never prints this line.
//
//! lrm 10.2
//! lrm C.4
//! lrm C.4:2
//! lrm 1.3.1
//! bias V(p) = 0.75, V(n) = 0.25
`default_discipline electrical
`include "check.vh"
module annex_c_default_discipline_accepted(p, n);
    inout p, n;
    analog begin
        `CHECKX("`default_discipline supplied the discipline of an undeclared port", V(p, n), 0.5);
        I(p, n) <+ V(p, n);
    end
endmodule
