// Annex C.5, the `!==` half of "the case equality operators (===, !==) are not
// supported in Verilog-A"; the `===` half is 10_case_equality_accepted.va.
//
// THIS FILE USED TO DEMAND A REJECTION (E0323) on C.5, a rule of the Verilog-A
// SUBSET. VerA targets Verilog-AMS, where §7.3.2 lists "the case inequality
// operator ( !== )" among the features supported in the analog context, so the
// verdict is inverted for the reason 10_case_equality_accepted.va gives.
//
// THE VALUES, by hand. IEEE 1364 §5.1.8: `!==` is the negation of `===`, which
// on the two-state bits of an analog integer is `!=`. `state` is assigned 1:
// state !== 1 is 0, state !== 2 is 1.
//
//! lrm C.5
//! lrm 4.2.6
//! lrm 7.3.2
//! lrm 4.2.6:1000
//! bias V(p) = 0.5
`include "check.vh"
module annex_c_case_inequality(p);
    inout p;
    electrical p;
    integer state;
    analog begin
        state = 1;
        `CHECKI("state !== 1 with state = 1", state !== 1, 0);
        `CHECKI("state !== 2 with state = 1", state !== 2, 1);
        I(p) <+ (state !== 1) + 0.0 * V(p);
    end
endmodule
