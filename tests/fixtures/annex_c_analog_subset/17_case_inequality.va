// annex C: ===/!== are 4-state digital operators, outside Verilog-A.
//! reject E0323
module annex_c_case_inequality(p); inout p; electrical p; integer state; analog I(p)<+(state !== 1)+0.0*V(p); endmodule
