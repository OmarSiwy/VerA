// Annex C.5, the `!==` half of "the case equality operators (===, !==) are not
// supported in Verilog-A"; §4.2.6 defines both. The `===` half is
// 10_case_equality_rejected.va.
//
//! lrm C.5
//! lrm 4.2.6
//! reject E0323
module annex_c_case_inequality(p); inout p; electrical p; integer state; analog I(p)<+(state !== 1)+0.0*V(p); endmodule
