// The legal neighbour of 34_port_access_contribution_rejected.va. §5.4.3: "The
// port access function shall not be used on the left side of a contribution
// operator <+." This module is 34's with that one thing changed: `I(<p>)` is
// READ on the right of an assignment instead of written on the left of `<+`.
// Same ports, same discipline, same legal `I(p, n) <+ V(p, n)`. So the pair
// separates "a port access as a contribution target" from "a port access" —
// 34's refusal cannot be a blanket refusal of `I(<p>)` in Verilog-A (C.6
// carries §5.4 into the subset whole).
//
// THE DIGITS. p is biased to 1.0 V, n to 0.0 V, and `//! solve` frees the
// port-flow unknown so Kirchhoff sets it: the only branch touching p is
// (p, n) with I = V(p, n) = 1.0 A, so §5.4.3's "flow into a port of a module"
// is
//
//     I(<p>) = 1.0 A
//
//! lrm C.6
//! lrm 5.4.3
//! bias V(p) = 1.0, V(n) = 0.0
//! solve
//! checks 1
`include "check.vh"
module annex_c_port_access_read_accepted(p, n);
    inout p, n;
    electrical p, n;
    real ip;

    analog begin
        ip = I(<p>);               // legal: a port access read, not a target
        I(p, n) <+ V(p, n);
        `CHECK("the flow into p is the one branch's V(p,n)/1 ohm", ip, 1.0, 1e-12);
    end
endmodule
