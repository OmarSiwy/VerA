// C.12 Compiler directives: "The compiler directives of Clause 10 are
// applicable to both Verilog-AMS HDL and Verilog-A." An inclusion with no
// exception, so its positive side is Clause 10 working in a Verilog-A module
// and its reject side is a Clause 10 prohibition refused there
// (38_define_vams_macro_text_rejected.va).
//
// Three of Clause 10's rules, each carrying a value:
//
//   §10.5 "The predefined macro is called __VAMS_ENABLE__. This macro shall
//   always be defined during the parsing of Verilog-AMS source text." So the
//   `ifdef below takes its first arm and `enabled` is 1; the `else arm, which
//   would give 0, is the one a tool without the macro takes.
//
//   §10.4 `define with a formal argument (Syntax 10-3's `text_macro_name ::=
//   text_macro_identifier [ ( list_of_formal_arguments ) ]`): TWICE(x) expands
//   to ((x) + (x)), so TWICE(V(p, n)) is 2 * 0.75 = 1.5, exact.
//
//   §10.4 `undef: after `undef SCALE the name is no longer defined, so the
//   `ifdef SCALE that follows takes its `else arm and `after_undef` is 0.
//   Before the `undef the same test gave 1 (`before_undef`). A tool that
//   ignored `undef reads 1 for both.
//
// The module is analog-only; the directives are the only thing under test.
//
//! lrm C.12
//! lrm 10.4
//! lrm 10.5
//! lrm 10.5:1
//! lrm 10.1
//! lrm 10.1:1000
//! bias V(p) = 0.75, V(n) = 0.0
`include "check.vh"
`define TWICE(x) ((x) + (x))
`define SCALE 3
module annex_c_compiler_directives(p, n);
    inout p, n;
    electrical p, n;
    integer enabled, before_undef, after_undef;

    analog begin
`ifdef __VAMS_ENABLE__
        enabled = 1;
`else
        enabled = 0;
`endif
`ifdef SCALE
        before_undef = 1;
`else
        before_undef = 0;
`endif
`undef SCALE
`ifdef SCALE
        after_undef = 1;
`else
        after_undef = 0;
`endif
        `CHECKI("__VAMS_ENABLE__ is predefined (10.5)", enabled, 1);
        `CHECKX("a `define with a formal expands its actual twice", `TWICE(V(p, n)), 1.5);
        `CHECKI("SCALE is defined before the `undef", before_undef, 1);
        `CHECKI("and not after it", after_undef, 0);
        I(p, n) <+ V(p, n);
    end
endmodule
