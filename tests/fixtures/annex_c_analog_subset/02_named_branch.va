// Annex C.2: "branches can be named for easy selection and access". §3.12 makes
// `branch (p, n) path` an alias for the (p, n) node pair, so the probe V(path)
// is that pair's potential difference — 0.75 V - 0.25 V = 0.5 V — and nothing
// else. A named branch resolved to the wrong pair, or to a node against ground,
// does not read 0.5.
//
//! lrm C.2
//! lrm 3.12
//! bias V(p) = 0.75
//! bias V(n) = 0.25
`include "check.vh"
module annex_c_named_branch(p, n);
    inout p, n;
    electrical p, n;
    branch (p, n) path;

    analog begin
        `CHECKX("named branch potential is that of its node pair", V(path), 0.5);
        I(path) <+ V(path);
    end
endmodule
