//! reject expression
// EXPECT: error
module annex_c_casex_rejected;
    integer selector, result;
    analog begin
        casex (selector)
            0: result = 0;
            default: result = 1;
        endcase
    end
endmodule
