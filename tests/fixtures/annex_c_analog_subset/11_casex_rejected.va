// Annex C.7, bullet 2: "casex and casez are not supported in Verilog-A." Only
// the plain `case` of §5.2.2 is in the subset; casex treats x and z digits in
// either operand as don't-cares, which is 4-state digital matching.
//
// The pinned code is E0209 (A.8.3, "expected an expression") rather than the
// bare word "expression": VerA reaches the rule through parser recovery, since
// `casex` is not a statement keyword it dispatches. src/diag_code.zig defines
// E0416 "casex/casez are not in the analog subset" with .lrm = "C.7" for exactly
// this rule, and it is unreachable today — when parseStmt starts dispatching
// casex, repoint this cite at E0416.
//
//! lrm C.7
//! lrm 5.2.2
//! reject E0209
//! reject casex
module annex_c_casex_rejected;
    integer selector, result;
    analog begin
        casex (selector)
            0: result = 0;
            default: result = 1;
        endcase
    end
endmodule
