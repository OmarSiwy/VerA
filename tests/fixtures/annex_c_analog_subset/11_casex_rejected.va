// Annex C.7, bullet 2: "casex and casez are not supported in Verilog-A." Only
// the plain `case` of §5.8.3 / A.6.7 is in the subset; casex treats x and z
// digits in either operand as don't-cares, which is 4-state digital matching.
//
// The pinned code is E0416, "casex/casez are not in the analog subset", whose
// own .lrm is "C.7" (lib/diag_code.zig) — it names THIS rule. The fixture used
// to pin E0209 (A.8.3, "expected an expression") instead, which is what VerA
// actually emits; that is a parser-recovery artifact naming no subset rule, so
// the arm was satisfied by any failure to parse casex for any reason.
//
//! lrm C.7
//! lrm 5.8.3
//! reject E0416
//! reject casex
module annex_c_casex_rejected;
    integer selector, result;
    analog begin
        casex (selector)
            0: result = 0;
            default: result = 1;
        endcase
    end
endmodule
