// A.6.2 `always_construct ::= always statement` is the digital procedural block;
// Verilog-A has exactly one procedural block, the `analog` block of §5.2, and
// Annex C.7 bullet 1 says why: "No digital behavior or events are supported in
// Verilog-A."
//
// WHY THIS ONE IS STILL A REJECTION when 13_digital_initial_accepted.va is not.
// The C.7 argument is NOT the reason — it is a rule of the Verilog-A subset and
// VerA targets Verilog-AMS, which is exactly why the `initial` half of C.7's
// bullet was re-verdicted. What is left is a property of this compiler and it
// falls on the two keywords differently: an `initial` block of constant
// assignments has one possible meaning (the target holds that constant for the
// analysis, §7.2.2), while an `always` block RE-RUNS on an event, so what its
// variable holds is a function of §8.5's simulation cycle. The keyword itself
// parses now (A.1.4 makes `always` a module item of every module), and what
// refuses it is E0437: VerA does not yet run §8.5's queue beside a device. The
// cite is kept because C.7 is still the clause that separates the two blocks.
//
// This is therefore VerA's ceiling and not an LRM prohibition. The pin is a code
// and a keyword so that the day the queue runs, the change is deliberate. (This
// `always` has no timing control, so it never yields — IEEE 1364-2005 §9.9.2's
// zero-delay loop — and a kernel that runs it hangs at time 0. That is the
// question this file will have to answer then.)
//
//! lrm C.7
//! lrm A.6.2
//! reject E0437
//! reject always
module annex_c_digital_always_rejected;
    integer state;
    always state = !state;
endmodule
