// C.17 Standard definitions: "The definitions of Annex D are applicable to both
// Verilog-AMS HDL and Verilog-A, with the exception of those disciplines with a
// domain of discrete. A Verilog-A implementation shall silently ignore any
// definition of a discipline with a domain of discrete."
//
// The second sentence binds "a Verilog-A implementation", i.e. a tool that
// implements the optional subset (CLAUSE-AUDIT §5.2); VerA implements full
// Verilog-AMS, where `logic` and `ddiscrete` are ordinary disciplines
// (ch07_mixed_signal/discrete_discipline.va). The first sentence is not the
// subset's: Annex D's continuous definitions mean the same thing in a
// Verilog-A module as anywhere else. This file is that sentence's positive
// side; 40_signal_flow_flow_access_rejected.va is its reject side.
//
// Four Annex D definitions, each asserted through what it defines:
//
//   `electrical` (D.1, disciplines.vams): potential Voltage, access V. The
//     port pair is biased 1.0/0.0, so V(p, n) reads 1.0.
//   `thermal` (D.1): potential Temperature, access Temp; flow Power, access
//     Pwr. The thermal port is biased to 300 K, so Temp(t) reads 300 — through
//     the access function the standard nature names, not one this file declares.
//   `P_K_NIST2018`, `P_Q_NIST2018` (D.2, constants.vams): 1.380649e-23 J/K and
//     1.602176634e-19 C. The thermal voltage at the thermal port is
//     P_K * Temp(t) / P_Q = 1.380649e-23 * 300 / 1.602176634e-19
//     = 0.025851999786435535 (evaluated in IEEE double, the order written), so
//     the check is relative at 1e-15. The explicitly-versioned names are used
//     because the bare `P_K` follows a selection macro and this file is not
//     about that selection.
//   `M_PI` (D.2): pi to double precision, 3.141592653589793, exact.
//
//! lrm C.17
//! lrm C.17:1
//! lrm D.1
//! lrm D.2
//! bias V(p) = 1.0, V(n) = 0.0
//! bias t = 300
`include "check.vh"
`include "disciplines.vams"
`include "constants.vams"
module annex_c_standard_definitions(p, n, t);
    inout p, n, t;
    electrical p, n;
    thermal t;

    analog begin
        `CHECKX("electrical: V reads the Voltage potential", V(p, n), 1.0);
        `CHECKX("thermal: Temp reads the Temperature potential", Temp(t), 300.0);
        `CHECKR("P_K_NIST2018 * T / P_Q_NIST2018 at 300 K",
                `P_K_NIST2018 * Temp(t) / `P_Q_NIST2018, 0.025851999786435535, 1e-15);
        `CHECKX("M_PI", `M_PI, 3.141592653589793);
        I(p, n) <+ V(p, n);
        Pwr(t) <+ Temp(t) / 1.0e3;
    end
endmodule
