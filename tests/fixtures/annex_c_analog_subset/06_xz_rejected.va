// Annex C.3, the 2.6 bullet, in both of its sentences:
//
//   "support for x and z values is limited in the analog block to the mixed
//    signal context, as defined in 7.3.2. In the same paragraph, the use of the
//    question mark character as an alternative for z is also limited to the
//    mixed signal context."
//
// Two literals, because those are two separate sentences and `?` is a distinct
// spelling the first one does not reach. The parser recovers from a bad literal
// and reports the next, so both are genuinely diagnosed — each literal is pinned
// as its own substring, so dropping either arm FAILs rather than passing on the
// other's diagnostic.
//
//! lrm C.3
//! lrm 2.6.1
//! reject E0130
//! reject 4'b0x1z
//! reject 4'b01?1
module annex_c_xz_rejected;
    integer xz_digits;
    integer question_digit;
    analog begin
        xz_digits = 4'b0x1z;
        question_digit = 4'b01?1;
    end
endmodule
