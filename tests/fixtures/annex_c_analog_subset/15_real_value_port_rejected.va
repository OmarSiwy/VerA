//! reject identifier
// EXPECT: error
module annex_c_real_value_port_rejected(p);
    input real p;
endmodule
