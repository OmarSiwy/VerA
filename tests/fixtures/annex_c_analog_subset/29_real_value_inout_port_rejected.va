// Annex C.8 / §6.5.3, the `inout` direction of the real value port. See
// 15_real_value_port_rejected.va for why the three directions are three files.
//
//! lrm C.8
//! lrm 6.5.3
//! reject E0208
module annex_c_real_value_inout_port_rejected(p);
    inout real p;
endmodule
