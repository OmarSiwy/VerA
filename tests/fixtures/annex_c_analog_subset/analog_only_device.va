// Annex C.2: the Verilog-A subset's baseline device — behaviour in an `analog`
// block, a parameter with a valid range limit (§3.4.2), and a flow contribution
// between two nodes. The value the rule pins is Ohm's law: with the parameter
// overridden to 2 kOhm and 1 V across the pair, the branch carries 0.5 mA.
//
// C.6 is pinned here too: "the signals defined in 5.4 are applicable to both
// Verilog-AMS HDL and Verilog-A" is an inclusion with no exception, so the only
// way to state it is a 5.4.1 signal access that must work, not a reject.
//
//! lrm C.2
//! lrm C.6
//! lrm 3.4.2
//! lrm 5.4.1
//! param resistance = 2k
//! bias V(p) = 1.5
//! bias V(n) = 0.5
`include "check.vh"
module annex_c_analog_only_device(p, n);
    inout p, n;
    electrical p, n;
    parameter real resistance = 1000.0 from (0:inf);

    analog begin
        // §5.4.1: the two-argument probe is the potential difference of the pair.
        `CHECKX("V(p,n) is the branch potential", V(p, n), 1.0);
        // §3.4.2: 2000 is inside (0:inf), so the override takes; 1 V / 2 kOhm.
        `CHECKR("Ohm's law: 1 V across 2 kOhm", V(p, n) / resistance, 5e-4, 1e-15);
        I(p, n) <+ V(p, n) / resistance;
    end
endmodule
