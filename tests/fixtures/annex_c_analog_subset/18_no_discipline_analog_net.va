// Annex C.4: "all Verilog-A modules shall have a discipline defined for each
// module" — this one declares none for its port, which records what VerA does
// with an undisciplined analog net. Whatever discipline it is given, §5.4.1
// fixes what the one-argument probe means: the potential of p relative to the
// global reference node, which the testbench holds at 0.25 V here.
//
//! bias V(p) = 0.25
`include "check.vh"
module annex_c_no_discipline(p);
    inout p;
    analog begin
        `CHECKX("V(p) is the potential of p against the reference node", V(p), 0.25);
        I(p) <+ V(p);
    end
endmodule
