// Annex C.16 lists `connect` among the ten keywords "not used by Verilog-A",
// and closes with "NOTE—All keywords of Verilog-AMS HDL are reserved words for
// Verilog-A": not used is not the same as free, so it may not serve as an
// identifier. Annex B Table B.1 lists it too.
//
// Its own file rather than an arm of 16: a `//! reject` substring is matched
// against every diagnostic of the file, and `connect` is a substring of
// `connectmodule`, `connectrules` and `endconnectrules` — next to any of those
// the arm is satisfied whether or not `connect` itself was ever flagged. Here
// it is the only keyword in the file, so nothing else can satisfy it. The
// module is named `annex_c_reserved_spelling_30`, not after the keyword, for
// the same reason: a diagnostic quoting the module name must not satisfy
// the arm.
//
// Reserving the spelling is a different rule from parsing the CONSTRUCT; the
// `connect` statement inside a connect rules block parses now (A.1.8) and its
// enclosing declaration's verdict is 24.
//
//! lrm C.16
//! lrm B
//! reject-only E0208
//! reject connect
module annex_c_reserved_spelling_30;
    real connect;
endmodule
