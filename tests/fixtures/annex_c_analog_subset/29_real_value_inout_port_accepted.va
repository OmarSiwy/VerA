// Annex C.8 / §6.5.3, the `inout` direction of the real value port. See
// 15_real_value_port_accepted.va for why the carve-out is the Verilog-A
// SUBSET's and not VerA's, and why a real value port is spelled `wreal`
// (A.2.1.2 admits `inout [discipline_identifier] [net_type | wreal] ...`).
//
// DERIVATION. The child drives its `inout wreal` port with 2.25 (exact); the
// parent's wreal `w` is the same net and has no other driver (§6.5.3's
// "maximum of one driver"), so the parent's analog block reads 2.25.
//
//! lrm C.8
//! lrm 6.5.3
//! lrm 6.5.3:1
//! bias V(p) = 0.5
`include "check.vh"
module annex_c_real_value_inout_port_accepted(p);
    inout p;
    electrical p;
    wreal w;
    annex_c_rvp_io u(w);
    analog begin
      `CHECKX("§6.5.3 an `inout wreal` port carries the child's driver", w, 2.25);
      I(p) <+ V(p);
    end
endmodule

module annex_c_rvp_io(p);
    inout wreal p;
    assign p = 2.25;
endmodule
