// Annex C.7, bullet 2: "casex and casez are not supported in Verilog-A." That
// is the SUBSET's rule. VerA targets Verilog-AMS, where §7.3.2 lists "the case,
// casex, and casez statements" among the analog context's features, so this
// file — `11_casex_rejected.va`, which pinned E0416 (now retired) — is
// inverted the way 07/09/10/13 were.
//
// DERIVATION. IEEE 1364 §9.5.1 makes x and z bits don't-cares under casex; an
// analog `integer` is two-state and has none, so casex over one is exactly
// §5.8.3's `case`. `selector` is 2, so the `2:` arm runs and result is 7; the
// `0:` arm (the §3.2 default of an uninitialised integer) must NOT run.
// Four-state casex is ch07_mixed_signal/xz_casex_statement_compared.va.
//
//! lrm C.7
//! lrm 5.8.3
//! lrm 7.3.2
//! lrm 5.8.3:1
//! bias V(p) = 0.5
`include "check.vh"
module annex_c_casex_accepted(p);
    inout p;
    electrical p;
    integer selector, result;
    analog begin
        selector = 2;
        casex (selector)
            0: result = 0;
            2: result = 7;
            default: result = 1;
        endcase
        `CHECKI("casex over a two-state integer is case", result, 7);
        I(p) <+ V(p);
    end
endmodule
