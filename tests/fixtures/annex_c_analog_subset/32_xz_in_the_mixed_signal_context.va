// C.3 "With the exception of certain keywords required for Verilog-AMS HDL,
// Clause 2 shall be applicable to both Verilog-A and Verilog-AMS HDL. ... From
// 2.6, Numbers: support for X and Z values is limited in the analog block to the
// mixed signal context, as defined in 7.3.2."
//
// §7.3.2 "Verilog-AMS HDL supports accessing of 4-state logic values within the
// analog context. The x and z states must be translated to equivalent analog
// real or integer values before being used within the analog context. The
// language supports ... the case equality operator (===) ... binary, octal and
// hexadecimal numeric constants which can contain x and z as digits."
//
// The positive half of C.3's limit: x/z digits are refused in PURELY analog
// use (06_xz_rejected.va, 05_xz_integer_rejected.va pin that), but allowed in
// the mixed-signal context the sentence names — an analog block comparing a
// DISCRETE net against an x/z constant with `===`, which is §7.3.2's own first
// example (`a2d`), transcribed with the digital driver made explicit.
//
// DERIVATION. `d` is a digital reg set to 1'bz at time zero by an `initial`
// block. The analog block translates it exactly as §7.3.2's example does:
//
//   d === 1'b1  -> no     d === 1'b0 -> no     d === 1'bz -> yes: avar = 2.5
//
// 2.5 is exact. No x or z value is used as an analog operand — only as a
// case-equality comparand — so none of §7.3.2's "it is an error if these
// operands return x or z" cases arises. (The `1'bx` arm is omitted: §7.3.2's
// second example labels `dnet === 1'bx` an error while its first example uses
// it, and this fixture does not need to take a side.)
//
// The x_*/z_*/xz_* files in ch07_mixed_signal used to refuse this construct
// citing Annex C.5, the Verilog-A SUBSET; the four-state comparison ones are
// now positive (`*_compared.va`). The initial block's `1'bz` is what makes
// this module mixed: a constant-shaped `initial` would otherwise be folded into
// analog variables, where a z has nowhere to live, so it runs on the kernel.
//
//! lrm C.3
//! lrm C.3:1
//! lrm 7.3.2
//! lrm 7.3.2:1
//! bias V(p) = 0.5
`include "check.vh"
module annex_c_xz_in_the_mixed_signal_context(p);
  inout p;
  electrical p;
  reg d;
  real avar;
  initial d = 1'bz;
  analog begin
    avar = 0.0;
    if (d === 1'b1)
      avar = 5.0;
    else if (d === 1'b0)
      avar = 0.0;
    else if (d === 1'bz)
      avar = 2.5;
    `CHECKX("C.3/7.3.2 a z on a discrete net is translated by === in the analog block", avar, 2.5);
    I(p) <+ V(p) * avar;
  end
endmodule
