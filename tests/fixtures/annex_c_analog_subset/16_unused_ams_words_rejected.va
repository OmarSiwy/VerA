// Annex B: "Verilog-AMS reserves the keywords listed in Table B.1." A reserved
// spelling is therefore not available as an identifier, and `real <keyword>;`
// is a syntax error in any conforming compiler.
//
// Annex C.16 lists the keywords "not used by Verilog-A" and closes with
// "NOTE-All keywords of Verilog-AMS HDL are reserved words for Verilog-A": not
// used is not the same as free, so none of them may serve as an identifier.
//
// The file previously declared nine of them in two comma-separated lists and
// pinned only `connect`. A declarator list does not resynchronise, so that
// spelled nine keywords and proved one. One declaration per line makes the
// parser report each spelling separately, and one `//! reject` line per spelling
// proves each one individually.
//
// TWO of the ten C.16 words are not here, because a `//! reject` substring is
// matched against EVERY diagnostic of the file (tests/torture.zig
// failureContains) and these two are prefixes of their neighbours:
//
//   `connect`      is a substring of `connectmodule`, `connectrules` and
//                  `endconnectrules`
//   `connectrules` is a substring of `endconnectrules`
//
// so in a file that also spells the longer word, those two arms are satisfied
// without the shorter keyword ever being flagged — the opposite of what lines
// 11-13 claim. They get their own files, 30_connect_reserved.va and
// 31_connectrules_reserved.va, where nothing else can satisfy them. The seven
// left here are pairwise non-containing, so each arm is load-bearing.
//
// Spelling: Table B.1 spells it `resolveto`, and Table B.1 is the normative
// reserved-word list. The C.16 list — in this LRM as well as in the 2.4.0 PDF —
// spells the same keyword `resolvedto`; that spelling appears nowhere in Annex
// B, so it is not a reserved word and cannot be tested as one.
//
// The tenth C.16 word, `net_resolution`, is NOT here either: VerA does not
// reserve it, so it would need `//! xfail` on the whole file and turn a
// multi-keyword proof into a known gap. It has its own fixture,
// 20_net_resolution_reserved.va.
//! lrm B
//! lrm C.16
//! reject E0208
//! reject connectmodule
//! reject driver_update
//! reject endconnectrules
//! reject merged
//! reject resolveto
//! reject split
//! reject wreal
module annex_c_unused_ams_words_rejected;
    real connectmodule;
    real driver_update;
    real endconnectrules;
    real merged;
    real resolveto;
    real split;
    real wreal;
endmodule
