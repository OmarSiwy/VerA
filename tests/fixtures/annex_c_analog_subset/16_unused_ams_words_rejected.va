// Annex B: "Verilog-AMS reserves the keywords listed in Table B.1." A reserved
// spelling is therefore not available as an identifier, and `real <keyword>;`
// is a syntax error in any conforming compiler.
//
// Annex C.16 lists the keywords "not used by Verilog-A" and closes with
// "NOTE-All keywords of Verilog-AMS HDL are reserved words for Verilog-A": not
// used is not the same as free, so none of them may serve as an identifier.
//
// The file previously declared nine of them in two comma-separated lists and
// pinned only `connect`. A declarator list does not resynchronise, so that
// spelled nine keywords and proved one. One declaration per line makes the
// parser report each spelling separately, and one `//! reject` line per spelling
// proves each one individually.
//
// TWO of the nine C.16 words are not here, because a `//! reject` substring is
// matched against EVERY diagnostic of the file (tests/torture.zig
// failureContains) and these two are prefixes of their neighbours:
//
//   `connect`      is a substring of `connectmodule`, `connectrules` and
//                  `endconnectrules`
//   `connectrules` is a substring of `endconnectrules`
//
// so in a file that also spells the longer word, those two arms are satisfied
// without the shorter keyword ever being flagged — the opposite of what lines
// 11-13 claim. They get their own files, 30_connect_reserved.va and
// 31_connectrules_reserved.va, where nothing else can satisfy them. The seven
// left here are pairwise non-containing, so each arm is load-bearing.
//
// Spelling: both lists spell the seventh word `resolveto` — C.16's own list and
// Table B.1 (physical p.400) — so `//! reject resolveto` is load-bearing. An
// earlier version of this header, keyed on an HTML transcription contaminated
// with Verilog-AMS 2.4 text, claimed C.16 spelled it `resolvedto` and that the
// C.16 spelling was therefore unpinnable. That spelling appears nowhere in the
// 2023 text and the claim is withdrawn.
//
// A tenth word used to be listed here, `net_resolution`, supported by a tenth
// fixture, 20_net_resolution_reserved.va. The 2023 edition removed the word
// from Annex B and C.16 together (Annex G item 5027, "Removed unused keyword
// net_resolution | B.1, C.16"), so the fixture demanded a diagnostic no rule
// backs and was deleted: a withdrawn claim, not a moved gap. The nine words
// that remain are the seven declared below plus `connect` (30) and
// `connectrules` (31).
//! lrm B
//! lrm C.16
//! reject-only E0208
//! reject connectmodule
//! reject driver_update
//! reject endconnectrules
//! reject merged
//! reject resolveto
//! reject split
//! reject wreal
module annex_c_unused_ams_words_rejected;
    real connectmodule;
    real driver_update;
    real endconnectrules;
    real merged;
    real resolveto;
    real split;
    real wreal;
endmodule
