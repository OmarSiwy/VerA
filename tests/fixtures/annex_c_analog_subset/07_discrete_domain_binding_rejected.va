// Annex C.4, bullet 1: "From 3.6.2.2, Domain binding: the domain binding type
// discrete shall be an error in Verilog-A."
//
// What is an error is BINDING a net to a discrete-domain discipline, not the
// discipline's definition: C.17 says a Verilog-A implementation "shall silently
// ignore any definition of a discipline with a domain of discrete", and
// annex_d_standard_definitions/discrete_disciplines.va pins that side of the
// boundary by compiling clean. So this fixture declares no discipline of its
// own — it uses `ddiscrete`, whose `domain discrete;` is Annex D's own
// definition — and binds a net to it. That binding is the error.
//
//! lrm C.4
//! lrm 3.6.2.2
//! reject discrete
//! xfail VerA has no subset gate on domain binding; `ddiscrete q;` inside a Verilog-A module compiles clean (rc=0), as does a net of any undefined discipline
module annex_c_discrete_domain_binding_rejected(p);
    inout p;
    electrical p;
    ddiscrete q;
    analog I(p) <+ V(p);
endmodule
