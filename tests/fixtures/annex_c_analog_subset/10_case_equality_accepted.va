// Annex C.5: "The case equality operators (===, !==) are not supported in
// Verilog-A." The `!==` half is 17_case_inequality.va.
//
// THIS FILE USED TO DEMAND A REJECTION (`10_case_equality_rejected.va`, E0323),
// and that verdict was the subset's, not the language's. C.5 is a rule of the
// Verilog-A SUBSET. VerA targets Verilog-AMS, where §7.3.2 lists "the case
// equality operator ( === )" first among the features "Verilog-AMS HDL supports
// ... within the analog context", and §4.2.6 says the operators "have limited
// support in the analog block (see 7.3.2)" — limited on the OPERANDS (4-state
// values translated to real or integer), not on the spelling. So the fixture
// demanded a diagnostic a conforming AMS compiler must not emit: the inversion
// 09_default_discipline_accepted.va and 13_digital_initial_accepted.va already
// had, with the same fix. If a `--std=verilog-a` mode is ever added, the subset
// half comes back as a SECOND fixture, not as an inversion of this one.
//
// Both operands are INTEGER, deliberately, as before: §4.2.1 bars `===` from a
// real operand in full AMS too (Table 4-2 does not list it), and that half is
// ch04_expressions/29_case_equality.va.
//
// THE VALUES, by hand. IEEE 1364 §5.1.8: `===` is 1 when both operands match
// bit for bit, x and z included, else 0; it never yields x. `state` is assigned
// 1 in the analog block, so every bit is 0 or 1 and the operator is `==`:
// state === 1 is 1, state === 2 is 0.
//
//! lrm C.5
//! lrm 4.2.6
//! lrm 7.3.2
//! lrm 4.2.6:1000
//! bias V(p) = 0.5, V(n) = 0
`include "check.vh"
module annex_c_case_equality_accepted(p, n);
    inout p, n;
    electrical p, n;
    integer state;
    integer equal, unequal;

    analog begin
        state = 1;
        equal = (state === 1);
        unequal = (state === 2);
        `CHECKI("state === 1 with state = 1", equal, 1);
        `CHECKI("state === 2 with state = 1", unequal, 0);
        I(p, n) <+ equal * 1m + 0.0 * V(p, n);
    end
endmodule
