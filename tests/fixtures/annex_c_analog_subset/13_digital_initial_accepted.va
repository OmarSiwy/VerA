// A.6.2 `initial_construct ::= initial statement` — the digital procedural
// block, in its bare-statement form (the `begin`/`end` form is
// ch07_mixed_signal/digital_initial_accepted.va). It is not the `analog initial`
// block of §5.2.1, which is a statement INSIDE the analog block; the two live in
// one module in ch08_scheduling/analog_digital_initial_order.va.
//
// THIS FILE USED TO DEMAND A REJECTION, on Annex C.7 bullet 1: "No digital
// behavior or events are supported in Verilog-A." That is a rule of the
// Verilog-A SUBSET. VerA targets Verilog-AMS, where A.6.2 puts the construct in
// the language, so the fixture was demanding a diagnostic a conforming AMS
// compiler must not emit — the same inversion 09_default_discipline_accepted.va
// had, and the same fix. The C.7 rule is not deleted, only re-scoped: it belongs
// to a dialect gate this compiler does not have, and if a `--std=verilog-a` mode
// is ever added, this file is where the subset half goes back as a SECOND
// fixture rather than as an inversion of this one.
//
// WHAT IS ASSERTED, and why it needs no digital kernel. §7.2.2's first sentence
// fixes the meaning: "The domain of a variable is that of the context from which
// its value is assigned", so `state` belongs to the discrete context — and
// §7.2.2 then makes it an error for the analog block to assign it as well, which
// is what leaves the constant standing. The block runs once, before the
// analysis, nothing else writes `state`, so 1 is the value the continuous
// context reads for the whole analysis. A compiler that parsed the block and
// discarded it reads §3.2's initial 0 and prints ok=0 on the line below.
//
// The ceiling of that reading is E0433: a statement in an `initial` block that
// is not a constant assignment — a delay, a loop, an event control, a
// non-constant right-hand side — is refused rather than guessed at, because
// choosing between its possible meanings is what §8.5's simulation cycle is for.
//
//! lrm C.7
//! lrm A.6.2
//! lrm 7.2.2
//! lrm A.6.2:1000
//! bias V(p) = 0.25
`include "check.vh"
module annex_c_digital_initial_accepted(p);
    inout p;
    electrical p;
    integer state;
    initial state = 1;
    analog begin
        `CHECKI("a digital initial block leaves its constant in the variable it assigns", state, 1);
        I(p) <+ V(p);
    end
endmodule
