// C.11 System tasks and functions: "All system tasks and functions in Clause 9
// that are applicable in the analog context are applicable to Verilog-A."
//
// "Applicable in the analog context" is not left to judgment: §9.2's tables
// carry a "Supported in analog context" column for every name. So C.11 has a
// positive side — a Verilog-A module may call what that column says Yes to, and
// the call must mean what Clause 9 says — and a reject side, the No cells, which
// is 36_time_in_analog_rejected.va. This is the positive side, from two tables:
//
//   Table 9-7 (Simulation Time)   $abstime   analog: Yes
//     §9.10: "$abstime returns the absolute time, that is a real value number
//     representing time in seconds." Read at the declared tran points below,
//     it must be those points, in seconds.
//
//   Table 9-8 (Conversion)        $rtoi, $itor, $realtobits, $bitstoreal
//                                            analog: Yes
//     §9.11: "Verilog AMS HDL extends the conversion functions defined in IEEE
//     Std 1364 Verilog so that $bitstoreal and $realtobits, $rtoi and $itor can
//     be used in the analog context." IEEE 1364 gives their meaning: $rtoi
//     converts by TRUNCATING, so 2.75 -> 2 and -2.75 -> -2 (not -3, which is
//     what a floor would give); $itor(2) is 2.0; and $bitstoreal undoes
//     $realtobits bit for bit, so 0.1 — not representable in binary, which is
//     what makes the round trip worth asserting — comes back exactly.
//
// The module is analog-only and uses nothing outside the Verilog-A subset. The
// operand of the conversions is read from the bias (V(p, n) = 1.0), so none of
// them folds to a constant before it reaches the device.
//
//! lrm C.11
//! lrm 9.10
//! lrm 9.11
//! lrm 9.10:1000
//! lrm 9.11:1000
//! analysis tran
//! time 0, 1u, 2.5u
//! bias V(p) = 1.0, V(n) = 0.0
`include "check.vh"
module annex_c_analog_context_system_functions(p, n);
    inout p, n;
    electrical p, n;
    integer up, down;
    real back, tenth;

    analog begin
        up    = $rtoi(V(p, n) * 2.75);
        down  = $rtoi(-V(p, n) * 2.75);
        back  = $itor(up);
        tenth = $bitstoreal($realtobits(V(p, n) * 0.1));

        `CHECKI("$rtoi truncates 2.75 to 2", up, 2);
        `CHECKI("$rtoi truncates -2.75 toward zero, to -2", down, -2);
        `CHECKX("$itor(2) is 2.0", back, 2.0);
        `CHECKX("$bitstoreal($realtobits(0.1)) is 0.1 exactly", tenth, 0.1);
        `CHECKI("$abstime is one of the declared points, in seconds",
                ($abstime == 0.0) || ($abstime == 1u) || ($abstime == 2.5u), 1);
        I(p, n) <+ V(p, n);
    end
endmodule
