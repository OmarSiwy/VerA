// Annex C.7, bullet 1: "No digital behavior or events are supported in
// Verilog-A." The construct under test is A.6.1 `continuous_assign ::= assign
// list_of_net_assignments ;`, which drives a net structurally, outside any
// analog block.
//
// RE-VERDICTED, as 13_digital_initial_accepted.va was before it: C.7 is a rule
// of the Verilog-A SUBSET, and VerA compiles Verilog-AMS, where A.1.4 makes
// `continuous_assign` a module item of every module. This file used to be
// `23_continuous_assign_rejected.va` and pinned E0205 (the grammar) and then
// E0437 (no event queue beside the device); both were VerA's ceiling, and the
// mixed-signal runner now executes the assignment.
//
// So the claim is the positive one, with a number: the net is driven to
// 1'b1, and VAMS §7.3.1 Table 7-1 reads a discrete net in the continuous
// context as an integer, so the analog block reads exactly 1. A tool that
// dropped the assignment reads the undriven net's z (a §7.3.2 error) or 0.
//
// The `wire w` carries no discipline: C.4 bullet 3 wants a discipline for each
// MODULE, which `electrical p` supplies, and `assign` drives nets, of which only
// an undisciplined (discrete) one is legal here.
//
//! lrm C.7
//! lrm A.6.1
//! lrm 7.3.1
//! lrm A.6.1:1000
`include "check.vh"
module annex_c_continuous_assign_accepted(p);
    inout p;
    electrical p;
    wire w;
    assign w = 1'b1;

    analog begin
        `CHECKI("A.6.1: the continuously assigned net reads 1 in the analog block", w, 1);
        I(p) <+ V(p);
    end
endmodule
