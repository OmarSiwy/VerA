// Annex C.2: the subset carries "a full set of operators including ... integrals
// and derivatives". Two of them, each with a value the LRM states outright:
//
//   §4.5.13  limexp() "returns a real value which is the exponential of its
//            single real argument"; the limiting is a convergence aid only, so
//            at a converged point limexp(0.7) is exp(0.7) = 2.0137527074704766.
//   §4.5.3   "In DC analysis, ddt() returns zero (0)." Exactly zero, whatever
//            the argument is — so the whole contribution here is limexp alone.
//
//! lrm C.2
//! lrm 4.5.13
//! lrm 4.5.3
//! bias V(p) = 0.7
`include "check.vh"
module annex_c_analog_operators(p, n);
    inout p, n;
    electrical p, n;

    analog begin
        `CHECKR("limexp(0.7) is exp(0.7)", limexp(V(p, n)), 2.0137527074704766, 1e-14);
        `CHECKX("ddt() is zero in a DC analysis", ddt(V(p, n)), 0.0);
        I(p, n) <+ limexp(V(p, n)) + ddt(V(p, n));
    end
endmodule
