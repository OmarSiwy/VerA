// Annex C.2: "a set of events to control when certain code is simulated". Two
// LRM facts make the events observable at a plain DC operating point:
//
//   §5.10.2 Table 5-1  initial_step returns 1 at the DCOP, so its statement runs.
//   §5.10.3.1          cross(expr, +1) fires only on a RISING crossing of zero
//                      by expr. A DC solve is a single point with no history, so
//                      no crossing exists and the statement must NOT run.
//
// `seen` exists only to give the first fact something to say: it is 3 before the
// event and 5 after, so a dropped initial_step reads 3. `state` is seeded to 7
// for the same reason: 0 is also its §3.2.1 initial value, so checking 0 against
// an unseeded variable passes in a compiler that drops both event bodies. Seeded,
// a dropped initial_step reads 7, a spuriously fired cross reads 1, and only the
// LRM's answer reads 0.
//
//! lrm C.2
//! lrm 5.10.2
//! lrm 5.10.3.1
//! bias V(p) = 2.0
`include "check.vh"
module annex_c_analog_event(p, n);
    inout p, n;
    electrical p, n;
    integer state;
    integer seen;

    analog begin
        seen = 3;
        state = 7;
        @(initial_step) state = 0;
        @(initial_step) seen = 5;
        @(cross(V(p, n), 1)) state = 1;
        `CHECKI("initial_step is active at the DC operating point", seen, 5);
        `CHECKI("cross(+1) does not fire without a rising zero crossing", state, 0);
        I(p, n) <+ state;
    end
endmodule
