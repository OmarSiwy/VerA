//! reject expression
// EXPECT: error
module annex_c_casez_rejected;
    integer selector, result;
    analog begin
        casez (selector)
            0: result = 0;
            default: result = 1;
        endcase
    end
endmodule
