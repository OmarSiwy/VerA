// THE OLD VERDICT HERE WAS AN ANNEX C ARGUMENT AND IT IS GONE. This file used
// to pin `reject E0201` on the keyword, reasoning from C.9 ("Clause 7 only
// applies to Verilog-AMS HDL") and C.16's keyword list that "a Verilog-A
// compiler has no digital side to convert to, so the declaration is out of the
// subset". Every quote in that argument is real; the conclusion does not follow
// for a compiler that implements Verilog-AMS. Annex C describes the Verilog-A
// SUBSET — C.9's sentence says which clauses bind an AMS implementation, and
// C.16's list is what the subset leaves out — and A.1.2 then leaves an AMS
// compiler no way to refuse the spelling:
//
//     module_keyword ::= module | macromodule | connectmodule
//
// The expectation also contradicted two other files outright:
// ch07_mixed_signal/connectmodule_accepted.va and
// ch09_system_tasks/38_driver_update_connectmodule.va both require the keyword
// ACCEPTED, the second because §9.22 paragraph 3 makes a connect module the only
// place §9.22.4's `always @(driver_update d)` may be written. No implementation
// satisfied this file and those two at once.
//
// WHAT IS LEFT TO PIN, AND IT IS NOT ABOUT CLAUSE 7. The connect module below is
// accepted: it parses, it produces no diagnostic of its own, and the refusal that
// remains is about the whole source_text rather than about any construct in it.
// §7.6 makes a connect module the bridge the INSERTION PHASE places on a mixed
// net — "the disciplines of mixed nets are determined prior to the connect module
// insertion phase" — so it is instantiated by the tool, never elaborated as a
// design of its own, and a compilation whose only design element is one has no
// device to build. §6.2 is the clause that says where a device comes from ("the
// module is the basic building block"), so E1001 "source contains no module
// declaration" is the diagnostic, and the reject line below is a CODE precisely
// so that it cannot be confused with the E0201 this file used to demand.
//
// THE CEILING, NAMED: a tool that only CHECKED a source_text would accept this
// file outright, because A.1.2's `source_text ::= { description }` is satisfied
// by one connectmodule and nothing in clause 7 requires an accompanying module.
// VerA compiles a device, so for VerA "nothing to compile" is a refusal. Any
// compiler in that shape refuses it; this file records which reason is the honest
// one, not a claim that the language forbids the declaration.
//
// The enclosing `connectrules ... endconnectrules` block is 24; see there for
// why they are two files. That one reached the same E1001 verdict by the same
// settlement: the block parses now (A.1.8, §7.7) and configures a phase that
// builds no device.
//
//! lrm 6.2
//! lrm A.1.2
//! reject-only E1001
//! neighbour ../ch07_mixed_signal/connectmodule_accepted.va
//! neighbour ../ch09_system_tasks/38_driver_update_connectmodule.va
connectmodule annex_c_connectmodule_rejected(digital_side, analog_side);
    input digital_side;
    output analog_side;
endmodule
