// §3.7 "The wreal, or real net data type, represents a real-valued physical
// connection between structural entities. ... If no driver is connected to a
// wreal net, its value shall be zero (0.0)."
//
// This file USED to demand the opposite, on Annex C.4 bullet 2: "From 3.7, Real
// net declarations: the wreal data type is not supported in Verilog-A." That is
// the SUBSET's rule, and VerA targets Verilog-AMS, where §3.7 makes the net
// legal and its own `drv` example reads one from the analog block. Inverted the
// way 07 and 09 were; the Verilog-A-only reading is recorded here and nowhere
// else.
//
// DERIVATION. `real_signal` has exactly one driver, `assign real_signal =
// 0.625;` (dyadic, exact), so the analog block reads 0.625 (§7.3.1 Table 7-1's
// real row: "no conversion"). ch03_data_types/93 carries the undriven-reads-0.0
// half.
//
//! lrm 3.7
//! lrm 3.7:2
//! lrm C.4
//! bias V(p) = 0.5
`include "check.vh"
module annex_c_wreal_accepted(p);
    inout p;
    electrical p;
    wreal real_signal;
    assign real_signal = 0.625;
    analog begin
      `CHECKX("§3.7 a wreal net declared in a Verilog-AMS module reads its driver", real_signal, 0.625);
      I(p) <+ V(p);
    end
endmodule
