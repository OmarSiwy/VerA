// C.17's reject side. "The definitions of Annex D are applicable to both
// Verilog-AMS HDL and Verilog-A" — including what they leave OUT. D.1 declares
// `voltage` as a signal-flow discipline:
//
//     discipline voltage;
//        potential    Voltage;
//     enddiscipline
//
// with no flow nature, so on a `voltage` net the flow access `I` is bound to
// nothing. §4.4: "The access function name shall match the discipline
// declaration for the nets, ports, or branch given in the argument expression
// list." `I(q)` below does not match, so a contribution to it is an error, not a 0 A
// source — in Verilog-AMS and, by C.17, in Verilog-A.
//
// 39_standard_definitions.va is the positive side (D.1's `electrical` and
// `thermal` and D.2's constants, read through the names Annex D gives them).
// annex_d_standard_definitions/signal_flow_flow_access_rejected.va pins the
// same D.1 fact from Annex D's side, on a port; this file puts it under the
// clause that makes Annex D bind a Verilog-A module, on an INTERNAL net, so
// the separate rule about a signal-flow discipline on an `inout` port (E0360) is
// not in play and the one thing wrong here is the access. VerA answers E0501
// "unknown access function"; the code is pinned.
//
//! lrm C.17
//! lrm D.1
//! lrm 4.4
//! lrm 4.4:5
//! reject-only E0501
//! neighbour 39_standard_definitions.va
`include "disciplines.vams"
module annex_c_signal_flow_flow_access_rejected(p, n);
    inout p, n;
    electrical p, n;
    voltage q;

    analog begin
        I(q) <+ 1.0;               // illegal: `voltage` has no flow nature
        I(p, n) <+ V(p, n);
    end
endmodule
