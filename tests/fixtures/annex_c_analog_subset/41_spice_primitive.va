// C.18 SPICE compatibility: "Annex E defines the SPICE compatibility for both
// Verilog-A and Verilog-AMS HDL." So a Verilog-A module may instantiate the
// Table E.1 primitives exactly as a Verilog-AMS one does — C.2 lists "support
// for accessing SPICE primitives from within the language" among the subset's
// features — and Table E.1's required names bind it in both directions: the
// names it declares are there (this file) and no others are
// (42_spice_parameter_name_rejected.va).
//
// E.3: "Table E.1 shows the required names for primitives, parameters, and
// ports which are otherwise unnamed in SPICE." The `resistor` row: ports p, n;
// parameters r, tc1, tc2; Behavior V = I * r * (1 + tc1*T + tc2*T^2). With
// tc1 = tc2 = 0 the temperature factor is 1 whatever T is, so
//
//     I(r1.p, r1.n) = V / r = 2.0 / 4000 = 5e-4 A
//
// relative 1e-15, the freedom a tool has in stamping a conductance rather than
// dividing. The override of `r` is read back through the instance (§6.7.1,
// hierarchical parameter access), which proves the parameter NAME `r` bound,
// and `4k` is §2.6.2's scale factor, 4000.0 exactly.
//
// The instantiating module is plain Verilog-A: analog-only, one discipline.
//
//! lrm C.18
//! lrm E.3
//! lrm 6.7.1
//! lrm 6.3.3
//! lrm 6.3.3:1
//! lrm 6.7.1:1
//! bias V(p) = 2.0, V(n) = 0.0
`include "check.vh"
module annex_c_spice_primitive(p, n);
    inout p, n;
    electrical p, n;
    resistor #(.r(4k), .tc1(0.0), .tc2(0.0)) r1(p, n);

    analog begin
        `CHECKX("Table E.1's r is the name the override binds", r1.r, 4000.0);
        `CHECKR("Table E.1 resistor: I = V/r = 2.0/4000", I(r1.p, r1.n), 5.0e-4, 1e-15);
    end
endmodule
