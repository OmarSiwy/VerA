// Annex C.2: "parameters can be specified with valid range limits". §3.4.2 says
// a bracket INCLUDES its end point, so `from [0:inf)` admits exactly 0 <= gain,
// and gain = 0 is a legal override. That is the rule this fixture pins: the
// override is accepted (a parenthesis there would make it an out-of-range
// error), and the device it produces carries no current across a 1 V bias.
//
//! lrm C.2
//! lrm 3.4.2
//! param gain = 0
//! bias V(p) = 1.0
`include "check.vh"
module annex_c_parameter_range(p, n);
    inout p, n;
    electrical p, n;
    parameter real gain = 1.0 from [0:inf);

    analog begin
        // Not the §3.4 default of 1.0 — the override took, and 0 is in range.
        `CHECKX("gain sits on the inclusive lower bound of [0:inf)", gain, 0.0);
        `CHECKX("the 1 V bias reaches the branch", V(p, n), 1.0);
        `CHECKX("a zero-gain transconductor carries no current", gain * V(p, n), 0.0);
        I(p, n) <+ gain * V(p, n);
    end
endmodule
