// Annex C.8: "The hierarchical structure defined in Clause 6 is applicable to
// both Verilog-AMS HDL and Verilog-A, except support for real value ports is
// only applicable to Verilog-AMS HDL and IEEE Std 1364 Verilog (see 6.5.3)."
//
// This file USED to reject `input wreal p;` on that carve-out. It is the
// SUBSET's rule; VerA targets Verilog-AMS, where §6.5.3 says "Ports may be
// declared as real-valued with a discrete-time discipline using the net type
// wreal", so the declaration is legal and must carry the value. Inverted the
// way 07/09/10 were.
//
// A real value port is spelled `wreal`, NOT `real`: A.2.1.2 gives
//
//   input_declaration ::= input [discipline_identifier] [net_type | wreal]
//                               [signed] [range] list_of_port_identifiers
//
// and this file writes the ONE-declaration form `input wreal p;` (the
// two-declaration `input in; wreal in;` is ch06_hierarchy/
// real_valued_wreal_port.va). One file per direction: 28 is `output`, 29 is
// `inout`.
//
// DERIVATION. The parent's wreal `w` has one driver, 0.375 (dyadic), and is
// bound to the child's input; the child reads 0.375 and makes it a potential.
//
//! lrm C.8
//! lrm 6.5.3
//! lrm 6.5.3:1
//! lrm 6.5
//! lrm 6.5:1000
//! lrm 7.4.2
//! lrm 7.4.2:2
//! solve
`include "check.vh"
module annex_c_real_value_port_accepted(out);
    output out;
    voltage out;
    wreal w;
    assign w = 0.375;
    annex_c_rvp_in u(w, out);
endmodule

module annex_c_rvp_in(p, out);
    input wreal p;
    output out;
    voltage out;
    analog begin
      `CHECKX("§6.5.3 an `input wreal` port carries the parent's real value", p, 0.375);
      V(out) <+ p;
    end
endmodule
