// Annex C.7, bullet 2: "casex and casez are not supported in Verilog-A." That
// is the SUBSET's rule. VerA targets Verilog-AMS, where §7.3.2 lists "the case,
// casex, and casez statements" among the analog context's features, so this
// file — `12_casez_rejected.va`, which pinned E0416 (now retired) — is
// inverted the way 07/09/10/13 were.
//
// DERIVATION. IEEE 1364 §9.5.1 makes z bits don't-cares under casez; an analog
// `integer` is two-state and has none, so casez over one is exactly §5.8.3's
// `case`. `selector` is 3, so the `3:` arm runs and result is 9; neither the
// `0:` arm nor the default may run. Four-state casez is
// ch07_mixed_signal/xz_casez_statement_compared.va.
//
//! lrm C.7
//! lrm 5.8.3
//! lrm 7.3.2
//! lrm 5.8.3:1
//! bias V(p) = 0.5
`include "check.vh"
module annex_c_casez_accepted(p);
    inout p;
    electrical p;
    integer selector, result;
    analog begin
        selector = 3;
        casez (selector)
            0: result = 0;
            3: result = 9;
            default: result = 1;
        endcase
        `CHECKI("casez over a two-state integer is case", result, 9);
        I(p) <+ V(p);
    end
endmodule
