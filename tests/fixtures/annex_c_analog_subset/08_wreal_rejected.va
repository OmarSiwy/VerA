// Annex C.4, bullet 2: "From 3.7, Real net declarations: the wreal data type is
// not supported in Verilog-A." Clause 3.7 is removed from the subset by name, so
// refusing `wreal` here is conformance, not a VerA limitation — this file used
// to be headed as DEBT against Clause 3.7, which is the Verilog-AMS rule and not
// this chapter's.
//
//! lrm C.4
//! lrm 3.7
//! reject E0205
//! reject wreal
module annex_c_wreal_rejected;
    wreal real_signal;
endmodule
