// Annex C.8 / §6.5.3, the `output` direction of the real value port. See
// 15_real_value_port_accepted.va for why the carve-out is the Verilog-A
// SUBSET's and not VerA's, and why a real value port is spelled `wreal`
// (A.2.1.2 admits `output [discipline_identifier] [net_type | wreal] ...`).
//
// DERIVATION. The child drives its `output wreal` port with its single driver,
// -1.5 (exact). §6.5.3 allows "a maximum of one driver of a real-valued net",
// and that is it: the parent's wreal `w` is the same net, so the parent's
// analog block reads -1.5.
//
//! lrm C.8
//! lrm 6.5.3
//! lrm 6.5.3:1
//! bias V(p) = 0.5
`include "check.vh"
module annex_c_real_value_output_port_accepted(p);
    inout p;
    electrical p;
    wreal w;
    annex_c_rvp_out u(w);
    analog begin
      `CHECKX("§6.5.3 an `output wreal` port delivers the child's driver", w, -1.5);
      I(p) <+ V(p);
    end
endmodule

module annex_c_rvp_out(p);
    output wreal p;
    assign p = -1.5;
endmodule
