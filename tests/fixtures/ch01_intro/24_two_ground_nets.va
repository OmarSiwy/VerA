// §1.3.1.1: "the node associated with the net shall be the global reference
// node in the circuit" — singular. Declaring two nets `ground` therefore does
// not create two references; both name the one global reference node, so there
// is no potential between them and either one measures the same potential on p.
//
// Every existing `ground` fixture declares exactly one, which cannot see the
// difference between "this net is zero" and "there is one reference node".
//
// Both grounds are biased away from zero, and away from each other, for the
// same reason 02_reference_ground.va biases its one ground: if the biases were
// left at the harness default of zero, all three assertions would restate the
// default rather than test the declaration. Here the declaration is what makes
// 3.0 and -1.0 both read as 0.
//
// All three wants exact: 0.0 - 0.0 == 0.0 and 0.75 - 0.0 == 0.75 in binary64.
//
//! lrm 1.3.1.1
//! bias V(p) = 0.75, V(g1) = 3.0, V(g2) = -1.0
`include "check.vh"
module ch01_two_ground_nets(p);
    inout p;
    electrical p, g1, g2;
    ground g1;
    ground g2;

    analog begin
        `CHECKX("two ground nets are one node, so no potential lies between them", V(g1, g2), 0.0);
        `CHECKX("potential measured to the first ground", V(p, g1), 0.75);
        `CHECKX("potential measured to the second ground", V(p, g2), 0.75);
        I(p, g1) <+ V(p, g1) * 1.0e-3;
    end
endmodule
