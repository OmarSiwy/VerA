// §1.3.1 a component can "be affected by" the potential at a node: here a probe
// of one branch drives a source in another (§5.4.2), a unity-gain buffer. At
// V(p)=0.8, V(n)=0.1, V(out)=0.4 the probed potential is 0.7 while the output
// branch sits at 0.3, so the source's residual is 0.3 - 0.7 = -0.4.
//
//! bias V(p) = 0.8, V(n) = 0.1, V(out) = 0.4
`include "check.vh"
module ch01_potential_probe(p, n, out);
    inout p, n, out;
    electrical p, n, out;
    analog begin
        `CHECK("probed input potential", V(p, n), 0.7, 1e-15);
        `CHECK("unity-gain residual", V(out, n) - V(p, n), -0.4, 1e-15);
        V(out, n) <+ V(p, n);
    end
endmodule
