// §1.3.1 a component can "be affected by" the potential at a node: here a probe
// of one branch drives a source in another (§5.4.2), a unity-gain buffer. At
// V(p)=0.8, V(n)=0.1, V(out)=0.4 the probed potential is 0.7 while the output
// branch sits at 0.3, so the source's residual is 0.3 - 0.7 = -0.4.
//
// THE TOLERANCE IS LOAD-BEARING HERE, unlike everywhere else in this chapter.
// 0.8-0.1 evaluates to 0.7000000000000001, one ulp (1.11e-16, about 11% of the
// 1e-15 budget) above double(0.7); the second want is exact only because the two
// roundings cancel. Do not promote these to `CHECKX` in a chapter-wide sweep, and
// do not tighten the tolerance below ~2e-16. Dyadic biases (0.875 / 0.125 / 0.5)
// would make it exact, at the cost of the chapter's only nonzero FP residual.
//
//! lrm 1.3.1
//! lrm 5.4.2
//! bias V(p) = 0.8, V(n) = 0.1, V(out) = 0.4
`include "check.vh"
module ch01_potential_probe(p, n, out);
    inout p, n, out;
    electrical p, n, out;
    analog begin
        `CHECK("probed input potential", V(p, n), 0.7, 1e-15);
        `CHECK("unity-gain residual", V(out, n) - V(p, n), -0.4, 1e-15);
        V(out, n) <+ V(p, n);
    end
endmodule
