// §1.3.1 a conservative branch: its potential is the DIFFERENCE of the two node
// potentials, and the constitutive relation turns that into a flow (§1.3.2).
// At V(p)=1.5, V(n)=0.25 the branch potential is 1.25 V, and Ohm's law over
// 250 ohm gives 1.25/250 = 5 mA.
//
//! lrm 1.3.1
//! lrm 1.3.2
//! param resistance = 250
//! bias V(p) = 1.5, V(n) = 0.25
`include "check.vh"
module ch01_conservative_resistor(p, n);
    inout p, n;
    electrical p, n;
    parameter real resistance = 1000.0 from (0:inf);

    analog begin
        `CHECK("branch potential is the node difference", V(p, n), 1.25, 1e-15);
        `CHECK("Ohm's law flow", V(p, n) / resistance, 5.0e-3, 1e-15);
        I(p, n) <+ V(p, n) / resistance;
    end
endmodule
