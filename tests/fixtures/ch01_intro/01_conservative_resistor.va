// §1.3.1 a conservative branch: its potential is the DIFFERENCE of the two node
// potentials, and the constitutive relation turns that into a flow (§1.3.2).
// At V(p)=1.5, V(n)=0.25 the branch potential is 1.25 V, and Ohm's law over
// 250 ohm gives 1.25/250 = 5 mA.
//
// Both steps are exact in binary64 — 1.5, 0.25 and 250 are dyadic, 1.5-0.25 is
// 1.25 exactly, and 1.25/250 is the correctly-rounded double of 5.0e-3 and
// therefore bit-equal to that literal — so CHECKX is the right macro. The
// `CHECK(..., 1e-15)` this replaces was an ABSOLUTE band, which on 5.0e-3 is a
// relative 2e-13: wide enough to swallow an ulp-level codegen regression.
//
// The second line is not arithmetic on the first: `resistance` is the §3.4
// parameter, overridden to 250 by the `//! param` line, so it goes ok=0 if the
// override is dropped and the declared default of 1000 is used instead.
//
//! lrm 1.3.1
//! lrm 1.3.2
//! param resistance = 250
//! bias V(p) = 1.5, V(n) = 0.25
`include "check.vh"
module ch01_conservative_resistor(p, n);
    inout p, n;
    electrical p, n;
    parameter real resistance = 1000.0 from (0:inf);

    analog begin
        `CHECKX("branch potential is the node difference", V(p, n), 1.25);
        `CHECKX("Ohm's law flow over the overridden resistance", V(p, n) / resistance, 5.0e-3);
        I(p, n) <+ V(p, n) / resistance;
    end
endmodule
