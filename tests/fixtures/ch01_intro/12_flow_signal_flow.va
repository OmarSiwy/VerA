// §1.3.4.2 the LRM's own worked example, `currmir`, transcribed from the
// clause: a current mirror on a flow-only signal-flow discipline. `current` is
// Annex D's flow-only discipline — compatible with `electrical` but binding a
// flow nature only — which is why the ports are `input`/`output` and never
// `inout` (16_sf_flow_on_inout.va pins that).
//
// The LRM PRINTS this module as legal, so the fixture must compile and run: a
// conforming compiler accepts it. Holding the input flow at 0.125 A (dyadic),
// the mirrored expression is -0.125 — IEEE-754 negation flips the sign bit and
// is exact, so the claim is an equality and not a tolerance.
//
// I(out) IS the assertion. The previous version asserted `-I(in)` — the right-
// hand side of the contribution retyped one line above it — which claims only
// that IEEE-754 negation works and says nothing about `currmir`. §5.4.2.2 makes
// the flow of a source branch readable anywhere in the module, and a flow source
// RETAINS its contributed value (§5.6.1.2), so I(out) is the mirrored -0.125 for
// a conforming compiler.
//
//! lrm 1.3.4.2
//! lrm 5.4.2.2
//! bias I(in) = 0.125
//! xfail two gaps, both needed for the XPASS: codegen refuses a contribution to a single-nature directional port (codegen.zig signalFlowNet), and the precondition is not yet expressible — tb.zig unknownName (src/backend/tb.zig:237) strips the `I(`...`)` and binds the unknown literally named `in`, i.e. the NODE potential, so `//! bias I(in) = 0.125` does not hold a port flow and I(in) reads 0 whatever codegen does. Closing only the codegen half leaves this XFAIL; the runner needs a real port-flow spelling
`include "check.vh"
module ch01_flow_signal_flow(in, out);
    input in;
    output out;
    current in, out;

    analog begin
        I(out) <+ -I(in);
        `CHECKX("the mirrored output flow negates the input flow", I(out), -0.125);
    end
endmodule
