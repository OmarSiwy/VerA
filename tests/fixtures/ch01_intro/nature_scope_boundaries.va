// §1.3.4's two prohibitions are scoped by the word ONLY:
//
//     "If a node is bound only to disciplines which have potential nature
//      only, current contributions to that node are not legal."
//     "Conversely, if a node is bound only to disciplines which have flow
//      nature only, potential contributions to that node are not legal."
//
// 14 and 19 pin the two refusals on `voltage` and `current`, the single-nature
// signal-flow disciplines. This is the boundary on the other side, the corner
// no fixture held: `electrical` binds BOTH natures, so neither sentence
// reaches it and both access functions must work. A checker that rejected
// `I(x)` on any net whose discipline merely *contains* a potential nature, or
// `V(x)` on any net that contains a flow nature, passes 14 and 19 and fails
// here; one that imposed the single-nature restriction on access functions in
// general (rather than on the node's declared natures) fails as well.
//
// DERIVATION. V(p) = V(n) = 0 from `//! bias`, and the flow source on (p, n)
// reads back the contributed 1.0e-3 A (§5.4.2.2, and a flow source retains its
// contributed value, §5.6.1.2), exactly equal to the literal because both are
// the same f64. `q` is the electrical output the device owns: V(q, n) <+ 0.5
// makes the branch potential 0.5 V exactly, both operands binary.
//
//! lrm 1.3.4
//! lrm 1.3.4:1001
//! lrm 1.3.4:1002
//! bias V(p) = 0.0
//! bias V(n) = 0.0
//! solve
`include "check.vh"
module ch01_nature_scope_boundaries(p, n, q);
    inout p, n;
    output q;
    electrical p, n, q;

    analog begin
        I(p, n) <+ 1.0e-3;
        V(q, n) <+ 0.5;
        `CHECKX("current contribution is legal where the node has both natures", I(p, n), 1.0e-3);
        `CHECKX("potential contribution is legal where the node has both natures", V(q, n), 0.5);
    end
endmodule
