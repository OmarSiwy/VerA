// §1.3.4, the "conversely" half: "if a node is bound only to disciplines which
// have flow nature only, potential contributions to that node are not legal.
// Potential for such a node is not defined." `ionly` is Annex D's `current` — a
// flow-only signal-flow discipline — so `V(ionly)` names a quantity the node
// does not have.
//
// The mirror of 14_signal_flow_illegal_quantity.va, which pins the first half
// (a flow contribution to a potential-only net). Kept in its own file so the
// runner says WHICH half fired: the two halves are separate sentences and a
// compiler can plausibly implement one and not the other.
//
// The conservative contribution on (p, n) is there only so the module is a
// well-formed device; the sole defect is the potential contribution to `ionly`.
//
// Same expectation as its mirror, and for the reason spelled out there: the
// phase label, not E0501. E0501 is the access-function NAME MISMATCH of §3.6.1.4;
// here the discipline binds no potential nature at all, and checkAccessMatch
// returns before E0501 on exactly that case.
//
//! lrm 1.3.4
//! reject DiagnosticsReported
module ch01_potential_contribution_to_flow_only(p, n);
    inout p, n;
    electrical p, n;
    current ionly;

    analog begin
        V(ionly) <+ 1.0;
        I(p, n) <+ V(p, n) * 1.0e-3;
    end
endmodule
