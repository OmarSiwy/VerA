// §1.3 defines a system as a hierarchical collection of interconnected
// components. Each component connects through ports to nets; a signal is a
// hierarchical collection of nets contiguous across port connections.
// This fixture demonstrates hierarchical port connections and the principle
// that a signal traverses the hierarchy unchanged.
//
//! lrm 1.3
//! lrm 1.3:1000
//! bias V(top_in) = 1.0, V(top_out) = 0.0
`include "check.vh"

module ch01_system_hierarchy_child(sig_in, sig_out);
  inout sig_in, sig_out;
  electrical sig_in, sig_out;

  analog begin
    // The signal entering through sig_in has the same potential at this level
    // as it does at the parent: hierarchy does not alter the signal value.
    `CHECKX("signal potential in child matches external connection", V(sig_in), 1.0);
    I(sig_in, sig_out) <+ V(sig_in, sig_out) / 1000.0;
  end
endmodule

module ch01_system_hierarchy(top_in, top_out);
  inout top_in, top_out;
  electrical top_in, top_out;

  // Instantiate a primitive component to form a hierarchical system.
  ch01_system_hierarchy_child child(.sig_in(top_in), .sig_out(top_out));

  analog begin
    // The same signal value passes through the hierarchy: what is 1.0 V at
    // top_in remains 1.0 V at the child's sig_in port (§1.3).
    `CHECKX("signal is contiguous across hierarchical port connection", V(top_in), 1.0);
    I(top_out) <+ 0.0;
  end
endmodule
