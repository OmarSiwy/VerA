// §1.3.4.1: "If, on the other hand, the output of this device were bound to a
// node of a conservative discipline (e.g., electrical), then the output of the
// device would appear to be a controlled voltage source to ground at that
// node. In that case, the flow (i.e., current) through the source would
// contribute to charge conservation at the node. If the input of this device
// were bound to a node of a conservative discipline then the input would act
// as a voltage probe to ground."
//
// The clause's own shiftPlus5, instantiated with BOTH ports on electrical
// nodes of the parent (11_potential_signal_flow.va runs it alone, on voltage
// nets). The parent's `a` is biased at 1.25 V; `n` is solved and loaded with
// R = 1000 ohms to ground.
//
//   output side: a voltage source to ground, so V(n) = 5.0 + 1.25 = 6.25
//                whatever the load; the resistor carries 6.25 / 1000 =
//                6.25e-3 A (the correctly-rounded double of 6.25e-3, compared
//                with a 1e-15 tolerance for the solver's last ulp).
//   input side:  a probe, so the instance draws nothing from `a`: V(a) stays
//                the biased 1.25 and the only flow at `a` is the host's.
//
// A compiler that refused the binding (discipline compatibility across the
// port, §1.3.3) fails to compile; one that dropped the source's flow from KFL
// at `n` cannot hold V(n) at 6.25 against the load.
//
//! lrm 1.3.4.1
//! lrm 1.3.4
//! bias V(a) = 1.25
//! solve
`include "check.vh"
module ch01_sf_shift(in, out);
  input in;
  output out;
  voltage in, out;
  analog V(out) <+ 5.0 + V(in);
endmodule

module ch01_sf_bound_to_conservative(a, n);
  inout a, n;
  electrical a, n;
  ch01_sf_shift u(.in(a), .out(n));
  analog begin
    I(n) <+ V(n) / 1000.0;
    `CHECK("the input probes the conservative node without loading it", V(a), 1.25, 0.0);
    `CHECK("the output is a voltage source to ground at the conservative node", V(n), 6.25, 1e-12);
    `CHECK("the load current flows through that source", I(n), 6.25e-3, 1e-15);
  end
endmodule
