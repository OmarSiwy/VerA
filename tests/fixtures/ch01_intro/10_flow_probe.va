// §1.3.1 the other half of the probe/source pair (§5.4.2): the FLOW through a
// named branch is read back and drives a POTENTIAL source on that same branch —
// the LRM's own resistor, written as `V(br) <+ R * I(br)`. The branch flow is a
// free unknown only for a potential source (§5.4.2.2): a flow source RETAINS its
// contributed value, so there would be nothing for the harness to hold.
// Holding the branch flow at 5 mA, the probe reads 5 mA, twice that is 10 mA,
// and 200 ohm gives 200.0 * 0.005 == 1.0 exactly in binary64 (verified).
//
// (The branch-flow unknown is `flow(p,n)`, which codegen spells with its
// punctuation escaped; `sweep` and not `bias` because a bias line splits its
// bindings on commas.)
//
//! lrm 1.3.1
//! lrm 5.4.2.2
//! sweep flowZ28pZ2cnZ29 = 0.005
`include "check.vh"
module ch01_flow_probe(p, n);
    inout p, n;
    electrical p, n;
    branch (p, n) measured;
    analog begin
        `CHECK("flow probe of the named branch", I(measured), 5.0e-3, 1e-15);
        `CHECK("doubled flow", 2.0 * I(measured), 1.0e-2, 1e-15);
        `CHECKX("contributed branch potential over 200 ohm", 200.0 * I(measured), 1.0);
        V(measured) <+ 200.0 * I(measured);
    end
endmodule
