// §1.3.1 the other half of the probe/source pair (§5.4.2): the FLOW through a
// named branch is read back and drives a POTENTIAL source on that same branch —
// the LRM's own resistor, written as `V(br) <+ R * I(br)`. The branch flow is a
// free unknown only for a potential source (§5.4.2.2): a flow source RETAINS its
// contributed value, so there would be nothing for the harness to hold.
// Holding the branch flow at 5 mA, both reads are 5 mA and both are exact — the
// swept literal itself — so CHECKX, not a 1e-15 absolute band on 5e-3 (which is
// a relative 2e-13).
//
// The two lines this replaces, `2.0 * I(measured)` want 1.0e-2 and
// `200.0 * I(measured)` want 1.0, were literal multiples of the line above them
// and the second was the right-hand side of the contribution retyped: three
// CHECKs, one claim, and a compiler that dropped the `<+` entirely passed all
// three. What replaces the second is the claim a named branch actually makes —
// §3.6.3/§5.4.1, `branch (p, n) measured` is an ALIAS for the pair, so I(p, n)
// must read the same unknown, and a compiler that minted a second unknown for
// the named form reads 0. (Contributing the retained potential back is still not
// asserted: V(measured) on a potential source reads the node difference, which
// here is 0.0 — see 05_potential_and_flow.va.)
//
// (The branch-flow unknown is `flow(p,n)`, which codegen spells with its
// punctuation escaped; `sweep` and not `bias` because a bias line splits its
// bindings on commas. That mangled name is a VerA codegen detail with no basis
// in the LRM — see the longer note in 05_potential_and_flow.va, which lists the
// three fixtures in this chapter that carry it.)
//
//! lrm 1.3.1
//! lrm 3.6.3
//! lrm 5.4.2.2
//! sweep flowZ28pZ2cnZ29 = 0.005
`include "check.vh"
module ch01_flow_probe(p, n);
    inout p, n;
    electrical p, n;
    branch (p, n) measured;
    analog begin
        `CHECKX("flow probe of the named branch", I(measured), 5.0e-3);
        `CHECKX("the name is an alias: the node pair is the same branch", I(p, n), 5.0e-3);
        V(measured) <+ 200.0 * I(measured);
    end
endmodule
