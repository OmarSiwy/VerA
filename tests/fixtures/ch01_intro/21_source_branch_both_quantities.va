// §1.3.1, the second half of the same sentence: "nor is it allowed to specify
// both the potential and flow of a source branch simultaneously."
//
// The UNCONDITIONALITY is the fixture. Both contributions sit in one straight
// block on the same node pair, so both are always active and the branch is
// asked to be a potential source and a flow source at once. Guarding them with
// mutually exclusive `if` arms would be a legal §5.6.5 switch branch and would
// test nothing — all four V+I pairs already in ch05_analog_behavior are of that
// conditional form, which is why this rule is uncovered.
//
// E0425 is not yet allocated in src/diag_code.zig: this is a behavioral rule,
// class 4. RESERVE E0425 FOR THIS RULE — if it is taken for something else this
// fixture stays XFAIL silently.
//
//! lrm 1.3.1
//! reject E0425
//! xfail lower.zig contribIndex treats any V+I pair on one node pair as a §5.6.5 switch branch, with no check that the two contributions are under exclusive conditions; unconditional both-quantity source branches lint AND emit clean
module ch01_source_branch_both_quantities(p, n);
    inout p, n;
    electrical p, n;

    analog begin
        V(p, n) <+ 1.0;
        I(p, n) <+ 1.0e-3;
    end
endmodule
