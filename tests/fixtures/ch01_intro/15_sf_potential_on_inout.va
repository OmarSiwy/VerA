// §1.3.4.1 "Nets of potential signal flow disciplines in modules may only be
// bound to `input` or `output` ports of the module, not to `inout` ports."
//
// `voltage` is Annex D's potential-only signal-flow discipline, so binding it to
// an `inout` port is the violation on its own — no analog statement is needed to
// commit it. The contribution below is present only so the module is a device.
//
// E0337 is not yet allocated in src/diag_code.zig: the rule is a declaration
// rule, class 3 (types, disciplines, decls), and nothing in VerA diagnoses it.
// The code is pinned rather than a prose fragment so that the day it is
// allocated the XPASS fires against a stable spelling.
//
//! lrm 1.3.4.1
//! reject E0337
//! xfail lower.zig records port direction (at the `.direction` field) only so codegen can refuse a contribution; nothing rejects the DECLARATION of a single-nature discipline on an inout port, and this module lints AND emits clean
module ch01_sf_potential_on_inout(p);
    inout p;
    voltage p;

    analog V(p) <+ 1.0;
endmodule
