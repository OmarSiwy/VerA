// §1.3.4.1 "Nets of potential signal flow disciplines in modules may only be
// bound to `input` or `output` ports of the module, not to `inout` ports."
//
// `voltage` is Annex D's potential-only signal-flow discipline, so binding it to
// an `inout` port is the violation on its own — no analog statement is needed to
// commit it. The contribution below is present only so the module is a device.
//
// The expectation is the phase label. It WAS `//! reject E0337`, a code that
// does not exist — src/diag_code.zig allocates class 3 up to E0336 (line 156) —
// and a code VerA cannot emit can never match the substring, so the fixture was
// pinned to XFAIL by construction: the day someone implements this rule and
// picks any other code, the reject still would not match and the gap would stay
// invisible. `.va` comments are not a reservation mechanism. `DiagnosticsReported`
// matches whichever code the rule gets, which is the only spelling that lets the
// XPASS fire; see ch05_analog_behavior/probe_both_quantities_invalid.va for the
// same choice made for the same reason.
//
//! lrm 1.3.4.1
//! reject DiagnosticsReported
//! xfail lower.zig records port direction (at the `.direction` field) only so codegen can refuse a contribution; nothing rejects the DECLARATION of a single-nature discipline on an inout port, and this module lints AND emits clean
module ch01_sf_potential_on_inout(p);
    inout p;
    voltage p;

    analog V(p) <+ 1.0;
endmodule
