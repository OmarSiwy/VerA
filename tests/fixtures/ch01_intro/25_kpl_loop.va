// §1.3.2 KPL: "The algebraic sum of all the branch potentials around a loop at
// any instant is zero (0)." Figure 1-3 states it as a SIGNED sum over four
// branches, two of which are traversed against their own reference direction:
//
//     -potential1 - potential2 + potential3 + potential4 = 0
//
// The word doing the work is "algebraic". 08_series_potentials.va sums two
// branches traversed the same way, which is subtraction telescoping — a
// compiler that dropped the sign on a reversed traversal still passes it. Here
// br1 and br2 are DECLARED reversed, (b,a) and (c,b), while the loop is walked
// a -> b -> c -> d -> a, so their contributions enter the sum negated and a lost
// sign moves the total by 1.5.
//
// Biases a=1.0, b=0.25, c=-0.5, d=0.125 are all dyadic, so every difference and
// the running total are exact in binary64 (checked with Fraction arithmetic, and
// the left-to-right partial sums 0.75, 1.5, 0.875, 0.0 are each representable):
//   V(br1) = V(b,a) = 0.25  - 1.0   = -0.75
//   V(br2) = V(c,b) = -0.5  - 0.25  = -0.75
//   V(br3) = V(c,d) = -0.5  - 0.125 = -0.625
//   V(br4) = V(d,a) = 0.125 - 1.0   = -0.875
//   -V(br1) - V(br2) + V(br3) + V(br4) = 0.75 + 0.75 - 0.625 - 0.875 = 0.0
//
// The four named branches are probes — none is on the left of a `<+` — so only
// their potentials are read, which §1.3.1 allows. The device's one contribution
// is on the chord (a,c), a node pair no probe branch names.
//
//! lrm 1.3.2
//! lrm 1.3.2:1000
//! bias V(a) = 1.0, V(b) = 0.25, V(c) = -0.5, V(d) = 0.125
`include "check.vh"
module ch01_kpl_loop(a, b, c, d);
    inout a, b, c, d;
    electrical a, b, c, d;
    branch (b, a) br1;
    branch (c, b) br2;
    branch (c, d) br3;
    branch (d, a) br4;

    analog begin
        `CHECKX("branch 1, reference direction b to a", V(br1), -0.75);
        `CHECKX("branch 2, reference direction c to b", V(br2), -0.75);
        `CHECKX("branch 3, reference direction c to d", V(br3), -0.625);
        `CHECKX("branch 4, reference direction d to a", V(br4), -0.875);
        `CHECKX("algebraic sum around the loop, two traversals reversed",
                -V(br1) - V(br2) + V(br3) + V(br4), 0.0);
        I(a, c) <+ V(a, c) * 1.0e-3;
    end
endmodule
