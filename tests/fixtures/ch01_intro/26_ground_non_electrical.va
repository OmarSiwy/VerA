// §1.3.1.1: "Any net of continuous discipline can be declared to be ground ...
// This is compatible with all analog disciplines." The clause is deliberately
// not about electricity — `ground` is a property of the reference NODE, and the
// nature that node carries is whatever its discipline binds.
//
// Every other ground fixture in the suite (02, 24, ch03/13, annex_h/08) declares
// an `electrical` net, so a compiler that special-cased `electrical` in its
// `ground` handling passed all of them. This one is thermal: the reference
// potential is a temperature, accessed with Temp, and the flow is Pwr.
//
// Same test shape as 02: the ground net is biased AWAY from zero so the word
// "always" is what the assertion measures. With `ground tgnd;` deleted the
// module reads Temp(tgnd)=300 and Temp(t,tgnd)=100 and both go ok=0.
//
// Both wants exact: 0.0 is a literal, and 400.0 - 0.0 == 400.0 in binary64.
//
//! lrm 1.3.1.1
//! bias t = 400.0, tgnd = 300.0
`include "check.vh"
module ch01_ground_non_electrical(t);
    inout t;
    thermal t, tgnd;
    ground tgnd;

    analog begin
        `CHECKX("a thermal ground net is zero regardless of bias", Temp(tgnd), 0.0);
        `CHECKX("a non-electrical net can be the global reference", Temp(t, tgnd), 400.0);
        Pwr(t, tgnd) <+ Temp(t, tgnd) * 1.0e-3;
    end
endmodule
