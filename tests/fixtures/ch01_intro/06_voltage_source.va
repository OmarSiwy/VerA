// §1.3.1.2 associated reference directions: the branch potential is positive
// when the + node (p) is above the - node (n). A potential source's equation is
// V(p,n) - 5.0 = 0, and probing it away from its solution reads the node
// difference: at V(p)=2.0, V(n)=-1.0 that is 3.0, and naming the terminals the
// other way round reads -3.0.
//
// The second line was `V(p,n) - 5.0`, want -2.0 — arithmetic on the value read
// one line above it, which cannot fail independently of it. What replaces it is
// the clause's own content: a second access expression the compiler evaluates
// separately, which a compiler that swapped + and - gets wrong on its own. Both
// biases are dyadic so both differences are exact in binary64, hence CHECKX.
//
//! lrm 1.3.1.2
//! lrm 1.3.1.2:1000
//! bias V(p) = 2.0, V(n) = -1.0
`include "check.vh"
module ch01_voltage_source(p, n);
    inout p, n;
    electrical p, n;
    analog begin
        `CHECKX("branch potential, + at p", V(p, n), 3.0);
        `CHECKX("+ at n instead: the same branch with the opposite sign", V(n, p), -3.0);
        V(p, n) <+ 5.0;
    end
endmodule
