// §1.3.1.2 associated reference directions: the branch potential is positive
// when the + node (p) is above the - node (n). A potential source's equation is
// V(p,n) - 5.0 = 0, so probing it away from its solution measures the mismatch:
// at V(p)=2.0, V(n)=-1.0 the branch potential is 3.0 and the residual is -2.0.
//
//! lrm 1.3.1.2
//! bias V(p) = 2.0, V(n) = -1.0
`include "check.vh"
module ch01_voltage_source(p, n);
    inout p, n;
    electrical p, n;
    analog begin
        `CHECK("branch potential, + at p", V(p, n), 3.0, 1e-15);
        `CHECK("source residual V(p,n) - 5", V(p, n) - 5.0, -2.0, 1e-15);
        V(p, n) <+ 5.0;
    end
endmodule
