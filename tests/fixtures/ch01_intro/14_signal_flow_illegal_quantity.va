// §1.3.4 "If a node is bound only to disciplines which have potential nature
// only, current contributions to that node are not legal. Flow for such a node
// is not defined." `vonly` is Annex D's `voltage` — a potential-only signal-flow
// discipline — so `I(vonly)` names a quantity the node does not have.
//
// The conservative contribution on (p, n) is there only so the module is a
// well-formed device; the sole defect is the flow contribution to `vonly`.
//
// The pinned code is E0501, "unknown access function": `I` is not an access
// function of `vonly`, which is exactly what lower.zig checkAccessMatch decides.
// (The earlier version of this file wrote `flow(outp) <+ ...`; `flow` is a
// discipline-item keyword per A.1.7, so it died in the parser at E0209 and never
// reached this rule at all.)
//
//! lrm 1.3.4
//! reject E0501
//! xfail lower.zig checkAccessMatch returns early on `want.len == 0`, so a discipline that binds no flow nature accepts every flow access on its nets silently
module ch01_signal_flow_illegal_quantity(p, n);
    inout p, n;
    electrical p, n;
    voltage vonly;

    analog begin
        I(vonly) <+ 1.0e-3;
        I(p, n) <+ V(p, n) * 1.0e-3;
    end
endmodule
