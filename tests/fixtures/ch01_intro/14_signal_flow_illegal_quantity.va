// §1.3.4 "If a node is bound only to disciplines which have potential nature
// only, current contributions to that node are not legal. Flow for such a node
// is not defined." `vonly` is Annex D's `voltage` — a potential-only signal-flow
// discipline — so `I(vonly)` names a quantity the node does not have.
//
// The conservative contribution on (p, n) is there only so the module is a
// well-formed device; the sole defect is the flow contribution to `vonly`.
//
// The expectation is the phase label and NOT E0501. E0501 is "unknown access
// function", `.lrm = "3.6.1.4"` (src/diag_code.zig:1463) — a NAME MISMATCH
// between an access function and a nature's `access =` attribute. This rule is a
// different one: the discipline binds no flow nature at all, so there is no
// spelling to mismatch. lower.zig checkAccessMatch says so in as many words —
// `if (want.len == 0 or ...) return;`, documented "the missing binding is its own
// diagnostic" — so E0501 is a code VerA has already decided not to use here, and
// pinning it would keep this fixture XFAIL forever no matter which code the rule
// eventually gets. `DiagnosticsReported` matches whichever one that is, which is
// what makes the XPASS able to fire. (The earlier version of this file wrote
// `flow(outp) <+ ...`; `flow` is a discipline-item keyword per A.1.7, so it died
// in the parser at E0209 and never reached this rule at all.)
//
//! lrm 1.3.4
//! reject DiagnosticsReported
module ch01_signal_flow_illegal_quantity(p, n);
    inout p, n;
    electrical p, n;
    voltage vonly;

    analog begin
        I(vonly) <+ 1.0e-3;
        I(p, n) <+ V(p, n) * 1.0e-3;
    end
endmodule
