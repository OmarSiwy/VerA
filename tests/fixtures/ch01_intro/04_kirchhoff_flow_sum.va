// §5.6.1.3 value retention: "multiple contributions to the same potential
// branch or same flow branch will be additive". Two flow contributions to the
// branch (p, n) accumulate rather than the second overwriting the first, which
// is what lets a transconductance be written as a second `<+` beside the
// resistive one instead of one fused expression.
//
// NOT §1.3.2. The filename says Kirchhoff and the header used to as well, but
// KFL is about the flows out of a NODE summing to zero; what produces 1.4 mA
// here is contribution accumulation onto one BRANCH, a chapter 5 rule.
// 25_kpl_loop.va and 08_series_potentials.va carry the §1.3.2 coverage.
//
// The accumulated value is now READ BACK off the branch instead of being
// retyped as an expression. §5.4.2.2 makes it readable — "both the potential
// and the flow of a source branch are accessible in expressions anywhere in the
// module" — and for a FLOW source the branch flow has no node-derived value, so
// the retained sum is the only thing `I(p, n)` can mean. The previous version
// asserted `V(p,n)/1000.0 + 2.0*V(control,n)/1000.0`, the two right-hand sides
// retyped on one line, which a compiler whose second `<+` OVERWROTE the first
// still printed ok=1 for; it was green and proved nothing, by its own admission.
// The read is placed AFTER both contributions because retention is sequential
// (§5.6.1.3 accumulates as the statements execute).
//
// The first line is harness plumbing, not a conformance claim: its got is a bias
// read straight back. It is kept only so a failure of the second line is
// readable.
//
// At V(p)=1.0, V(n)=0.2, V(control)=0.5 every step is exact in binary64
// (0.5-0.2 is bit-exactly double(0.3), and the sum below is bit-equal to the
// literal 1.4e-3), so CHECKX and not a tolerance:
//   resistive       (1.0-0.2)/1000       = 8.0e-4
//   transconductive 2*(0.5-0.2)/1000     = 6.0e-4
//   total                                = 1.4e-3
//
//! lrm 5.6.1.3
//! lrm 5.6.1.2
//! lrm 5.4.2.2
//! bias V(p) = 1.0, V(n) = 0.2, V(control) = 0.5
//! xfail VerA reads I(p,n) on a flow-SOURCE branch as 0 instead of the retained accumulated value (§5.4.2.2): the read is lowered as a branch-flow unknown that only a potential source frees, so it stays at its initial 0 — the same gap 07_current_source.va pins for a single contribution
`include "check.vh"
module ch01_kirchhoff_flow_sum(p, n, control);
    inout p, n, control;
    electrical p, n, control;

    analog begin
        `CHECKX("control probe, plumbing for the line below", V(control, n), 0.3);
        I(p, n) <+ V(p, n) / 1000.0;
        I(p, n) <+ 2.0 * V(control, n) / 1000.0;
        `CHECKX("the second contribution ADDS to the first on one flow branch",
                I(p, n), 1.4e-3);
    end
endmodule
