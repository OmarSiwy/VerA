// §5.6.1.3 value retention: "multiple contributions to the same potential
// branch or same flow branch will be additive". Two flow contributions to the
// branch (p, n) accumulate rather than the second overwriting the first, which
// is what lets a transconductance be written as a second `<+` beside the
// resistive one instead of one fused expression.
//
// NOT §1.3.2. The filename says Kirchhoff and the header used to as well, but
// KFL is about the flows out of a NODE summing to zero; what produces 1.4 mA
// here is contribution accumulation onto one BRANCH, a chapter 5 rule.
// 25_kpl_loop.va and 08_series_potentials.va carry the §1.3.2 coverage.
//
// KNOWN WEAKNESS, recorded rather than papered over: neither assertion observes
// the two `<+` statements. Both evaluate expressions written out on their own
// line, so a compiler whose second `<+` OVERWROTE the first still prints ok=1
// twice. Asserting the accumulated branch value needs a runner directive that
// checks one residual entry with the same ok= discipline as CHECK, which does
// not exist; adding it is a runner change, out of scope for a fixtures pass. Do
// not read this file as evidence that accumulation was tested.
//
// The digits are right and unchanged. At V(p)=1.0, V(n)=0.2, V(control)=0.5,
// every step exact in binary64:
//   resistive       (1.0-0.2)/1000       = 8.0e-4
//   transconductive 2*(0.5-0.2)/1000     = 6.0e-4
//   total                                = 1.4e-3
//
//! lrm 5.6.1.3
//! lrm 5.6.1.2
//! bias V(p) = 1.0, V(n) = 0.2, V(control) = 0.5
`include "check.vh"
module ch01_kirchhoff_flow_sum(p, n, control);
    inout p, n, control;
    electrical p, n, control;

    analog begin
        `CHECK("transconductive term", 2.0 * V(control, n) / 1000.0, 6.0e-4, 1e-15);
        `CHECK("both contributions summed",
               V(p, n) / 1000.0 + 2.0 * V(control, n) / 1000.0, 1.4e-3, 1e-15);
        I(p, n) <+ V(p, n) / 1000.0;
        I(p, n) <+ 2.0 * V(control, n) / 1000.0;
    end
endmodule
