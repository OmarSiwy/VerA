// §1.3.2 KFL: flows into a node SUM. Two flow contributions to the same branch
// therefore add rather than overwrite. At V(p)=1.0, V(n)=0.2, V(control)=0.5:
//   resistive       (1.0-0.2)/1000       = 0.8 mA
//   transconductive 2*(0.5-0.2)/1000     = 0.6 mA
//   total                                = 1.4 mA
//
//! bias V(p) = 1.0, V(n) = 0.2, V(control) = 0.5
`include "check.vh"
module ch01_kirchhoff_flow_sum(p, n, control);
    inout p, n, control;
    electrical p, n, control;

    analog begin
        `CHECK("transconductive term", 2.0 * V(control, n) / 1000.0, 6.0e-4, 1e-15);
        `CHECK("both contributions summed",
               V(p, n) / 1000.0 + 2.0 * V(control, n) / 1000.0, 1.4e-3, 1e-15);
        I(p, n) <+ V(p, n) / 1000.0;
        I(p, n) <+ 2.0 * V(control, n) / 1000.0;
    end
endmodule
