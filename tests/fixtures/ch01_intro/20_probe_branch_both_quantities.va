// §1.3.1, last sentence of the probe/source paragraph: "The potential and flow
// of a probe branch may not both appear in expressions in a given module."
//
// `prb` is a PROBE branch, and the reason is structural, not a matter of
// wording: it never appears on the left-hand side of a `<+`. §1.3.1 defines the
// term exactly that way — "if the branch potential and flow are left
// unspecified, not on the left-hand side of a contribution statement, then the
// branch acts as a probe". Do not "fix" this file by contributing to `prb`:
// that makes it a source branch and the sentence above stops applying. The
// near-miss ch05_analog_behavior/source_probe_both.va is legal for precisely
// that reason — it writes `V(b) <+ 10.0*I(b)`, so `b` is a source.
//
// The output branch is (o, r), disjoint from (p, n), so nothing contributes to
// the probe's node pair even indirectly.
//
// E0424 is not yet allocated in src/diag_code.zig: this is a behavioral rule,
// class 4. Pinned as a code rather than a message fragment so the XPASS fires
// against a stable spelling the day it is allocated. RESERVE E0424 FOR THIS
// RULE — if it is taken for something else this fixture stays XFAIL silently.
//
//! lrm 1.3.1
//! reject E0424
//! xfail lower.zig never correlates the two accesses of an uncontributed node pair: V(prb) and I(prb) are lowered independently, so nothing observes that both quantities of one probe branch were read; `vera --lint` and `--emit-zig` both exit 0
module ch01_probe_branch_both_quantities(p, n, o, r);
    inout p, n, o, r;
    electrical p, n, o, r;
    branch (p, n) prb;

    analog I(o, r) <+ V(prb) + I(prb);
endmodule
