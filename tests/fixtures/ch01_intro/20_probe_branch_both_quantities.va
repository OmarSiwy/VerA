// §1.3.1, last sentence of the probe/source paragraph: "The potential and flow
// of a probe branch may not both appear in expressions in a given module."
//
// `prb` is a PROBE branch, and the reason is structural, not a matter of
// wording: it never appears on the left-hand side of a `<+`. §1.3.1 defines the
// term exactly that way — "if the branch potential and flow are left
// unspecified, not on the left-hand side of a contribution statement, then the
// branch acts as a probe". Do not "fix" this file by contributing to `prb`:
// that makes it a source branch and the sentence above stops applying. The
// near-miss ch05_analog_behavior/source_probe_both.va is legal for precisely
// that reason — it writes `V(b) <+ 10.0*I(b)`, so `b` is a source.
//
// The output branch is (o, r), disjoint from (p, n), so nothing contributes to
// the probe's node pair even indirectly.
//
// §5.4.2.1 is cited alongside §1.3.1 because it is the clause that states the
// rule with the word illegal: "Using both the potential and the flow of a probe
// branch is illegal." ch05_analog_behavior/probe_both_quantities_invalid.va pins
// the same rule on an UNNAMED branch; the two now demand the same expectation,
// so implementing the rule closes both instead of one.
//
// That expectation is the phase label. It WAS `//! reject E0424`, a code that
// does not exist — src/diag_code.zig allocates class 4 up to E0422 (line 181) —
// so nothing VerA can emit would match, and the "RESERVE E0424 FOR THIS RULE"
// comment that used to sit here reserved nothing: a `.va` comment is not a
// mechanism. The phase label matches whichever code the rule gets.
//
//! lrm 1.3.1
//! lrm 5.4.2.1
//! reject DiagnosticsReported
module ch01_probe_branch_both_quantities(p, n, o, r);
    inout p, n, o, r;
    electrical p, n, o, r;
    branch (p, n) prb;

    analog I(o, r) <+ V(prb) + I(prb);
endmodule
