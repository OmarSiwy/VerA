// §1.3.5 "Conservative components and signal-flow components can be freely
// mixed." One module holds both halves of the clause's own worked examples: the
// conservative `resistor` ports (`inout a, b; electrical a, b;`) and the
// signal-flow `voltage_amplifier` output (`output out; voltage out;`), whose
// declaration "only require[s] types for those values which are actually used".
//
// The LRM states this as a guarantee, so the fixture must compile and run: a
// conforming compiler accepts it. Biased at V(a) = 2.0 with `b` at the default
// zero, the conservative probe reads 2.0; the LRM's own GAIN_V = 10.0 makes the
// signal-flow drive 10.0 * 2.0 = 20.0, exact in binary64; and the resistor's
// constitutive flow is 2.0 / 1000.0, which is the correctly-rounded double of
// 2.0e-3 and therefore compares bit-equal to that literal.
//
// Both halves are read back off the net they were contributed to, not retyped
// as expressions. The previous version asserted `GAIN_V * V(a, b)` and
// `V(a, b) / R`, which are exactly the two right-hand sides one and two lines
// below them: neither observed a `<+`, so the file would have XPASSed having
// proved only that V(a,b) is 2.0. Reading V(out) is strictly stronger — it still
// fails if GAIN_V's §3.4 default is wrong — and it routes through the mixing the
// clause guarantees. §5.4.2.2 makes both quantities of a source branch readable;
// the flow source on (a, b) retains 2.0e-3, and V(out) on a potential-only
// signal-flow net is defined by its source alone.
//
// The directives are the netlist, and each line says which side of the
// device/host boundary an unknown lives on. `a` and `b` are CONSERVATIVE
// terminals: an isolated device cannot decide their potentials — solve it and
// `b` becomes an open lead that follows `a`, KCL through it being zero — so the
// host states both, `b` at the reference. `out` is the signal-flow `output` and
// belongs to the device, so `//! solve` frees it and the solver reads back the
// 20.0 the source imposes. Naming `b` explicitly rather than leaning on the
// default is what lets the two coexist on one module.
//
//! lrm 1.3.5
//! lrm 5.4.2.2
//! lrm 1.3.5:1000
//! bias V(a) = 2.0
//! bias V(b) = 0.0
//! solve
`include "check.vh"
module ch01_mixed_conservative_signal_flow(a, b, out);
    inout a, b;
    electrical a, b;
    output out;
    voltage out;
    parameter real GAIN_V = 10.0;
    parameter real R = 1000.0 from (0:inf);

    analog begin
        `CHECKX("conservative probe across the resistor branch", V(a, b), 2.0);
        V(out) <+ GAIN_V * V(a, b);
        I(a, b) <+ V(a, b) / R;
        `CHECKX("the signal-flow output is the gain times the conservative probe", V(out), 20.0);
        `CHECKX("the conservative flow alongside it", I(a, b), 2.0e-3);
    end
endmodule
