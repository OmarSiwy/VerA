// §1.3.4.2, second sentence of the port restriction: "Flow contributions may not
// be made to input ports in this case."
//
// The mirror of 17_sf_potential_contribution_to_input.va. The DECLARATION is
// legal — `current` on an `input` port is exactly what currmir writes — and it is
// the CONTRIBUTION `I(inp) <+ ...` that the clause forbids. The contribution to
// `outp` is legal and is there to show the rule is about direction.
//
// E0423 is not yet allocated in src/diag_code.zig — see the note in
// 17_sf_potential_contribution_to_input.va, including why this must not be
// pinned as `GeneratedCompileError`.
//
//! lrm 1.3.4.2
//! reject E0423
//! xfail no front-end diagnostic distinguishes an input from an output contribution target; `vera --lint` is silent and only codegen refuses, generically
module ch01_sf_flow_contribution_to_input(inp, outp);
    input inp;
    output outp;
    current inp, outp;

    analog begin
        I(inp) <+ 1.0e-3;
        I(outp) <+ 2.0e-3;
    end
endmodule
