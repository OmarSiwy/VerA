// §1.3.1 a flow source: "the branch potential or flow is specified as a function
// of branch potentials and flows" — here the flow is specified as a constant, so
// the branch imposes that flow whatever the node potentials do, and §5.6.1
// retention makes the contributed value the one a probe of the same branch reads
// back.
//
// The independence is the claim, and it needs more than one operating point to be
// a claim at all: the branch is swept across +0.75 V, 0 V and -2.5 V and the flow
// must read 1 mA at every one of them. A compiler whose source value drifted with
// the bias fails on the second sweep point.
//
// The previous version of this file asserted only `CHECKX("scale factor m is
// 1e-3", 1m, 1.0e-3)`, which is §2.6.2, not §1.3.1, and is already covered by
// ch02_lexical/07_si_scale_factors.va. Nothing in it was about a flow source.
//
// The want is exact: 1.0e-3 is the retained literal itself. §5.4.2.2 is what
// makes the probe legal: "Both the potential and the flow of a source branch are
// accessible in expressions anywhere in the module."
//
// The read sits AFTER the `<+`, and must. §5.6.1.2 states retention
// sequentially — a contribution "adds the value of the right-hand side to any
// previously retained value", with the assignment made "at the end of the
// simulation cycle" — so before line 30 nothing has been retained and 1.0e-3 is
// the right number only for a read that follows. The LRM does the same in
// §5.4.3 Example 1, where the diode reads `I(i_diode)` after contributing it.
//
// Note this is NOT in tension with 06_voltage_source.va, which reads V(p,n) on a
// potential source and gets the node difference: a source branch's POTENTIAL
// still has the value §1.3.1 gives every branch, while a flow source's branch
// flow has no node-derived value at all. The asymmetry is in the LRM.
//
//! lrm 1.3.1
//! lrm 5.4.2.2
//! lrm 5.6.1
//! sweep V(p) = 0.75, 0.0, -2.5
//! xfail VerA reads I(p,n) on a flow-SOURCE branch as 0 instead of the retained contributed value (§5.4.2.2); the read is lowered as a branch-flow unknown that only a potential source frees, so it stays at its initial 0 at every sweep point
`include "check.vh"
module ch01_current_source(p, n);
    inout p, n;
    electrical p, n;
    analog begin
        I(p, n) <+ 1.0e-3;
        `CHECKX("the flow source value does not depend on the node potentials", I(p, n), 1.0e-3);
    end
endmodule
