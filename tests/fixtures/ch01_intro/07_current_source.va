// §1.3.1 a flow source: the flow onto the node is fixed and independent of the
// node potentials. Its value is written with the §2.6.2 scale factor `m`, which
// Table 2-1 gives as 1e-3, so `1m` and `1.0e-3` must round to the same IEEE 754
// double and compare exactly.
//
`include "check.vh"
module ch01_current_source(p, n);
    inout p, n;
    electrical p, n;
    analog begin
        `CHECKX("scale factor m is 1e-3", 1m, 1.0e-3);
        I(p, n) <+ 1m;
    end
endmodule
