// §1.3.4 "A discipline with only a potential nature or only a flow nature is
// known as a signal flow discipline." ... "If a node is bound only to
// disciplines which have potential nature only, current contributions to that
// node are not legal. ... Conversely, if a node is bound only to disciplines
// which have flow nature only, potential contributions to that node are not
// legal."
//
// The clause's positive half: on a potential-only node the POTENTIAL
// contribution is the legal one, and on a flow-only node the FLOW contribution
// is. 14_signal_flow_illegal_quantity.va and
// 19_potential_contribution_to_flow_only.va pin the two refusals; this file pins
// that the permitted quantity is accepted and determines the node.
//
// `voltage` and `current` are Annex D's two signal-flow disciplines (potential
// Voltage only, flow Current only).
//
// DERIVATION. `vout` is driven by `V(vout) <+ 2.0 * V(in)` with V(in) = 0.375
// (dyadic), so V(vout) = 0.75 exactly. `iout` is driven by
// `I(iout) <+ 0.5 * V(in)`, so I(iout) = 0.1875 exactly. `//! solve` leaves both
// outputs to the device: on a signal-flow node the contribution is the only
// equation, so a conforming compiler reads back exactly what was contributed.
//
//! lrm 1.3.4
//! lrm 1.3.4:1
//! bias V(in) = 0.375
//! solve
`include "check.vh"
module ch01_signal_flow_single_nature_contributions(in, vout, iout);
    input in;
    output vout, iout;
    voltage in, vout;
    current iout;

    analog begin
        V(vout) <+ 2.0 * V(in);
        I(iout) <+ 0.5 * V(in);
        `CHECKX("§1.3.4 a potential contribution determines a potential-only node", V(vout), 0.75);
        `CHECKX("§1.3.4 a flow contribution determines a flow-only node", I(iout), 0.1875);
    end
endmodule
