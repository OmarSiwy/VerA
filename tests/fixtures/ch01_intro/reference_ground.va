// §1.3.1.1 the reference node: "The potential of the reference node, which is
// called ground in electrical systems, is always zero (0). Any net of continuous
// discipline can be declared to be ground. In this case, the node associated
// with the net shall be the global reference node in the circuit."
//
// The whole content of the clause is the word "always", so `gnd` is biased AWAY
// from zero and asserted to be zero anyway. That is what makes this a test: with
// `ground gnd;` deleted the same file reads V(gnd)=3 and V(p,gnd)=-2.25 and both
// assertions go ok=0. The previous version biased only V(p), left gnd at the
// harness default of zero, and therefore passed identically with or without the
// declaration it claimed to be testing. Its second assertion, V(p,gnd) - 1.25,
// was arithmetic on the line above it and is gone.
//
// Both wants are exact: 0.0 is a literal and 0.75 - 0.0 == 0.75 in binary64.
//
//! lrm 1.3.1.1
//! lrm 1.3.1.1:1
//! bias V(p) = 0.75, V(gnd) = 3.0
`include "check.vh"
module ch01_reference_ground(p);
    inout p;
    electrical p, gnd;
    ground gnd;

    analog begin
        `CHECKX("a ground net is zero regardless of bias", V(gnd), 0.0);
        `CHECKX("potential to the zero reference node", V(p, gnd), 0.75);
        V(p, gnd) <+ 1.25;
    end
endmodule
