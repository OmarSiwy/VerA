// §1.2 lists the language's salient features, and one of them is a
// prohibition:
//
//     "analog potentials and flows can only receive contributions (write
//      operations) from inside an analog procedural block"
//
// So a contribution statement inside an `always` block is illegal. Nothing
// else in this module is: the `always @(posedge clk)` block with a digital
// statement in it compiles (probed: the same module with `q = 1'b1` in place of
// the contribution and a separate `analog V(p, n) <+ 1.0;` is accepted), so the
// one error is the write to V(p, n) from a discrete context.
//
// VerA reports E0435 "a continuous net cannot be written from a discrete
// context: contributed from an always block", which names this rule.
//
//! lrm 1.2
//! lrm 1.2:1000
//! reject-only E0435
//! neighbour analog_and_digital_declarations_coexist.va
`include "disciplines.vams"
module ch1_contribution_from_always(p, n, clk);
  inout p, n;
  electrical p, n;
  input clk;
  wire clk;

  always @(posedge clk) V(p, n) <+ 1.0;   // illegal: not inside an analog block
endmodule
