// §1.3.2 KPL: the algebraic sum of branch potentials around a loop is zero, so
// two series branch potentials telescope into the end-to-end one. At V(p)=1.0,
// V(mid)=0.3, V(n)=-0.5 that is 0.7 + 0.8 = 1.5, which is also V(p) - V(n).
// Both subtractions are exact in binary64 (1.0-0.3 == 0.7, 0.3-(-0.5) == 0.8)
// and the sum lands exactly on 1.5, so the tolerance is not doing any work here.
//
//! bias V(p) = 1.0, V(mid) = 0.3, V(n) = -0.5
`include "check.vh"
module ch01_series_potentials(p, mid, n);
    inout p, mid, n;
    electrical p, mid, n;
    analog begin
        `CHECK("series branch potentials", V(p, mid) + V(mid, n), 1.5, 1e-15);
        `CHECK("end-to-end potential", V(p, n), 1.5, 1e-15);
        V(p, mid) <+ 1.0;
        V(mid, n) <+ 2.0;
    end
endmodule
