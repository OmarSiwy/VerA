// §1.3.2 KPL: the algebraic sum of branch potentials around a loop is zero, so
// two series branch potentials telescope into the end-to-end one. At V(p)=1.0,
// V(mid)=0.25, V(n)=-0.5 that is 0.75 + 0.75 = 1.5, which is also V(p) - V(n).
//
// The biases are dyadic on purpose, so the exactness claim is true and not merely
// lucky: 1.0, 0.25 and 0.5 are each representable, 1.0-0.25 == 0.75 and
// 0.25-(-0.5) == 0.75 exactly, and 0.75+0.75 == 1.5 exactly, so the tolerance is
// doing no work. The previous V(mid)=0.3 produced the same two 1.5s with residual
// 0.0, but neither of ITS subtractions was exact — double(1.0)-double(0.3) is not
// representable and rounds to double(0.7) — so the comment justifying the wants
// was false about the arithmetic it justified. Since every step is exact, the
// macro is CHECKX: a 1e-15 absolute band on values of order 1 was doing nothing
// except hiding an ulp-level regression.
//
//! lrm 1.3.2
//! lrm 1.3.2:1000
//! bias V(p) = 1.0, V(mid) = 0.25, V(n) = -0.5
`include "check.vh"
module ch01_series_potentials(p, mid, n);
    inout p, mid, n;
    electrical p, mid, n;
    analog begin
        `CHECKX("series branch potentials", V(p, mid) + V(mid, n), 1.5);
        `CHECKX("end-to-end potential", V(p, n), 1.5);
        V(p, mid) <+ 1.0;
        V(mid, n) <+ 2.0;
    end
endmodule
