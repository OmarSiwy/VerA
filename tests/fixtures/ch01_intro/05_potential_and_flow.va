// §1.3.1 "there are two values associated with every node, the potential ...
// and the flow". This is the resistor written the other way round: the FLOW is
// probed and the potential is contributed (§5.4.2 probe/source). Holding the
// branch flow at 20 mA and leaving `resistance` at its §3.4 declared default of
// 10 ohm, the contributed potential is 10 * 0.02 = 0.2 V.
//
// (The branch-flow unknown is `flow(p,n)`, which codegen spells with its
// punctuation escaped; `sweep` and not `bias` because a bias line splits its
// bindings on commas.)
//
//! sweep flowZ28pZ2cnZ29 = 0.02
`include "check.vh"
module ch01_potential_and_flow(p, n);
    inout p, n;
    electrical p, n;
    parameter real resistance = 10.0;

    analog begin
        `CHECK("flow probe reads the branch flow", I(p, n), 2.0e-2, 1e-15);
        `CHECK("contributed potential", resistance * I(p, n), 0.2, 1e-15);
        V(p, n) <+ resistance * I(p, n);
    end
endmodule
