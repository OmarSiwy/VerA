// §1.3.1 "there are two values associated with every node, the potential ...
// and the flow". This is the resistor written the other way round: the FLOW is
// probed and the potential is contributed (§5.4.2 probe/source). Holding the
// branch flow at 20 mA and leaving `resistance` at its §3.4 declared default of
// 10 ohm, the contributed potential is 10 * 0.02 = 0.2 V.
//
// (The branch-flow unknown is `flow(p,n)`, which codegen spells with its
// punctuation escaped; `sweep` and not `bias` because a bias line splits its
// bindings on commas. That mangled name is a VerA codegen detail with no basis
// in the LRM, and it makes this file and 10_flow_probe.va the two unportable
// fixtures in the chapter. The fix is to teach the `//!` grammar the source-level
// spelling `//! sweep I(p,n) = 0.02` — tb.zig unknownName strips only `V(`, `I(`
// and `x[`, so `I(p,n)` resolves to the NODE unknown `p,n` today. That is a
// runner change, out of scope for a fixtures pass.)
//
// The first CHECK is harness plumbing, not a conformance claim: its got is the
// swept value routed back through codegen, so it proves the sweep bound the
// branch-flow unknown and nothing about §1.3.1. It is kept because if it goes
// ok=0 the second CHECK's failure is unreadable. The §3.4 default is the claim.
//
//! lrm 1.3.1
//! lrm 3.4
//! lrm 5.4.2
//! sweep flowZ28pZ2cnZ29 = 0.02
`include "check.vh"
module ch01_potential_and_flow(p, n);
    inout p, n;
    electrical p, n;
    parameter real resistance = 10.0;

    analog begin
        `CHECK("flow probe reads the branch flow", I(p, n), 2.0e-2, 1e-15);
        `CHECK("contributed potential", resistance * I(p, n), 0.2, 1e-15);
        V(p, n) <+ resistance * I(p, n);
    end
endmodule
