// §1.3.1 "there are two values associated with every node, the potential ...
// and the flow". This is the resistor written the other way round: the FLOW is
// probed and the potential is contributed (§5.4.2 probe/source). Holding the
// branch flow at 20 mA and leaving `resistance` at its §3.4 declared default of
// 10 ohm, the contributed potential is 10 * 0.02 = 0.2 V.
//
// (The branch-flow unknown is `flow(p,n)`, which codegen spells with its
// punctuation escaped; `sweep` and not `bias` because a bias line splits its
// bindings on commas. That mangled name is a VerA codegen detail with no basis
// in the LRM, and it makes this file, 10_flow_probe.va and 23_flow_antisymmetry.va
// the three unportable fixtures in the chapter (ch05_analog_behavior/flow_probe.va,
// port_flow_probe.va and source_probe_both.va are the same shape elsewhere in the
// tree, so this is a suite-wide runner debt, not a ch01 one). No `//! xfail` is
// hung on it: xfail means VerA does not satisfy the fixture, and VerA does — it
// is the OTHER compilers this directive locks out.
// The fix is to teach the `//!` grammar the source-level
// spelling `//! sweep I(p,n) = 0.02` — tb.zig unknownName strips only `V(`, `I(`
// and `x[`, so `I(p,n)` resolves to the NODE unknown `p,n` today. That is a
// runner change, out of scope for a fixtures pass.)
//
// The first CHECK is harness plumbing, not a conformance claim: its got is the
// swept value routed back through codegen, so it proves the sweep bound the
// branch-flow unknown and nothing about §1.3.1. It is kept because if it goes
// ok=0 the second CHECK's failure is unreadable. The §3.4 default is the claim:
// the second line reads `resistance`, which carries no `//! param` override, so
// it goes ok=0 on a compiler that ignored the declared default of 10 — that is
// why it is not merely the right-hand side of line 34 retyped. (What it does NOT
// assert is the CONTRIBUTED value: for a conservative potential source, reading
// V(p,n) back gives the node difference, which at this deliberately off-solution
// operating point is 0.0, not 0.2 — see ch05_analog_behavior/source_probe_both.va,
// which pins exactly that. Observing the retained value needs a residual-
// inspection directive the runner does not have.)
//
// Both wants are exact in binary64 — 0.02 is the swept literal itself and
// 10.0*0.02 is bit-equal to 0.2 — so CHECKX, not a 1e-15 absolute band.
//
//! lrm 1.3.1
//! lrm 3.4
//! lrm 5.4.2
//! sweep flowZ28pZ2cnZ29 = 0.02
`include "check.vh"
module ch01_potential_and_flow(p, n);
    inout p, n;
    electrical p, n;
    parameter real resistance = 10.0;

    analog begin
        `CHECKX("flow probe reads the branch flow", I(p, n), 2.0e-2);
        `CHECKX("the §3.4 declared default resistance times that flow", resistance * I(p, n), 0.2);
        V(p, n) <+ resistance * I(p, n);
    end
endmodule
