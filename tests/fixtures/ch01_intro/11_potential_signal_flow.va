// §1.3.4.1 the LRM's own worked example, `shiftPlus5`, transcribed from the
// clause: a level-shifting voltage follower on a potential-only signal-flow
// discipline. `voltage` is Annex D's signal-flow discipline — compatible with
// `electrical` but binding a potential nature only — which is why the ports are
// `input`/`output` and never `inout` (15_sf_potential_on_inout.va pins that).
//
// The LRM PRINTS this module as legal, so the fixture must compile and run: a
// conforming compiler accepts it. Biased at V(in) = 1.25, the shifted output
// expression is 5.0 + 1.25 = 6.25, exact in binary64 — both operands dyadic.
//
// V(out) is deliberately NOT asserted: `out` carries the potential-source
// branch, whose unknown the harness pins, not the contributed value.
//
//! lrm 1.3.4.1
//! bias V(in) = 1.25
//! xfail codegen refuses a contribution to a single-nature directional port (codegen.zig signalFlowNet); `vera --lint` is silent, `vera --emit-zig` reports "codegen refused a construct"
`include "check.vh"
module ch01_potential_signal_flow(in, out);
    input in;
    output out;
    voltage in, out;

    analog begin
        `CHECKX("level-shifted output", 5.0 + V(in), 6.25);
        V(out) <+ 5.0 + V(in);
    end
endmodule
