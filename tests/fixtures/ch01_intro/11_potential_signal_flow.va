// §1.3.4.1 the LRM's own worked example, `shiftPlus5`, transcribed from the
// clause: a level-shifting voltage follower on a potential-only signal-flow
// discipline. `voltage` is Annex D's signal-flow discipline — compatible with
// `electrical` but binding a potential nature only — which is why the ports are
// `input`/`output` and never `inout` (15_sf_potential_on_inout.va pins that).
//
// The LRM PRINTS this module as legal, so the fixture must compile and run: a
// conforming compiler accepts it. Biased at V(in) = 1.25, the shifted output
// expression is 5.0 + 1.25 = 6.25, exact in binary64 — both operands dyadic.
//
// V(out) IS the assertion. The previous version asserted `5.0 + V(in)` — the
// right-hand side of the contribution retyped one line above it — which claims
// only that V(in) is 1.25 and that a double can be added, and says nothing about
// `shiftPlus5`. §5.4.2.2 makes the potential of a source branch readable
// anywhere in the module, and on a potential-only signal-flow net there is no
// conservation law competing for the value: the source is what defines V(out),
// so a conforming compiler reads 6.25.
//
// `//! bias` pins `in`, which is what an `input` port means — the netlist
// supplies it — and `//! solve` leaves `out` to the device, which is what an
// `output` port means. §1.3.4.1's whole point is that the direction says who
// determines the value, so the two directives are the clause restated for the
// harness.
//
//! lrm 1.3.4.1
//! lrm 5.4.2.2
//! lrm 1.3.4.1:1
//! lrm 1.3.4.1:2
//! bias V(in) = 1.25
//! solve
`include "check.vh"
module ch01_potential_signal_flow(in, out);
    input in;
    output out;
    voltage in, out;

    analog begin
        V(out) <+ 5.0 + V(in);
        `CHECKX("the signal-flow output is the input shifted by 5", V(out), 6.25);
    end
endmodule
