// §1.3.4.1, second sentence of the port restriction: "In that case, potential
// contributions may not be made to `input` ports."
//
// Distinct from 15_sf_potential_on_inout.va: here the DECLARATION is legal —
// `voltage` on an `input` port is exactly what shiftPlus5 writes — and it is the
// CONTRIBUTION `V(inp) <+ ...` that the clause forbids. The contribution to
// `outp` is legal and is there to show the rule is about direction, not about
// the discipline.
//
// The expectation is the phase label. It WAS `//! reject E0423`, a code that
// does not exist — src/diag_code.zig allocates class 4 up to E0422 (line 181) —
// so no diagnostic VerA can emit would ever match it and the XPASS could never
// fire. It must equally NOT be pinned as `GeneratedCompileError`: codegen refuses
// every single-nature directional contribution for its own generic reason
// (11_potential_signal_flow.va is the xfail for that), so the fixture would pass
// for the wrong reason today and go on passing after codegen learns to lower
// signal-flow nets. `DiagnosticsReported` requires a FRONT-END diagnostic, which
// is what this rule needs, and is satisfied by whichever code it gets.
//
//! lrm 1.3.4.1
//! reject DiagnosticsReported
module ch01_sf_potential_contribution_to_input(inp, outp);
    input inp;
    output outp;
    voltage inp, outp;

    analog begin
        V(inp) <+ 1.0;
        V(outp) <+ 2.0;
    end
endmodule
