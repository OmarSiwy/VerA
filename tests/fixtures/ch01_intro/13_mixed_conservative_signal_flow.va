// §1.3.5 "Conservative components and signal-flow components can be freely
// mixed." One module holds both halves of the clause's own worked examples: the
// conservative `resistor` ports (`inout a, b; electrical a, b;`) and the
// signal-flow `voltage_amplifier` output (`output out; voltage out;`), whose
// declaration "only require[s] types for those values which are actually used".
//
// The LRM states this as a guarantee, so the fixture must compile and run: a
// conforming compiler accepts it. Biased at V(a) = 2.0 with `b` at the default
// zero, the conservative probe reads 2.0; the LRM's own GAIN_V = 10.0 makes the
// signal-flow drive 10.0 * 2.0 = 20.0, exact in binary64; and the resistor's
// constitutive flow is 2.0 / 1000.0, which is the correctly-rounded double of
// 2.0e-3 and therefore compares bit-equal to that literal.
//
// V(out) is deliberately NOT asserted: `out` carries the potential-source
// branch, whose unknown the harness pins, not the contributed value.
//
//! lrm 1.3.5
//! bias V(a) = 2.0
//! xfail codegen refuses a contribution to a single-nature directional port (codegen.zig signalFlowNet), so the mixed module the clause guarantees does not lower
`include "check.vh"
module ch01_mixed_conservative_signal_flow(a, b, out);
    inout a, b;
    electrical a, b;
    output out;
    voltage out;
    parameter real GAIN_V = 10.0;
    parameter real R = 1000.0 from (0:inf);

    analog begin
        `CHECK("conservative probe across the resistor branch", V(a, b), 2.0, 1e-15);
        `CHECKX("signal-flow gain applied to the conservative probe", GAIN_V * V(a, b), 20.0);
        `CHECK("conservative flow alongside the signal-flow drive", V(a, b) / R, 2.0e-3, 1e-15);
        V(out) <+ GAIN_V * V(a, b);
        I(a, b) <+ V(a, b) / R;
    end
endmodule
