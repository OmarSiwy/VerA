// §1.3.5 "Conservative components and signal-flow components can be freely
// mixed." One module holds both halves of the clause's own worked examples: the
// conservative `resistor` ports (`inout a, b; electrical a, b;`) and the
// signal-flow `voltage_amplifier` output (`output out; voltage out;`), whose
// declaration "only require[s] types for those values which are actually used".
//
// The LRM states this as a guarantee, so the fixture must compile and run: a
// conforming compiler accepts it. Biased at V(a) = 2.0 with `b` at the default
// zero, the conservative probe reads 2.0; the LRM's own GAIN_V = 10.0 makes the
// signal-flow drive 10.0 * 2.0 = 20.0, exact in binary64; and the resistor's
// constitutive flow is 2.0 / 1000.0, which is the correctly-rounded double of
// 2.0e-3 and therefore compares bit-equal to that literal.
//
// Both halves are read back off the net they were contributed to, not retyped
// as expressions. The previous version asserted `GAIN_V * V(a, b)` and
// `V(a, b) / R`, which are exactly the two right-hand sides one and two lines
// below them: neither observed a `<+`, so the day codegen learns signalFlowNet
// the file would XPASS having proved only that V(a,b) is 2.0. Reading V(out) is
// strictly stronger — it still fails if GAIN_V's §3.4 default is wrong — and it
// routes through the mixing the clause guarantees. §5.4.2.2 makes both
// quantities of a source branch readable; the flow source on (a, b) retains
// 2.0e-3, and V(out) on a potential-only signal-flow net is defined by its
// source alone.
//
//! lrm 1.3.5
//! lrm 5.4.2.2
//! bias V(a) = 2.0
//! xfail the flow-source half is CLOSED — I(a,b) now reads the retained 2.0e-3 (§5.4.2.2) — but two gaps remain: codegen refuses a contribution to a single-nature directional port (codegen.zig signalFlowNet), so the mixed module the clause guarantees does not lower at all, and V(out) is lowered as a node POTENTIAL probe (§5.4.1), which without a Newton loop in tb.zig reads its bias default 0 rather than the 20.0 its source imposes
`include "check.vh"
module ch01_mixed_conservative_signal_flow(a, b, out);
    inout a, b;
    electrical a, b;
    output out;
    voltage out;
    parameter real GAIN_V = 10.0;
    parameter real R = 1000.0 from (0:inf);

    analog begin
        `CHECKX("conservative probe across the resistor branch", V(a, b), 2.0);
        V(out) <+ GAIN_V * V(a, b);
        I(a, b) <+ V(a, b) / R;
        `CHECKX("the signal-flow output is the gain times the conservative probe", V(out), 20.0);
        `CHECKX("the conservative flow alongside it", I(a, b), 2.0e-3);
    end
endmodule
