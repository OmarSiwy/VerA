// §1.3.1 "a branch is a path of flow between two nodes ... every branch has an
// associated potential (the potential difference between the two nodes)", and
// §1.3.1.2 fixes WHICH difference: "the branch potential is positive whenever
// the potential of the port marked with a plus sign (A) is larger than the
// potential of the port marked with a minus sign (B)". `branch (a, b)` puts the
// plus on `a`, so naming the pair the other way round negates the value.
//
// That second assertion is what this file was missing. Nothing in ch01 asserted
// the §1.3.1.2 polarity, though tests/fixtures/ch01_intro/COVERAGE.md at 8b1514d4 credited this file with it, so a
// compiler that silently swapped + and - passed the whole chapter. The old
// `V(path_ab)/50.0` line it replaces was arithmetic on the value read one line
// above it and could not fail independently of it.
//
// At V(a)=1.0, V(b)=0.5 both differences are exact in binary64: 1.0-0.5 == 0.5
// and 0.5-1.0 == -0.5, so CHECKX.
//
// The third line WAS a `CHECKEQ(V(path_ab), V(a, b))`. It is not a CHECKEQ case:
// line 1 already pins V(path_ab) at 0.5, so the digits for the node-pair form
// exist and README says write them. `CHECKX(V(a, b), 0.5)` is the strictly
// stronger claim — an error common to both sides passes the relational form —
// and it removes the chapter's only CHECKEQ.
//
//! lrm 1.3.1
//! lrm 1.3.1.2
//! lrm 1.3.1.2:1000
//! bias V(a) = 1.0, V(b) = 0.5
`include "check.vh"
module ch01_named_branch(a, b);
    inout a, b;
    electrical a, b;
    branch (a, b) path_ab;

    analog begin
        `CHECKX("named branch potential", V(path_ab), 0.5);
        `CHECKX("reversing the orientation negates the potential", V(b, a), -0.5);
        `CHECKX("the node-pair form of the same branch", V(a, b), 0.5);
        I(path_ab) <+ V(path_ab) / 50.0;
    end
endmodule
