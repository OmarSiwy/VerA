// §1.2 Verilog-AMS mixes analog and digital modeling in one language.
// A single module can declare both analog and digital signals, and contain
// both initial/always digital blocks and analog blocks in the same module.
// This file asserts the basic coexistence: electrical (analog) and
// integer (digital) signals in one scope.
//
//! lrm 1.2
//! lrm 1.2:1000
//! bias V(p) = 1.0, V(n) = 0.0
`include "check.vh"
module ch01_mixed_signal_language(p, n);
    inout p, n;
    electrical p, n;
    integer counter;

    initial begin
        counter = 42;
    end

    analog begin
        `CHECKI("digital signal written in initial block is readable in analog block", counter, 42);
        `CHECKX("analog potential accessible in analog block", V(p, n), 1.0);
        I(p, n) <+ V(p, n) / 1000.0;
    end
endmodule
