// §5.10.3.3: "If the period expression evaluates to a value less than or equal
// to 0.0, the timer shall trigger only once at the specified start_time (if the
// start_time is in the future with respect to the current simulation time)."
//
// Two claims in one sentence — it fires at start_time, and it fires ONLY ONCE —
// and neither is observable from a run that stops before start_time, which is
// what this file used to do: every declared timepoint was strictly before 1n,
// so it asserted the §3.2 default and proved nothing about timer() at all.
//
// The run now straddles t = 1n, and the body counts instead of assigning, so a
// repeating timer is distinguishable from a one-shot rather than overwriting
// the same 1.0. timer(1n, 0.0) has exactly one event. time_tol is omitted, so
// §5.10.3.3's default sentence applies: "If time_tol is not specified, the
// default time point is at, or just beyond, the time of the event." The event
// time is therefore asserted in [start_time, next declared point] =
// [1n, 1.5n], not pinned to 1n: a tool that places it just beyond 1n conforms.
//
//   t = 0, 0.5n    before start_time      n = 0
//   t = 1n         at, or just beyond     n = 0 or 1
//   t = 1.5n, 2n   the single firing done n = 1
//
// The runner asserts at every timepoint. A timer that never fires leaves n = 0
// at the last two points; one that fires before start_time is caught by the
// n = 0 checks; and one that ignored `period <= 0` and repeated on a default
// period reads 2 or more by t = 2n. All three fail.
//
//! lrm 5.10.3.3
//! lrm 5.10.3.3:4
//! analysis tran
//! time 0, 0.5n, 1n, 1.5n, 2n
//! lrm 5.10.3.3:1003
`include "check.vh"
module ch5_timer_once(p);
  inout p; electrical p; integer n; real at;
  analog begin
    @(timer(1n, 0.0)) begin
      n = n + 1;
      at = $abstime;
    end
    if ($abstime < 1n)
      `CHECKI("no event before start_time", n, 0);
    `CHECKI("the one-shot never fires more than once", n <= 1, 1);
    if ($abstime >= 1.5n) begin
      `CHECKI("the default tolerance delivered the single event", n, 1);
      `CHECKI("the default time point is at, or just beyond, start_time",
              (at >= 1n) && (at <= 1.5n), 1);
    end
    I(p) <+ 1m*n;
  end
endmodule
