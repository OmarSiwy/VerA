// §5.10.3.3: "If the period expression evaluates to a value less than or equal
// to 0.0, the timer shall trigger only once at the specified start_time (if the
// start_time is in the future with respect to the current simulation time)."
//
// Two claims in one sentence — it fires AT start_time, and it fires ONLY ONCE —
// and neither is observable from a run that stops before start_time, which is
// what this file used to do: every declared timepoint was strictly before 1n,
// so it asserted the §3.2 default and proved nothing about timer() at all.
//
// The run now straddles t = 1n, and the body counts instead of assigning, so a
// repeating timer is distinguishable from a one-shot rather than overwriting
// the same 1.0. timer(1n, 0.0) has exactly one event, at t = 1n:
//
//   t = 0, 0.5n    before start_time      n = 0
//   t = 1n         the single firing      n = 1
//   t = 1.5n, 2n   period <= 0, so no further firing   n = 1
//
// The runner asserts at every timepoint and n is not constant across them, so
// the oracle is $abstime >= 1n — the same partition of the run stated from the
// clock instead of from the timer. A timer that never fires reads 0 at the last
// three points; one that fired at t = 0 reads 1 at the first; and a timer that
// ignored `period <= 0` and repeated on a default period reads 2 or more by
// t = 2n. All three fail.
//
//! lrm 5.10.3.3
//! lrm 5.10.3.3:4
//! analysis tran
//! time 0, 0.5n, 1n, 1.5n, 2n
//! lrm 5.10.3.3:1003
`include "check.vh"
module ch5_timer_once(p);
  inout p; electrical p; integer n;
  analog begin
    @(timer(1n, 0.0)) n = n + 1;
    `CHECKEQ("timer(1n,0) fires at 1n and never again", n, ($abstime >= 1n) ? 1 : 0, 0.0);
    I(p) <+ 1m*n;
  end
endmodule
