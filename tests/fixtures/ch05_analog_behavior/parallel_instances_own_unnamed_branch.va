// §5.6.8.1: "a new unnamed branch is created in the module containing the
// direct contribution statements", and §5.6.8.2 reaches "the unnamed branch
// between nets x and y in top.drv" by `top.drv.branch(x,y)`: an unnamed
// branch belongs to a module INSTANCE. Two instances wired across the same two
// nets therefore hold two branches in parallel, and each one's flow is its
// own (§6.7.1 hierarchical access, §5.5.5).
//
// ROADMAP §5.3 (AMS 5.6.8.2, 6.7.1): flattening merged both instances' (p,n)
// branches onto the one node pair, so every read returned the parallel sum.
//
// THE CIRCUIT. r1 (1 kohm) and r2 (2 kohm), each `I(p,n) <+ V(p,n)/r`, across
// (a, gnd), with a biased to 1.0 V:
//   I(r1.branch(p,n)) = 1.0/1000 = 1.0e-3 A
//   I(r2.branch(p,n)) = 1.0/2000 = 0.5e-3 A
//   each instance's own I(p,n), read inside it, is the same pair of numbers.
// The merged reading is 1.5e-3 for all four. The hierarchical NET spelling
// `I(r1.p, r1.n)` is not this: §5.6.8.1 makes it a branch of the WRITER
// between those nets, and VerA reads it as the pair's whole flow
// (annex_e_spice/primitive_segment_discipline.va).
//
// No invalid form: §5.6.8.2's refusals (a wrong access function, a switch
// branch) are about contributions, not reads.
//
//! lrm 5.6.8.2
//! lrm 5.6.8.1
//! lrm 6.7.1
//! bias V(a) = 1.0, V(gnd) = 0.0
//! checks 4
`include "check.vh"
module pib_res1k(p, n);
  inout p, n; electrical p, n;
  analog begin
    I(p, n) <+ V(p, n) / 1k;
    `CHECK("inside r1, I(p,n) is r1's own branch", I(p, n), 1.0e-3, 1e-15);
  end
endmodule
module pib_res2k(p, n);
  inout p, n; electrical p, n;
  analog begin
    I(p, n) <+ V(p, n) / 2k;
    `CHECK("inside r2, I(p,n) is r2's own branch", I(p, n), 0.5e-3, 1e-15);
  end
endmodule
module pib_top(a, gnd);
  inout a, gnd; electrical a, gnd;
  pib_res1k r1(a, gnd);
  pib_res2k r2(a, gnd);
  analog begin
    `CHECK("I(r1.branch(p,n)) is r1's flow alone", I(r1.branch(p, n)), 1.0e-3, 1e-15);
    `CHECK("I(r2.branch(p,n)) is r2's flow alone", I(r2.branch(p, n)), 0.5e-3, 1e-15);
  end
endmodule
