// §5.6.1.3 value retention, Example 1 verbatim — the ideal switch:
//
//     if (closed) V(p,n) <+ 0;      is equivalent to      if (closed)
//                                                            V(p,n) <+ 0;
//                                                         else
//                                                            I(p,n) <+ 0;
//
// because "if a branch is not contributed to ... for any particular iteration,
// and it is not a branch probe, it shall be treated as a flow source with a
// value of 0". So the else arm the source never writes is not "nothing": it is
// an open circuit, and the two arms differ in WHICH quantity is pinned to zero.
//
// A §4.2.5 relational is an integer 1 or 0, so the guard can be multiplied
// rather than branched on, which keeps the checks unconditional. At the declared
// bias V(c) = 0.75 the guard is 1: the closed switch constrains V(p,n) to 0, so
// its residual is the node difference 0.75 - 0.25 = 0.5 exactly. The
// complementary guard is 0 there, and its product is the zero the open arm
// contributes to the flow.
//
//! bias V(c) = 0.75
//! bias V(p) = 0.75
//! bias V(n) = 0.25
`include "check.vh"
module ch5_implicit_zero(p, n, c);
  inout p, n, c; electrical p, n, c;
  analog begin
    `CHECKI("V(c) = 0.75 clears the 0.5 threshold, so the switch is closed", V(c) > 0.5, 1);
    `CHECKX("closed, the branch is a potential source of 0 and its residual is V(p,n)",
            (V(c) > 0.5) * V(p, n), 0.5);
    `CHECKX("open, Example 1's implied else arm is a flow source of 0",
            (V(c) < 0.5) * V(p, n), 0.0);
    if (V(c) > 0.5) V(p, n) <+ 0.0;
  end
endmodule
