// §5.6.5's switch branch, SOLVED in both states — the companion to
// switch_branch.va, which pins which arm executes but forces every unknown.
// Here the solver has to honour §5.6.1.3's per-cycle rule: "If a value is
// retained for the potential of a branch, the branch is a potential source ...
// otherwise, if a value is retained for the flow, it is a flow source". One
// matrix structure, two row contents, selected by the cycle's execution path.
//
// The network, and the two solutions, derived by hand:
//
//   I(p) <+ (V(p) - 2.0)/1000     a 2 V Thevenin source behind 1 kΩ into p
//   I(n) <+ V(n)/1000             a 1 kΩ resistor from n to the reference
//   closed (V(c) = 1): V(p,n) <+ 0 retains a potential, so V(p) = V(n) = V and
//     the switch conducts. KCL: (V-2)/1000 + V/1000 = 0 → V = 1.0 exactly,
//     with 1 mA through the branch.
//   open (V(c) = 0): I(p,n) <+ 0 retains a zero flow — §5.4.4's open circuit —
//     so no current crosses: V(p) = 2.0 (nothing loads the source) and
//     V(n) = 0.0 (nothing drives the resistor).
//
// Each check folds the two states onto ONE literal with a §4.2.5 relational
// (an integer 1 or 0), so the same line asserts both operating points:
//
//   V(p) + (V(c)>0.5)*1.0    closed: 1 + 1 = 2;   open: 2 + 0 = 2
//   V(n) + (V(c)<0.5)*1.0    closed: 1 + 0 = 1;   open: 0 + 1 = 1
//
// A compiler that emits the potential row unconditionally — the pre-fix
// behaviour — shorts p to n in BOTH states: at the open point it reads
// V(p) = V(n) = 1 and both checks miss by a volt. One that drops the closed
// arm's ±I_b coupling starves n and misses the closed point instead.
//
//! lrm 5.6.5
//! lrm 5.6.1.3
//! lrm 5.6.5:1
//! lrm 5.6.5:2
//! solve
//! sweep V(c) = 1.0, 0.0
`include "check.vh"
module ch5_switch_solved(p, n, c);
  inout p, n, c; electrical p, n, c;
  analog begin
    I(p) <+ (V(p) - 2.0)/1000.0;
    I(n) <+ V(n)/1000.0;
    if (V(c) > 0.5) V(p, n) <+ 0.0;
    else I(p, n) <+ 0.0;
    `CHECK("closed pins V(p) to V(n) at the 1.0 V divider point; open frees the source", V(p) + (V(c) > 0.5)*1.0, 2.0, 1e-9);
    `CHECK("closed drives n through the branch; open leaves it at the reference", V(n) + (V(c) < 0.5)*1.0, 1.0, 1e-9);
  end
endmodule
