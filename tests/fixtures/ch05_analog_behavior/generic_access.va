// §5.5.1 Syntax 5-3: `nature_access_function ::= nature_attribute_identifier |
// potential | flow`. The generic names are an alternative spelling of the
// discipline's own access functions, not a different operation — §5.5.1's
// measure1 example writes `potential(p) / V` verbatim, and does so precisely
// because a parameter named `V` has shadowed the electrical access function.
//
// Same shape as source_probe_both.va, which pins the identical rule for V/I on
// a named branch: with V(p) = 1.0, V(n) = 0.25 the branch potential is the node
// difference 0.75, and the branch flow is held at 0.125 A by the sweep. Both
// are dyadic rationals, hence exact. The two contributions make the branch a
// source as well as a probe, so the generic names are exercised on both sides
// of `<+`.
//
//! lrm 5.5.1
//! bias V(p) = 1.0, V(n) = 0.25
//! sweep flowZ28pZ2cnZ29 = 0.125
//! xfail VerA has no generic potential()/flow() access functions; `potential(b)` dies at E0209 (expected an expression)
`include "check.vh"
module ch5_generic_access(p, n);
  inout p, n; electrical p, n; branch (p, n) b;
  analog begin
    `CHECKX("potential(b) is the branch potential, i.e. V(b)", potential(b), 0.75);
    `CHECKX("flow(b) is the branch flow, i.e. I(b)", flow(b), 0.125);
    `CHECKX("the source relation written with generic access", 10.0 * flow(b), 1.25);
    potential(b) <+ 10.0 * flow(b);
    flow(p) <+ potential(b) + flow(b);
  end
endmodule
