// §4.5.7 absolute transport delay, on the SHORT side: a td smaller than the
// timestep the simulator takes. The clause's time-domain formula does not
// care how the delay compares to the step,
//
//   Output(t) = Input(max(t - td, 0))
//
// but an implementation that answers only from accepted history has nothing
// newer than the previous timepoint, and falling back to that newest sample
// silently stretches every delay shorter than a step to the step itself —
// the bug this pins. The sound answer interpolates between the newest
// accepted sample and the current in-flight input, which on this ramp is the
// formula's own value.
//
// The driven waveform is a 1 V/ns ramp sampled every nanosecond with
// td = 0.5 ns, so the closed form reads max(t/1ns - 0.5, 0) and, as in the
// long-delay fixture (ch04_expressions/19_absdelay.va), it is written in
// $abstime so an error common to the operator and the oracle cannot cancel;
// output minus closed form is one literal want, 0.0, at every point:
//
//   t/ns    0     1     2     3
//   in      0     1     2     3
//   out     0     0.5   1.5   2.5
//
// The derivative line is the same closed form differentiated: with td half a
// step, half of the delayed value is the CURRENT input, so d out/d in = 0.5
// on every transient point — and 1.0 at t = 0, where "In DC analysis ...
// absdelay() returns the value of its input" makes it the identity. A
// history-only fallback answers 0.0 there and misreports the Jacobian.
//
//! lrm 4.5.7
//! bias V(n) = 0
//! wave V(p) = 0, 1, 2, 3
//! time 0, 1n, 2n, 3n
//! analysis tran
//! print none
`include "check.vh"
module ch5_absdelay_short(p, n);
    inout p, n;
    electrical p, n;

    analog begin
        `CHECK("output(t) == input(max(t - 0.5ns, 0)) for td < step",
               absdelay(V(p, n), 0.5n) - max($abstime * 1e9 - 0.5, 0.0), 0.0, 1e-12);
        `CHECK("d out/d in is the in-flight fraction (1 at dc, td/step after)",
               ddx(absdelay(V(p, n), 0.5n), V(p)) - ($abstime > 0.0 ? 0.5 : 1.0), 0.0, 1e-12);
        I(p, n) <+ absdelay(V(p, n), 0.5n) * 1.0e-3;
    end
endmodule
