// §5.4.1: "There can be any number of named branches between any two signals."
// §5.4.3 Example 1 is the clause's own use of that permission — the LRM prints
// this junction diode:
//
//     branch (a, c) i_diode, junc_cap;
//     analog begin
//        I(i_diode) <+ is*(limexp(V(i_diode)/$vt) - 1);
//        I(junc_cap) <+ ddt(tf*I(i_diode) - 2*cjo*sqrt(phi*(phi*V(junc_cap))));
//
// One declaration, two names, one terminal pair, and the two are NOT one source:
// the first is the conduction current, the second the junction charge, and a
// compiler that retained them on a shared accumulator would put the charge into
// the conduction source and answer the `I(i_diode)` inside the second statement
// with the sum of both.
//
// This file is that rule with digits instead of device physics, and it is
// deliberately the SAME shape as the LRM's line: one `branch` declaration with
// two identifiers over (a, c).
//
// WHAT DISCRIMINATES. Both reads are placed AFTER both contributions, so what
// they show is what each branch RETAINED (§5.6.1.2), not the order the
// statements ran in: 1.0 on `cond` and 0.25 on `cap`. A compiler that collapsed
// the two names onto one accumulator reads 1.25 for BOTH — the sum — and fails
// both lines. Reading the same figure twice is the failure the collapse
// produces, so a single want could not catch it; two different wants can.
//
// AND THE NODE STILL SEES THE TOTAL. §5.4.3's `I(<a>)` is "the flow into a port
// of a module", which by KCL is everything this module stamps at `a` — the sum
// over both branches, 1.0 + 0.25 = 1.25. That is the other half of the rule and
// the half a naive fix breaks: giving each branch its own retained value must
// not stop either from reaching the node. It needs `//! solve`, because the port
// flow is an unknown the DEVICE's own equations determine (§5.6) rather than one
// the harness can impose; `//! bias` still pins the two terminals it names.
//
// 1.0, 0.25 and 1.25 are dyadic rationals, exact in IEEE 754 to the last bit, so
// all three are checked exactly.
//
//! lrm 5.4.1
//! lrm 5.4.3
//! lrm 5.6.1.2
//! lrm 5.6.1.2:1000
//! bias V(a) = 0.5, V(c) = 0.25
//! solve
`include "check.vh"
module ch5_two_branches_retain(a, c);
  inout a, c;
  electrical a, c;
  branch (a, c) cond, cap;
  analog begin
    I(cond) <+ 1.0;
    I(cap) <+ 0.25;
    `CHECKX("the first named branch retains its own contribution", I(cond), 1.0);
    `CHECKX("the second retains its own, over the same terminal pair", I(cap), 0.25);
    `CHECKX("and the port carries the sum of both branches", I(<a>), 1.25);
  end
endmodule
