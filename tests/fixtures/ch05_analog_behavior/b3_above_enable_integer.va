// §5.10.3.2 above(): "The enable argument, if specified, shall evaluate to an
// integer" and "If enable is specified and nonzero, then above() functions as
// just described."
//
// ../ch08_scheduling/above_initial_event.va with every optional argument
// written, the enable as the integer 1. "If the expression is positive at the
// conclusion of the initial condition analysis that precedes a transient
// analysis, the above() function shall generate an event": V(c) - 0.5 = 0.9 -
// 0.5 = +0.4, so the event fires at the initial condition and samples V(p) =
// 0.75. V(c) is held, so the expression never crosses zero from below again,
// and at t = 1n, where V(p) has stepped to 0.25, `sample` still holds 0.75.
// A tool that read the enable as 0 leaves §3.2's 0.0 on both rows. This is
// the legal neighbour of b3_above_noninteger_enable_rejected.va (enable 0.5).
//
//! lrm 5.10.3.2
//! lrm 5.10.3.2:3
//! analysis tran
//! time 0, 1n
//! bias V(c) = 0.9
//! wave V(p) = 0.75, 0.25
//! checks 2
`include "check.vh"
module b3_above_enable_integer(p, c);
  inout p, c; electrical p, c; real sample;
  analog begin
    @(above(V(c) - 0.5, 1p, 1u, 1)) sample = V(p);
    `CHECKX("above(+0.4) with enable 1 fires at the initial condition and holds", sample, 0.75);
    I(p) <+ sample;
  end
endmodule
