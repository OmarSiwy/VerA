// §5.3.2, the second half of the sentence 04 pins: "an UNIQUE LOCATION exists
// for all variables", and "The block names give a means of uniquely identifying
// all variables at any simulation time."
//
// Uniquely identifying: retention is keyed on the VARIABLE, i.e. on the pair
// (scope, name), not on the spelling. Three declarations here are all spelled
// `n` — one in block `lo`, one in block `hi`, one at module level — and the
// three are three locations. §5.3.2's own worked example relies on the same
// rule from the other side (`moduleVar = myscope.localVar`, pinned by fixture
// 06): the local and the module variable coexist.
//
// This is the case VerA's implementation is structurally unable to get right.
// `markHeldVars` (src/analog/lower.zig) collects event-assigned targets into a
// `StringHashMap` of BARE NAMES, and `declareVarDecl` then grants a persistent
// slot to any MODULE-scope declaration whose name is in that set. So the name
// `n` is what is tracked, the scope is not, and the two block-locals that
// actually need slots are the two declarations that cannot get one.
//
// THE EVENT SOURCES. One-shot timers again (§5.10.3.3, "the timer shall
// trigger only once at the specified start_time"), at four distinct times so
// the two locals are driven on interleaved schedules. Exact by construction.
//
// THE DERIVATION, per timepoint, each local starting at the §3.2 default 0:
//
//                        events that fire        lo.n     hi.n     module n
//     t = 0              none                      0        0         7
//     t = 1n             timer(1n): lo.n += 1      1        0         7
//     t = 2n             timer(2n): hi.n += 10     1       10         7
//     t = 3n             timer(3n): lo.n += 1      2       10         7
//     t = 4n             timer(4n): hi.n += 10     2       20         7
//
// Every cell is load-bearing:
//
//   * lo.n = 1 at t = 2n and hi.n = 10 at t = 3n are the retention;
//   * lo.n = 2 at t = 3n needs the t = 1n value read back, so one shared slot
//     for "n" would read 10 there and produce 11;
//   * hi.n = 10 at t = 2n would be 11 under one shared slot;
//   * module n = 7 at all five points is the anti-leak assertion — the module
//     variable is assigned once, outside any `@`, and no event names it, so a
//     held slot handed to it by NAME must not change what it reads.
//
// a and b are unconditional copies taken inside each block so the spine can see
// them; neither is itself event-assigned.
//
// OBSERVED TODAY: a reads 0, 1, 0, 1, 0 and b reads 0, 0, 10, 0, 10 — both
// locals reset at every evaluation. Module n reads 7 throughout, so the
// name-keyed slot does not corrupt it; that assertion passes today and is kept
// as the guard that a scope-keyed fix does not introduce the leak instead.
//
//! lrm 5.3.2
//! lrm 5.10
//! lrm 5.10.3.3
//! lrm 5.3.2:1000
//! analysis tran
//! time 0, 1n, 2n, 3n, 4n
`include "check.vh"
module a03_shadowed_locals(p);
  inout p; electrical p;
  integer n, a, b;
  analog begin
    n = 7;
    begin : lo
      integer n;
      @(timer(1n, 0.0)) n = n + 1;
      @(timer(3n, 0.0)) n = n + 1;
      a = n;
    end
    begin : hi
      integer n;
      @(timer(2n, 0.0)) n = n + 10;
      @(timer(4n, 0.0)) n = n + 10;
      b = n;
    end
    `CHECKEQ("lo.n is its own location and keeps its own value between events",
             a, ($abstime < 1n) ? 0 : (($abstime < 3n) ? 1 : 2), 0.0);
    `CHECKEQ("hi.n likewise, on a different schedule, despite the same spelling",
             b, ($abstime < 2n) ? 0 : (($abstime < 4n) ? 10 : 20), 0.0);
    `CHECKEQ("and the module-level n is a third location no event names",
             n, 7, 0.0);
    I(p) <+ 0.0;
  end
endmodule
