// §5.10.2 Table 5-1, the rows nothing else in the chapter reads. initial_step.va,
// final_step.va and initial_final_analysis_lists.va all sit on a single dc
// operating point, which is one column of the table; a sweep is a different
// column, and it is the only one where "first point" and "last point" are
// distinct places.
//
// Four rows, read off the Sweep column (d1, d2 ... dN):
//
//   initial_step          1  0  0    fires at the FIRST sweep point only
//   initial_step(unknown) 0  0  0    an analysis name the tool does not know
//                                    never matches — "Additional analysis names
//                                    can also be used as necessary for specific
//                                    implementations", and one that is not is
//                                    simply false, not an error
//   final_step            0  0  1    fires at the LAST sweep point only
//   final_step("ac")      0  0  0    a dc sweep is not an ac analysis
//
// The bodies count rather than assign, so "fired once" is distinguishable from
// "fires at every point" — which is the failure mode a boolean flag hides, and
// the reason the two zero rows are worth asserting at all: they are only
// meaningful next to a row in the same file that must be nonzero.
//
// Three of the four counters are constant across the sweep and are checked
// against literals. final_step is 0, 0, 1, so no literal is right at all three
// points and the oracle is the sweep variable's own last value.
//
//! lrm 5.10.2
//! lrm 5.10.2:1000
//! analysis dc
//! sweep V(s) = 0.0, 1.0, 2.0
`include "check.vh"
module ch5_initial_step_unknown_analysis(p, s);
  inout p, s; electrical p, s;
  integer n_init, n_unknown, n_final, n_final_ac;
  analog begin
    @(initial_step)                 n_init     = n_init + 1;
    @(initial_step("chunky_bacon")) n_unknown  = n_unknown + 1;
    @(final_step)                   n_final    = n_final + 1;
    @(final_step("ac"))             n_final_ac = n_final_ac + 1;

    `CHECKI("initial_step fires at the first sweep point and no other", n_init, 1);
    `CHECKI("an unrecognised analysis name never matches", n_unknown, 0);
    `CHECKI("final_step(\"ac\") does not fire in a dc sweep", n_final_ac, 0);
    `CHECKEQ("final_step fires at the last sweep point and no other", n_final, (V(s) > 1.5) ? 1 : 0, 0.0);
    I(p) <+ 1m*n_init;
  end
endmodule
