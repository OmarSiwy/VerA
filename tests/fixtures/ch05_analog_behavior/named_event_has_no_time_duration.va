// §5.10, the list of what an event IS:
//
//   "— events have no time duration
//    — events can be triggered and detected in different parts of the
//      behavioral model
//    — events do not block the execution of an analog block
//    — events can be detected using the @ operator
//    — events do not hold any data"
//
// and §5.10.4 named events, whose worked example is the shape of this fixture:
//
//     analog begin
//        @(timer(1n)) -> ana_event;
//        @(ana_event) $display("Event: ana_event detected in analog");
//        @(dig_event) $display("Event: dig_event detected in analog");
//     end
//
// TWO CLAIMS, one counter.
//
// (1) "triggered and detected in different parts of the behavioral model" — a
// `-> ev` under one event statement is seen by an `@(ev)` further down the same
// analog block, in the same evaluation. That is the LRM's own example ordering:
// the trigger precedes the detection lexically.
//
// (2) "events have no time duration" — the trigger of `ev` at t = 1n must not
// still be pending at t = 2n. Combined with §5.10's retention rule ("the
// execution of the procedural statement is skipped unless the analog event has
// occurred"), a counter driven by `@(ev)` therefore has to be FLAT between
// triggers. This is the "unchanged between events" claim of the row, stated
// about a named event rather than about a monitored one.
//
// THE EVENT SOURCE. Two one-shot timers (§5.10.3.3: "If the period expression
// evaluates to a value less than or equal to 0.0, the timer shall trigger only
// once at the specified start_time"), both triggering the SAME named event, so
// the event occurs at exactly two instants: 1n and 3n.
//
// THE DERIVATION. `n` starts at the §3.2 default 0:
//
//     t = 0     no trigger                          n = 0
//     t = 1n    timer(1n) -> ev,  @(ev) n = n + 1   n = 1
//     t = 2n    no trigger; ev has no duration      n = 1   <-- claim (2)
//     t = 3n    timer(3n) -> ev,  @(ev) n = n + 1   n = 2
//     t = 4n    no trigger                          n = 2   <-- claim (2)
//
//   asserted: n = 0, 1, 1, 2, 2
//
// An event flag that persisted once set reads 0, 1, 2, 3, 4. One that was never
// delivered across the two statements reads 0 throughout. One whose detection
// re-ran the body on every evaluation after the first reads the persisting
// sequence too. The two flat intervals and the two steps are what separate
// them, and `n = n + 1` also requires the retained n to be readable, so this is
// the same retention claim as fixture 04 seen through a named event.
//
// WITHDRAWN: the second half of this fixture used to assert `m == 0`, where `m`
// was incremented by a second `@(ev)` placed LEXICALLY BEFORE the trigger, on
// the argument that the analog block is evaluated top to bottom so the trigger
// for this evaluation has not run yet. That claim is gone, for two reasons:
//
//   * It is not in the clauses. §5.10.4's worked example puts the trigger
//     before the detection and says nothing whatever about the other order;
//     §5.10's bullet list ("events have no time duration", "events do not block
//     the execution of an analog block") does not fix when within an evaluation
//     a trigger becomes visible. A tool that evaluated the block to a fixed
//     point could justify m = n and still be conforming. The assertion pinned
//     VerA's sequential lowering, not the standard.
//   * It had no teeth in either direction. `m == 0` is what a tool with no
//     named events at all reads, what a tool whose `->` is a no-op reads, and
//     what §3.2's "Integer variables whose values are assigned in an analog
//     context default to an initial value of zero (0)" gives for a variable
//     never assigned on any executing path.
//
// WHERE IT WENT: nowhere, deliberately. The question — in what order, and over
// how many passes, an analog block observes an event triggered within its own
// evaluation — belongs to A10 (analog event scheduling, §5.10.3.x) and not to
// a held-state row. It can come back as an A10 fixture the day a clause fixes
// the order; §8.3 fixes the analog/digital simulation cycle but says nothing
// about intra-block trigger visibility, so today there is nothing to cite.
//
// OBSERVED TODAY: this fixture PASSES. Named events and their retention are
// implemented (`lowerEventTrigger` / `lowerEventControl`); nothing previously
// pinned the no-duration half, which is why it is written here rather than
// assumed.
//
//! lrm 5.10
//! lrm 5.10.3.3
//! lrm 5.10.3.3:4
//! lrm 5.10.4
//! analysis tran
//! time 0, 1n, 2n, 3n, 4n
//! lrm 5.10:1001
//! lrm 5.10:1002
`include "check.vh"
module a03_named_event_duration(p);
  inout p; electrical p;
  event ev;
  integer n;
  analog begin
    @(timer(1n, 0.0)) -> ev;
    @(timer(3n, 0.0)) -> ev;
    @(ev) n = n + 1;
    `CHECKEQ("the event is delivered where it is detected, and only when triggered",
             n, ($abstime < 1n) ? 0 : (($abstime < 3n) ? 1 : 2), 0.0);
    I(p) <+ 0.0;
  end
endmodule
