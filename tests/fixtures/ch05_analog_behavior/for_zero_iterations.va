// §5.9.2 the `for` loop tests its condition BEFORE the first pass, so `i < 0`
// with `i` initialised to 0 runs the body zero times. x therefore keeps the
// V(p) it was given, and `i` keeps the 0 the initial assignment put there — one
// pass would have left x = V(p) + 1 = 1.25 and i = 1.
//
//! lrm 5.9.2
//! bias V(p) = 0.25
//! lrm 5.9.2:1001
`include "check.vh"
module ch5_for_zero(p);
  inout p; electrical p; integer i; real x;
  analog begin
    x = V(p);
    for (i = 0; i < 0; i = i + 1) x = x + 1.0;
    `CHECK("a for whose condition is false on entry runs zero passes", x, 0.25, 0.0);
    `CHECKI("the loop variable keeps its initial assignment", i, 0);
    I(p) <+ x;
  end
endmodule
