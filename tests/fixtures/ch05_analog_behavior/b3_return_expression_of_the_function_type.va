// §5.11 Jump statements: "In a function returning a value, the return
// statement shall have an expression of the correct type."
//
// Two functions, one per numeric return type, each returning an expression of
// its own type:
//
//     scale(2.0)  real:     return 2.5 * x  ->  2.5 * 2.0 = 5.0
//     triple(2)   integer:  return 3 * k    ->  3 * 2     = 6
//
// Both identifier variables are left unassigned, so the only way to the digits
// is through the return: §4.7.2.1's default for an unassigned identifier is 0,
// and a tool that dropped the return reads 0.0 and 0. 5.0 is exact in binary,
// so the real check is CHECKX. This is the legal neighbour of
// b3_return_string_from_integer_function_rejected.va, which differs only in
// what `triple` returns.
//
//! lrm 5.11
//! lrm 5.11:1
//! lrm 4.7.2.2
//! bias V(p) = 0.0
//! checks 2
`include "check.vh"
module b3_return_expression_of_the_function_type(p);
  inout p; electrical p;

  analog function real scale;
    input x;
    real x;
    begin
      return 2.5 * x;
    end
  endfunction

  analog function integer triple;
    input k;
    integer k;
    begin
      return 3 * k;
    end
  endfunction

  analog begin
    `CHECKX("a real function returns its real expression", scale(2.0), 5.0);
    `CHECKI("an integer function returns its integer expression", triple(2), 6);
    I(p) <+ 0.0;
  end
endmodule
