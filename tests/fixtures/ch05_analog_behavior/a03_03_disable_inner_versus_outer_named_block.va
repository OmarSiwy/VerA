// A.6.5 `disable_statement ::= disable hierarchical_block_identifier ;` — the
// block identifier is an OPERAND, so which block ends is chosen by the name and
// by nothing else. Two nested pairs, identical in shape, differing only in the
// name the disable writes.
//
// §5.3: "the control shall pass out of the block after the last statement is
// executed"; §6.7 makes a block label a scope name, so `i1` and `o1` name
// different scopes and `disable i1` cannot mean `disable o1`.
//
// THE DERIVATION. Both halves are straight-line arithmetic on variables that
// are assigned outside any `@` — §5.10 retention does not apply, so every
// evaluation recomputes them from 0.
//
//   HALF 1, the disable names the INNER block:
//     begin : o1
//       begin : i1
//         a = 1;                        1
//         @(initial_step) disable i1;
//         a = a + 10;                   11   -- in i1, skipped at t = 0
//       end
//       a = a + 100;                    -- in o1, after i1: ALWAYS runs
//     end
//     t = 0   -> a = 1 + 100          = 101
//     t = 1n  -> a = 1 + 10 + 100     = 111
//
//   HALF 2, the disable names the OUTER block from inside the inner one:
//     begin : o2
//       begin : i2
//         b = 1;                        1
//         @(initial_step) disable o2;
//         b = b + 10;                   -- in i2, skipped at t = 0
//       end
//       b = b + 100;                    -- in o2: ALSO skipped at t = 0
//     end
//     t = 0   -> b = 1
//     t = 1n  -> b = 1 + 10 + 100      = 111
//
// The pair is the test: at t = 0 the two halves must disagree (101 vs 1) even
// though their statements are identical, because the names differ. A disable
// that always unwinds to the outermost block gives a = 1 and fails half 1; one
// that always unwinds exactly one block gives b = 101 and fails half 2. At
// t = 1n both read 111, which pins that neither disable leaks into an
// evaluation where its event did not fire.
//
// c is the same claim one level further out: the analog block itself is not a
// disable target here, so it runs to the end at both timepoints and c reads 5
// always. A disable implemented as "abandon this evaluation" fails that.
//
// OBSERVED TODAY: error[E0402]: `disable` is not implemented.
//
//! inherited IEEE 1364-2005 10.3
//! lrm 5.3
//! lrm 5.10.2
//! lrm 6.7
//! analysis tran
//! time 0, 1n
`include "check.vh"
module a03_disable_inner_outer(p);
  inout p; electrical p;
  integer a, b, c;
  analog begin
    begin : o1
      begin : i1
        a = 1;
        @(initial_step) disable i1;
        a = a + 10;
      end
      a = a + 100;
    end
    begin : o2
      begin : i2
        b = 1;
        @(initial_step) disable o2;
        b = b + 10;
      end
      b = b + 100;
    end
    c = 5;
    `CHECKEQ("disable i1 ends the inner block only, so o1's tail still runs",
             a, ($abstime == 0.0) ? 101 : 111, 0.0);
    `CHECKEQ("disable o2 names the outer block, so o2's tail is skipped too",
             b, ($abstime == 0.0) ? 1 : 111, 0.0);
    `CHECKEQ("and neither disable touches the analog block that contains them",
             c, 5, 0.0);
    I(p) <+ 0.0;
  end
endmodule
