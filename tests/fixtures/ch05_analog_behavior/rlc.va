// §5.6.4 RLC circuits: three contributions summing into one branch (§5.6.1.2), exercising the §4.5
// analog operators at their DC operating point, where the LRM pins both:
//
//   §4.5.3 "In DC analysis, ddt() returns zero (0)."
//   §4.5.4 "When used in DC or IC analyses, idt() returns the initial
//           condition (ic) if specified."  — here ic is 0.0.
//
// So at DC the whole branch collapses to the resistor: at V(p) = 1.0, V(n) = 0.0
// and r = 10 the flow is 1.0/10 = 0.1 A, with the reactive terms contributing
// nothing. The parameter defaults also pin §2.6.2 Table 2-1: `1p` is 1e-12 and
// `1n` is 1e-9.
//
//! lrm 5.6.4
//! lrm 5.6.1.2
//! lrm 4.5.3
//! lrm 4.5.4
//! bias V(p) = 1.0, V(n) = 0.0
`include "check.vh"
module ch5_rlc(p, n);
  inout p, n; electrical p, n;
  parameter real r = 10.0 from (0:inf);
  parameter real c = 1p from (0:inf);
  parameter real l = 1n from (0:inf);
  analog begin
    `CHECKX("scale factor p is 1e-12", c, 1.0e-12);
    `CHECKX("scale factor n is 1e-9", l, 1.0e-9);
    `CHECKX("ddt returns zero in DC", ddt(V(p, n)), 0.0);
    `CHECKX("idt returns its initial condition in DC", idt(V(p, n)/l, 0.0), 0.0);
    `CHECKR("at DC the branch is just the resistor", V(p, n)/r, 0.1, 1e-15);
    I(p, n) <+ V(p, n)/r + c*ddt(V(p, n)) + idt(V(p, n)/l, 0.0);
  end
endmodule
