// §5.4.1 / §5.6.1.1: "If the second net is not specified, the global reference
// node (ground) is used as the reference net." A branch declared with one net is
// therefore the branch from that net to ground, so V(path) is V(p) alone — the
// reference node contributes nothing (§1.3.1.1 its potential is zero).
//
// At V(p) = 0.75 with the branch flow held at 0.375 A, the probe V(path) reads
// 0.75 and the source relation 2*I(path) evaluates to 0.75 as well; the two
// agreeing is what "solved" would mean here, but each is asserted against its own
// literal so a wrong probe cannot hide behind a wrong source.
//
//! lrm 5.4.1
//! lrm 5.6.1.1
//! lrm 5.6.1.1:1000
//! bias V(p) = 0.75
//! sweep flowZ28pZ2cgndZ29 = 0.375
`include "check.vh"
module ch5_single_branch(p); inout p; electrical p; branch (p) path; analog begin `CHECKX("a single-net branch is referenced to ground", V(path), 0.75); `CHECKX("its flow is the branch unknown", I(path), 0.375); `CHECKX("the source relation", 2.0*I(path), 0.75); V(path) <+ 2.0*I(path); end endmodule
