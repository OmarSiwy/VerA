// §3.2 initializes the variable and then nothing re-initializes it until the
// next ANALYSIS:
//
//   "Real variables are initialized to zero (0) at the start of a simulation."
//                                                                    // §3.2
//   "Variables shall be re-initialized to zero (or x, for integers whose
//    values are assigned in a digital context) at the start of each new
//    analysis."
//                                                                  // §4.6.2
//
// The declared times below are the steps of ONE transient analysis (the
// runner's `//! time` grid), so between them `held` is storage: an assignment
// that does not execute leaves the value the previous evaluation put there.
// The §3.2 default makes that value zero only before the first assignment.
//
// This is the hidden-variable rule of vampyre's
// cmcqa/mextram*504*/hidden/Iqs row: `Iqs` is assigned only when
// `Ic1c2 > 0.0`, and `OP_iqs = Iqs;` reads it on every evaluation, so at
// `Ic1c2 <= 0` the read sees the previous evaluation's value. VerA holds it;
// a tool that resets an unassigned variable to its default on every
// evaluation reads zero. The wave puts the condition through false, true,
// false so the second false point is the one that can only pass by retention.
//
// DERIVATION. `held` starts at the §3.2 default 0. The block runs once per
// declared point:
//
//     t = 0     V(p) = 0   0 > 0.5 false   no assignment   held = 0
//     t = 1n    V(p) = 1   1 > 0.5 true    held = 2*1      held = 2.0
//     t = 2n    V(p) = 0   0 > 0.5 false   no assignment   held = 2.0  <-- claim
//
// Both values are exact in binary and the want is a literal selected by
// $abstime, so the comparison is CHECKX's. The want at t = 2n distinguishes
// retention (2.0) from re-initialization (0.0); the count of three verdicts
// (`//! checks 3`) also fails a run that skips the third point.
//
//! lrm 3.2
//! lrm 4.6.2
//! analysis tran
//! time 0, 1n, 2n
//! wave V(p) = 0, 1, 0
//! checks 3
`include "check.vh"
module triage_conditional_variable_retains(p);
  inout p; electrical p;
  real held;
  analog begin
    if (V(p) > 0.5)
      held = 2.0 * V(p);
    `CHECKX("an assignment that does not execute leaves the previous evaluation's value",
            held, ($abstime < 0.5n) ? 0.0 : 2.0);
    I(p) <+ 0.0;
  end
endmodule
