// §4.5.15: "Analog operators shall not be used inside conditional (if, case,
// or ?:) statements unless the conditional expression controlling the
// statement consists of terms which can not change their value during the
// course of a simulation." The clause gives its reason in the paragraph
// before: "It is important to ensure that all analog operators are evaluated
// every iteration of a simulation to ensure that the internal state is
// maintained." A condition that cannot change picks the same arm on every
// iteration, so the operator in that arm is evaluated on every iteration.
//
// Here the condition reads a VARIABLE, `td`, but the only value `td` ever
// holds is arithmetic on two parameters and a literal (§3.4: a parameter is
// fixed for the simulation). So the term cannot change during the course of
// a simulation, and the `ddt` in the else arm is legal. This is the shape of
// the SPICE Gummel-Poon excess-phase network (ptf, tf), where the model
// skips the network entirely when the excess phase is zero.
//
// §5.8.1 words the same carve-out as "a analysis_or_constant_expression",
// the A.8.3 production, whose primaries are syntactically parameters and
// literals. Read as grammar it would refuse this file; read with §4.5.15's
// wording and reason it admits it. VerA takes §4.5.15's: the property the rule
// protects (operator history) depends on whether the value can change, not on
// how the source spelled it. conditional_ddt_bias_variable_invalid.va is the
// other half: a variable that DOES depend on the solution keeps E0514.
//
// The wants, by hand:
//   td = ptf * 0.017453292519943295 * tf = 30 * 0.017453292519943295 * 1e-9
//      = 5.235987755982989e-10 (the double Python and IEEE 754 give; CHECKR)
//   td != 0, so the else arm runs; at the DC operating point ddt(.) is 0
//   (§4.5.3), and the arm contributes V(p, n)/1k. With V(p) = 1.0, V(n) = 0.0
//   the branch current is 1e-3, which `i` records.
//
//! lrm 4.5.15
//! lrm 4.5.15:1
//! lrm 5.8.1
//! lrm 5.8.1:4
//! bias V(p) = 1.0, V(n) = 0.0
`include "check.vh"
module ch05_conditional_ddt_parameter_variable(p, n);
    inout p, n;
    electrical p, n;
    parameter real ptf = 30.0;
    parameter real tf = 1.0e-9;
    real td, i;
    analog begin
        td = ptf * 0.017453292519943295 * tf;
        if (td == 0.0) begin
            i = 0.0;
            I(p, n) <+ 0.0;
        end else begin
            i = V(p, n) / 1.0e3;
            I(p, n) <+ i;
            I(p, n) <+ ddt(td * V(p, n));
        end
        `CHECKR("td is parameter arithmetic", td, 5.235987755982989e-10, 1e-15);
        `CHECKR("the else arm ran", i, 1.0e-3, 1e-15);
    end
endmodule
