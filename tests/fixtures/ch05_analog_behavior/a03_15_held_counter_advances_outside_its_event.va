// §5.10.2 "initial_step and final_step generate global events on the first and
// the last point in an analysis respectively."
//
// §3.2 "Integer variables whose values are assigned in an analog context
// default to an initial value of zero (0)." and "Real variables are
// initialized to zero (0) at the start of a simulation."
//
// A variable is initialized once, at the start of the simulation, and not at
// every evaluation; so a variable the analog block writes keeps the value the
// previous evaluation left in it. `@(initial_step) k = 0` resets `k` on the
// first point only. `k = k + 1` sits OUTSIDE the event, so it runs at every
// evaluation and reads what the last one wrote: `k` counts evaluations.
//
// THE BUG THIS ROW PINS (ARPice docs/vera-gaps.md, the LTRA/TXL history
// write). Setup's solve-invariance fixpoint (lib/backend/codegen/plan/
// setup.zig) assumed `k`'s held read invariant because `k` was assumed
// initial-only, found `k + 1` invariant under that assumption, and so kept
// it: a self-justifying cycle. `setup` computed `k = 0 + 1` once and every
// point printed k = 1. The history index `i` froze with it.
//
// THE DERIVATION. The number of evaluations per point is the simulator's (one
// per accepted point, or one per Newton iterate), so only what holds for every
// count is asserted. Let idx = $abstime / 1n be the point's index.
//
//   k: every evaluation of point 0 is the initial step, so k = 0 + 1 = 1
//      there exactly. Every later point adds at least one evaluation, so
//      k >= idx + 1. (One evaluation per point, as VerA's testbench commits,
//      gives k = 1, 2, 3, 4, 5. The frozen device gave 1, 1, 1, 1, 1.)
//
//   h: a four-slot history ring. Each evaluation stores $abstime at
//      i = k % 4 and reads prev = h[(k + 3) % 4], the slot the previous
//      evaluation wrote (or the §3.2 zero before one exists). The previous
//      evaluation ran at this point or at the one before, so
//      $abstime - 1n <= prev <= $abstime. One evaluation per point gives
//      prev = 0, 0, 1n, 2n, 3n, wrapping the ring at t = 3n (i = 0). The
//      frozen index read h[0] = 0 forever, which fails from t = 2n.
//
// The bound is written with 1.5n, not 1n, so the grid's rounding of $abstime
// cannot decide it.
//
//! lrm 5.10.2
//! lrm 3.2
//! analysis tran
//! time 0, 1n, 2n, 3n, 4n
`include "check.vh"
module a03_held_counter_outside_event(p, n);
  inout p, n; electrical p, n;
  integer k, i, idx;
  real h[0:3];
  real prev;
  analog begin
    @(initial_step) k = 0;
    k = k + 1;
    i = k % 4;
    h[i] = $abstime;
    prev = h[(k + 3) % 4];
    idx = $rtoi($abstime / 1n + 0.5);
    `CHECKI("k is 1 at the initial step, and counts at least one per point after",
            (idx == 0) ? (k == 1) : (k >= idx + 1), 1);
    `CHECKI("the history ring's previous slot is this point's or the last one's",
            (prev > $abstime - 1.5n) && (prev <= $abstime), 1);
    I(p, n) <+ V(p, n);
  end
endmodule
