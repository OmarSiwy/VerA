// §5.4.1 Example 2: `V(p, n)` accesses the potential DIFFERENCE from p to n,
// not the potential of either net, and §5.6.1.1 directs the branch from the
// first net to the second — so V(n, p) is its negation. At V(p) = 0.75 and
// V(n) = 0.25 the branch potential is 0.5 V exactly, and the probe driving a
// flow source through 1 kohm gives 0.5/1000 = 500 uA.
//
//! lrm 5.4.1
//! lrm 5.6.1.1
//! lrm 5.6.1.1:1000
//! bias V(p) = 0.75, V(n) = 0.25
`include "check.vh"
module ch5_potential_probe(p, n);
  inout p, n; electrical p, n;
  analog begin
    `CHECKX("branch potential is the node difference", V(p, n), 0.5);
    `CHECKX("the branch is directed p to n", V(n, p), -0.5);
    `CHECKR("probed potential drives the flow source", V(p, n) / 1000.0, 5.0e-4, 1e-15);
    I(p, n) <+ V(p, n) / 1000.0;
  end
endmodule
