// §5.10.3.3: "The enable argument, if specified, shall evaluate to an
// integer." and "If enable is specified and nonzero, then timer() functions as
// just described."
//
// event_timer.va with its fourth argument written: the integer 1. The timer
// must behave exactly as without it. timer(0.0, 1n) fires at t = 0 and every
// 1 ns after; the body toggles `state` from §3.2's 0.0:
//
//     t = 0    first event  -> state = 1 - 0 = 1
//     t = 1n   second event -> state = 1 - 1 = 0
//
// The partition is written at the transition, 1n, as event_timer.va explains.
// A tool that read the enable as 0 leaves state at 0.0 at t = 0. This is the
// legal neighbour of b3_timer_noninteger_enable_rejected.va (enable 0.5).
//
//! lrm 5.10.3.3
//! analysis tran
//! time 0, 1n
//! checks 2
`include "check.vh"
module b3_timer_enable_integer(p);
  inout p; electrical p; real state;
  analog begin
    @(timer(0.0, 1n, 1p, 1)) state = 1.0 - state;
    `CHECKX("timer(0, 1n) with enable 1 fires at t=0 and one period later", state, ($abstime < 1n) ? 1.0 : 0.0);
    V(p) <+ transition(state, 0.0, 1p, 2p);
  end
endmodule
