// §5.10.3.1 cross(), the tolerance arguments:
//
//   cross ( expr [ , dir [ , time_tol [ , expr_tol [ , enable ] ] ] ] )
//
//   "The tolerances (time_tol and expr_tol) are specified as analog_expression
//    and shall be non-negative. If a value of zero (0.0) is specified, the
//    simulator shall apply a suitable value."
//
//   "expr_tol and time_tol are absolute tolerances ... They represent the
//    maximum allowable error between the true crossing point and when the event
//    triggers. The event shall occur after the threshold crossing, and while the
//    signal remains in the box defined by actual crossing and expr_tol and
//    time_tol."
//
// and the disabling sentence, which is what the tolerance arguments have to be
// told apart FROM:
//
//   "Thus, there are two ways to disable the cross function, either by
//    specifying enable as 0, or giving a value other than -1, 0, or 1 to dir."
//
// Read the positions off Syntax 5-16 before reading the claims: in
// `cross(expr, dir, time_tol, expr_tol, enable)` the tolerances are arguments 3
// and 4 and THE ENABLE IS ARGUMENT 5. (The four-argument shape of timer() is
// different — `timer(start_time, period, time_tol, enable)` — and that is
// exactly the confusion this file exists to catch, so the two spellings must
// not be described in the same words. Fixture 02 pins timer's.)
//
// Three claims, all of them observable from inside the model:
//
//   (a) SUPPLYING tolerances does not change WHETHER the event happens. A
//       four-argument cross() still fires once on the one rising crossing. The
//       failure this rules out is positional: a tool that has borrowed timer()'s
//       argument order reads expr_tol as the enable, so a nonzero fourth
//       argument looks "enabled" by luck and a ZERO one looks "disabled", which
//       is the next claim.
//
//   (b) A tolerance of ZERO is not a disabled cross. The clause spells this out
//       — zero means "the simulator shall apply a suitable value" — so
//       `cross(expr, +1, 0, 0)` fires exactly like `cross(expr, +1)`.
//
//   (c) The FIFTH argument is the enable, and setting it to 0 does disable the
//       event: `cross(expr, +1, 0, 0, 0)` fires on no row of this run. (b) and
//       (c) differ only in whether the fifth slot is written, and they are
//       required to answer differently — which is the only way a fixture can
//       state "argument 4 is not the enable" rather than assert it in prose. A
//       tool that ignores the enable argument, or that reads it from position 4,
//       fails exactly one of the two.
//
// (c) is the first of the clause's "two ways to disable"; the second — a dir
// outside {-1, 0, +1} — is fixture 04, which fails today. This one holds today,
// so the pair also fixes which of the two ways is the defect.
//
// THE WAVEFORM. V(p) walks 0 -> 0.5 -> 1.5, so `V(p) - 1.0` crosses zero upward
// exactly once, between t = 1n and t = 2n, and never downward. Each counter is
// therefore 0 on the two rows before the crossing and 1 on every row after it,
// and the sample each event captured lies in [1.0, 1.5]: the clause's box, whose
// lower edge is the crossing value (the event "shall occur after the threshold
// crossing") and whose upper edge is the last declared point, since the
// generated testbench only evaluates the `//! time` rows. A conforming host that
// resolves the crossing to time_tol lands a point just past it and samples
// approximately 1.0, which is inside the same box — so this bound holds for both
// and no tighter literal would.
//
// The `1n` and `0.1` in (a) are not arbitrary: 1 ns is one declared step of this
// run and 0.1 V is a fifth of the swing between the last two points, so they are
// tolerances a real host would have to honour by inserting a point, rather than
// values so loose that any grid satisfies them.
//
//! lrm 5.10.3.1
//! lrm 5.10.3.1:5
//! lrm 5.10.3.1:2
//! analysis tran
//! time 0, 1n, 2n
//! wave V(p) = 0, 0.5, 1.5
//! print none
`include "check.vh"
module a10_cross_tolerances(p);
  inout p;
  electrical p;
  integer n_tol, n_zero, n_off;
  real held;
  analog begin
    @(cross(V(p) - 1.0, +1, 1n, 0.1)) begin
      n_tol = n_tol + 1;
      held = V(p);
    end
    @(cross(V(p) - 1.0, +1, 0, 0)) n_zero = n_zero + 1;
    @(cross(V(p) - 1.0, +1, 0, 0, 0)) n_off = n_off + 1;
    `CHECKEQ("explicit tolerances do not change whether the crossing fires", n_tol,
             (V(p) > 1.0) ? 1 : 0, 0.0);
    `CHECKEQ("a zero tolerance means `pick one`, not `disabled`", n_zero,
             (V(p) > 1.0) ? 1 : 0, 0.0);
    `CHECKI("the FIFTH argument is the enable, and 0 there does disable the event",
            n_off, 0);
    `CHECKI("the sample sits in the box the clause draws around the crossing",
            (V(p) > 1.0) ? (held >= 1.0 && held <= 1.5) : (held == 0.0), 1);
    I(p) <+ 0.0;
  end
endmodule
