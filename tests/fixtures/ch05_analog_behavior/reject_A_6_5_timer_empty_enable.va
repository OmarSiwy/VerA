// A.6.5 writes every monitored event's last slot, the enable, as an
// analog_expression and the slots before it as analog_expression_or_null:
//
//     timer ( analog_expression [ , analog_expression_or_null
//             [ , analog_expression_or_null [ , analog_expression ] ] ] )
//
// so a comma before the enable promises one. `timer(0.0, 1n, 1p, )` writes the
// comma and no enable, which derives from nothing (5.10.3.3's "if specified"
// is about leaving the whole slot out, comma included). The legal neighbour,
// b3_timer_enable_integer.va, writes the enable `1`; this file is that one with
// the `1` deleted, the grammar diff's mutant.
//
// VerA refuses it with E0517, the 5.10.3 event-argument code; the code is
// pinned.
//
//! lrm 5.10.3.3
//! lrm A.6.5
//! lrm A.6.5:1000
//! reject-only E0517
//! reject-only comma before its enable
//! neighbour b3_timer_enable_integer.va
`include "check.vh"
module b3_timer_enable_integer(p);
  inout p; electrical p; real state;
  analog begin
    @(timer(0.0, 1n, 1p, )) state = 1.0 - state;    // illegal: an empty enable
    `CHECKX("timer(0, 1n) with enable 1 fires at t=0 and one period later", state, ($abstime < 1n) ? 1.0 : 0.0);
    V(p) <+ transition(state, 0.0, 1p, 2p);
  end
endmodule
