// §5.10.3.2 above() with both tolerances given: `above(expr, time_tol,
// expr_tol)`. "The tolerances (time_tol and expr_tol) are optional, but if
// specified shall be non-negative. If a value of zero (0.0) is specified, the
// simulator shall apply a suitable value."
//
// The tolerances bound only WHEN the event lands relative to the true crossing;
// they do not gate whether it happens. So this file is event_above.va's dc
// sweep with the two tolerance arguments added and the same answer demanded —
// that invariance is the claim, and it is why the two fixtures share an
// operating point. (It used to assert a firing at a standalone dc point, which
// §5.10.3.2 permits but does not require; see event_above.va.)
//
// A negative tolerance is the other half of the sentence, and is
// cross_tolerance_negative_invalid.va.
//
//! lrm 5.10.3.2
//! lrm 5.10.3.2:1
//! lrm 5.10.3.2:4
//! analysis dc
//! bias V(p) = 0.6
//! sweep V(c) = -1.0, 1.25
`include "check.vh"
module ch5_above_tol(p, c);
  inout p, c; electrical p, c; real x;
  analog begin
    @(above(V(c) - 0.5, 1p, 1u)) x = V(p);
    `CHECKEQ("both tolerances given, the dc-sweep crossing still fires", x, (V(c) > 0.5) ? 0.6 : 0.0, 0.0);
    I(p) <+ x;
  end
endmodule
