// §5.6.7: "Indirect branch contributions shall not be used in conditional or
// looping statements, unless the conditional expression is a constant
// expression. The constant expression shall not include the analysis()
// function with an argument that can result in different return values during
// a single analysis, such as the "ic" or "nodeset" arguments."
//
// The carve-out, in its ordinary form: the condition is a module parameter,
// which A.8.4 makes a `constant_primary` and so a constant expression. It
// cannot change during an analysis, so the equation system the indirect
// contribution belongs to has one shape for the whole run. This is the legal
// neighbour of b3_indirect_under_analysis_ic_rejected.va, which differs only
// in the condition.
//
// DERIVATION, as in indirect_contribution.va: use_eq = 1, so the contribution
// is active and reads "drive V(p,n) so that V(ctrl) == 2*V(p,n)". With ctrl
// held at 1.5 the only solution is V(p,n) = 1.5/2 = 0.75, exact in binary.
// p and n are free (`//! solve`), so 0.75 is the solver's answer, not an
// input: a tool that dropped the guarded statement leaves the branch
// undriven and does not land on it.
//
//! lrm 5.6.7
//! bias V(ctrl) = 1.5
//! solve
`include "check.vh"
module b3_indirect_under_parameter_condition(p, n, ctrl);
  inout p, n, ctrl; electrical p, n, ctrl;
  parameter integer use_eq = 1;
  analog begin
    `CHECKX("the probed control voltage is the harness input", V(ctrl), 1.5);
    `CHECKX("the indirect branch under a parameter condition settles at V(ctrl)/2", V(p, n), 0.75);
    if (use_eq)
      V(p, n) : V(ctrl) == 2.0 * V(p, n);
  end
endmodule
