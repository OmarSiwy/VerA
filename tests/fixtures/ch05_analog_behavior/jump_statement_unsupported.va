// LRM 5.11: "The break statement jumps out of the loop." The loop control here
// would otherwise run i from 0 to 4, so the value of i after the loop says
// whether break was honoured: break fires on the very first pass, before the
// `i = i + 1` step of LRM 5.9.2's three-step process ever runs, so i is still 0.
// A `break` that is parsed and then ignored leaves i = 4, the value that ends
// the loop by its own test.
//
// (§5.11 permits break only in a loop and not inside an analog_for, so the loop
// is a plain LRM 5.9.2 for statement inside the analog block.)
`include "check.vh"
module ch5_jump(p);
  inout p; electrical p; integer i;
  analog begin
    for (i = 0; i < 4; i = i + 1) begin
      break;
    end
    `CHECKI("break left the loop before the first update of i", i, 0);
  end
endmodule
