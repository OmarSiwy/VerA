// The legal neighbour of event_null_argument_invalid.va. §5.10.3.1: "If either
// or both tolerances are defined, then the direction shall also be defined."
// This module is that file's module with that one thing changed: the dir slot
// that file leaves null is written as 0 ("If the direction indicator is set to
// 0 ... both positive and negative crossings"), and the time_tol of 1n stays.
// So the pair separates "a tolerance without a direction" from "a tolerance" —
// the refusal cannot be a blanket refusal of a time_tol (event_cross_any.va
// writes a direction but no tolerance, so it cannot tell the two apart).
//
// THE DIGITS. A dc operating point at V(p) = 0.6. §5.10.3.1: cross() "will not
// generate events for non-transient analyses, such as ac, dc, or noise
// analyses", so the body never runs and x keeps the 0.0 it is given first.
//
//! lrm 5.10.3.1
//! bias V(p) = 0.6
//! checks 1
`include "check.vh"
module ch5_event_cross_tol_with_dir(p);
  inout p; electrical p; real x;
  analog begin
    x = 0.0;
    @(cross(V(p) - 1.0, 0, 1n)) x = 1.0;
    `CHECKX("cross with dir 0 and a time_tol compiles; no event in dc", x, 0.0);
    I(p) <+ x;
  end
endmodule
