// LRM 5.4.3: "The expression V(<a>) is invalid for ports and nets, where V is a
// potential access function."  A port access function reads the FLOW into the
// port and nothing else.  (The .va comment cites 4.4.2, which gives the access
// function grammar; 5.4.3 is where the prohibition itself is stated.)
//! lrm 5.4.3
//! reject E0507
//! reject potential access function
// EXPECT: error -- LRM 4.4.2: a port branch supports FLOW access only, so
// V(<p>) is illegal.
module ch5_bad_port_potential(p);
  inout p; electrical p;
  analog I(p) <+ V(<p>);
endmodule
