// LRM 5.8.3: the case items are "evaluated and compared in the exact order in
// which they are given", and one item may carry a comma-separated list of
// expressions. LRM 4.2.5 makes the relational `V(p) > 0.0` an integer, so at
// V(p) = 0.5 V the selector is 1 — which matches the SECOND label of the
// `1, 2:` item, not the `0:` item and not default. x must therefore be 1.0,
// not 0.0 and not -1.0.
//
//! lrm 5.8.3
//! lrm 5.8.3:1
//! bias V(p) = 0.5
`include "check.vh"
module ch5_case(p);
  inout p; electrical p; integer mode; real x;
  analog begin
    mode = V(p) > 0.0;
    case (mode)
      0: x = 0.0;
      1, 2: x = 1.0;
      default: x = -1.0;
    endcase
    `CHECKI("a relational selector is an integer", mode, 1);
    `CHECKX("the comma-separated case item matched", x, 1.0);
    I(p) <+ x;
  end
endmodule
