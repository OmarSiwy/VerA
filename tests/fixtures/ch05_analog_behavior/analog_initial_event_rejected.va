// LRM 5.2.1: event control statements are forbidden in an analog initial block.
//! lrm 5.2.1
//! reject E0702
module ch5_initial_event_rejected;
  real initialized;
  analog initial @(initial_step) initialized = 1.0;
endmodule
