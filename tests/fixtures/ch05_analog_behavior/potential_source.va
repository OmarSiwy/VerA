// §5.6.1.2: a potential contribution retains its right-hand side for assignment
// to the source branch, so the equation the solver is given is V(p,n) - 1.25 = 0.
// Held off that solution at V(p) = 1.0, V(n) = 0.5, the probed branch potential
// is 0.5 and the source's residual is 0.5 - 1.25 = -0.75. Both exact in IEEE 754.
//
//! lrm 5.6.1.2
//! bias V(p) = 1.0, V(n) = 0.5
`include "check.vh"
module ch5_potential_source(p, n);
  inout p, n; electrical p, n;
  analog begin
    `CHECKX("probed branch potential", V(p, n), 0.5);
    `CHECKX("potential source residual off its solution", V(p, n) - 1.25, -0.75);
    V(p, n) <+ 1.25;
  end
endmodule
