// §5.7, the third semantic restriction on analog procedural assignments:
// "Hierarchical assignment of a variable from another scope/module is not
// allowed."
//
// Note which direction the rule runs. §5.5.4 makes a hierarchical NET reference
// legal on the right of an access function, and §5.6.8.1 makes one legal as the
// target of a contribution — hierarchical_access_unsupported.va and
// hierarchical_contribution_unsupported.va are those two clauses. A hierarchical
// VARIABLE, on the left of a procedural `=`, is the one hierarchical target the
// analog block may not write, because a variable is scope-owned storage and not
// a solver unknown the elaborator can share.
//
// procedural_assignments.va is the positive §5.7 fixture and keeps compiling;
// assignment_concatenation_invalid.va is the first of the three restrictions.
//
// VerA's E0214 is the right verdict reached by the shorter route: it has no
// hierarchical references at all, so the `.` stops the statement at parse time
// rather than at a scope check. That is still a refusal of exactly the
// construct §5.7 bans — `x = 1.0` in the same position compiles — but should
// VerA ever resolve hierarchical names, this fixture must start matching the
// §5.7 scope diagnostic instead, and it will say so by failing.
//
//! lrm 5.7
//! reject E0214
module ch5_assignment_hierarchical(p);
  inout p; electrical p; real x;
  analog begin
    x = 1.0;
    top.child.x = 1.0;       // illegal: a variable in another scope
    I(p) <+ x;
  end
endmodule
