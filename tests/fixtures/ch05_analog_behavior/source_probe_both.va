// §5.4.2 the probe/source pair: one named branch is BOTH sourced (`V(b) <+ ...`)
// and probed (`I(b)`, `V(b)` on a right-hand side). §5.4.1 Example 1 makes V(b)
// the potential across the branch, which for branch(p,n) is the node difference,
// and I(b) the flow through it — two independent unknowns of the solve.
//
// At V(p) = 1.0, V(n) = 0.25 with the branch flow held at 0.125 A: V(b) = 0.75,
// the source relation 10*I(b) = 1.25, and the flow contributed onto node p is
// V(b) + I(b) = 0.875. Every value is a dyadic rational, hence exact.
//
//! lrm 5.4.2.2
//! lrm 5.4.2.2:1000
//! bias V(p) = 1.0, V(n) = 0.25
//! sweep flowZ28pZ2cnZ29 = 0.125
//! lrm 5.4.2.2:1001
`include "check.vh"
module ch5_source_probe(p,n); inout p,n; electrical p,n; branch(p,n) b; analog begin `CHECKX("named branch potential is the node difference", V(b), 0.75); `CHECKX("named branch flow probe", I(b), 0.125); `CHECKX("the source relation", 10.0*I(b), 1.25); `CHECKX("flow contributed onto node p", V(b)+I(b), 0.875); V(b)<+10.0*I(b); I(p)<+V(b)+I(b); end endmodule
