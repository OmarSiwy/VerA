// §5.8.1's carve-out, exercised on a reactive contribution: "If any of the
// conditionally-executed statements contains an analog operator, the
// conditional expression shall be a analysis_or_constant_expression." A.8.3
// admits a parameter (A.8.4 constant_primary) and an analysis() call
// (§4.6.1, fixed for the whole analysis), combined with operators, so
// `use_cap && analysis("tran")` is one and the `ddt` under it is legal. The
// illegal side is conditional_ddt_contribution_invalid.va.
//
// THE NUMBERS. The branch is §4.5.3's capacitor, I = c·dV/dt. The wave drives
// V(p) = 0, 1, 2, 3 V at t = 0, 1n, 2n, 3n with V(n) = 0, a ramp of
// 1 V/1 ns = 1e9 V/s. As a02_04 derives, the harness's backward-Euler
// difference over the uniform 1 ns step is exactly that slope after the DC
// point (a trapezoidal integrator would ring on this input; the harness is
// not one):
//
//     I(cap) = c · 1e9 = 1e-9 · 1e9 = 1 A        at t = 1n, 2n, 3n
//     I(cap) = 0                                 at t = 0 (the dc point:
//                                                §4.5.3 "In DC analysis,
//                                                ddt() returns zero")
//
// use_cap = 1 and the analysis is tran, so the then-arm is the one that runs.
// A compiler that dropped the contribution under the condition reads 0 at
// every point; one that took the else arm reads 0 as well.
//
//! lrm 5.8.1
//! lrm 4.5.15
//! lrm 4.5.3
//! lrm 4.5.15:1
//! lrm 5.8.1:1
//! lrm 5.8.4
//! lrm 5.8.4:1000
//! bias V(n) = 0
//! wave V(p) = 0, 1, 2, 3
//! time 0, 1n, 2n, 3n
//! analysis tran
//! print none
`include "check.vh"
module ch5_conditional_ddt_static(p, n);
  inout p, n;
  electrical p, n;
  branch (p, n) cap;
  parameter real c = 1n from (0:inf);
  parameter integer use_cap = 1;
  analog begin
    if (use_cap && analysis("tran")) I(cap) <+ c * ddt(V(cap));
    else I(cap) <+ 0.0;
    `CHECK("the reactive contribution under a static condition is the capacitor's c*dV/dt",
           I(cap), ($abstime > 0) * 1.0, 1e-9);
  end
endmodule
