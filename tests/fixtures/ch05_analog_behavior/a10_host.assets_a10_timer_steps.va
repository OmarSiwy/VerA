// §5.10.3.3 timer(): "The analog simulator PLACES A TIME POINT within time_tol
// of an event. At that time point, the event evaluates to True."
//
// Two single-shot timers at times that are deliberately NOT on the printstep
// grid of the deck that instantiates this model (`.tran 1e-4 1e-3` walks
// 0, 1e-4, 2e-4, …). 2.5e-4 and 6.25e-4 fall strictly between printsteps, so an
// accepted time point at either one exists only because this model asked for it.
//
// Both periods are 0, which §5.10.3.3 makes single-shot ("the timer shall
// trigger only once at the specified start_time"), so the output is a staircase
// with exactly two risers and its value identifies WHICH timers have fired:
//
//   t <  2.5e-4              lvl = 0   V(p,n) = 0 V
//   2.5e-4  <= t < 6.25e-4   lvl = 1   V(p,n) = 1 V
//   t >= 6.25e-4             lvl = 2   V(p,n) = 2 V
//
// The start times are written as plain decimals and not as §2.6 scale factors
// (`250u`) on purpose: a scale factor is lowered as a MULTIPLICATION, so `250u`
// is 250 * 1e-6 = 2.5000000000000005e-4, one ulp away from the decimal 2.5e-4
// the oracle asks for, and the oracle compares the accepted time to the
// breakpoint exactly.
`include "disciplines.vams"

module a10_timer_steps(p, n);
  inout p, n;
  electrical p, n;
  integer lvl;
  analog begin
    @(timer(2.5e-4, 0)) lvl = lvl + 1;
    @(timer(6.25e-4, 0)) lvl = lvl + 1;
    V(p, n) <+ 1.0 * lvl;
  end
endmodule
