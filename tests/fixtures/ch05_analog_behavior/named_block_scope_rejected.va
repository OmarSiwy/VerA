// §6.8: a named block "defines a new scope", and §5.3.2 says naming a block is
// exactly what "allows local variables to be declared for that block". The
// restrictive half of that is the part nothing in the suite pinned: a block item
// declaration is INVISIBLE outside its begin-end. named_block_locals.va tests
// that a block-local is usable inside its block, and ch06_hierarchy/
// local_scope_shadow.va tests that the enclosing scope stays visible from
// inside — both permissive directions.
//
// `hidden` is declared in :inner and read after the matching `end`, so the
// reference has no declaration in scope.
//
// (VerA answers with E0314 "unknown identifier", not E0313 "unknown variable",
// even though E0313's explain text advertises this exact case. Pinned against
// the code that actually fires; E0313 remains cited by zero fixtures.)
//! lrm 6.8
//! lrm 5.3.2
//! reject E0314
module ch5_named_block_scope(p);
  inout p; electrical p;
  real out;
  analog begin
    begin : inner
      real hidden;
      hidden = V(p);
    end
    out = hidden;            // illegal: `hidden` died with :inner
    I(p) <+ out;
  end
endmodule
