// §5.6.6 Implicit Contributions:
//
//   "An important feature of contribution statements is that the value of the
//    target may be expressed in terms of itself. This is referred to as an
//    implicit or fixed-point formulation. ... Notice that I(diode) is found on
//    both sides of the contribution operator. The underlying implementation of
//    the simulator will find the value of I(diode) that equals the sum of the
//    contributions made to it, even if the contributions are a function of
//    I(diode) itself."
//
// tests/fixtures/ch05_analog_behavior/implicit_fixed_point.va already exists and
// is green, and it does NOT test this sentence. It FORCES the branch-flow
// unknown with `//! sweep flowZ28pZ2cnZ29 = 0.25`, i.e. a human supplies the
// fixed point and the fixture checks that the right-hand side reproduces it.
// Nothing there asks the simulator to FIND it. This file does, by leaving that
// unknown free and letting the solver close the loop.
//
// THE CIRCUIT, and why it has a free node as well as a free branch flow:
//
//        s ---[ implicit element b ]--- m ---[ rl = 4 ohm ]--- g
//       1V                                                    0V
//
//   I(b) <+ gm*(V(b) - rs*I(b))     gm = 0.5 S, rs = 2 ohm
//   I(m,g) <+ V(m,g)/rl             rl = 4 ohm
//
// Two unknowns, two equations, and the implicit one is the whole point:
//
//   (1) I  = gm*(V(s) - V(m) - rs*I)      the §5.6.6 fixed point
//   (2) I  = V(m)/rl                      Kirchhoff at m
//
// BY HAND. Rearranging (1): I*(1 + gm*rs) = gm*(1 - V(m)), and with
// gm*rs = 0.5*2 = 1 that is 2*I = 0.5*(1 - V(m)). Substituting (2)'s
// V(m) = 4*I gives 2*I = 0.5 - 2*I, hence
//
//   I(b)  = 0.125 A       (1/8, exact in binary)
//   V(m)  = 4 * 0.125     = 0.5 V
//   V(b)  = 1.0 - 0.5     = 0.5 V
//
// and the residual check: 0.5*(0.5 - 2*0.125) = 0.5*0.25 = 0.125. Every number
// is a dyadic rational, so CHECKX would be defensible; 1e-12 is used only
// because Newton stops on a tolerance and not on an identity.
//
// Replacing the RHS probe I(b) by zero instead would solve
// I=0.5*(1-4I), giving I=1/6 and V(m)=2/3. Those differ from the
// derived solution, so the assertions distinguish the missing feedback.
//
//! lrm 5.6.6
//! lrm 5.6.6:1
//! lrm 5.6.1.2
//! bias V(s) = 1.0
//! bias V(g) = 0.0
//! solve
//! lrm 5.6.6:1001
`include "check.vh"
module a02_implicit_solved(s, g);
  inout s, g;
  electrical s, g, m;
  branch (s, m) b;
  parameter real gm = 0.5 from (0:inf);
  parameter real rs = 2.0 from [0:inf);
  parameter real rl = 4.0 from (0:inf);
  analog begin
    I(b) <+ gm*(V(b) - rs*I(b));
    I(m, g) <+ V(m, g)/rl;
    `CHECK("the solver finds the fixed point, not the linearised value", I(b), 0.125, 1e-12);
    `CHECK("and the load node follows it", V(m, g), 0.5, 1e-12);
    `CHECK("at the solution the right-hand side reproduces the target",
           gm*(V(b) - rs*I(b)), 0.125, 1e-12);
  end
endmodule
