// §5.10.3.4 suppresses delta events within time_tol of the preceding event.
// V(p) rises 0.1 V/ns, delta = 0.25 V, and expr_tol = 0.2 V permits a delta
// event 0.5..4.5 ns after its predecessor. time_tol = 4 ns narrows that window
// to 4..4.5 ns. Starting with initialization at zero, two delta events must
// therefore have happened by 9 ns; a third cannot happen before 12 ns.
// At 10 ns n = 3, with each noninitial event separated by 4..4.5 ns.
// Half a 1 ps tick is added to each time bound (two ticks for the difference).
// Three final-step assertions give checks = 3. Negative time_tol has its
// named rejection neighbor event_bounds_absdelta_negative_time_tol_rejected.va.
//! lrm 5.10.3.4
//! analysis tran
//! time 0, 10n
//! wave V(p) = 0.0, 1.0
//! checks 3
//! lrm 5.10.3.4:1006
`timescale 1ns/1ps
`include "check.vh"
module ch5_absdelta_time_tol(p);
  inout p; electrical p;
  integer n;
  real first, second;
  initial begin n = 0; first = -1; second = -1; end
  always @(absdelta(V(p), 0.25, 4n, 0.2)) begin
    n = n + 1;
    if (n == 2) first = $realtime;
    if (n == 3) second = $realtime;
  end
  analog begin
    @(final_step) begin
      `CHECKI("time_tol filters the intervening thresholds", n, 3);
      `CHECKI("first delta event is in its allowed window", first >= 3.9995 && first <= 4.5005, 1);
      `CHECKI("next delta event respects the same minimum spacing", second - first >= 3.999 && second - first <= 4.501, 1);
    end
    I(p) <+ 0.0;
  end
endmodule
