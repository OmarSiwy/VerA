// §5.10.3.1 the direction argument of cross(): "If the direction indicator is
// set to 0 or is not specified, the event and timestep control occur on both
// positive and negative crossings of the signal. If dir is +1 (-1), the event
// and timestep control only occur on rising (falling) edge transitions".
//
// V(p) is walked -1 -> 1 -> -1 over 0, 1n, 2n: one rising crossing of zero
// strictly between 0 and 1n, one falling crossing strictly between 1n and 2n,
// and no point sits on the threshold. The pure analog testbench is a fixed
// grid (no inserted point), so an event fires at the first point past its
// crossing and its body samples V(p) there:
//
//   t     V(p)  any (dir 0)  rise (dir +1)  fall (dir -1)
//   0     -1    0            0.0            0.0
//   1n     1    1            1.0            0.0    the rising crossing
//   2n    -1    2            1.0           -1.0    the falling crossing
//
// `any` counts firings; `rise` and `fall` keep the last sampled value (§5.10's
// event-assigned variables hold; §3.2 starts them at 0). Each want is a literal
// selected by the point (`$abstime`), so a direction that is ignored, or a
// dir 0 that fires one way only, fails at the point it gets wrong.
// event_cross_falling.va and event_cross_any.va are the single-direction and
// dc halves.
//
//! lrm 5.10.3.1
//! analysis tran
//! time 0, 1n, 2n
//! wave V(p) = -1, 1, -1
//! checks 9
//! lrm 5.10.3.1:1001
`include "check.vh"
module ch5_cross_rising_and_falling(p);
  inout p; electrical p; integer any; real rise, fall;
  analog begin
    @(cross(V(p), 0)) any = any + 1;
    @(cross(V(p), +1)) rise = V(p);
    @(cross(V(p), -1)) fall = V(p);
    `CHECKI("dir 0 fires on both crossings", any - (($abstime > 1.5n) ? 2 : ($abstime > 0.5n) ? 1 : 0), 0);
    `CHECK("dir +1 samples the rising crossing only", rise - (($abstime > 0.5n) ? 1.0 : 0.0), 0.0, 0.0);
    `CHECK("dir -1 samples the falling crossing only", fall - (($abstime > 1.5n) ? -1.0 : 0.0), 0.0, 0.0);
    I(p) <+ V(p);
  end
endmodule
