// §5.5.5: "A module is allowed to access the potential and flow of a branch in
// another module instance using an access function providing that value is
// available in the other instance." Its example:
//
//     module top; A a1(); B b1(); endmodule
//     module A; electrical n,p; branch (n,p) b; analog V(b) <+ 1.34; endmodule
//     module B; analog $strobe("voltage == %g", V(top.a1.b)); endmodule
//
// The path opens with the TOP MODULE'S name, read from inside b1: IEEE 1364
// §12.6's upward name referencing, which §6.7.1's last paragraph adopts. This
// is the legal twin of reject_5_5_5_hierarchical_access_to_missing_branch.va.
//
// Three changes, each forced by the suite's contract and none by the clause.
// The top is named `ch5_hier_named_top`, not `top`, so its path is spelled
// with that name. It has ports, which the device contract needs. And A's
// branch is between its PORTS, bound to the top's p and n, because A's
// internal nets in the example float and give its potential no digits;
// a resistor keeps the branch a real branch. With a1(n, p) binding A's n to
// the top's n and A's p to the top's p, and the bias V(p) = 0.75,
// V(n) = 0.25:
//
//     V(a1.b) = V(a1.n) - V(a1.p) = 0.25 - 0.75 = -0.5       (dyadic, exact)
//
// The check is the top's read through its own name. b1 reads the same path
// from below, the clause's shape, into a contribution on a net of its own;
// the testbench observes no number there, so what b1 pins is that the upward
// path resolves at all (it was E0901, "names nothing").
//
//! lrm 5.5.5
//! lrm 6.7.1
//! lrm 6.7.1:1
//! bias V(p) = 0.75, V(n) = 0.25
`include "check.vh"
module ch5_hier_named_a(n, p);
  inout n, p;
  electrical n, p;
  branch (n, p) b;
  analog I(b) <+ V(b) / 1k;
endmodule

module ch5_hier_named_b();
  electrical q;
  analog I(q) <+ V(ch5_hier_named_top.a1.b) / 1k;
endmodule

module ch5_hier_named_top(p, n);
  inout p, n;
  electrical p, n;
  ch5_hier_named_a a1(n, p);
  ch5_hier_named_b b1();
  analog begin
    `CHECKX("V(top.a1.b) is a1's named branch, V(n) - V(p)", V(ch5_hier_named_top.a1.b), -0.5);
  end
endmodule
