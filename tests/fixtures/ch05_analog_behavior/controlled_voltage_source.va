// §5.4.1 a voltage-controlled voltage source. Two rules:
//
//   §4.4.1  a one-argument access function is the potential of that net with
//           respect to the reference node (§1.3.1.1), so `V(c)` at V(c)=0.4 is
//           0.4 and NOT a difference against p or n.
//   §5.4.1  `V(p,n) <+ 3.0*V(c)` states V(p,n) - 3*V(c) = 0. At V(p)=1.0,
//           V(n)=0.25 the branch potential is 0.75 and the control term is
//           3*0.4 = 1.2, so the source residual is 0.75 - 1.2 = -0.45.
//
//! lrm 5.4.1
//! lrm 4.4.1
//! bias V(p) = 1.0, V(n) = 0.25, V(c) = 0.4
`include "check.vh"
module ch5_ctrl_v(p, n, c);
  inout p, n, c; electrical p, n, c;
  analog begin
    `CHECK("single-argument probe is relative to ground", V(c), 0.4, 1e-15);
    `CHECK("source residual V(p,n) - 3*V(c)", V(p, n) - 3.0 * V(c), -0.45, 1e-15);
    V(p, n) <+ 3.0 * V(c);
  end
endmodule
