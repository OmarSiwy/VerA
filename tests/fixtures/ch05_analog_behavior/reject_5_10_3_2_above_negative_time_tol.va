// §5.10.3.2 (above): "The tolerances (time_tol and expr_tol) are optional, but
// if specified shall be non-negative."
//
// time_tol is given as the constant -1n. The expression argument is legal and
// the same call with 1n compiles; a zero is also legal ("If a value of zero
// (0.0) is specified, the simulator shall apply a suitable value"), so only a
// negative value is refused.
//
// VerA reports E0517 "`above()` time_tol shall be non-negative, got
// -0.000000001". (It refuses a negative expr_tol the same way.)
//
//! lrm 5.10.3.2
//! lrm 5.10.3.2:1
//! reject-only E0517
//! neighbour event_above_tolerance.va
`include "disciplines.vams"
module ch5_above_negative_time_tol(p, n);
  inout p, n;
  electrical p, n;
  real s;

  analog begin
    s = 0.0;
    @(above(V(p, n), -1n)) s = 1.0;    // illegal: time_tol < 0
    I(p, n) <+ s;
  end
endmodule
