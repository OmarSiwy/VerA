// §5.4.3 the PORT access function. `I(<p>)` reads the flow into the module
// through port p; `I(p)` is the unnamed branch from net p to ground (§5.4.1
// Example 3). They are different quantities, so contributing `I(<p>) + V(p)`
// to `I(p)` has to read the port-branch unknown and the node potential apart
// from each other.
//
// Holding the port flow at 62.5 mA and the node at 250 mV, the port probe reads
// 0.0625 and the contributed flow is 0.0625 + 0.25 = 0.3125. Both are exact in
// IEEE 754, so exact equality is the right claim.
//
//! lrm 5.4.3
//! bias V(p) = 0.25
//! sweep flowZ28Z3cpZ3eZ29 = 0.0625
`include "check.vh"
module ch5_port_flow(p);
  inout p; electrical p;
  analog begin
    `CHECKX("port access function reads the port branch flow", I(<p>), 0.0625);
    `CHECKX("the node potential is a different quantity", V(p), 0.25);
    `CHECKX("contributed flow", I(<p>) + V(p), 0.3125);
    I(p) <+ I(<p>) + V(p);
  end
endmodule
