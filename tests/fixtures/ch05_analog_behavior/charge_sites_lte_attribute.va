// §2.9 attributes on analog statements and on a `ddt` call: VerA's `vera_lte`,
// which leaves a charge out of the host's local-truncation-error check.
//
// §2.9: "An attribute_instance can appear in the Verilog-AMS description as a
// prefix attached to a declaration, a module item, a statement, or a port
// connection. It can appear as a suffix to an operator or a Verilog-AMS
// function name in an expression." And: "If a value is not specifically
// assigned to the attribute, then its value shall be 1." A.6.4 draws the
// statement slot (`{ attribute_instance } contribution_statement`); A.8.2
// draws the name slot only for `analog_function_call`, and VerA extends it to
// `ddt`, which is the one call that names a single charge.
//
// WHY. `q` returns one charge per `ddt` site (§5.6.1.2; `contract.QStamp`), so
// a host truncation-checks each charge on its own. SPICE device truncation
// routines check some charges and not others (mos1trun.c: qgs, qgd, qgb, never
// the junctions), and the attribute is how a model states that. The rule is
// innermost wins: a `ddt`'s own suffix, then the nearest enclosing statement,
// then the default 1.
//
// THE SITES, in source order, with the rows each stamps (§1.3.1.2: a flow
// contribution adds its charge at hi and subtracts it at lo; each line lists
// its rows in the order of `U`, the ports as declared):
//
//   0  I(g,s) <+ ddt(cgs*V(g,s))       no attribute           g+ s-   lte
//   1  (* vera_lte = 0 *) I(b,s) ...   the statement's 0      s- b+   nolte
//   2  ddt (* vera_lte *) (cbd*...)    its own 1, inside a    b+ d-   lte
//      block whose prefix says 0 — the innermost wins
//   3  ddt(cbx*V(b,d)) in that block   the block's 0          b+ d-   nolte
//
// Every charge depends on a node voltage, so none is solve-invariant and each
// keeps its slot. `//! qsite` reads the device's published table.
//
// The attribute changes which charges a host CHECKS, never a value: the one
// CHECK below reads the excluded body charge, cbs*V(b,s) = 2e-12*(-0.25 - 0)
// = -5e-13, through the same expression the contribution differentiates.
//! lrm 2.9
//! lrm 2.9:3
//! lrm 5.6.1.2
//! bias V(g) = 0.5, V(s) = 0.0, V(b) = -0.25, V(d) = 1.0
//! print none
//! qsite g+ s- lte
//! qsite s- b+ nolte
//! qsite b+ d- lte
//! qsite b+ d- nolte
`include "check.vh"
module charge_sites_lte_attribute(g, s, b, d);
  inout g, s, b, d; electrical g, s, b, d;
  parameter real cgs = 1e-12, cbs = 2e-12, cbd = 3e-12, cbx = 4e-12;
  analog begin
    I(g, s) <+ V(g, s) / 1e3 + ddt(cgs * V(g, s));
    (* vera_lte = 0 *) I(b, s) <+ ddt(cbs * V(b, s));
    `CHECK("an excluded site's charge is unchanged", cbs * V(b, s), -5e-13, 1e-27);
    (* vera_lte = 0 *) begin
      I(b, d) <+ ddt (* vera_lte *) (cbd * V(b, d));
      I(b, d) <+ ddt(cbx * V(b, d));
    end
  end
endmodule
