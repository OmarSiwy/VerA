// A §5.4.3 port-flow probe of a node that a §5.6.5 collapsible short touches.
//
// §5.4.3: "I(<a>) ... the flow through the port a", entering the module. The
// only path from p to n is p -> ai (the switch: a 0 V short when rs = 0, a
// resistor rs otherwise) -> n (1000 Ohm), so with V(p) = 1 V and V(n) = 0 the
// port current is 1 / (1000 + rs): 1e-3 A at rs = 0, 5e-4 A at rs = 1000, and
// `I(<p>) * (1000 + rs)` is exactly 1 at both sweep points.
//
// What this pins beyond static_switch_elision: the port-probe row is the port
// row negated, so when the short's branch current is a guarded `jac_const`
// column (contract.JacWhen), the probe row carries that guarded constant too.
// The testbench's wide-vs-narrow gate checks it under both collapse settings.
//! lrm 5.4.3
//! lrm 5.6.5
//! solve
//! bias V(p) = 1.0, V(n) = 0.0
//! psweep rs = 0.0, 1000.0
`include "check.vh"
module static_switch_port_probe(p, n);
  inout p, n; electrical p, n, ai;
  parameter real rs = 1000.0 from [0:inf);
  analog begin
    I(ai, n) <+ V(ai, n) / 1000.0;
    if (rs > 0.0) I(p, ai) <+ V(p, ai) / rs;
    else V(p, ai) <+ 0.0;
    `CHECK("port current is the series divider's", I(<p>) * (1000.0 + rs), 1.0, 1e-12);
  end
endmodule
