// §5.10.1 "The OR-ing of events indicates the occurrence of any one of the
// events specified shall trigger the execution of the procedural statement
// following the event."
//
// Only one half of this or-list can ever fire here: V(c) is held at -1 for the
// whole run, so cross(V(c),+1) has no rising crossing to detect (and §5.10.3.1
// bars cross() from non-transient analyses besides). The timer half is
// timer(1n, 1n), whose first event is at t = 1n (§5.10.3.3). So
//
//     t = 0    neither event -> held keeps the 0.0 of §3.2
//     t = 1n   timer event   -> held = V(p) = 0.7
//     t = 2n   timer event   -> held = V(p) = 0.7
//
// and the check states that as a select on $abstime (§9.10). The breakpoint is
// the timer's own first event, 1n, and not a value that merely separates the
// declared timepoints: `held` is 0.0 on [0, 1n) and 0.7 from 1n, so `>= 1n` is
// the true partition of the run and stays right at any timepoint a tool chooses
// to add. It fails if the or-list drops its timer operand (held stays 0), and it
// fails if the or-list is treated as a conjunction (the silent cross() would
// veto the timer).
//
//! lrm 5.10.1
//! lrm 5.10.1:1
//! lrm 5.10.3.1
//! lrm 5.10.3.3
//! analysis tran
//! bias V(p) = 0.7, V(c) = -1.0
//! time 0, 1n, 2n
`include "check.vh"
module ch5_event_or(p, c);
  inout p, c; electrical p, c; real held;
  analog begin
    @(cross(V(c), +1) or timer(1n, 1n)) held = V(p);
    `CHECK("the timer half of an or-list fires on its own", held - (($abstime >= 1n) ? 0.7 : 0.0), 0.0, 1e-15);
    I(p) <+ held;
  end
endmodule
