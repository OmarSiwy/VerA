// LRM 5.2: "All the statements within the analog block shall be executed
// sequentially at a given point of time", and 5.3.1 says a begin-end block runs
// its statements "in sequence, one after another in the given order". So the
// second assignment must see what the first left behind: at V(p,n) = 0.9 - 0.25
// = 0.65 V, x is 0.65 after the first statement and 1.30 after the second.
// A block whose statements were reordered, or whose first assignment were
// dropped as dead, could not land on 1.30.
//
//! lrm 5.2
//! lrm 5.2:1
//! bias V(p) = 0.9, V(n) = 0.25
`include "check.vh"
module ch5_analog_block(p, n);
  inout p, n; electrical p, n;
  real x;
  analog begin
    x = V(p, n);
    x = x + 0.65;
    `CHECK("the second statement sees the first's result", x, 1.30, 1e-15);
    I(p, n) <+ V(p, n);
  end
endmodule
