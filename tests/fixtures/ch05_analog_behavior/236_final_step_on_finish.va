// §5.10.2: "initial_step and final_step generate global events on the first
// and the last point in an analysis respectively. final_step will also
// generate a global event upon the termination of the simulation due to a
// $finish() simulation control task."
//
// The ordinary final_step is the last point's solve, which the runner already
// marks. This fixture is the second arm: `$finish` ends the analysis at the
// first point, before any "last point" exists, so the event can only fire if
// the control task itself raises it. The CHECK lives inside the event body;
// at the normal accepted pass `sim.final_step` is false and it does not run,
// and the `$finish` re-runs the chain with the flag true before halting. A
// device that only sets final_step at the last analysis point prints nothing
// here, so `//! checks 1` fails — the transcript's one `ok=` column is the
// whole assertion.
//
//! lrm 5.10.2
//! lrm 5.10.2:1001
//! checks 1
`include "check.vh"
module ch05_final_step_on_finish(p, n);
  inout p, n; electrical p, n;
  analog begin
    @(final_step) begin
      `CHECKI("§5.10.2 final_step fired on $finish", 1, 1);
    end
    $finish;
    I(p, n) <+ V(p, n);
  end
endmodule
