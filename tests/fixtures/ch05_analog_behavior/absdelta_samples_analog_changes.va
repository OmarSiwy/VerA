// §5.10.3.4 permits absdelta in a discrete initial/always block; §7.3.5
// describes analog events in that discrete context. At delta=0 every
// observed expression change generates an event, without interpolation.
// With positive delta, event timing also depends on time_tol and expr_tol.
//
// DERIVATION: the input rises by 0.5 V per listed 5 ns interval, from
// 0 V to 2 V. The delta=0 sampler follows each observed change; delta=0.3
// is smaller than each interval's change, so it also updates repeatedly.
// These are broad VerA mixed-runner observation checks: 0.6 V for tracked
// and 0.5 V for held allow the analog point to observe the preceding
// digital update. A sampler stuck at its initial zero fails both by 20 ns.
//
// These bounds are not universal LRM timing guarantees. They use VerA's
// documented default tolerances (Vague_Decisions.md §6), with the 100 ps
// digital precision, and do not close same-point A2D/D2A visibility.
// absdelta_runtime_*.va separately exercises explicit tolerances, enables,
// reversals and the default policy. Equality at an interpolated event is
// deliberately not asserted by this analog observation fixture.
//
//! lrm 5.10.3.4
//! lrm 7.3.5
//! lrm 7.3.5:1000
//! analysis tran
//! time 0, 5n, 10n, 15n, 20n
//! wave V(e_in) = 0.0, 0.5, 1.0, 1.5, 2.0
//! lrm 5.10.3.4:1
//! lrm 5.10.3.4:1001
//! lrm 5.10.3.4:1003
//! lrm 5.10.3.4:1005
//! lrm 5.10.3.4:1009
`timescale 1ns/100ps
`include "check.vh"
module ch5_absdelta_samples(e_in, p);
  inout e_in, p;
  electrical e_in, p;
  real tracked, held;

  always @(absdelta(V(e_in), 0.0))
    tracked = V(e_in);

  always @(absdelta(V(e_in), 0.3))
    held = V(e_in);

  analog begin
    // Broad observation bounds; see the runner and tolerance scope above.
    // Bounds, not values with a band: each is a CHECKI of its inequality, so
    // a perturbed run has a want to move (`benchmark -- --perturb`).
    `CHECKI("absdelta with delta = 0 samples every timestep, so the copy follows the signal",
            abs(tracked - $abstime * 1e8) <= 0.6, 1);
    `CHECKI("absdelta with delta = 0.3 never lets the held sample drift past 0.5 V",
            abs(held - V(e_in)) <= 0.5, 1);
    I(p) <+ 1m * tracked;
  end
endmodule
