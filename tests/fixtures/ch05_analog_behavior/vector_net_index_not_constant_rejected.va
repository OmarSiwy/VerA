// §5.5.2, signal access for vector branches: "The index must be a constant
// expression, though it may include genvar variables. Genvar variables can only
// be assigned to as the iteration index of for loops; they allow signal access
// within looping constructs."
//
// `k` below is an ordinary `integer` variable, assigned at run time, so
// `I(v[k])` names no element that elaboration can pick: a vector net is one
// node per element (§3.6.3), and which node this contribution stamps would
// depend on the solve.
//
// The legal forms are a literal index (vector_access.va) and the genvar of a
// §5.9.3 analog `for` (analog_genvar_loop.va).
//
//! lrm 5.5.2
//! lrm 5.5.2:1
//! reject-only E0352
//! neighbour analog_genvar_loop.va
//! neighbour vector_access.va
`include "disciplines.vams"
module ch5_vector_net_index_not_constant(p, n);
  inout p, n; electrical p, n;
  electrical [1:0] v;
  integer k;
  analog begin
    k = 1;
    I(v[k]) <+ V(p, n);
  end
endmodule
