// §5.10.3.2: the same negative-to-positive crossing drives two above monitors.
// A zero enable preserves the default held value, while the enabled control
// samples 0.3 V. The explicit crossing discriminates an ignored enable even
// on a host that does not generate above events during a standalone DC point.
//! lrm 5.10.3.2
//! analysis tran
//! time 0, 1n, 2n
//! wave V(c) = 0.0, 1.25, 1.25
//! bias V(p) = 0.3
//! lrm 5.10.3.2:1004
`include "check.vh"
module ch5_above_enable(p, c);
  inout p, c; electrical p, c; real held, control; integer enabled;
  analog begin
    `CHECKI("an unassigned integer defaults to 0 in the analog context", enabled, 0);
    @(above(V(c) - 0.5, 1p, 1u, enabled)) held = V(p);
    @(above(V(c) - 0.5, 1p, 1u, 1)) control = V(p);
    `CHECK("enable = 0 makes above() inactive", held, 0.0, 0.0);
    if ($abstime >= 1n)
      `CHECKX("the enabled control responds to the same crossing", control, 0.3);
    I(p) <+ held;
  end
endmodule
