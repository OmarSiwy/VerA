// §5.10.3.4 permits changing delta and tolerances, but those arguments "do
// not directly trigger an absdelta() event". delta = 0 samples changed
// analog timepoints without interpolation, and ignores both tolerances.
// At 1 ns the controls change while V(p) stays zero: only initialization has
// fired at 2 ns. The 2..3 ns ramp rises 0.5 V/ns, so delta = 0.25 V is reached
// at 2.5 ns. The 1u expression window costs 2e-6 ns, plus half a 1 fs tick.
// At 3.5 ns delta becomes zero while V(p) stays 0.5 V: no new event by 4 ns.
// The next changed analog point is 5 ns and fires despite huge tolerances.
// V(q) rises to 1 V, then falls 0.05 V: that reversal is less than its 0.1 V
// tolerance. Reducing its tolerance to 0.01 V at 2.5 ns while V(q) is flat
// cannot trigger an event. Its next decrease during 3..4 ns does trigger.
// Three intermediate and four final assertions give checks = 7.
//! lrm 5.10.3.4
//! analysis tran
//! time 0, 1n, 2n, 3n, 4n, 5n
//! wave V(p) = 0.0, 0.0, 0.0, 0.5, 0.5, 1.0
//! wave V(q) = 0.0, 1.0, 0.95, 0.95, 0.8, 0.8
//! checks 7
//! lrm 5.10.3.4:1009
//! lrm 5.10.3.4:1010
`timescale 1ns/1fs
`include "check.vh"
module ch5_absdelta_dynamic_controls(p, q);
  inout p, q; electrical p, q;
  integer n, n_q;
  real delta, ttol, etol, interpolated, observed, jitter_tol;
  initial begin
    n = 0; delta = 1.0; ttol = 100n; etol = 0.1;
    n_q = 0; jitter_tol = 0.1;
    interpolated = -1; observed = -1;
    #1 begin delta = 0.25; ttol = 1p; etol = 1u; end
    #1.5 jitter_tol = 0.01;
    #1 begin delta = 0.0; ttol = 100n; etol = 100.0; end
  end
  always @(absdelta(V(p), delta, ttol, etol, 1)) begin
    n = n + 1;
    if (n == 2) interpolated = $realtime;
    if (n == 3) observed = $realtime;
  end
  always @(absdelta(V(q), 10.0, 100n, jitter_tol)) n_q = n_q + 1;
  analog begin
    if ($abstime == 2n) `CHECKI("changing controls does not create an event", n, 1);
    if ($abstime == 3n) `CHECKI("smaller tolerance does not trigger on an old reversal", n_q, 1);
    if ($abstime == 4n) `CHECKI("switching to zero delta on a flat signal is silent", n, 2);
    @(final_step) begin
      `CHECKI("initialization, positive delta, then zero delta", n, 3);
      `CHECK("runtime positive delta interpolates in ns", interpolated, 2.5, 2.5e-6);
      `CHECKX("zero delta uses the observed timepoint in ns", observed, 5.0);
      `CHECKI("the next observed change triggers the significant reversal", n_q, 2);
    end
    I(p) <+ 0.0;
    I(q) <+ 0.0;
  end
endmodule
