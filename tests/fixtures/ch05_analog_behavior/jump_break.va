// LRM 5.11: "The break statement jumps out of the loop." The loop control here
// would otherwise run i from 0 to 4, so the value of i after the loop says
// whether break was honoured: break fires on the very first pass, before the
// `i = i + 1` step of LRM 5.9.2's three-step process ever runs, so i is still 0.
// A `break` that is parsed and then ignored leaves i = 4, the value that ends
// the loop by its own test.
//
// (§5.11 permits break only in a loop and not inside an analog_for, so the loop
// is a plain LRM 5.9.2 for statement inside the analog block. The two negative
// halves of that sentence are jump_outside_loop_invalid.va and
// jump_in_analog_for_invalid.va; this file is the positive, and it passes — the
// `_unsupported` suffix it used to carry, which this directory reserves for
// constructs VerA rejects, said the reverse.)
//
//! lrm 5.11
//! lrm 5.9.2
//! lrm 5.11:1001
//! lrm 5.11:1002
`include "check.vh"
module ch5_jump(p);
  inout p; electrical p; integer i;
  analog begin
    for (i = 0; i < 4; i = i + 1) begin
      break;
    end
    `CHECKI("break left the loop before the first update of i", i, 0);
  end
endmodule
