// §5.10.3.1: "The cross() function maintains its internal state and has the
// same restrictions as analog operators. In particular, it shall not be used
// inside an if, case, casex, or casez statement unless the conditional
// expression is a genvar expression. In addition, cross() is not allowed in
// the repeat and while iteration statements. It is allowed in the analog_for
// statements."
//
// Both permissions at once: cross() inside an analog_for (§5.9.3), under an
// `if` whose condition `k == 1` is a genvar expression. The loop unrolls to two
// copies of the body, and the condition selects the copy for k = 1 only, so
// exactly ONE cross() instance exists.
//
// DERIVATION, as in event_bounds_cross_legal.va: V(p) rises from -1.0 to 0.5
// over (0, 1n) and stays positive, so it crosses zero once, rising. "the
// cross() function can only generate an event after the simulation time has
// advanced from zero", so the one instance fires once and n ends at 1. A tool
// that ignored the genvar condition would hold two instances and count 2.
//
// The legal neighbour of b3_cross_under_runtime_condition_rejected.va (the
// condition reads a probe), b3_cross_in_repeat_rejected.va and
// b3_cross_in_while_rejected.va.
//
//! lrm 5.10.3.1
//! lrm 5.9.3
//! analysis tran
//! time 0, 1n, 2n
//! wave V(p) = -1.0, 0.5, 1.0
//! checks 1
`include "check.vh"
module b3_cross_under_genvar_condition(p);
  inout p; electrical p;
  genvar k;
  integer n;
  analog begin
    for (k = 0; k < 2; k = k + 1)
      if (k == 1) @(cross(V(p), 1)) n = n + 1;
    @(final_step) `CHECKI("only the k == 1 copy of cross() exists, and it fires once", n, 1);
    I(p) <+ 0.0;
  end
endmodule
