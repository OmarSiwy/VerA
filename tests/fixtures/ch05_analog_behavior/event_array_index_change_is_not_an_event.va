// §5.10.4, Syntax 5-20/5-21: `event_identifier { dimension }` declares an
// event array and `-> hierarchical_event_identifier { [ expression ] }`
// triggers one element. "A declared event is made to occur by the activation
// of an event triggering statement ... An event is not made to occur by
// changing the index of an event array in an event control expression."
//
// THE POINTS. `//! time 0, 1, 2` is one transient analysis; `k` selects the
// element the event control `@(ev[k])` waits on and flips from 0 to 1 at t = 1.
//
//   t = 0  `-> ev[1]` (initial_step) while k = 0: `@(ev[k])` is `@(ev[0])`,
//          not triggered, so `hits` stays 0.
//   t = 1  k changes to 1 and NOTHING triggers. ev[1] occurred at t = 0, so
//          an implementation that keeps a triggered flag, or that treats the
//          new index as an occurrence, counts here. The clause says it is
//          not an event: `hits` stays 0.
//   t = 2  the timer (it fires at the first grid point past 1.5) runs
//          `-> ev[k]`, a RUNTIME subscript, with k = 1: ev[1] occurs, and
//          `@(ev[k])` counts it. `hits` is 1.
//
// `@(ev[0])` (a constant subscript) is never triggered, so `zeros` stays 0; an
// implementation that raised the whole array on `-> ev[k]` counts 1 there.
// Both counts are read at final_step, the t = 2 point.
//
//! lrm 5.10.4
//! lrm 5.10.4:2
//! lrm 5.10.4:1002
//! analysis tran
//! time 0, 1, 2
//! checks 2
`include "check.vh"
module ch05_event_array_index_change_is_not_an_event(p);
  inout p; electrical p;
  event ev[0:1];
  integer k, hits, zeros;
  analog begin
    k = ($abstime > 0.5) ? 1 : 0;
    @(initial_step) -> ev[1];
    @(timer(1.5)) -> ev[k];
    @(ev[k]) hits = hits + 1;
    @(ev[0]) zeros = zeros + 1;
    @(final_step) begin
      `CHECKI("§5.10.4 only the t = 2 trigger is an occurrence of ev[k]", hits, 1);
      `CHECKI("§5.10.4 -> ev[k] raises one element, never ev[0]", zeros, 0);
    end
    V(p) <+ 0.0;
  end
endmodule
