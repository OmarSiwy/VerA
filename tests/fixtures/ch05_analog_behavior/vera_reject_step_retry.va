// VerA's `$vera_reject_step(t_retry)` system task: on the accepted solution
// of a transient step, ask the host to reject that step and retry it ending
// at `t_retry` (`contract.UpdateResult.request_reject_at`). §2.8.3 leaves
// `$` names beyond the LRM's to the tool; this one is VerA's
// (specification/Vague_Decisions.md §6).
//
// WHY. A device that knows where its next event lies (an LTRA wavefront, a
// switch threshold) can make the host land on it instead of stepping over it.
//
// The run is t = 0, 1, 2, 3. `hit` is held (§5.10, assigned under `above`);
// the request is made while it still reads 0 past t = 1.5. Hand derivation:
//
//   t = 0, 1     $abstime <= 1.5, no request; hit = 0.
//   t = 2        hit is still 0, so the step to 2 is rejected with a retry at
//                1.5. The testbench prints this attempt, undoes it, and
//                solves t = 1.5 (dt = 0.5).
//   t = 1.5      above($abstime - 1.25) crossed 0 since t = 1: hit = 1,
//                t_hit = 1.5. No request: $abstime is not past 1.5.
//   t = 2        solved again from 1.5 (dt = 0.5): hit = 1, no request.
//   t = 3        hit = 1, t_hit = 1.5.
//
// Six printed points (0, 1, rejected 2, 1.5, 2, 3) with one verdict each:
// the retried point is the only way to print six, and t_hit = 1.5 at t = 3
// is the only way the crossing can land on 1.5 rather than on 2. Each point
// checks that t_hit is 1.5 wherever it has been set.
//! lrm 2.8.3
//! analysis tran
//! time 0, 1, 2, 3
//! checks 6
`include "check.vh"
module vera_reject_step_retry(p, n);
  inout p, n; electrical p, n;
  integer hit;
  real t_hit;
  analog begin
    I(p, n) <+ V(p, n) / 1k;
    if ($abstime > 1.5 && hit == 0) $vera_reject_step(1.5);
    `CHECKX("the crossing lands on the retried time", hit ? t_hit : 1.5, 1.5);
    @(above($abstime - 1.25)) begin hit = 1; t_hit = $abstime; end
  end
endmodule
