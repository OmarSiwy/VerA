// DEBT — this rejection is NOT conformance.
// The LRM permits what VerA refuses here. The substrings below record
// CURRENT behavior so the suite stays green on it; they do not claim it
// is right. `zig build ledger` counts this rule against VerA.
//
// VAMS-5.10.3.4-01  (ch5-analog.html)
// [absdelta] The mandatory expr and delta arguments are specified as an analog_expression and delta shall be non-negative.
// VAMS-5.10.3.4-02  (ch5-analog.html)
// [absdelta] Both the tolerances (time_tol and expr_tol) are specified as an analog_expression and shall be non-negative.
// VAMS-5.10.3.4-04  (ch5-analog.html)
// [absdelta] The enable argument is specified as an analog_expression and shall evaluate to an integer.
//
//! reject E0513
//! reject absdelta
// EXPECT: error -- absdelta is legal only in a digital initial/always block.
module ch5_absdelta(p);
  inout p; electrical p; real x;
  analog @(absdelta(V(p), 1p)) x = V(p);
endmodule
