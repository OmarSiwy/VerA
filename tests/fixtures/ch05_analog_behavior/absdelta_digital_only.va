// §5.10.3.4 on absdelta(): "This function is only allowed in an initial or
// always block of a Verilog-AMS module." An `analog` block is neither, so
// rejecting this file is conformance, not a VerA limitation — the header this
// file used to carry said the opposite.
//
// VerA's E0513 currently reads "absdelta() is not implemented", which is the
// right verdict reached by the shorter route. Should VerA ever implement
// absdelta in a digital initial/always block, this fixture must start matching
// the §5.10.3.4 placement diagnostic instead, and it will say so by failing.
//
// The other §5.10.3.4 constraints — delta and the tolerances non-negative, the
// enable argument an integer — are constraints on a legal call site and cannot
// be pinned here; they belong with a fixture that has one.
//
//! lrm 5.10.3.4
//! reject E0513
module ch5_absdelta(p);
  inout p; electrical p; real x;
  analog @(absdelta(V(p), 1p)) x = V(p);
endmodule
