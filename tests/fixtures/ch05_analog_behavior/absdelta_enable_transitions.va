// §5.10.3.4: enable = 0 makes absdelta inactive; events occur during
// initialization and "When the enable argument changes from zero to non-zero".
// V(p) stays 1 V, so no delta or reversal event can occur. The initially
// disabled monitor therefore fires only when en rises at 1 ns and 5 ns.
// Its first and last event times are exactly those digital transition times.
// The monitor with no enable argument is active and initializes once.
// Four final-step assertions give checks = 4. Invalid literal enables are
// pinned by event_bounds_absdelta_noninteger_enable_rejected.va.
//! lrm 5.10.3.4
//! lrm 5.10.3.4:1
//! analysis tran
//! time 0, 2n, 4n, 6n, 8n
//! bias V(p) = 1.0
//! checks 4
//! lrm 5.10.3.4:1005
//! lrm 5.10.3.4:1011
`timescale 1ns/1ps
`include "check.vh"
module ch5_absdelta_enable(p);
  inout p; electrical p;
  integer en, n, n_on;
  real first, last;
  initial begin
    en = 0; n = 0; n_on = 0; first = -1; last = -1;
    #1 en = 1;
    #2 en = 0;
    #2 en = 1;
  end
  always @(absdelta(V(p), 0.25, 1p, 1u, en)) begin
    n = n + 1;
    if (n == 1) first = $realtime;
    last = $realtime;
  end
  always @(absdelta(V(p), 0.25, 1p, 1u)) n_on = n_on + 1;
  analog begin
    @(final_step) begin
      `CHECKI("disabled initialization is silent; each re-enable fires", n, 2);
      `CHECKX("first enable transition time in ns", first, 1.0);
      `CHECKX("second enable transition time in ns", last, 5.0);
      `CHECKI("an enabled constant signal initializes once", n_on, 1);
    end
    I(p) <+ 0.0;
  end
endmodule
