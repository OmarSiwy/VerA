// §3.3: "A string or a string literal can be assigned directly to a string
// variable.", and §5.10's event-controlled statements run only when their
// event fires. Between
// events nothing writes the variable, so a later evaluation must read the
// value the last event left, exactly as a real or integer does
// (a03_04_block_local_is_static_between_events.va). A string never reaches
// the residual, but a §9.4 task observes it: here $strobe at every point.
//
// Points 0, 1n, 2n, 3n (tran). By hand:
//   s: declared "none"; @(initial_step) makes it "init" at 0; nothing writes
//      it at 1n; @(timer(2n, 0.0)) makes it "late" at 2n; nothing at 3n.
//      So s = "init", "init", "late", "late". A tool that holds no string
//      prints "init", then the declaration's "none" (or ""), at 1n.
//   t: @(initial_step) $sformat(t, "n=%0d", 7) gives "n=7" at 0 and, held,
//      at every later point (§9.5.3's formatted result is the same kind of
//      string value).
// 8 checks, two per point. The fixed grid puts the timer's event on the
// declared point 2n. There is no invalid input: any string may be held.
//! lrm 3.3
//! lrm 5.10
//! lrm 9.5.3
//! analysis tran
//! time 0, 1n, 2n, 3n
//! checks 8
`include "check.vh"
module string_written_in_event_body_is_held(p);
  inout p; electrical p;
  string s = "none";
  string t;
  analog begin
    @(initial_step) begin
      s = "init";
      $sformat(t, "n=%0d", 7);
    end
    @(timer(2n, 0.0)) s = "late";
    `CHECKI("s holds what the last event wrote", s == (($abstime < 1.5n) ? "init" : "late"), 1);
    `CHECKI("t holds the formatted string", t == "n=7", 1);
    I(p) <+ V(p);
  end
endmodule
