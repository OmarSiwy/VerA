// §5.8.1: "If the expression evaluates to True (that is, has a non-zero
// value), the analog statements specified" by the first arm run; §4.2.12
// picks expression2 when expression1 is true and expression3 when it is
// false.
//
// The integer flag `c` is (V(p) > -0.1) ? 1 : 0, and `if (c)` picks a
// conductance of 2.0 or 3.0, so dI/dV(p, n) is 2 or 3 depending on x. The
// device must not declare `constant.g` (tools/contract.zig `Constant`: a
// wrong promise silently freezes the Jacobian). Every arm is a constant: x
// reaches `g` only through the condition of a `?:` and then through the
// branch that chooses which assignment reaches the contribution, the path a
// claim built on the arms alone missed (#78).
//
// The testbench's const_check gate evaluates a second bias,
// x' = 1.5 x - 0.25 - 0.125 i for unknown i, and fails the run when a
// declared-constant Jacobian differs there. At the bias below V(p) = 0, so
// c = 1 and g = 2.0; at x' V(p) = -0.25 - 0.125 i <= -0.25, so c = 0 and
// g = 3.0, whichever index p has.
//
// The checks, by hand: V(p) = 0 > -0.1, so c = 1 and the `if` arm sets 2.0.
//! lrm 5.8.1
//! lrm 4.2.12
//! bias V(p) = 0.0, V(n) = 0.0
//! checks 2
`include "check.vh"
module conditional_flag_conductance_not_constant(p, n);
  inout p, n;
  electrical p, n;
  integer c;
  real g;
  analog begin
    c = (V(p) > -0.1) ? 1 : 0;
    if (c) g = 2.0; else g = 3.0;
    `CHECKI("the flag is 1 where V(p) > -0.1", c, 1);
    `CHECKX("if (c) takes its first arm", g, 2.0);
    I(p, n) <+ V(p, n) * g;
  end
endmodule
