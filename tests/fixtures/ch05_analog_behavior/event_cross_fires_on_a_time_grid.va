// §5.10.3.1 cross(): "The cross() function will not generate events for
// non-transient analyses, such as ac, dc, or noise analyses of SPICE (see
// 4.6.1)", and "cross() can only generate an event after the simulation time
// has advanced from zero". A `//! time` grid advances simulation time, so it
// is a transient analysis whether or not an `//! analysis tran` line says so;
// run as dc, the event below never fires and the latch holds its precharge.
//
// A StrongARM-style latch, no `//! analysis` line on purpose. V(clk) is 0 at
// 0 and 5 ns and 1.8 V from 7 ns on, so `V(clk) - V(vdd)/2` rises through zero
// once, strictly between the 5 ns and 7 ns points. The testbench inserts no
// point there, so the event fires at the next declared point, 7 ns, which
// §5.10.3.1 allows ("the event shall occur after the threshold crossing")
// with the box set by the tool's own tolerances. V(vinp, vinn) = 0.1 V > voff
// = 0, so the rising-edge block sets hp = 0: hp reads 1 at 0 and 5 ns and 0
// at 7 and 9 ns, and n counts exactly one event. Two checks per point. That
// the event fires at a grid point and not at its own time is W0750.
// Expectations are literal values selected by the declared sample times,
// independent of the clock expression used to detect the crossing.
//
//! lrm 5.10.3.1
//! warn W0750
//! time 0, 5n, 7n, 9n
//! wave V(clk) = 0, 0, 1.8, 1.8
//! bias V(vdd) = 1.8, V(vinp) = 0.95, V(vinn) = 0.85
//! checks 8
`include "check.vh"
module ch5_cross_on_time_grid(vinp, vinn, outp, clk, vdd);
  inout vinp, vinn, outp, clk, vdd;
  electrical vinp, vinn, outp, clk, vdd;
  parameter real voff = 0.0;
  real hp; integer n;
  analog begin
    @(initial_step) hp = 1.0;
    @(cross(V(clk) - V(vdd) / 2, +1)) begin
      hp = (V(vinp, vinn) > voff) ? 0.0 : 1.0;
      n = n + 1;
    end
    if ($abstime < 6n) begin
      `CHECKX("hp is precharged at 0 and 5 ns", hp, 1.0);
      `CHECKI("no clk edge before 7 ns", n, 0);
    end else begin
      `CHECKX("hp is latched low at 7 and 9 ns", hp, 0.0);
      `CHECKI("one rising clk edge is one event", n, 1);
    end
    I(outp) <+ (V(outp) - hp * V(vdd)) / 1e3;
  end
endmodule
