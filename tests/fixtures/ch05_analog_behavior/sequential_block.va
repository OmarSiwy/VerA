// §5.3.1 a sequential block (`begin`/`end`) executes its statements in the order
// they are written, and §5.2 makes each procedural assignment take effect before
// the next statement reads the variable. So `a = 1.0; a = a + 2.0;` must leave
// a = 3.0 — not 2.0 (the second read stale), and not 1.0 (order reversed).
//
//! lrm 5.3.1
//! lrm 5.3
//! lrm 5.3:1
`include "check.vh"
module ch5_sequential(p);
  inout p; electrical p; real a;
  analog begin
    a = 1.0;
    a = a + 2.0;
    `CHECKX("statements execute in source order", a, 3.0);
    I(p) <+ a;
  end
endmodule
