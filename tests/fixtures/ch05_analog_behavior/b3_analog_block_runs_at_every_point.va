// §5.2, verbatim: "Analog blocks shall be executed at every point in a
// simulation."
//
// A transient over four declared points, the first of which is the dc point
// that opens it (§8.4.2). The block copies the point's input into `seen` and
// asserts it, once, unconditionally, so each execution prints exactly one
// verdict:
//
//     t = 0    V(p) = 0.5      t = 2n   V(p) = 1.5
//     t = 1n   V(p) = 1.0      t = 3n   V(p) = 2.0
//
// `//! checks 4` is the rule itself: a point at which the block did not run
// prints no verdict and the count comes out short. The want, piecewise in
// $abstime with each breakpoint half-way between two declared points, is what
// makes each verdict belong to ITS point: a block skipped at 2n whose previous
// result was reported in its place would read 1.0 against a want of 1.5.
// Every wave value is exact in binary, so the tolerance is CHECKX's.
//
//! lrm 5.2
//! lrm 5.2:2
//! analysis tran
//! time 0, 1n, 2n, 3n
//! wave V(p) = 0.5, 1.0, 1.5, 2.0
//! checks 4
`include "check.vh"
module b3_analog_block_runs_at_every_point(p);
  inout p; electrical p;
  real seen;
  analog begin
    seen = V(p);
    `CHECKX("the block ran at this point and read this point's input", seen,
            ($abstime < 0.5n) ? 0.5 : ($abstime < 1.5n) ? 1.0 : ($abstime < 2.5n) ? 1.5 : 2.0);
    I(p) <+ 0.0;
  end
endmodule
