// §5.5.1: "Branch or port probe function calls shall only reference nets and
// ports that have been declared to belong to a continuous discipline".
//
// `d` is declared `logic`, the discrete discipline of disciplines.vams (domain
// discrete, no natures), so `V(d)` is a probe of a net that does not belong to
// a continuous discipline. Replacing `V(d)` with `V(p)` makes the module legal.
//
// VerA reports E0501 "`V` is not an access function of `d`": a discrete
// discipline binds no potential nature, so it has no access function at all,
// which is the form the rule takes in the discipline tables.
//
//! lrm 5.5.1
//! lrm 5.5.1:2
//! reject-only E0501
//! neighbour generic_access.va
`include "disciplines.vams"
module ch5_probe_of_discrete_net(p, n);
  inout p, n;
  electrical p, n;
  logic d;

  analog I(p, n) <+ V(d);       // illegal: d is not of a continuous discipline
endmodule
