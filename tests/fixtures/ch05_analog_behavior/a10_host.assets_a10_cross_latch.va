// §5.10.3.1 cross(), the half of the clause that is about the SIMULATOR and not
// about the model:
//
//   "In addition, cross() CONTROLS THE TIMESTEP to accurately resolve the
//    crossing."
//
//   "expr_tol and time_tol are absolute tolerances ... They represent the
//    maximum allowable error between the true crossing point and when the event
//    triggers. The event shall occur AFTER the threshold crossing, and while the
//    signal remains in the box defined by actual crossing and expr_tol and
//    time_tol."
//
// time_tol is written here as an explicit 1 us so the box has a width a deck
// can be built around: the latch must be low everywhere before the crossing and
// high by 1 us after it, whatever the deck's own step control would have
// preferred.
//
// The latched level is contributed directly, with no transition() filter, on
// purpose: a filter would smear the edge over its own rise time and the
// resulting waveform would no longer say WHEN the event happened.
// WHAT THIS FILE ASSERTS ON ITS OWN. The deck it was written for owns the
// TIMESTEP half — where the simulator chose to put an accepted point. The
// LATCH half needs no step control at all and is asserted here, on a grid the
// `//! wave` line supplies:
//
//   t        V(vin)   V(vin)-0.5   state    why
//   0        0.00     -0.50        0.0      no crossing has happened
//   1us      0.25     -0.25        0.0      still below
//   2us      0.75     +0.25        1.0      "The event shall occur AFTER the
//   3us      1.00     +0.50        1.0      threshold crossing" — and once it
//   4us      1.00     +0.50        1.0      has, `state` is a latch and holds
//
// so the want is one expression, piecewise in `$abstime`, switching at 1.5us:
// any time strictly inside the crossing interval (1us, 2us) names the same
// partition, and 1.5us is its midpoint.
//
// The grid step is the declared `time_tol` of 1us, which is what makes this
// the clause's own box and not an arbitrary sampling: the event is required to
// have fired by one time_tol past the crossing, and 2us is exactly that.
//
// `//! analysis tran` is not decoration. §5.10.3.2: "The cross() function will
// not generate events for non-transient analyses, such as ac, dc, or noise
// analyses of SPICE" — a latch that fired in a dc sweep would be a different
// defect, and a10_06_above_fires_in_dc_sweep_cross_does_not.va pins that half.
//
// time_tol is written here as an explicit 1 us so the box has a width a deck
// can be built around: the latch must be low everywhere before the crossing and
// high by 1 us after it, whatever the deck's own step control would have
// preferred.
//
// The latched level is contributed directly, with no transition() filter, on
// purpose: a filter would smear the edge over its own rise time and the
// resulting waveform would no longer say WHEN the event happened.
//
//! lrm 5.10.3.1
//! lrm 5.10.3.1:5
//! analysis tran
//! time 0, 1u, 2u, 3u, 4u
//! wave V(vin) = 0.0, 0.25, 0.75, 1.0, 1.0
//! bias V(vout) = 0.0
`include "check.vh"

module a10_cross_latch(vin, vout);
  inout vin, vout;
  electrical vin, vout;
  real state;
  analog begin
    @(cross(V(vin) - 0.5, +1, 1e-6)) state = 1.0;
    `CHECKX("the latch is low before the 0.5 V crossing and high within one time_tol of it",
        state, ($abstime > 1.5e-6) * 1.0);
    V(vout) <+ state;
  end
endmodule
