// §5.10.3.4 generates an event when expr changes direction, except changes
// smaller than expr_tol. delta = 10 V prevents delta events in this waveform.
// The rise to 1 V establishes the first direction. A fall of 0.05 V by 2 ns
// is below expr_tol = 0.1 V: no event. By 3 ns the fall is 0.2 V: one reversal.
// A rise of 0.05 V by 4 ns is again too small; by 5 ns the rise is 0.3 V,
// giving the second reversal. Thus n is 1 at 2 ns, 2 at 4 ns, and 3 finally.
// Event times are bounded by these observations, not pinned to a particular
// interpolation choice. The time_tol condition belongs to the delta trigger;
// the 100 ns value cannot suppress either direction-change event.
// Two intermediate and three final assertions give checks = 5.
//! lrm 5.10.3.4
//! analysis tran
//! time 0, 1n, 2n, 3n, 4n, 5n, 6n
//! wave V(p) = 0.0, 1.0, 0.95, 0.8, 0.85, 1.1, 1.1
//! checks 5
//! lrm 5.10.3.4:1008
`timescale 1ns/1ps
`include "check.vh"
module ch5_absdelta_reversal(p);
  inout p; electrical p;
  integer n;
  real down, up;
  initial begin n = 0; down = -1; up = -1; end
  always @(absdelta(V(p), 10.0, 100n, 0.1)) begin
    n = n + 1;
    if (n == 2) down = $realtime;
    if (n == 3) up = $realtime;
  end
  analog begin
    if ($abstime == 2n) `CHECKI("small falling excursion is ignored", n, 1);
    if ($abstime == 4n) `CHECKI("small rising excursion is ignored", n, 2);
    @(final_step) begin
      `CHECKI("initialization plus two significant reversals", n, 3);
      `CHECKI("falling reversal follows the sub-tolerance observation", down > 2.0 && down <= 3.0, 1);
      `CHECKI("rising reversal follows the sub-tolerance observation", up > 4.0 && up <= 5.0, 1);
    end
    I(p) <+ 0.0;
  end
endmodule
