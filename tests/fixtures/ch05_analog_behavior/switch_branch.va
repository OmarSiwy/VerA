// LRM 5.6.5 switch branches: contribution to a branch may be switched between a
// potential and a flow by an ordinary conditional, which is why contribution
// statements are legal inside `if`. The control branch is only probed.
//
// The assertion pins the arm the condition selects. V(c) is biased at 1.0, and
// 1.0 > 0.5 is true, so the CLOSED (potential-source) arm runs and `arm` ends at
// 1. A dropped conditional leaves it 0; the flow arm leaves it -1.
//
// The second assertion is 5.4.1: the potential of the switched branch is the
// potential difference of its two nets, 0.75 - 0.25 = 0.5, whichever arm ran.
// Both operands are exact in binary, so the difference is exact.
//
//! lrm 5.6.5
//! bias V(c) = 1.0, V(p) = 0.75, V(n) = 0.25
`include "check.vh"
module ch5_switch(p, n, c);
  inout p, n, c; electrical p, n, c;
  integer arm;
  analog begin
    arm = 0;
    if (V(c) > 0.5) begin
      arm = 1;
      V(p, n) <+ 0.0;
    end else begin
      arm = -1;
      I(p, n) <+ 0.0;
    end
    `CHECKI("V(c)=1.0 clears the 0.5 threshold, so the potential-source arm runs", arm, 1);
    `CHECKX("the switched branch potential is the node difference 0.75-0.25", V(p, n), 0.5);
  end
endmodule
