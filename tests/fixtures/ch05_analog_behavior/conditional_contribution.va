// LRM 5.8.2 conditional statement, with a contribution in each arm (LRM 5.8.4
// allows contributions as part of a conditional analog statement). The guard is
// `>=`, so at the boundary V(c) = 0 it is TRUE — LRM 4.2.5 makes the relational
// an integer 1 — and the then-arm contributes V(p) = 0.4 A rather than the
// else-arm's -0.4 A. A guard lowered as `>` would read 0 here.
//
//! lrm 5.8.2
//! lrm 5.8.4
//! bias V(c) = 0.0, V(p) = 0.4
//! lrm 5.6.5:2
`include "check.vh"
module ch5_conditional(p, c);
  inout p, c; electrical p, c;
  analog begin
    `CHECKI("V(c) >= 0.0 is true at the boundary", V(c) >= 0.0, 1);
    `CHECK("the then-arm's contributed flow", V(p), 0.4, 1e-15);
    if (V(c) >= 0.0) I(p) <+ V(p); else I(p) <+ -V(p);
  end
endmodule
