// §5.6.7.2 Indirect and direct contribution:
//
//   "Indirect contribution statements is incompatible with direct contribution
//    statements ACROSS THE SAME PAIR OF ANALOG NETS (or any of its parallel
//    branches). Once a value is indirectly assigned to a branch, it cannot be
//    contributed to using the branch contribution operator <+."
//
// The prohibition is scoped to a PAIR of nets. `indirect_and_direct.va` and
// `source_both_potential_and_flow_rejected.va` pin the refusal on the same pair;
// this file pins the other half of the scope, the permission: an indirect
// assignment and direct contributions coexist in one analog block as long as
// they target DIFFERENT pairs — even pairs that SHARE a net with the indirect
// target, and even a pair whose potential the indirect equation PROBES.
//
// Here the indirect target is (a, gnd). The direct contributions are on
// (a, b) — sharing net a with it — on (b, gnd), whose potential V(b) is the
// indirect equation's probe, on (b, c) and on (c, gnd). None is (a, gnd) or
// parallel to it, so the clause forbids none of them.
//
// THE CIRCUIT (all unknowns free):
//
//     a --[1k]-- b --[1k]-- gnd        V(a) : V(b) == 0.5   (drive a until V(b) = 0.5)
//                b --[0.25 mA source]--> c --[1k]-- gnd
//
// BY HAND.
//   the indirect equation fixes        V(b) = 0.5
//   KCL at c:  0.25e-3 = V(c)/1k   =>  V(c) = 0.25
//   KCL at b:  (V(a)-0.5)/1k = 0.5/1k + 0.25e-3
//                               =>     V(a) = 0.5 + 0.5 + 0.25 = 1.25
//
// All three are exact in binary, and V(a) = 1.25 is only reachable if the
// solver honours the indirect equation AND every direct contribution around it:
// drop the current source and V(a) is 1.0; drop the (b, gnd) resistor and it is
// 0.75.
//
//! lrm 5.6.7.2
//! lrm 5.6.7
//! lrm 5.6.7.2:1000
//! solve
`include "check.vh"
module ch5_indirect_direct_disjoint(a, b, c);
  inout a, b, c;
  electrical a, b, c;
  analog begin
    V(a) : V(b) == 0.5;
    I(a, b) <+ V(a, b) / 1000.0;
    I(b) <+ V(b) / 1000.0;
    I(b, c) <+ 0.25e-3;
    I(c) <+ V(c) / 1000.0;
    `CHECK("the indirect target settles where every direct contribution puts it", V(a), 1.25, 1e-12);
    `CHECK("the equation holds on the probed net", V(b), 0.5, 1e-12);
    `CHECK("and a direct source two branches away is untouched by the rule", V(c), 0.25, 1e-12);
  end
endmodule
