// §5.4.2 a current-controlled current source. Probing `I(sense)` makes the
// sense branch's flow a solver unknown in its own right; the output is a flow
// contribution of 2 * that unknown.
//
// The sense branch is held at 2 mA, so the CCCS output is 2 * 2m = 4 mA. The
// sense branch's own equation is `V(sense) <+ 0.0`, i.e. V(cp,cn) = 0, and at
// V(cp)=V(cn)=0 that source is already satisfied — the probe below reads the
// unknown, not the contributed 0.0.
//
// `flowZ28cpZ2ccnZ29` is `flow(cp,cn)` under the codegen's identifier mangling
// (Z28 `(`, Z2c `,`, Z29 `)`), which is what tb.zig's `ix()` looks up. `sweep`
// rather than `bias` because `bias` splits its line on commas.
//
//! lrm 5.4.2
//! sweep flowZ28cpZ2ccnZ29 = 2m
`include "check.vh"
module ch5_cccs(op, on, cp, cn);
  inout op, on, cp, cn; electrical op, on, cp, cn;
  branch (cp, cn) sense;
  analog begin
    `CHECK("flow probe reads the branch-current unknown", I(sense), 2.0e-3, 1e-18);
    `CHECK("CCCS output 2 * I(sense)", 2.0 * I(sense), 4.0e-3, 1e-18);
    V(sense) <+ 0.0;
    I(op, on) <+ 2.0 * I(sense);
  end
endmodule
