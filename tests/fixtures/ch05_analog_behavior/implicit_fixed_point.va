// §5.6.6 Implicit Contributions: "the value of the target may be expressed in
// terms of itself... Notice that I(diode) is found on both sides of the
// contribution operator. The underlying implementation of the simulator will
// find the value of I(diode) that equals the sum of the contributions made to
// it, even if the contributions are a function of I(diode) itself."
//
// The LRM's own example is the diode `I(diode) <+ is*(limexp((V(diode) -
// r*I(diode))/$vt) - 1)`, whose fixed point has no closed form and whose $vt
// depends on physical constants the LRM does not fix — nothing to write digits
// for. The same construct with a linear body does have one, and it is the
// construct that §5.6.6 is about:
//
//     I(b) = g*(V(b) - r*I(b))   =>   I(b) = g*V(b) / (1 + g*r)
//
// With V(b) = 1.0, g = 0.5, r = 2.0 that is 0.5 / 2.0 = 0.25 exactly — the
// series resistance r halves the conductance g, which is the whole point of
// writing the model implicitly rather than folding r in by hand.
//
// The operating point is placed ON the fixed point: the branch flow is swept to
// 0.25, so the contributed expression must come back as 0.25 too. That is the
// defining property of the solution and it is what the two assertions say — the
// target is readable on its own right-hand side, and there it evaluates to
// itself. A compiler that fed the right-hand-side occurrence a zero instead of
// the branch flow would compute g*V(b) = 0.5 and fail the second check.
//
//! lrm 5.6.6
//! bias V(p) = 1.0, V(n) = 0.0
//! sweep flowZ28pZ2cnZ29 = 0.25
//! lrm 5.6.6:1001
`include "check.vh"
module ch5_implicit_fixed_point(p, n);
  inout p, n; electrical p, n;
  branch (p, n) b;
  parameter real g = 0.5, r = 2.0;
  analog begin
    `CHECKX("the contribution target is readable on its own right-hand side", I(b), 0.25);
    `CHECKX("and at the fixed point the contribution reproduces it", g*(V(b) - r*I(b)), 0.25);
    I(b) <+ g*(V(b) - r*I(b));
  end
endmodule
