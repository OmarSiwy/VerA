// §5.10 a variable assigned under an event is held between evaluations, and
// §3.2 it keeps its declared type: an `integer` stays an integer however many
// joins its end-of-block value passes through.
//
//   §3.2 "Integers are stored as values of at least 32 bits"
//   §4.2.1 "Integer division truncates any fractional part toward zero."
//
// THE BUG THIS ROW PINS (ARPice docs/vera-gaps.md, module `heldint`). `k` is
// held because `@(initial_step)` assigns it. Its end-of-block value is a join
// of joins three `if`s deep. The value-typing pass typed a join from its first
// operand in a fixed two sweeps; SSA builds nested joins outer-first, so the
// outer one stayed `real`, the core returned `k` as `S`, and `updateState`
// stored that into the `i64` field: the device did not compile. The fix is a
// fixpoint (lib/ir/analysis.zig) and a store derived from the core field's own
// type (lib/backend/codegen/state.zig); the unit test beside the fixpoint is
// the shape that failed.
//
// THE DERIVATION. The three conditions are monotone in $abstime and all true
// from t = 2.5n on, so no retention question beyond §5.10's arises:
//
//     t = 0            @(initial_step): k = 0            k = 0
//     t = 1n, 2n       no event; innermost if not taken  k = 0 (held)
//     t = 3n, 4n       all three ifs taken: k = 1        k = 1
//
// `k / 2` is the integer test: §4.2.1 integer division gives 0 for k = 1,
// where a real k would give 0.5.
//
//! lrm 5.10
//! lrm 3.2
//! lrm 4.2.1
//! analysis tran
//! time 0, 1n, 2n, 3n, 4n
`include "check.vh"
module a03_held_integer_nested_joins(p, n);
  inout p, n; electrical p, n;
  integer k;
  analog begin
    @(initial_step) k = 0;
    if ($abstime > 0.5n)
      if ($abstime > 1.5n)
        if ($abstime > 2.5n)
          k = 1;
    `CHECKI("a held integer through three joins keeps its value", k, ($abstime < 2.5n) ? 0 : 1);
    `CHECKI("and stays an integer: k / 2 truncates", k / 2, 0);
    I(p, n) <+ V(p, n);
  end
endmodule
