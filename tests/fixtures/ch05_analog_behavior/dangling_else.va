// §5.8.2: "Because the else part of an if-else is optional, there can be
// confusion when an else is omitted from a nested if() sequence. This is
// resolved by always associating the else with the closest previous if() which
// lacks an else."
//
// The clause's own example, run twice with the two values of index that
// discriminate. `result` starts at the sentinel -1.0, which neither arm can
// produce, so "no arm ran" is distinguishable from "the else ran".
//
//   index = -1: the outer if is false. The else belongs to the INNER if, which
//               is inside the untaken branch, so nothing at all runs and
//               result stays -1.0. A compiler that bound the else to the OUTER
//               if would run it and read j = 5.0 — the exact value the
//               begin-end variant in dangling_else_begin_end.va produces, and
//               the reason the two fixtures are a pair.
//
//   index =  1: the outer if is true, the inner test 3 > 5 is false, so the
//               else runs and result is j = 5.0. This half proves the else is
//               reachable at all, so the -1.0 above is a binding result and not
//               a dropped statement.
//
// 3.0 and 5.0 are exact in binary; no arithmetic is performed on them.
//
//! lrm 5.8.2
//! lrm 5.8.2:1001
`include "check.vh"
module ch5_dangling_else(p);
  inout p; electrical p;
  real i, j, result_outer_false, result_outer_true;
  integer index;
  analog begin
    i = 3.0; j = 5.0;

    result_outer_false = -1.0;
    index = -1;
    if (index > 0)
      if (i > j)
        result_outer_false = i;
      else                       // else applies to preceding if
        result_outer_false = j;

    result_outer_true = -1.0;
    index = 1;
    if (index > 0)
      if (i > j)
        result_outer_true = i;
      else
        result_outer_true = j;

    `CHECKX("the else hangs on the inner if, so a false outer if runs nothing", result_outer_false, -1.0);
    `CHECKX("with the outer if true, 3 > 5 fails and that same else runs", result_outer_true, 5.0);
    I(p) <+ 0.0;
  end
endmodule
