// LRM 5.4.1 Example 2: "V(n1, n2) creates an unnamed branch from n1 to n2 ...
// and then accesses the branch potential (or the potential difference between
// n1 to n2)". At V(p)=0.9 and V(n)=0.25 that difference is 0.9 - 0.25 = 0.65 V;
// naming the nets the other way round reverses the branch, giving -0.65 V.
//
//! lrm 5.4.1
//! lrm 5.4.1:1000
//! bias V(p) = 0.9, V(n) = 0.25
`include "check.vh"
module ch5_access_two(p, n);
  inout p, n; electrical p, n;
  analog begin
    `CHECK("two-argument access is the potential difference", V(p, n), 0.65, 1e-15);
    `CHECK("reversing the arguments reverses the branch", V(n, p), -0.65, 1e-15);
    I(p, n) <+ V(p, n);
  end
endmodule
