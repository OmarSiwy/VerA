// §5.10.3.3 "The timer() function schedules an event which occurs at an
// absolute time (start_time) ... If the period is specified as greater than
// zero, the timer function schedules subsequent events at multiples of period."
//
// timer(0.0, 1n) therefore fires at t = 0, 1n, 2n, … and the body toggles
// `state`, which §3.2 starts at 0.0. Statements in an analog block run in
// order at each timepoint, so a check placed AFTER the event control sees the
// toggle that timepoint's event performed:
//
//     t = 0    first event (start_time)  -> state = 1 - 0 = 1
//     t = 1n   second event (one period) -> state = 1 - 1 = 0
//
// The want is written as a select on $abstime (§9.10) rather than two separate
// fixtures because a display task must stay unconditional; 0.5n merely
// separates the two declared timepoints. It pins BOTH halves of the rule: a
// timer that ignored start_time leaves state at 0 for t = 0, and one that
// ignored the period leaves it at 1 for t = 1n.
//
// FAILS TODAY — known VerA defect, not a wrong want. `__hit` is written in
// `updateState`, which runs on the accepted solution AFTER the timepoint has
// been evaluated, and is read back in `eval`. Every cross()/timer() event is
// therefore observed one timepoint LATE: VerA gives state = 0 at t = 0 and
// state = 1 at t = 1n, the exact mirror of §5.10.3.3's "at that time point,
// the event evaluates to True".
//
//! lrm 5.10.3.3
//! analysis tran
//! time 0, 1n
`include "check.vh"
module ch5_timer(p);
  inout p; electrical p; real state;
  analog begin
    @(timer(0.0, 1n, 1p)) state = 1.0 - state;
    `CHECK("timer(0,1n) fires at t=0 and again one period later", state - (($abstime < 0.5n) ? 1.0 : 0.0), 0.0, 0.0);
    V(p) <+ transition(state, 0.0, 1p, 2p);
  end
endmodule
