// §5.4.1: "There can be any number of named branches between any two signals."
// `a` and `b` are two DISTINCT branches over the same net pair, and §5.4.2.2
// makes both quantities of a source branch readable anywhere in the module.
//
// The potential half is easy and was all this file used to assert: §5.4.1 fixes
// each branch's potential as "the potential difference between n1 to n2", so
// with p at 0.75 V and n at 0.25 V both names read 0.5. Both operands are exact
// in binary, so the difference is exact — but a compiler that COLLAPSED the two
// declarations into one branch also reads 0.5 twice, which is precisely the
// failure the header claimed to catch and could not.
//
// The flows discriminate. Each branch is a flow source with a different value,
// and §5.4.2.2 makes the flow of a flow-source branch the value contributed to
// it, so I(a) is 3 mA and I(b) is 7 mA — two different numbers off one net
// pair, which one merged branch cannot produce. A collapsed pair reads the same
// figure for both names, whether that is 3m, 7m or their 10m sum.
//
// 3m and 7m are 3e-3 and 7e-3 (§2.6.2), neither exact in binary, so the flows
// are checked relatively; the potentials are exact and are checked as such.
//
// THE COLLAPSE THIS FILE WAS WRITTEN FOR IS GONE, and what is left is a second
// defect the old xfail reason hid. Two named branches over one pair now retain
// their values separately — `two_named_branches_retain_separately.va` pins that,
// on §5.4.3 Example 1's own `branch (a, c) i_diode, junc_cap;` shape, reading
// after the contributions. What still fails here is the POSITION of the reads:
// the four CHECKs sit above the two `<+` lines, and VerA answers a branch-flow
// read out of the accumulator as it stands at that statement, per §5.6.1.2's
// sequentially-stated retention. This file asks for §5.4.2.2's reading instead —
// "both the potential and the flow of a source branch are accessible in
// expressions anywhere in the module" — under which the flow of a flow source is
// a property of the whole block and not of a prefix of it. §9.4.1 says the same
// of the reporting: "$strobe provides the ability to display simulation data
// when the simulator has converged on a solution for all nodes". The fixture is
// not weakened to match VerA: nothing here is reordered.
//
//! lrm 5.4.1
//! lrm 5.4.2.2
//! bias V(p) = 0.75, V(n) = 0.25
//! xfail the shared accumulator is fixed (each named branch retains its own value now); what is left is that VerA lowers a branch-flow READ at its statement position, and these CHECKs precede the two `<+` lines, so §5.6.1.2's "previously retained value" is still nothing there and I(a)/I(b) read 0. §5.4.2.2's "accessible ... anywhere in the module" needs a display operand evaluated after the block (§9.4.1 converged reporting), which is a lowering change to every §9.4 task and not a branch-identity one
`include "check.vh"
module ch5_two_branches(p, n);
  inout p, n; electrical p, n;
  branch (p, n) a;
  branch (p, n) b;
  analog begin
    `CHECKX("branch a spans p,n: 0.75-0.25", V(a), 0.5);
    `CHECKX("the second named branch spans the same nets, so it reads the same", V(b), 0.5);
    `CHECKR("but a carries its own flow", I(a), 3.0e-3, 1e-15);
    `CHECKR("and b carries a different one", I(b), 7.0e-3, 1e-15);
    I(a) <+ 3m;
    I(b) <+ 7m;
  end
endmodule
