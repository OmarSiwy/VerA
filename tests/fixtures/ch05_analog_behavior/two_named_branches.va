// LRM 5.4.1: "There can be any number of named branches between any two
// signals." `a` and `b` are two DISTINCT branches over the same net pair -- `a`
// is a flow source (a 1 ohm resistor), `b` a potential source -- yet 5.4.1 fixes
// the potential of each as "the potential difference between n1 to n2", and
// 5.4.2.2 makes a source branch's potential readable anywhere in the module.
//
// So with p at 0.75 V and n at 0.25 V, BOTH named branches must read 0.5 V. A
// compiler that collapsed the two declarations, or that handed back a source
// branch's contributed value instead of the node difference, misses one of them.
// 0.75 and 0.25 are exact in binary, so the difference is exact.
//
//! bias V(p) = 0.75, V(n) = 0.25
`include "check.vh"
module ch5_two_branches(p, n);
  inout p, n; electrical p, n;
  branch (p, n) a;
  branch (p, n) b;
  analog begin
    `CHECKX("the flow-source branch a spans p,n: 0.75-0.25", V(a), 0.5);
    `CHECKX("the second named branch b spans the same nets, so it reads the same", V(b), 0.5);
    I(a) <+ V(a);
    V(b) <+ I(b);
  end
endmodule
