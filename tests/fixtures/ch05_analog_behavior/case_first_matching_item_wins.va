// §5.8.3: "The analog_case_item expressions are evaluated and compared in the
// exact order in which they are given." The selector is 2, and the first two
// items both match it: the first item is the literal 2 and the second is the
// list `1, 2`. Evaluating in source order takes the first arm and leaves x at
// 2.0; evaluating the whole set and taking the last match, or reordering the
// arms, gives 3.0. The default arm would give -1.0.
//
//! lrm 5.8.3
//! lrm 5.8.3:1001
`include "check.vh"
module ch5_case_order(p);
  inout p; electrical p; integer s; real x;
  analog begin
    s = 2;
    case (s)
      2: x = 2.0;
      1, 2: x = 3.0;
      default: x = -1.0;
    endcase
    `CHECKX("the first matching case item ran", x, 2.0);
    I(p) <+ x;
  end
endmodule
