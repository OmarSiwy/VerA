// §5.10.3.1 the direction argument of cross(): "If dir is -1, the event and
// timestep control only occur on falling edge transitions of the signal."
//
// V(p) is walked -1 -> 1 -> 2, which is a single RISING crossing of zero,
// strictly between the first two points (no point sits on the threshold, so
// the crossing is not a question of what "crossing" means at zero), and no
// falling crossing at all. A cross(V(p), -1) must therefore stay silent for the
// whole run, so the sampled `x` keeps the 0.0 a real variable starts at
// (§3.2). Had the direction argument been dropped and the event fired on any
// sign change, x would have been sampled at the rising crossing and read 1 or 2.
//
// Transient on purpose: §5.10.3.1 also says "the cross() function will not
// generate events for non-transient analyses, such as ac, dc, or noise
// analyses", so under the default dc analysis x would read 0.0 whatever the
// direction argument did and this fixture would pin nothing. The firing side
// of the same argument is event_cross_rising_and_falling.va.
//
//! lrm 5.10.3.1
//! analysis tran
//! time 0, 1n, 2n
//! wave V(p) = -1, 1, 2
`include "check.vh"
module ch5_cross_fall(p);
  inout p; electrical p; real x;
  analog begin
    @(cross(V(p), -1)) x = V(p);
    `CHECK("cross(expr,-1) ignores a rising crossing", x, 0.0, 0.0);
    I(p) <+ x;
  end
endmodule
