// §5.6.1.2 splits a contribution into a resistive part and a reactive part,
// the reactive part being the charge whose time derivative §4.5.3's ddt
// takes. `ddt(V(p, n))` below is legal source: it is an ordinary operand of
// an A.8.1 assignment pattern, the `input` array actual of a §4.7.2.3
// function call, and `first` returns it unchanged — so the branch carries the
// reactive current d/dt V(p,n), a 1 F capacitor.
//
// So the device publishes exactly one charge site, the charge V(p,n) entering
// row p with + and row n with − (§1.3.1.2, rows in `U` order, ports first):
// `//! qsite p+ n- lte`. A compiler that lowered the call as a resistive
// backward-Euler difference publishes no charge site at all, and a host's AC
// analysis sees no capacitance.
//
// The CHECK pins the other half — `first` returns element 0 of its pattern —
// on the same shape without the ddt: V(p,n) = 1.0 at the declared bias.
//
//! lrm 5.6.1.2
//! lrm 4.5.3
//! bias V(p) = 1.0, V(n) = 0.0
//! print none
//! qsite p+ n- lte
//! xfail E0503: VerA models a reactive part only when ddt is a linear factor of the contribution, and a ddt under a call is not
`include "disciplines.vams"
`include "check.vh"
module ch5_ddt_inside_array_pattern(p, n);
  inout p, n; electrical p, n;
  analog function real first;
    input [0:1] a;
    real a[0:1];
    begin
      first = a[0];
    end
  endfunction
  analog begin
    `CHECKX("first returns element 0 of its pattern", first('{V(p, n), 0.0}), 1.0);
    I(p, n) <+ first('{ddt(V(p, n)), 0.0});
  end
endmodule
