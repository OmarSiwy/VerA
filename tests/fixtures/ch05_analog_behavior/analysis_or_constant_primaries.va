// §5.8.1: "If any of the conditionally-executed statements contains an analog
// operator, the conditional expression shall be a analysis_or_constant_
// expression." A.8.3 builds that from `constant_primary`, and A.8.4 lists
// more primaries than a literal and a bare parameter:
//
//   constant_primary ::= number
//       | parameter_identifier [ [ constant_range_expression ] ]
//       | ...
//       | constant_analog_built_in_function_call
//       | ...
//       | system_parameter_identifier
//       | nature_attribute_reference
//
// Each of the four below is fixed for the whole simulation, which is the
// clause's point (§4.5.15: "terms which can not change their value during the
// course of a simulation"):
//
//   abs(c)                 constant_analog_built_in_function_call over a
//                          parameter (A.8.2: `analog_built_in_function_name (
//                          constant_expression ...)`)
//   ca[1]                  parameter_identifier [ constant_range_expression ]
//   $mfactor               system_parameter_identifier, §9.18 Syntax 9-13
//   p.potential.abstol     nature_attribute_reference ::= net_identifier .
//                          potential_or_flow . nature_attribute_identifier
//
// so the `ddt` under their conjunction is legal, and E0514 was wrong to refuse
// it. The illegal side, a probe in the condition, is
// conditional_ddt_contribution_invalid.va.
//
// THE NUMBERS. c = 1n, ca = '{1n, 2n}, $mfactor = 1 (§6.3.6: no instance
// specifies one), and Annex D's disciplines.vams gives the Voltage nature
// `abstol = 1e-6`. Every term is positive, so the then-arm runs: the branch is
// §4.5.3's capacitor on a 1 V/ns ramp,
//
//     I(cap) = c · 1e9 = 1 A        at t = 1n, 2n, 3n,  and 0 at the dc point
//
// (the same derivation as conditional_ddt_contribution_static.va). The else
// arm would read 0 everywhere.
//
//! lrm 5.8.1
//! lrm 4.5.15
//! lrm A.8.4
//! lrm 4.5.15:1
//! lrm 5.8.1:1
//! lrm A.8.4:1000
//! bias V(n) = 0
//! wave V(p) = 0, 1, 2, 3
//! time 0, 1n, 2n, 3n
//! analysis tran
//! print none
`include "disciplines.vams"
`include "check.vh"
module ch5_analysis_or_constant_primaries(p, n);
  inout p, n;
  electrical p, n;
  branch (p, n) cap;
  parameter real c = 1n from (0:inf);
  parameter real ca[0:1] = '{1n, 2n};
  analog begin
    if (abs(c) > 0.0 && ca[1] > 0.0 && $mfactor > 0.0 && p.potential.abstol > 0.0)
      I(cap) <+ c * ddt(V(cap));
    else
      I(cap) <+ 0.0;
    `CHECK("a ddt under four A.8.4 constant primaries is the capacitor's c*dV/dt",
           I(cap), ($abstime > 0) * 1.0, 1e-9);
  end
endmodule
