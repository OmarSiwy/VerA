// §5.6.1.3 Value retention, Example 2 — the LRM prints this module and states
// the answer: "The value retention rules specify that the example below will
// result in an assignment of 7.0 to the potential source for the unnamed branch
// between ports p and n."
//
// The four contributions are the clause's own, comments and all:
//
//   V(p,n) <+ 1.0   nothing retained yet, so 1 is retained as a potential
//   I(p,n) <+ 2.0   "contributing a flow to a branch which already has a value
//                    retained for the potential results in the potential being
//                    discarded and the branch being converted to a flow source"
//   V(p,n) <+ 3.0   and conversely: the flow of 2 is discarded, 3 retained
//   V(p,n) <+ 4.0   same kind as what is retained, so "multiple contributions
//                    to the same potential branch will be additive": 3 + 4 = 7
//
// 7.0, not 8.0. A compiler that accumulated every potential contribution and
// ignored the two conversions reads 1 + 3 + 4 = 8.0, which is the single digit
// this whole clause exists to rule out. Every value is an integer held exactly
// in a real, so nothing rounds.
//
// §5.4.2.2 makes the potential of a source branch readable anywhere in the
// module, which is what the assertion does. The two files that head themselves
// 5.6.1.3 — implicit_zero_contribution.va and retained_conditional_contribution.va
// — test §5.4.4's unassigned switch arm instead; this is the clause's numeric
// rule, and nothing in the tree carried it.
//
//! lrm 5.6.1.3
//! xfail VerA's retention arithmetic is now right — the emitted device carries ONE source, a potential of 0+3+4, with the discarded flow of 2.0 gone — but the assertion needs a CONVERGED solution: V(p,n) is the node difference (§5.4.1), and tb.zig writes the `//! bias` values straight into x[] without a Newton loop, so the retained 7.0 never reaches the nodes and V(p,n) reads 0
`include "check.vh"
module ch5_value_retention(p, n);
  inout p, n;
  electrical p, n;
  analog begin
    V(p,n) <+ 1.0; // no previously-retained value, 1 is retained
    I(p,n) <+ 2.0; // potential discarded; flow of 2 retained
    V(p,n) <+ 3.0; // flow discarded; potential of 3 retained
    V(p,n) <+ 4.0; // 4 added to previously-retained 3
    `CHECKX("the retained potential is 3 + 4, not 1 + 3 + 4", V(p,n), 7.0);
  end
endmodule
