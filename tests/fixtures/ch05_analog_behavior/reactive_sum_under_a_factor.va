// §5.6.1.2 separates a contribution into its resistive part and its reactive
// part, the latter being the charge (or flux) whose time derivative the branch
// carries. §4.5.3 defines ddt as "the time derivative of its argument" — a
// derivative, so it is linear:
//
//     c * (ddt(a) + ddt(b))  =  c * ddt(a + b)  =  d/dt [ c * (a + b) ]   (c constant)
//
// and the second form is plainly a charge c*(a + b). Nothing in §5.6.1.2 or
// §4.5.3 asks the source to distribute the factor by hand first; E0503 refused
// both lines below although each has exactly the charge the expanded spelling
// `c*ddt(a) + c*ddt(b)` has.
//
// THE NUMBERS. V(p) ramps 1 V/ns and V(q) 2 V/ns (the two `//! wave` lines),
// V(n) is held at 0. As a02_04 derives, §4.5.3 makes ddt 0 at the DC point and
// the harness's backward-Euler difference over a uniform 1 ns step is exactly
// the ramp slope after it: dV(p)/dt = 1e9 V/s, dV(q)/dt = 2e9 V/s.
//
//   b1: 1e-12 * (ddt(V(p)) + ddt(V(q)))     = 1e-12 * (1e9 + 2e9)    = 3e-3 A
//   b2: 1e-12 * -(ddt(V(p)) - ddt(V(q)))    = 1e-12 * -(1e9 - 2e9)   = 1e-3 A
//
// both 0 at t = 0. The relative tolerance is a few ulps of the 1/1e-9 step.
//
//! lrm 5.6.1.2
//! lrm 4.5.3
//! bias V(n) = 0
//! wave V(p) = 0, 1, 2, 3
//! wave V(q) = 0, 2, 4, 6
//! time 0, 1n, 2n, 3n
//! analysis tran
//! print none
`include "check.vh"
module ch5_reactive_sum_under_a_factor(p, q, n);
  inout p, q, n;
  electrical p, q, n;
  branch (p, n) b1;
  branch (q, n) b2;
  analog begin
    I(b1) <+ 1e-12 * (ddt(V(p)) + ddt(V(q)));
    I(b2) <+ 1e-12 * -(ddt(V(p)) - ddt(V(q)));
    `CHECKR("a factor over a sum of ddt terms scales both charges",
            I(b1), ($abstime > 0) * 3e-3, 1e-9);
    `CHECKR("and over a difference, under a sign",
            I(b2), ($abstime > 0) * 1e-3, 1e-9);
  end
endmodule
