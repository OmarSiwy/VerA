// LRM 5.8.1 if-else-if statement: the conditional statement executes the first arm whose expression is
// true and NO other. The chain here is `if (V(c) > 1.0) ... else if (V(c) > 0.0)
// ... else ...`, and at V(c) = 1.5 BOTH guards are true — so x is what tells
// "first match wins" apart from "last match wins" or a mis-associated else.
// First match wins, so x = 2.0; the other association leaves 1.0, and taking no
// arm at all leaves the LRM 3.2 initial 0.0.
//
//! lrm 5.8.1
//! lrm 5.8.1:2
//! lrm 5.8.2
//! lrm 5.8.2:3
//! bias V(c) = 1.5
`include "check.vh"
module ch5_if_else(p, c);
  inout p, c; electrical p, c; real x;
  analog begin
    if (V(c) > 1.0) x = 2.0;
    else if (V(c) > 0.0) x = 1.0;
    else x = 0.0;
    `CHECKX("both guards true: the FIRST arm is the one taken", x, 2.0);
    I(p) <+ x;
  end
endmodule
