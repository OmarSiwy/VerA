// §5.10.3.1 requires time_tol when expr_tol is supplied. It also permits
// time_tol alone, and its `sh` example omits both tolerances before enable.
// Run all three forms. The tolerances here are model parameters, which the
// argument grammar permits as analog expressions.
//
// DERIVATION: V(p) rises from -1 to 0.5 V over 0..1 ns, crossing zero once
// at 2/3 ns, and then remains positive. Each enabled rising monitor therefore
// fires once by 2 ns. The supplied 1 ns and 1 V tolerances contain the grid
// point at 1 ns (1/3 ns late, 0.5 V above zero). Three final-step assertions
// compare each independent counter to the one crossing, so checks = 3.
//! lrm 5.10.3.1
//! lrm 5.10.3.1:1
//! analysis tran
//! time 0, 1n, 2n
//! wave V(p) = -1.0, 0.5, 1.0
//! checks 3
`include "check.vh"
module event_bounds_cross_legal(p);
  inout p; electrical p;
  parameter real ttol = 1n, etol = 1.0;
  integer both, time_only, omitted;
  analog begin
    @(cross(V(p), 1, ttol, etol)) both = both + 1;
    @(cross(V(p), 1, ttol)) time_only = time_only + 1;
    @(cross(V(p), 1, , , 1)) omitted = omitted + 1;
    @(final_step) begin
      `CHECKI("cross with both tolerances fires", both, 1);
      `CHECKI("cross with time_tol alone fires", time_only, 1);
      `CHECKI("cross with both tolerances omitted fires", omitted, 1);
    end
    I(p) <+ 0.0;
  end
endmodule
