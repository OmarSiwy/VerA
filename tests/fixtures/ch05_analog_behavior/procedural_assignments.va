// §5.2 procedural assignment: the right-hand side is evaluated and stored in the
// variable at once, so a later statement reads the stored value. §4.2.5 makes a
// relational operator yield the INTEGER 1 when true and 0 when false — not an
// arbitrary nonzero — which is what makes `select` usable as the `?:` chooser.
//
// At V(p) = 0.75: x = 1.5 (exact, 0.75 is a dyadic rational), select = 1 because
// 1.5 > 0, and the conditional's true arm is x itself.
//
//! lrm 5.7
//! lrm 5.7:1
//! bias V(p) = 0.75
//! lrm 5.7:1002
`include "check.vh"
module ch5_proc_assign(p);
  inout p; electrical p; real x; integer select;
  analog begin
    x = V(p) * 2.0;
    select = x > 0.0;
    `CHECKX("procedural assignment stores the probed expression", x, 1.5);
    `CHECKI("a true relational is exactly 1", select, 1);
    `CHECKI("a false relational is exactly 0", -x > 0.0, 0);
    `CHECKX("the conditional selects the true arm", select ? x : 0.0, 1.5);
    I(p) <+ select ? x : 0.0;
  end
endmodule
