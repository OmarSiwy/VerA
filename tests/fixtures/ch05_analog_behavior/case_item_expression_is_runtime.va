// §5.8.3: "The analog_expression and the analog_case_item expression can be
// computed at runtime; neither expression is required to be a constant
// expression." The selector and both items below are computed from `V(sel)`,
// a probe of the solution, which the harness drives to 1.0 at t = 0 and 2.0 at
// t = 1n. At 1 V the second item, 2.0 - V(sel) = 1.0, matches (x = 2.0); at
// 2 V neither item matches and default runs (x = 5.0). A tool that required
// case items to be elaboration-time constants would refuse the module; one that
// evaluated an item at the wrong time, or against the wrong selector, picks the
// wrong arm at one of the two points. The want is written per declared time.
//
//! lrm 5.8.3
//! lrm 5.8.3:1003
//! time 0, 1n
//! wave V(sel) = 1.0, 2.0
`include "check.vh"
module ch5_case_runtime_item(sel);
  inout sel; electrical sel; real x;
  analog begin
    case (V(sel))
      V(sel) + 1.0: x = -1.0;
      2.0 - V(sel): x = 2.0;
      default: x = 5.0;
    endcase
    `CHECKX("the runtime item matches at 1 V and misses at 2 V",
            x, ($abstime < 0.5n) ? 2.0 : 5.0);
    I(sel) <+ 0.0;
  end
endmodule
