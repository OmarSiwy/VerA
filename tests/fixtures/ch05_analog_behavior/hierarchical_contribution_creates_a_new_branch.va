// §5.6.8.1 Contributions to branches between hierarchical nets:
//
//   "Direct contribution statements can contribute to a branch between
//    combinations of local and hierarchical nets.
//
//    In these cases, A NEW UNNAMED BRANCH IS CREATED IN THE MODULE CONTAINING
//    THE DIRECT CONTRIBUTION STATEMENTS."
//
// The same sentence is in §5.5.4 for the probe form. It is what makes §5.4.1's
// "there can only be one unnamed branch between any two nets" a PER-MODULE rule:
// the child's unnamed branch (x,y) and the parent's unnamed branch (drv.x,drv.y)
// are two branches in parallel between the same node pair, not one branch two
// modules take turns writing to. That distinction is the entire difference
// between §5.6.8.1 and §5.6.8.2, which is about contributing to the branch the
// child already owns and gets its own fixture here (09).
//
// THE CIRCUIT. The child owns a 1 kohm conductance between x and y and a 1 kohm
// load from y to ground, and pins x at 3 V. The parent, from outside, hangs a
// 1.2 V source across the same node pair:
//
//     x  o---+----[ child: I(x,y) <+ V(x,y)/1k ]----+---o y ---[ 1k ]--- gnd
//       3 V  |                                      |
//            +----[ parent: V(drv.x,drv.y) <+ 1.2 ]-+
//
// BY HAND. The parent's source pins V(x,y) = 1.2, and the child pins V(x) = 3.0,
// so V(y) = 1.8 V — and that much is true under BOTH readings, which is why the
// node voltage alone cannot settle the question. The branch flows can:
//
//   child's own branch     I(x,y)          = V(x,y)/1000 = 1.2/1000 = 1.2 mA
//   the 1k load at y       V(y)/1000       = 1.8/1000    = 1.8 mA
//   parent's new branch    by KCL at y     = 1.8 - 1.2   = 0.6 mA
//
// Two independent numbers, 1.2 mA read inside the child and 0.6 mA read in the
// parent, and §5.4.2.2 makes both readable because each branch is a source in
// the module that reads it.
//
// WHAT MERGING ANSWERS. Fold the two into one branch and §5.6.1.3's value
// retention applies across the module boundary: the parent's potential
// contribution discards the child's retained flow, the 1 kohm conductance
// disappears from the matrix entirely, and the single surviving branch carries
// the load current 1.8 mA. That is 1.8, not 1.2 and not 0.6 — no reading of a
// merged network produces this fixture's pair.
//
// OBSERVED TODAY: merged. `x[flowZ28drvZ2exZ2cdrvZ2eyZ29] = 1.8e-3`, the child's
// `I(x,y)` reads 0, and `d res[drv.x]/d x[drv.x]` carries no 1e-3 conductance
// term at all — the child's own equation was thrown away by a statement in
// another module.
//
//! lrm 5.6.8.1
//! lrm 5.6.8
//! lrm 5.4.1
//! lrm 5.6.1.3
//! bias V(g) = 0.0
//! solve
//! lrm 5.6.8.1:1001
`include "check.vh"
module a02_hier_new_branch(g);
  inout g;
  electrical g;
  a02_hier_new_branch_child drv(g);
  analog begin
    // §5.6.8.1's own second example, `V(top.drv.x, top.drv.y) <+ 1.2;`, with
    // the path made resolvable by instantiating the child here.
    V(drv.x, drv.y) <+ 1.2;
    `CHECK("the branch this statement created carries what KCL leaves for it",
           I(drv.x, drv.y), 0.6e-3, 1e-12);
    I(g) <+ 0.0;
  end
endmodule

module a02_hier_new_branch_child(b);
  inout b;
  electrical b, x, y;
  analog begin
    V(x) <+ 3.0;
    I(x, y) <+ V(x, y)/1000.0;
    I(y) <+ V(y)/1000.0;
    I(b) <+ 0.0;
    `CHECK("the child's own branch keeps its own constitutive law", I(x, y), 1.2e-3, 1e-12);
    `CHECK("and the parallel source fixes the node either way", V(y), 1.8, 1e-12);
  end
endmodule
