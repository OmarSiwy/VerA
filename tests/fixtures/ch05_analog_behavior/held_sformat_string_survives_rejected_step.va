// §5.10 and §3.3: a string assigned in an event body is held between events,
// as a real or an integer is (string_written_in_event_body_is_held.va); §9.5.3
// makes a `$sformat` result an ordinary string value. §9.3: a call "during an
// iteration that is rejected should cause no side-effects on the next
// iteration". So when a step is rejected, the held string reads afterwards
// what the last ACCEPTED event formatted (#19: it was a slice of the
// `$sformat` site's buffer, and the rejected attempt, every Newton iterate
// and the next firing all rewrote that buffer under it).
//
// VerA's `$vera_reject_step(t_retry)` (specification/Vague_Decisions.md §6) rejects a
// step from its own accepted solution: the testbench undoes the step, solves
// and accepts t_retry, then solves the rejected time again.
//
// The run is t = 0, 1, 2, 3. @(timer(1, 1)) fires at 1, 2, 3 (§5.10.3.3:
// start time 1, period 1) and formats 10*$abstime with %g: "10", "20", "30",
// all two characters, so a held slice that kept its length but lost its
// bytes reads a wrong two-character text rather than a short one. `hit` is
// held (assigned under `above`) and still 0 past t = 1.5, so the step to 2 is
// rejected with a retry at 1.5, exactly as in vera_reject_step_retry.va.
// The check reads `s` BEFORE this evaluation's timer statement, so it sees
// the held value, the text of the last accepted firing:
//
//   t = 0        nothing fired yet: the declared "none".
//   t = 1        the timer fires after the check: still "none".
//   t = 2        rejected attempt; held from t = 1: "10".
//   t = 1.5      the retry; the attempt's "20" was undone: "10".
//                (No firing at 1.5: the next is due at 2.)
//   t = 2        solved again from 1.5: "10".
//   t = 3        held from the accepted t = 2: "20".
//
// Six printed points, one verdict each. There is no invalid input: any
// string may be held, and $vera_reject_step's refusals have their own
// fixtures (reject_vera_reject_step_analog_initial.va).
//! lrm 3.3
//! lrm 5.10
//! lrm 9.5.3
//! analysis tran
//! time 0, 1, 2, 3
//! checks 6
`include "check.vh"
module held_sformat_string_survives_rejected_step(p, n);
  inout p, n; electrical p, n;
  integer hit;
  string s = "none";
  analog begin
    I(p, n) <+ V(p, n) / 1k;
    if ($abstime > 1.5 && hit == 0) $vera_reject_step(1.5);
    `CHECKI("the held string is the last accepted text",
            s == (($abstime < 1.25) ? "none" : ($abstime < 2.5) ? "10" : "20"), 1);
    @(above($abstime - 1.25)) hit = 1;
    @(timer(1, 1)) $sformat(s, "%g", 10 * $abstime);
  end
endmodule
