// LRM 5.2.1: the analog initial block "is executed once for each analysis",
// before a matrix solution exists — so its assignment is already visible to the
// analog block that follows. LRM 3.2 starts a real at 0, so a `gain` that
// read 0 here would mean the initial block never ran or ran too late. At
// V(p) = 0.3 the contributed flow is 2.0 * 0.3 = 0.6 A.
//
// ONCE PER ANALYSIS, NOT ONCE PER EVALUATION. A timer at 0.5n sets `gain` to
// 3.0 in an event body (§5.10, so it holds). The fixed grid fires it at the
// first point past 0.5n, which is 1n. At 2n no event fires: if the analog
// initial block ran again on every evaluation, it would have put gain back to
// 2.0; run once for the transient, it leaves 3.0. So gain reads 2.0 at 0 and
// 3.0 at 1n and 2n, and the flow is 0.6 A, then 0.9 A.
//
//! lrm 5.2.1
//! analysis tran
//! time 0, 1n, 2n
//! bias V(p) = 0.3
//! lrm 5.2.1:1003
`include "check.vh"
module ch5_analog_initial(p);
  inout p; electrical p; real gain;
  analog initial gain = 2.0;
  analog begin
    @(timer(0.5n)) gain = 3.0;
    `CHECKX("analog initial ran before the analog block, once", gain - (($abstime > 0.5n) ? 3.0 : 2.0), 0.0);
    `CHECK("contributed flow", gain * V(p) - (($abstime > 0.5n) ? 0.9 : 0.6), 0.0, 1e-15);
    I(p) <+ gain * V(p);
  end
endmodule
