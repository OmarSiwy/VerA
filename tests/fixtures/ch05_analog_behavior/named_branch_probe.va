// LRM 3.6.3 / 5.4: `branch (p, n) path;` names the branch between p and n, and a
// probe of that branch is the potential of the FIRST net minus the second —
// V(path) is V(p) - V(n), not the other way round. At V(p) = 1.0 and V(n) = 0.25
// that is 0.75; the reversed orientation would read -0.75, and a probe that
// ignored n would read 1.0.
//
//! lrm 5.4.1
//! lrm 3.6.3
//! bias V(p) = 1.0
//! bias V(n) = 0.25
`include "check.vh"
module ch5_named_probe(p, n);
  inout p, n; electrical p, n; branch (p, n) path;
  analog begin
    `CHECKX("V(path) is V(p) - V(n), in that order", V(path), 0.75);
    V(path) <+ 10.0 * I(path);
  end
endmodule
