// LRM 5.6.2.1, the four controlled sources: a VCCS is `I(out) <+ Gm*V(in)` --
// the flow of the output branch is a source, the input branch only a probe.
//
// Gm here is written `2m`, which LRM 2.6 defines as the scale factor m = 1e-3,
// so Gm = 2e-3 S. The control branch is biased at 0.75 - 0.25 = 0.5 V, so the
// sourced current is 2e-3 * 0.5 = 1e-3 A. Read `2m` as 2e-6 or 2e6 -- or drop
// the second control net and probe V(cp) alone -- and the number moves by
// decades, which is why the tolerance is relative.
//
// The output is biased away from zero on purpose: the input branch is only
// probed, so V(op) must not enter the transconductance at all.
//
//! lrm 5.6.2.1
//! bias V(cp) = 0.75, V(cn) = 0.25, V(op) = 0.4
`include "check.vh"
module ch5_vccs(op, on, cp, cn);
  inout op, on, cp, cn; electrical op, on, cp, cn;
  real ig;
  analog begin
    ig = 2m*V(cp, cn);
    `CHECKR("2 mS across a 0.5 V control branch sources 1 mA", ig, 1e-3, 1e-15);
    I(op, on) <+ ig;
  end
endmodule
