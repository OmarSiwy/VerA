// §1.3.1.1: "The ground node ... is the global reference node, and its potential
// is zero." It is a NODE, not a spelling: §3.6.5's `ground` declaration is the
// only thing that makes a net the reference, and §2.7 lets any net be called
// `gnd`. So `I(a)` — which §5.4.1 says is the branch from `a` to the reference —
// and `I(a,gnd)` — the branch from `a` to the net declared here as `gnd` — are
// two DIFFERENT branches carrying two different flows, and §5.4.2.2 makes both
// readable.
//
// The circuit is the smallest one where they are forced apart. Two potential
// sources hang off `a`: one to the reference (V(a) <+ 1.0) and one to the net
// `gnd` (V(a,gnd) <+ 2.0), so V(gnd) = 1 - 2 = -1 V. A 1 kΩ resistor ties `gnd`
// to the reference. KCL (§1.3.1) then fixes both flows with no iteration:
//
//   at `gnd`:  the resistor carries V(gnd)/1k = -1 mA out to the reference, and
//              the only other branch at that node is (a,gnd), so I(a,gnd) = -1 mA;
//   at `a`:    its two branches are all there is, so I(a) = -I(a,gnd) = +1 mA.
//
// Two flows of equal magnitude and OPPOSITE sign is the discrimination: any
// compiler that gives them one unknown reads the same number twice, whatever
// that number is. 1e-3 is not exact in binary, hence `CHECK` with an absolute
// tolerance well under the difference being claimed.
//
// WHY THIS IS NOT `//! reject`: nothing in the LRM forbids a net called `gnd`,
// so demanding a diagnostic would invert the fixture (README.md, "Written the
// other way ... a conforming compiler fails it, and only VerA passes"). Every
// `want` below is a number derived from the clauses cited above, not a
// transcript of what VerA prints.
//
// It SHIPPED as `//! xfail`, and the reason was one sentence: two spellings,
// one unknown. Wave 11 split node identity from node spelling — a §5.4.2 branch
// is keyed on its NODE PAIR in `lower.flow_unknowns`, and codegen asks that
// table rather than re-deriving `flow(a,gnd)` and matching it as a string — so
// the last two CHECKs now hold and the marker is gone.
//
// SCOPE: dc only, and it stands on no TODO.md §3 ceiling.
//
//! lrm 1.3.1.1
//! lrm 5.4.1
//! lrm 5.4.2.2
//! lrm 1.3.1
//! lrm 1.3.1:1
//! lrm 1.3.2
//! lrm 1.3.2:1000
//! analysis dc
//! solve
`include "check.vh"
module ch5_gnd_named_net;
  electrical a;
  electrical gnd; // a plain net that happens to be spelled `gnd`; NOT declared `ground`
  real i_ref, i_gnd;
  analog begin
    V(a)     <+ 1.0;
    V(a,gnd) <+ 2.0;
    I(gnd)   <+ V(gnd) / 1000.0;
    i_ref = I(a);     // §5.4.1 the branch (a, reference)
    i_gnd = I(a,gnd); // the branch (a, net `gnd`) — a different branch
    `CHECK("the source to the reference sets V(a)", V(a), 1.0, 1e-12);
    `CHECK("the second source sets V(gnd) = 1 - 2", V(gnd), -1.0, 1e-12);
    `CHECK("KCL at `a`: I(a) = -I(a,gnd) = +1 mA", i_ref, 1.0e-3, 1e-12);
    `CHECK("KCL at `gnd`: I(a,gnd) = V(gnd)/1k = -1 mA", i_gnd, -1.0e-3, 1e-12);
  end
endmodule
