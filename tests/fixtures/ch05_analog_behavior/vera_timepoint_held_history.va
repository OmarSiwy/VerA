// §2.9 VerA's `vera_timepoint` statement over a §5.10 held array: the shape of
// a lossy line's history (ESPice's txl.va, coupled_ltra.va). The statement
// commits the point accepted last into the history, then walks the history;
// every later evaluation at the timepoint reads both back from the cache.
//
// §5.10: an evaluation starts every held variable from what the last
// ACCEPTED evaluation left. The bookkeeping after the statement runs on every
// evaluation and is kept only for an accepted one: it stages that point's
// time (`tacc`) and value (`sv = 2 tacc`) for the next timepoint to commit.
// Each statement store is a store into a held array inside a cached
// statement, which a device writes straight into the cache slot (#82).
//
// The hand derivation, on the grid t_k = k/2, k = 0..4. The first point
// stages t_0; the point at t_k (k >= 1) commits t_{k-1}, so nh = k entries,
// hv[j] = 2 t_j, and s = sum_{j<k} 2 t_j = sum_{j<k} j = k(k-1)/2. With
// k = 2t: nh = 2t and s = t (2t - 1):
//       t  = 0, 0.5, 1, 1.5, 2
//       nh = 0, 1,   2, 3,   4
//       s  = 0, 0,   1, 3,   6
// and the newest entry, for nh > 0, is the point before: ht[nh-1] = t - 0.5,
// hv[nh-1] = 2 (t - 0.5). The values change from point to point, so they are
// asserted with CHECKEQ against their formula in $abstime. Five verdicts at
// five points.
//! lrm 2.9
//! lrm 5.10
//! analysis tran
//! time 0, 0.5, 1, 1.5, 2
//! checks 25
`include "check.vh"
module vera_timepoint_held_history(p, n);
  inout p, n; electrical p, n;
  integer nh, i, staged;
  real ht[0:2047], hv[0:2047];
  real tacc, sv, s;
  analog begin
    (* vera_timepoint *) begin
      if (staged) begin
        ht[nh] = tacc;
        hv[nh] = sv;
        nh = nh + 1;
        staged = 0;
      end
      s = 0.0;
      for (i = 0; i < nh; i = i + 1) s = s + hv[i];
    end
    I(p, n) <+ V(p, n) / 1k + 1u * s;
    `CHECKEQ("nh = 2t entries", nh, 2.0 * $abstime, 0.0);
    `CHECKEQ("s = t (2t - 1)", s, $abstime * (2.0 * $abstime - 1.0), 0.0);
    `CHECKEQ("newest time ht[nh-1] = t - 0.5", (nh > 0) ? ht[nh - 1] : -0.5, $abstime - 0.5, 0.0);
    `CHECKEQ("newest value hv[nh-1] = 2 (t - 0.5)", (nh > 0) ? hv[nh - 1] : -1.0, 2.0 * ($abstime - 0.5), 0.0);
    `CHECKEQ("an entry past the history is still zero", hv[nh], 0.0, 0.0);
    staged = 1;
    tacc = $abstime;
    sv = 2.0 * $abstime;
  end
endmodule
