// §5.2.1 "Additionally, digital values cannot be accessed from the analog
// initial block as they have not yet been assigned when the analog initial
// block is executed." The read of `digital_value` on the last line is that
// error, and it is the only rule this fixture pins.
//
// Everything the error depends on is legal Verilog-AMS: `reg` (A.2.1.3) and the
// digital `initial` block (A.6.2) are both in the language, and there is no way
// to write "a digital value read from an analog initial block" without them.
// A conforming AMS compiler must therefore accept the declarations and reject
// the read. The sibling fixtures analog_initial_access_rejected.va,
// analog_initial_contribution.va and analog_initial_event_rejected.va cover the
// other three §5.2.1 restrictions, which need no digital constructs at all.
//
// The expectation is prose rather than a code because VerA has no code for a
// rule it cannot reach: it is a Verilog-A compiler, it has no digital-owned
// values, and it stops at `reg`. That is the xfail, and it is a real gap in
// coverage of §5.2.1 rather than a fixture defect — the previous version of
// this file demanded E0205 and so asserted VerA's refusal of legal AMS syntax.
//
//! lrm 5.2.1
//! reject analog initial
//! reject digital
//! xfail VerA has no digital-owned values: `reg` is refused at E0205 (unsupported module item) long before §5.2.1's analog-initial read is reached
module ch5_initial_digital_access_rejected;
  reg digital_value;
  real initialized;
  initial digital_value = 1'b1;
  analog initial initialized = digital_value;
endmodule
