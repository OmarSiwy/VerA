// §5.2.1 "Additionally, digital values cannot be accessed from the analog
// initial block as they have not yet been assigned when the analog initial
// block is executed." The read of `digital_value` on the last line is that
// error, and it is the only rule this fixture pins.
//
// Everything the error depends on is legal Verilog-AMS: `reg` (A.2.1.3) and the
// digital `initial` block (A.6.2) are both in the language, and there is no way
// to write "a digital value read from an analog initial block" without them.
// A conforming AMS compiler must therefore accept the declarations and reject
// the read. The sibling fixtures analog_initial_access_rejected.va,
// analog_initial_contribution.va and analog_initial_event_rejected.va cover the
// other three §5.2.1 restrictions, which need no digital constructs at all.
//
// The expectation stays prose rather than a code because it travels: no other
// compiler prints E0431. VerA now reaches the rule — it parses `reg` and the
// `initial` block, refuses the block as an item it cannot execute, and still
// judges the body, so §5.2.1's read is diagnosed at the read. What made that
// possible without a digital engine is §7.2.2's own first sentence, "the domain
// of a variable is that of the context from which its value is assigned": the
// set of assignment targets in the `initial` block IS the set of digital-owned
// values, so no driver state and no scheduler is needed to know that
// `digital_value` is one.
//
//! lrm 5.2.1
//! reject-only analog initial
//! reject digital
//! lrm 5.2.1:1002
//! neighbour analog_initial.va
module ch5_initial_digital_access_rejected;
  reg digital_value;
  real initialized;
  initial digital_value = 1'b1;
  analog initial initialized = digital_value;
endmodule
