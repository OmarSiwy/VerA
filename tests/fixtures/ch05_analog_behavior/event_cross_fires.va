// §5.10.3.1 cross(), the positive half of the rule: "the cross function is used
// to monitor an expression for a zero crossing... If dir is +1, the event and
// timestep control only occur on rising transitions of the signal."
//
// event_cross.va, event_cross_any.va, event_cross_falling.va and
// event_cross_enable.va all assert that the sampled variable is STILL zero —
// three of them in dc, where §5.10.3.1 bars the event outright. A compiler that
// implemented cross() as a no-op passes every one of them. This fixture is the
// other direction: the event must fire, and something must change when it does.
//
// V(p) is walked 0 -> 0.5 -> 1.5, so `V(p) - 1.0` crosses zero from below
// exactly once, between the second and third timepoint. Nothing crosses before
// that, and there is no falling crossing anywhere in the run.
//
// The runner asserts at every timepoint, and the sampled value is 0.0 before
// the crossing and nonzero after, so no one literal is right at all three
// points — hence a relational oracle against `V(p) > 1.0`, which is the same
// partition of the run stated independently of the event machinery.
//
// WHAT THE SAMPLE IS NOT PINNED TO. The first check bounds x instead of naming
// 1.5, because 1.5 is only the answer for a tool that evaluates strictly on the
// declared grid. §5.10.3.1: "cross() controls the timestep to accurately
// resolve the crossing", and with no tolerances given "the tool (e.g., the
// simulator) sets them" — so a conforming simulator inserts a timepoint just
// past V(p) = 1.0 and the event samples ≈1.0 there, never 1.5. What the clause
// does fix is the box: "the event shall occur after the threshold crossing, and
// while the signal remains in the box defined by actual crossing and expr_tol
// and time_tol", so past the crossing x lies in [1.0, 1.5] and before it x is
// untouched. Both bounds carry weight — a cross() that never fires leaves x at
// 0.0 and fails the last point, one that fires early at t = 1n leaves x = 0.5
// and fails that point, and one that fires twice reads n = 2 and fails the
// second check.
//
//! lrm 5.10.3.1
//! lrm 5.10.3.1:5
//! lrm 5.10.3
//! lrm 5.10.3:1000
//! analysis tran
//! time 0, 1n, 2n
//! wave V(p) = 0, 0.5, 1.5
//! lrm 5.10.3.1:1003
// Timestep control itself is checked by cross_expr_tol_and_time_tol_both_hold.va;
// this fixed-grid fixture only observes the event and its retained value.
`include "check.vh"
module ch5_cross_fires(p);
  inout p; electrical p; real x; integer n;
  analog begin
    @(cross(V(p) - 1.0, +1)) begin
      x = V(p);
      n = n + 1;
    end
    `CHECKI("x is untouched before the crossing and inside the box after it",
            (V(p) > 1.0) ? (x >= 1.0 && x <= 1.5) : (x == 0.0), 1);
    `CHECKEQ("and one rising crossing produces exactly one event", n, (V(p) > 1.0) ? 1 : 0, 0.0);
    I(p) <+ x;
  end
endmodule
