// §5.10.3.1 cross(), the positive half of the rule: "the cross function is used
// to monitor an expression for a zero crossing... If dir is +1, the event and
// timestep control only occur on rising transitions of the signal."
//
// event_cross.va, event_cross_any.va, event_cross_falling.va and
// event_cross_enable.va all assert that the sampled variable is STILL zero —
// three of them in dc, where §5.10.3.1 bars the event outright. A compiler that
// implemented cross() as a no-op passes every one of them. This fixture is the
// other direction: the event must fire, and something must change when it does.
//
// V(p) is walked 0 -> 0.5 -> 1.5, so `V(p) - 1.0` crosses zero from below
// exactly once, between the second and third timepoint. Nothing crosses before
// that, and there is no falling crossing anywhere in the run.
//
// The runner asserts at every timepoint, and the sampled value is 0.0 before
// the crossing and 1.5 after, so no one literal is right at all three points —
// hence CHECKEQ against `V(p) > 1.0`, which is the same partition of the run
// stated independently of the event machinery. It is the weaker relational
// form, but it is not weak here: a cross() that never fires leaves x at 0.0 and
// fails the third point, and one that fires twice reads n = 2 and fails it too.
//
//! lrm 5.10.3.1
//! analysis tran
//! time 0, 1n, 2n
//! wave V(p) = 0, 0.5, 1.5
`include "check.vh"
module ch5_cross_fires(p);
  inout p; electrical p; real x; integer n;
  analog begin
    @(cross(V(p) - 1.0, +1)) begin
      x = V(p);
      n = n + 1;
    end
    `CHECKEQ("x is sampled exactly on the timepoints past the rising crossing", x, (V(p) > 1.0) ? 1.5 : 0.0, 0.0);
    `CHECKEQ("and one rising crossing produces exactly one event", n, (V(p) > 1.0) ? 1 : 0, 0.0);
    I(p) <+ x;
  end
endmodule
