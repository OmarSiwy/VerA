// §5.8.1 conditional statements, 10,000 of them one after another, written
// as a §6.6.1 genvar loop: "It shall be an error if the loop does not
// terminate", and this one ends after 10,000 iterations, so it is unrolled in
// full into 10,000 sequential `if`s. Each `if` joins before the next, so the
// device's dominator tree, the SSA read of `x` and the emitted chain are all
// 10,000 deep; VerA walks each on a heap stack (the SSA builder's join reads,
// the prover's dominator preorder, codegen's block chain). Until 2026-10-15
// the loop was refused past 4096 iterations (E0485, retired), and 10,000
// sequential `if`s overflowed the compiler's native stack.
//
// `sqrt` keeps each `if` a branch: its argument is non-negative only under
// the guard, which the prover reads off the branch edge (§4.3.2).
//
// BY HAND. The bias pins V(p) = 0. With k = i + 1 (k = 1 .. 10000), every
// guard `0 > -k` holds, and every term is sqrt(0 + k) / sqrt(k): the same
// correctly rounded double divided by itself, exactly 1.0. Ten thousand
// exact 1.0s sum to 10000.0 exactly (every partial sum is an integer below
// 2^53).
//
//! lrm 5.8.1
//! lrm 6.6.1
//! bias V(p) = 0
//! checks 1
`include "check.vh"
module sequential_ifs_10000(p);
  inout p; electrical p;
  genvar i;
  real x;
  analog begin
    x = 0.0;
    for (i = 0; i < 10000; i = i + 1)
      if (V(p) > -(i + 1.0)) x = x + sqrt(V(p) + i + 1.0) / sqrt(i + 1.0);
    `CHECKX("10000 sequential ifs, each adding exactly 1", x, 10000.0);
    I(p) <+ V(p);
  end
endmodule
