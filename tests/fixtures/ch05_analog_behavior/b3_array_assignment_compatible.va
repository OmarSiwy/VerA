// §5.7, the unpacked-array assignment rules:
//
//   "The array on the LHS of the assignment shall be an array variable, a
//    slice of an array variable or an array parameter (when the default value
//    of the parameter is assigned)."
//   "The arrays on the LHS and the RHS of the assignment must be unpacked."
//   "Array assignments shall only be done with arrays that are compatible. An
//    array ... shall be assignment compatible with any other such array ... if
//    ... The element types of source and target shall be equivalent. Every
//    dimension of the source array shall have the same number of elements as
//    the target array."
//
// The legal case every one of those sentences admits: A and B are both
// unpacked `integer` array VARIABLES with two elements each, so `A = B` is a
// whole-array copy. B is filled first, element by element, so the copy has
// digits to carry:
//
//     B[0] = 3, B[1] = 4   ->   A = B   ->   A[0] = 3, A[1] = 4
//
// A tool that copied nothing reads §3.2's 0 in both, and one that copied only
// the first element reads 0 in A[1].
//
// This is the legal neighbour of three refusals that each change one thing:
// b3_array_parameter_assigned_outside_default_rejected.va (the target is an
// array parameter), b3_array_assignment_from_packed_vector_rejected.va (the
// source is a packed vector) and
// b3_array_assignment_element_types_differ_rejected.va (the source holds
// reals).
//
//! lrm 5.7
//! lrm 5.7:4
//! lrm 5.7:6
//! lrm 5.7:7
//! lrm 5.7:8
//! bias V(p) = 0.0
//! checks 2
`include "check.vh"
module b3_array_assignment_compatible(p);
  inout p; electrical p;
  integer A[0:1];
  integer B[0:1];
  analog begin
    B[0] = 3;
    B[1] = 4;
    A = B;
    `CHECKI("the whole-array copy carries B[0] into A[0]", A[0], 3);
    `CHECKI("and B[1] into A[1]", A[1], 4);
    I(p) <+ 0.0;
  end
endmodule
