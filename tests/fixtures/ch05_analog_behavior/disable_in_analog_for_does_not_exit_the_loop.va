// §5.9.3 analog_for + A.6.5 `disable`: a disable of the LOOP BODY's block ends
// that iteration, not the loop.
//
// §5.9 lists the restrictions that make this the only loop it can be written
// in: "The following restrictions are applied to looping statements (repeat,
// while and for) EXCEPT FOR analog_for statements ... Event control statements
// are not allowed". `disable` is legal only under an `@` (A.6.4 puts
// `disable_statement` in `analog_event_statement` and nowhere else), so an
// ordinary `for` cannot host one at all and the genvar-driven analog_for of
// §5.9.3 is where the interaction lives.
//
// §5.3 gives the rule the whole fixture turns on: "the control shall pass out
// of the block after the last statement is executed". `disable it` passes
// control out of `it` — out of ONE iteration's body block, whose closing brace
// is followed by the loop's own step and test, not by the end of the loop.
// Nothing in A.6.5 lets a disable of an inner block terminate an enclosing
// construct it does not name; §6.7's scope rule is what makes `it` a name at
// all, and in an unrolled analog_for each iteration's `it` is a distinct scope.
//
// THE DERIVATION. Three iterations, k = 0, 1, 2:
//
//     n = 0; m = 0;
//     for (k = 0; k < 3; k = k + 1) begin : it
//       n = n + 1;                       -- before the disable
//       @(initial_step) disable it;
//       m = m + 1;                       -- after it, skipped when disabled
//     end
//
//   t = 0     initial_step fires in EVERY iteration, so each one increments n
//             and then leaves:  n = 3, m = 0
//   t = 1n    no event anywhere:          n = 3, m = 3
//
// n = 3 at t = 0 is the assertion this file exists for. The three ways to get
// it wrong each produce a different number:
//
//   * disable ends the loop  (`break`)      -> n = 1, m = 0
//   * disable ends the whole analog block   -> n = 1, m = 0 and the $strobe
//                                              below never runs
//   * disable is a no-op                    -> n = 3, m = 3 at both points
//
// n and m are assigned outside any `@`, so §5.10 retention does not apply to
// them and both are recomputed from 0 at every evaluation — the numbers above
// are one evaluation's arithmetic, not an accumulation across the run.
//
// OBSERVED TODAY: error[E0402]: `disable` is not implemented.
//
//! inherited IEEE 1364-2005 10.3
//! lrm 5.3
//! lrm 5.9.3
//! lrm 5.10.2
//! analysis tran
//! time 0, 1n
`include "check.vh"
module a03_disable_in_analog_for(p);
  inout p; electrical p;
  genvar k;
  integer n, m;
  analog begin
    n = 0;
    m = 0;
    for (k = 0; k < 3; k = k + 1) begin : it
      n = n + 1;
      @(initial_step) disable it;
      m = m + 1;
    end
    `CHECKEQ("every iteration still runs: disable ends the body block, not the loop",
             n, 3, 0.0);
    `CHECKEQ("and in each iteration the statements after the disable are skipped",
             m, ($abstime == 0.0) ? 0 : 3, 0.0);
    I(p) <+ 0.0;
  end
endmodule
