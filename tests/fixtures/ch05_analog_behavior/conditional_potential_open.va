// §5.6.1.3, third case: "If a value is retained for the potential of a branch,
// the branch is a potential source ... otherwise, if a value is retained for
// the flow, it is a flow source ... otherwise the branch is an open circuit."
// Retention is a property of the CYCLE'S EXECUTION PATH, so a potential
// contribution under a false conditional retains NOTHING this cycle and the
// branch must read as an OPEN CIRCUIT — not as a phantom source still pinning
// the arm's value (§5.4.4 states the same rule as the implicit `else`: an
// unassigned source branch "shall be treated as a flow source with a value of
// 0", which is §5.4.4's open circuit).
//
// The network makes the two readings a full volt apart, derived by hand:
//
//   I(p) <+ V(p)/1000    a 1 kΩ resistor from p to the reference
//   I(p) <+ -2m          2 mA driven INTO p (§1.3.1.2: positive branch flow
//                        leaves through p, so -2m enters)
//   V(sw) <+ 1.0         under V(c) > 0.5, FALSE at the bias V(c) = 0
//
// RIGHT (open):  the switch branch pins its own current, I_sw = 0, so KCL at p
//                is V(p)/1000 - 2m = 0 and V(p) = 2m * 1000 = 2.0 exactly.
// WRONG (source retained anyway): the row V(p) - 1.0 = 0 pins V(p) = 1.0 and
//                the phantom source swallows 1 mA that the model never wired.
//
//! lrm 5.6.1.3
//! lrm 5.4.4
//! lrm 5.4.4:1000
//! lrm 5.6.1.3:1
//! solve
//! bias V(c) = 0.0
`include "check.vh"
module ch5_cond_potential_open(p, c);
  inout p, c; electrical p, c;
  branch (p) sw;
  analog begin
    `CHECKI("V(c) = 0 is below the guard, so no potential is retained this cycle", V(c) > 0.5, 0);
    `CHECK("the branch is an open circuit and the 1k/2mA network sets V(p)", V(p), 2.0, 1e-9);
    I(p) <+ V(p)/1000.0;
    I(p) <+ -2.0e-3;
    if (V(c) > 0.5) V(sw) <+ 1.0;
  end
endmodule
