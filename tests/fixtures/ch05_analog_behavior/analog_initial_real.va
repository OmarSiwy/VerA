// LRM 5.2.1: the analog initial block runs once per analysis, before the analog
// block, and may only do initialization — no access functions, no contributions.
// Its assignment is what the potential source below contributes. LRM 3.2
// starts a real at 0, so 0.25 here can only have come from the initial block.
//
//! lrm 5.2.1
`include "check.vh"
module ch5_initial_real(p);
  inout p; electrical p; real bias;
  analog initial bias = 0.25;
  analog begin
    `CHECKX("analog initial value reaches the analog block", bias, 0.25);
    V(p) <+ bias;
  end
endmodule
