// §5.10.1: either operand of an OR event list triggers its statement.
// initial_step samples -1 V at time zero; a later rising crossing samples
// a nonnegative value. The counter must advance once for each operand,
// so ignoring either event or requiring both to occur together fails.
// V(p) is positive only at the 2n point, past the one rising crossing
// (between 1n and 2n), so the wants are written per declared time.
//
//! lrm 5.10.1
//! lrm 5.10.2
//! lrm 5.10.3.1
//! lrm 5.10.1:1
//! analysis tran
//! time 0, 1n, 2n
//! wave V(p) = -1.0, -0.5, 1.0
`include "check.vh"
module ch5_initial_or_cross(p);
  inout p; electrical p; real x; integer events;
  analog begin
    @(initial_step or cross(V(p), +1)) begin
      x = V(p);
      events = events + 1;
    end
    `CHECKI("initial_step and the later crossing each trigger the OR statement",
            events, ($abstime > 1.5n) ? 2 : 1);
    `CHECKI("the first event samples -1 V and the later event samples the crossing",
            ($abstime > 1.5n) ? (x >= 0.0 && x <= 1.0) : (x == -1.0), 1);
    I(p) <+ x;
  end
endmodule
