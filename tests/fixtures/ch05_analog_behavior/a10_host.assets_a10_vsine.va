// §9.17.2 $bound_step, the LRM's own example, copied verbatim from the clause
// except for the port spelling and the 1 kHz default:
//
//   module vsine(out);
//     output out;
//     voltage out;
//     parameter real freq = 1.0, ampl = 1.0, offset = 0.0;
//     analog begin
//       V(out) <+ ampl * sin(2.0 * `M_PI * freq * $abstime) + offset;
//       $bound_step(0.05 / freq);
//     end
//   endmodule
//
//   "The example below implements a sinusoidal voltage source and uses the
//    $bound_step() task to assure the simulator faithfully follows the output
//    signal (IT IS FORCING 20 POINTS PER CYCLE)."
//
// and the requirement itself: "For a given time step, the simulator shall ensure
// that the next time step taken is no larger than the smallest $bound_step()
// argument currently active."
//
// freq = 1 kHz, so the bound is 0.05/1000 = 5e-5 s and the period is 1e-3 s:
// twenty points per cycle, as the clause says. The circuit this drives is purely
// resistive, so nothing else in the deck asks for a small step — the truncation
// error controller has no charge to look at — and the only thing standing
// between the accepted grid and the deck's own dt_max is this task.
//
// WHAT THIS FILE ASSERTS ON ITS OWN. $bound_step has no reading inside the
// analog block — §9.17.2 gives it no return value and makes its whole effect a
// property of the step the SIMULATOR takes next — so the deck owns that half
// and always will. What is assertable here is the WAVEFORM the bound exists to
// resolve, sampled exactly on the grid the bound forces, which is the same
// three numbers a reviewer would check the deck's output against:
//
//   t          2*pi*freq*t   ampl*sin(...)          what it is
//   0          0             0.0                    the dc point
//   5e-5       pi/10         0.3090169943749474     ONE bound step,
//                                                   0.05/freq with freq = 1k
//   2.5e-4     pi/2          1.0                    the quarter period, i.e.
//                                                   five bound steps in, and
//                                                   the peak of the sine
//
// The middle row is the clause's arithmetic made visible: "it is forcing 20
// points per cycle", so the first forced point after the dc one is at one
// twentieth of the 1 ms period, and sin(pi/10) is 0.30901699437494745 — a
// number no step controller chooses by accident. A model whose `freq` override
// did not reach it, or whose `2*pi` was a `pi`, lands somewhere else.
//
// Digits: sin(pi/10) is irrational, so the want is binary64's correctly-rounded
// value of it and the band is 1e-15 absolute — about four ulp at this
// magnitude, which covers a libm that is a bit off the last place without
// admitting a wrong angle.
//
// The contributed expression is `CHECK`ed as written rather than bound to a
// variable: it is a pure function of `$abstime` with no operator state, so
// check.vh's double-expansion warning does not reach it, and the module stays
// the clause's own listing character for character.
//
//! lrm 9.17.2
//! lrm 9.17.2:3
//! analysis tran
//! time 0, 5e-5, 2.5e-4
//! bias V(p) = 0.0
//! bias V(n) = 0.0
`include "check.vh"
`include "constants.vams"

module a10_vsine(p, n);
  inout p, n;
  electrical p, n;
  parameter real freq = 1000.0 from (0:inf);
  parameter real ampl = 1.0;
  analog begin
    `CHECK("a 1 kHz sine sampled on the 20-points-per-cycle grid $bound_step forces",
        ampl * sin(2.0 * `M_PI * freq * $abstime),
        ($abstime < 2.5e-5) ? 0.0 : (($abstime < 1.5e-4) ? 0.30901699437494745 : 1.0),
        1e-15);
    V(p, n) <+ ampl * sin(2.0 * `M_PI * freq * $abstime);
    $bound_step(0.05 / freq);
  end
endmodule
