// LRM 5.11: "The continue statement jumps to the end of the loop and executes
// the loop control if present." So the body's remaining statements are skipped
// for that pass only, and the loop still runs to completion: over i = 0..3 the
// accumulator takes 0 + 1 + 3 = 4, because the pass with i == 2 jumps past the
// add. A `continue` that is parsed and then ignored sums 0 + 1 + 2 + 3 = 6, and
// one mistaken for `break` leaves 0 + 1 = 1.
//
// (§5.11 permits continue only in a loop and not inside an analog_for, and §5.9
// bars contribution statements from a plain loop, so the contribution is made
// once from the accumulated value. loop_contribution_invalid.va is that §5.9
// prohibition's own fixture. This file passes — the `_unsupported` suffix it
// used to carry, which this directory reserves for constructs VerA rejects,
// said the reverse.)
//
//! lrm 5.11
//! lrm 5.9.2
//! lrm 5.11:1001
//! lrm 5.11:1002
`include "check.vh"
module ch5_jump_continue(p);
  inout p; electrical p; integer i; integer acc;
  analog begin
    acc = 0;
    for (i = 0; i < 4; i = i + 1) begin
      if (i == 2) continue;
      acc = acc + i;
    end
    `CHECKI("continue skipped the rest of the body only for i == 2", acc, 4);
    I(p) <+ acc;
  end
endmodule
