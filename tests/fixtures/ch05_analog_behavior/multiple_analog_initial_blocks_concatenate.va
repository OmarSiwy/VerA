// §5.2.1: "If there are multiple analog initial blocks, they are executed as if
// concatenated." The first sets x to 1.0 and the second adds 2.0 to the value
// it sees, so source order gives 3.0. Executing the two in reverse order gives
// 1.0 (the first block's assignment overwrites the second's result), and
// executing only one of them gives 1.0 or 2.0. The analog block then runs
// after both, once per analysis, and reads 3.0.
//
//! lrm 5.2.1
//! lrm 5.2.1:1001
`include "check.vh"
module ch5_multiple_analog_initial(p);
  inout p; electrical p; real x;
  analog initial x = 1.0;
  analog initial x = x + 2.0;
  analog begin
    `CHECKX("the two analog initial blocks ran concatenated in source order", x, 3.0);
    I(p) <+ 0.0 * V(p);
  end
endmodule
