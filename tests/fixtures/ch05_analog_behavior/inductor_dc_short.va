// §5.6.1.2 / §4.5.3: an inductor is a PURELY REACTIVE potential contribution,
// `V(hi,lo) <+ L*ddt(I(hi,lo))`, and no fixture wrote one — MEASURED before
// this file, `grep -rn "ddt(I(" tests/fixtures` was 0.
//
// The predicate that matters is wider than that grep, though, and finding out
// how much wider is what this file bought: it is "a POTENTIAL contribution
// whose resistive half is zero", which `V(out) <+ ddt(V(dt[k]))` also satisfies
// — so `ch05_analog_behavior/analog_genvar_loop.va` was already standing on the
// bug and passing, because its two CHECKs read `tmp` and a bare `ddt()` rather
// than the branch. That is exactly the blindness this file exists to remove:
// the assertions below are about the ROW, not about the value.
//
// What §5.6 requires of the resistive half. A potential contribution's branch
// relation `V(hi) - V(lo) - <value> = 0` is the DEFINING equation of the branch
// flow unknown, and the same row is where that unknown enters KCL at hi and lo
// (§1.3.1.2, "the value flows into hi and out of lo"). Both live in `eval`.
// With `<value>` purely reactive the resistive half is zero, but the row is
// not: it says the flow unknown exists, it is in KCL, and its branch voltage is
// zero. Deleting it leaves a column with no pivot and a current that no node
// equation sees — an inductor with no KCL stamp, exit 0, no diagnostic.
//
// DC-ONLY, DELIBERATELY, and this line is the fixture's contract. TODO.md §3
// records that the Newton solve factors the RESISTIVE residual only; §5.6.1.2's
// reactive half needs `q(x)` and the `q` of the last accepted step, which the
// testbench does not have. A transient inductor fixture would therefore stand
// OVER that ceiling and convert it into a bug, which TODO.md §3's own preamble
// forbids. At DC `zDdt` returns 0, so the row this file asserts is
// `V(hi) - V(lo) - 0 = 0` — an inductor is a short at DC, which is the correct
// physics and a fact about the RESISTIVE residual alone.
//
// So: `solve`, with the source leg pinned at 1 V and the inductor's far end
// pinned at 0 V, and a 1 kΩ series resistor to set the current. The two CHECKs
// are the two halves of the claim — the branch is a short (0 V across it, so l0
// sits at the reference and the whole 1 V is across the resistor), and the
// inductor's flow unknown is stamped into KCL at l0, where it is the only other
// term and must therefore equal the resistor's 1 mA.
//
//! lrm 5.6.1.2
//! lrm 4.5.3
//! lrm 1.3.1.2
//! lrm 1.3.1
//! lrm 1.3.1:1
//! lrm 5.6.1.2:1000
//! bias V(src) = 1.0
//! bias V(l1) = 0.0
//! solve
`include "check.vh"

module ch5_inductor_dc_short(src, l0, l1);
  inout src, l0, l1;
  electrical src, l0, l1;
  parameter real ind = 1e-3 from (0:inf);
  parameter real res = 1000.0 from (0:inf);

  analog begin
    // The source leg: a 1 kΩ resistor from the driven terminal into l0.
    I(src, l0) <+ V(src, l0) / res;
    // The inductor itself, and l1 is tied to the reference by the harness.
    V(l0, l1) <+ ind * ddt(I(l0, l1));

    `CHECKX("at DC the inductor branch is a short, so l0 sits at the source", V(l0, l1), 0.0);
    `CHECKX("and its flow unknown is in KCL at l0: it carries the resistor's current", I(l0, l1), 1.0e-3);
  end
endmodule
