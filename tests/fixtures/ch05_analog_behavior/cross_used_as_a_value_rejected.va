// §5.10.3.1 introduces cross() by its grammar:
//
//     analog_event_functions ::= cross ( analog_expression [ , ... ] ) | ...
//
// and A.6.5 reaches analog_event_functions only from analog_event_expression,
// the operand of an `@ ( ... )` event control. A.8.4's analog_primary has no
// alternative for it. So cross() is an EVENT, with no value: "The cross()
// function is used for generating a monitored analog event".
//
// `y = cross(V(p, n))` below uses it as a real operand. The legal use,
// `@(cross(...))`, is a10_05_cross_tolerances_are_not_the_enable.va.
//
//! lrm 5.10.3.1
//! lrm A.6.5
//! lrm 5.10.3
//! lrm 5.10.3:1000
//! lrm A.6.5:1000
//! reject-only E0701
//! neighbour a10_05_cross_tolerances_are_not_the_enable.va
`include "disciplines.vams"
module ch5_cross_used_as_a_value(p, n);
  inout p, n; electrical p, n;
  real y;
  analog begin
    y = cross(V(p, n));
    I(p, n) <+ y * V(p, n);
  end
endmodule
