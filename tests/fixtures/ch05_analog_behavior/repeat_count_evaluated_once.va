// §5.9.1: "The repeat and while expressions shall be evaluated once before the
// execution of any statement in order to determine the number of times, if any,
// the statements are executed."
//
// repeat_loop.va and repeat_single.va use literal counts, where a per-iteration
// re-evaluation is invisible. Here the count is the variable `n` and the body
// decrements it, so the two readings of the clause part company:
//
//   evaluated once (correct): 3 passes, x = 3.0 and n ends at 0
//   re-evaluated each pass:   n goes 3, 2, 1, 0 while the pass counter climbs
//                             0, 1, 2 — the loop stops when they meet, after 2
//                             passes, leaving x = 2.0 and n = 1
//
// Every value is a small integer held exactly in a real, so the two outcomes
// cannot be confused. `n` is asserted as well as `x`: it proves the body really
// did mutate the count, so 3.0 is the count being latched and not the mutation
// being optimised away.
//
//! lrm 5.9.1
//! lrm 5.9.1:1
`include "check.vh"
module ch5_repeat_count_once(p);
  inout p; electrical p; integer n; real x;
  analog begin
    n = 3;
    x = 0.0;
    repeat (n) begin
      n = n - 1;
      x = x + 1.0;
    end
    `CHECKX("the count was latched at 3 before the first pass", x, 3.0);
    `CHECKI("and the body really did decrement it three times", n, 0);
    I(p) <+ x;
  end
endmodule
