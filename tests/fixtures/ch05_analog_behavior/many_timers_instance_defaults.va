// §5.10.3.3 timer(): a module may hold any number of timer events. Each
// one keeps its start time and period in Instance fields whose default is
// NaN ("not armed yet"). With 80 timers that is 160 NaN defaults, all
// evaluated in the one comptime context that checks the Instance against
// the contract; writing each as a std.math.nan call ran out of the
// 1000-branch comptime quota and the generated device did not compile
// (ARPice vsource.va, 2026-10-01). Nothing here depends on the timers
// firing: the check is that the device compiles and runs, and that the
// probe passes through unchanged, V(p, n) = 0.75 by the bias below.
//
//! lrm 5.10.3.3
//! bias V(p) = 0.75, V(n) = 0
//! checks 1
`include "check.vh"
module many_timers(p, n);
    inout p, n;
    electrical p, n;
    integer k;
    analog begin
        @(timer(1e-3, 1e-3)) k = 0;
        @(timer(2e-3, 2e-3)) k = 1;
        @(timer(3e-3, 3e-3)) k = 2;
        @(timer(4e-3, 4e-3)) k = 3;
        @(timer(5e-3, 5e-3)) k = 4;
        @(timer(6e-3, 6e-3)) k = 5;
        @(timer(7e-3, 7e-3)) k = 6;
        @(timer(8e-3, 8e-3)) k = 7;
        @(timer(9e-3, 9e-3)) k = 8;
        @(timer(10e-3, 10e-3)) k = 9;
        @(timer(11e-3, 11e-3)) k = 10;
        @(timer(12e-3, 12e-3)) k = 11;
        @(timer(13e-3, 13e-3)) k = 12;
        @(timer(14e-3, 14e-3)) k = 13;
        @(timer(15e-3, 15e-3)) k = 14;
        @(timer(16e-3, 16e-3)) k = 15;
        @(timer(17e-3, 17e-3)) k = 16;
        @(timer(18e-3, 18e-3)) k = 17;
        @(timer(19e-3, 19e-3)) k = 18;
        @(timer(20e-3, 20e-3)) k = 19;
        @(timer(21e-3, 21e-3)) k = 20;
        @(timer(22e-3, 22e-3)) k = 21;
        @(timer(23e-3, 23e-3)) k = 22;
        @(timer(24e-3, 24e-3)) k = 23;
        @(timer(25e-3, 25e-3)) k = 24;
        @(timer(26e-3, 26e-3)) k = 25;
        @(timer(27e-3, 27e-3)) k = 26;
        @(timer(28e-3, 28e-3)) k = 27;
        @(timer(29e-3, 29e-3)) k = 28;
        @(timer(30e-3, 30e-3)) k = 29;
        @(timer(31e-3, 31e-3)) k = 30;
        @(timer(32e-3, 32e-3)) k = 31;
        @(timer(33e-3, 33e-3)) k = 32;
        @(timer(34e-3, 34e-3)) k = 33;
        @(timer(35e-3, 35e-3)) k = 34;
        @(timer(36e-3, 36e-3)) k = 35;
        @(timer(37e-3, 37e-3)) k = 36;
        @(timer(38e-3, 38e-3)) k = 37;
        @(timer(39e-3, 39e-3)) k = 38;
        @(timer(40e-3, 40e-3)) k = 39;
        @(timer(41e-3, 41e-3)) k = 40;
        @(timer(42e-3, 42e-3)) k = 41;
        @(timer(43e-3, 43e-3)) k = 42;
        @(timer(44e-3, 44e-3)) k = 43;
        @(timer(45e-3, 45e-3)) k = 44;
        @(timer(46e-3, 46e-3)) k = 45;
        @(timer(47e-3, 47e-3)) k = 46;
        @(timer(48e-3, 48e-3)) k = 47;
        @(timer(49e-3, 49e-3)) k = 48;
        @(timer(50e-3, 50e-3)) k = 49;
        @(timer(51e-3, 51e-3)) k = 50;
        @(timer(52e-3, 52e-3)) k = 51;
        @(timer(53e-3, 53e-3)) k = 52;
        @(timer(54e-3, 54e-3)) k = 53;
        @(timer(55e-3, 55e-3)) k = 54;
        @(timer(56e-3, 56e-3)) k = 55;
        @(timer(57e-3, 57e-3)) k = 56;
        @(timer(58e-3, 58e-3)) k = 57;
        @(timer(59e-3, 59e-3)) k = 58;
        @(timer(60e-3, 60e-3)) k = 59;
        @(timer(61e-3, 61e-3)) k = 60;
        @(timer(62e-3, 62e-3)) k = 61;
        @(timer(63e-3, 63e-3)) k = 62;
        @(timer(64e-3, 64e-3)) k = 63;
        @(timer(65e-3, 65e-3)) k = 64;
        @(timer(66e-3, 66e-3)) k = 65;
        @(timer(67e-3, 67e-3)) k = 66;
        @(timer(68e-3, 68e-3)) k = 67;
        @(timer(69e-3, 69e-3)) k = 68;
        @(timer(70e-3, 70e-3)) k = 69;
        @(timer(71e-3, 71e-3)) k = 70;
        @(timer(72e-3, 72e-3)) k = 71;
        @(timer(73e-3, 73e-3)) k = 72;
        @(timer(74e-3, 74e-3)) k = 73;
        @(timer(75e-3, 75e-3)) k = 74;
        @(timer(76e-3, 76e-3)) k = 75;
        @(timer(77e-3, 77e-3)) k = 76;
        @(timer(78e-3, 78e-3)) k = 77;
        @(timer(79e-3, 79e-3)) k = 78;
        @(timer(80e-3, 80e-3)) k = 79;
        `CHECK("probe passes through", V(p, n), 0.75, 1e-12);
        I(p, n) <+ 1e-3 * V(p, n);
    end
endmodule
