// §5.10.2 final_step, and the contribution that reads the variable it writes.
//
// Table 5-1 gives final_step the value 1 in the DCOP column, so on a single-point
// dc analysis it fires — but the body assigns 0.0, which is also what §3.2.1
// gives an untouched real, so the firing itself leaves no trace a probe inside
// the module can see. What IS pinned is that `x` is 0.0 on either path, and so
// the contributed flow is the branch potential alone: 0.7 A into a 1 ohm
// conductance at 0.7 V.
//
// A lowering that let the guarded assignment escape its guard, or left the
// event-held variable uninitialised, moves this number.
//
//! analysis dc
//! bias V(p) = 0.7
`include "check.vh"
module ch5_final_step(p);
  inout p; electrical p; real x;
  analog begin
    @(final_step) x = 0.0;
    `CHECK("the final_step body assigns 0, as does §3.2.1", x, 0.0, 0.0);
    `CHECK("so the contributed flow is the branch potential alone", x + V(p), 0.7, 1e-15);
    I(p) <+ x + V(p);
  end
endmodule
