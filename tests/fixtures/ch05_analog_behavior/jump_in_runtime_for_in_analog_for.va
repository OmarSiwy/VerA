// §5.11: "The continue and break statements cannot be used inside an analog
// for loop. Refer 5.9.3." The legal neighbour of
// jump_in_analog_for_invalid.va: the `break` and `continue` sit inside a
// §5.9.2 procedural `for` nested in the analog_for, so the loop they leave
// or skip is the procedural one, which "jumps out of the loop" (break) and
// "jumps to the end of the loop body" (continue) exactly as jump_break.va
// and jump_continue.va show at top level.
//
// Derivation. The analog_for unrolls k = 0, 1, 2. In each copy the inner
// loop runs i = 0..9 but breaks when i == k + 2, so it executes i = 0..k+1:
// k + 2 passes. `continue` skips the add on i == 0, so each copy adds
// k + 1 to x. Total: (0+1) + (1+1) + (2+1) = 6. A break that left the
// analog_for instead would stop after the first copy (x = 1); a break that
// was ignored would run i = 0..9 in every copy (x = 27).
//
//! lrm 5.11
//! lrm 5.9.3
//! lrm 5.9.2
`include "check.vh"
module ch5_jump_in_runtime_for_in_analog_for(p);
  inout p; electrical p; genvar k; integer i; real x;
  analog begin
    x = 0.0;
    for (k = 0; k < 3; k = k + 1) begin
      for (i = 0; i < 10; i = i + 1) begin
        if (i == k + 2) break;
        if (i == 0) continue;
        x = x + 1.0;
      end
    end
    `CHECK("break/continue left only the procedural loop", x, 6.0, 1e-12);
  end
endmodule
