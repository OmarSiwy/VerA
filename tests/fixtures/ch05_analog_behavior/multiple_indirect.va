// §5.6.7.1 multiple indirect contributions: "For multiple indirect contribution
// statements, the targets frequently can be paired with any equation." The
// clause's example is three equations across three DISTINCT targets, written
// three times with the pairings permuted, "without affecting the results".
//
// That is the point being pinned, so the shape has to match: three unknowns,
// three independent equations, and the pairing deliberately rotated one place
// off the obvious one. This file used to aim two equations at a single branch,
// which is an over-determined system in one unknown — a thing §5.6.7.1 never
// defines, and whose "solution" was just the declared bias read back.
//
// The system, with a unique solution because its matrix is nonsingular
// (determinant 4):
//
//     2*V(x) +   V(y)            == 1.25
//                V(y) + 2*V(z)   == 0.5
//       V(x) +          V(z)     == 0.625
//
//   =>  V(x) = 0.5, V(y) = 0.25, V(z) = 0.125
//
// Every coefficient and every solution component is a negative power of two, so
// the arithmetic is exact and the three answers cannot be reached by rounding.
// Nothing in the operating point declares them: the three nets are free, and the
// only thing that can put 0.5 on V(x) is the solver honouring the constraints.
// That is what makes this a §5.6.7 test rather than a restatement of `//! bias`.
//
// EACH EQUATION IS SOLVED FOR ITS OWN PROBE, because §5.6.7 constrains what may
// stand left of the `==`: "the left-hand side of the equality operator must
// either be an access function, or ddt, idt or idtmod applied to an access
// function", and Syntax 5-6's indirect_expression admits nothing else. A sum
// like `2.0*V(x) + V(y)` is not one of those alternatives — the tolerance for
// the equation is taken from that operand, so it has to name a single quantity
// — and writing one here would demand that a conforming compiler accept source
// the grammar forbids, which is exactly what indirect_equation_lhs_invalid.va
// rejects. So the coefficients move to the right of the `==`, one row at a
// time, and each row is still the same equation:
//
//     V(x) == 0.625 - V(z)          <=>    V(x) +          V(z)   == 0.625
//     V(y) == 1.25 - 2.0*V(x)       <=>  2*V(x) +   V(y)          == 1.25
//     V(z) == 0.25 - 0.5*V(y)       <=>            V(y) + 2*V(z)  == 0.5
//
// The pairing is then rotated one place off the obvious one, which is the whole
// point of §5.6.7.1: no target names the probe its own row solves for.
//
//! lrm 5.6.7.1
//! lrm 5.6.7
//! xfail VerA's generated testbench forces every unknown to its declared operating point instead of solving, so an indirect contribution's target cannot move: V(x), V(y) and V(z) all read 0
`include "check.vh"
module ch5_multiple_indirect(x, y, z);
  inout x, y, z; electrical x, y, z;
  analog begin
    `CHECKX("the system's unique solution for x", V(x), 0.5);
    `CHECKX("its unique solution for y", V(y), 0.25);
    `CHECKX("its unique solution for z", V(z), 0.125);
    V(y) : V(x) == 0.625 - V(z);
    V(z) : V(y) == 1.25 - 2.0*V(x);
    V(x) : V(z) == 0.25 - 0.5*V(y);
  end
endmodule
