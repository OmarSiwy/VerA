// §5.3.2 Block names, the sentence this row exists to honour:
//
//   "All named block variables are static—that is, an unique location exists
//    for all variables and leaving or entering the block do not affect the
//    values stored in them."
//
// and §5.10, which says why that is observable at all:
//
//   "The analog event detection is non-blocking, meaning the execution of the
//    procedural statement is skipped unless the analog event has occurred."
//
// Put together: a variable assigned only under an `@` keeps its value at every
// timepoint where the event did not occur. tests/fixtures/ch05/event_cross.va
// and friends pin that for a MODULE-level variable. §5.3.2's "unique location"
// sentence says a named-block local is storage with exactly the same lifetime,
// which is the lifetime this fixture checks.
//
// THE EVENT SOURCE. Two ONE-SHOT timers, §5.10.3.3: "If the period expression
// evaluates to a value less than or equal to 0.0, the timer shall trigger only
// once at the specified start_time". The LRM permits a default point at or
// just beyond that time. This testbench explicitly includes 1n and 3n in
// its fixed grid, so its events fire there; exact times are a harness choice.
//
// THE DERIVATION. `n` lives in block `samp`, starts at the §3.2 default 0, and
// is only ever assigned inside an event statement:
//
//     t = 0     no event                          n = 0
//     t = 1n    timer(1n, 0.0)  -> n = n + 1      n = 1
//     t = 2n    no event, the value is RETAINED   n = 1   <-- the claim
//     t = 3n    timer(3n, 0.0)  -> n = n + 10     n = 11
//     t = 4n    no event, the value is RETAINED   n = 11  <-- the claim
//
// `n = n + 1` reads the retained value as well as writing it, so a slot that
// held the write but not the read would produce 10 at t = 3n, not 11.
//
// `out` is a module-level copy taken after the two event statements, because
// the assertions run on the analog spine where `samp`'s local is out of scope.
// It is assigned unconditionally, so `out` itself is never a held variable —
// everything asserted here is `n`'s lifetime, nothing is `out`'s.
//
// The oracle is a select on $abstime over four hand-written literals; $abstime
// only says WHICH timepoint, it does not re-derive the retention.
//
//! lrm 5.3.2
//! lrm 5.10
//! lrm 5.10.3.3
//! lrm 5.10.3.3:4
//! lrm 5.3.2:1000
//! analysis tran
//! time 0, 1n, 2n, 3n, 4n
//! lrm 5.3.2:1001
`include "check.vh"
module a03_block_local_static(p);
  inout p; electrical p;
  integer out;
  analog begin
    begin : samp
      integer n;
      @(timer(1n, 0.0)) n = n + 1;
      @(timer(3n, 0.0)) n = n + 10;
      out = n;
    end
    `CHECKEQ("a named block's local is static: it keeps its value between events",
             out, ($abstime < 1n) ? 0 : (($abstime < 3n) ? 1 : 11), 0.0);
    I(p) <+ 0.0;
  end
endmodule
