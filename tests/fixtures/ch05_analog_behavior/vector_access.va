//! reject identifier
module ch5_vector_access(p);
  inout [0:3] p; electrical [0:3] p;
  analog begin
    I(p[0]) <+ V(p[1]);
    I(p[2]) <+ V(p[3]);
  end
endmodule
