// §5.5.2 "the access functions can only be applied to scalars or individual
// elements of a vector. The scalar element of a vector is selected with an
// index, e.g., V(in[1]) accesses the voltage in[1]."
//
// This is the clause's own DAC8 example, with the `cross(V(clk) - 2.5, +1)`
// gate dropped so the assertion stays unconditional (check.vh: a display task
// under an event control is not straight-line code). The bit weighting is the
// LRM's, literal index by literal index.
//
// Bits 7, 5 and 0 are driven to 3.0 V and the rest sit at the default 0.0, so
// with the declared vth = 2.5 exactly those three compare high:
//
//     fullscale/2 + fullscale/8 + fullscale/256
//   = 0.5 + 0.125 + 0.00390625 = 0.62890625
//
// every term a negative power of two, so the sum is exact in binary. A
// compiler that read the index the other way round would weight bits 0, 2 and
// 7 instead and get 1/256 + 1/64 + 1/2 = 0.51953125.
//
//! lrm 5.5.2
//! bias V(in[7]) = 3.0, V(in[5]) = 3.0, V(in[0]) = 3.0
//! xfail VerA has no vector nets: `input [0:7] in` dies at E0208 (expected an identifier: found `[`)
`include "check.vh"
module ch5_vector_access(out, in);
  parameter real fullscale = 1.0, vth = 2.5;
  output out;
  input [0:7] in;
  electrical out;
  electrical [0:7] in;
  real aout;
  analog begin
    `CHECKX("V(in[5]) selects that element of the vector", V(in[5]), 3.0);
    `CHECKX("V(in[6]) selects a different element", V(in[6]), 0.0);
    aout = 0.0;
    aout = aout + ((V(in[7]) > vth) ? fullscale/2.0   : 0.0);
    aout = aout + ((V(in[6]) > vth) ? fullscale/4.0   : 0.0);
    aout = aout + ((V(in[5]) > vth) ? fullscale/8.0   : 0.0);
    aout = aout + ((V(in[4]) > vth) ? fullscale/16.0  : 0.0);
    aout = aout + ((V(in[3]) > vth) ? fullscale/32.0  : 0.0);
    aout = aout + ((V(in[2]) > vth) ? fullscale/64.0  : 0.0);
    aout = aout + ((V(in[1]) > vth) ? fullscale/128.0 : 0.0);
    aout = aout + ((V(in[0]) > vth) ? fullscale/256.0 : 0.0);
    `CHECKX("literal element access weights bits 7, 5 and 0", aout, 0.62890625);
    V(out) <+ aout;
  end
endmodule
