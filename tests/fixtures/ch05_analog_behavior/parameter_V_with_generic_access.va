// §5.5.1, the measure1 example: "Note V cannot be used as an access function
// because there is a parameter called V declared in the module." The
// DECLARATION is legal; it is the call `V(...)` that the note rules out, and
// the example reaches the potential through the generic spelling instead:
// `potential(p) / V`. This is the legal twin of
// reject_5_5_1_parameter_V_hides_access_function.va.
//
// With V(p) = 1.0 and V(n) = 0.25 the branch potential is 0.75 (dyadic, so
// exact), and the parameter V reads its default 1.1. The quotient is
// 0.75 / 1.1 = 15/22 = 0.681818... (the 18 repeats); 1.1 is not a dyadic
// rational, so the double result is checked to 1e-12, not bit for bit.
//
//! lrm 5.5.1
//! bias V(p) = 1.0, V(n) = 0.25
`include "check.vh"
module ch5_parameter_V_generic_access(p, n);
  inout p, n;
  electrical p, n;
  parameter real V = 1.1;

  analog begin
    `CHECKX("the parameter V is a value, not an access function", V, 1.1);
    `CHECKX("potential(p, n) is the branch potential", potential(p, n), 0.75);
    `CHECK("measure1's potential / V", potential(p, n) / V, 0.681818181818, 1e-12);
    I(p, n) <+ potential(p, n) / V;
  end
endmodule
