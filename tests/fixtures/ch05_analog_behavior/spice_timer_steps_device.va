// §5.10.3.3 timer(): "The analog simulator PLACES A TIME POINT within time_tol
// of an event. At that time point, the event evaluates to True."
//
// Two single-shot timers at times that are deliberately NOT on the printstep
// grid of the deck that instantiates this model (`.tran 1e-4 1e-3` walks
// 0, 1e-4, 2e-4, …). 2.5e-4 and 6.25e-4 fall strictly between printsteps, so an
// accepted time point at either one exists only because this model asked for it.
//
// Both periods are 0, which §5.10.3.3 makes single-shot ("the timer shall
// trigger only once at the specified start_time"), so the output is a staircase
// with exactly two risers and its value identifies WHICH timers have fired:
//
//   t <  2.5e-4              lvl = 0   V(p,n) = 0 V
//   2.5e-4  <= t < 6.25e-4   lvl = 1   V(p,n) = 1 V
//   t >= 6.25e-4             lvl = 2   V(p,n) = 2 V
//
// The start times are written as plain decimals and not as §2.6 scale factors
// (`250u`) on purpose: a scale factor is lowered as a MULTIPLICATION, so `250u`
// is 250 * 1e-6 = 2.5000000000000005e-4, one ulp away from the decimal 2.5e-4
// the oracle asks for, and the oracle compares the accepted time to the
// breakpoint exactly.
//
// WHAT THIS FILE ASSERTS ON ITS OWN. The deck owns the half that is about the
// GRID — that an accepted time point exists at 2.5e-4 and at 6.25e-4 although
// the printstep never lands there. The half that is about the MODEL is the
// staircase above, and it is asserted here against the `//! time` line, which
// samples on both sides of each riser and ON each riser:
//
//   t         lvl   why
//   0         0     neither timer has fired
//   1e-4      0     still before the first start_time
//   2.5e-4    1     "The analog simulator places a time point within time_tol
//                    of an event. At that time point, the event evaluates to
//                    True" — so the riser is AT the start time, not after it
//   4e-4      1     period 0 makes it single-shot: "the timer shall trigger
//                    only once at the specified start_time"
//   6.25e-4   2     the second timer, same rule
//   8e-4      2     and it too fires only once
//
// The want is that table written once, piecewise in `$abstime`, with `<` and
// not `<=` at both boundaries precisely because the event is True AT the start
// time. A tool that fired one sample late reads 0 at 2.5e-4; one that read
// `period = 0` as "every step" reads more than 2 by 8e-4.
//
// `lvl` is the assertion and not `V(p,n)`: the contribution makes this a source
// branch whose terminal voltage is whatever the netlist around it solves to,
// while `lvl` is the model's own state and is what the staircase is made of.
//
//! lrm 5.10.3.3
//! analysis tran
//! time 0, 1e-4, 2.5e-4, 4e-4, 6.25e-4, 8e-4
//! bias V(p) = 0.0
//! bias V(n) = 0.0
`include "check.vh"

module a10_timer_steps(p, n);
  inout p, n;
  electrical p, n;
  integer lvl;
  analog begin
    @(timer(2.5e-4, 0)) lvl = lvl + 1;
    @(timer(6.25e-4, 0)) lvl = lvl + 1;
    `CHECKI("two single-shot timers make a two-riser staircase, each riser at its start_time",
        lvl, ($abstime < 2.5e-4) ? 0 : (($abstime < 6.25e-4) ? 1 : 2));
    V(p, n) <+ 1.0 * lvl;
  end
endmodule
