// §5.6.8.1 hierarchical direct contributions to nets: a contribution statement
// may name nets in other module instances, and "a new unnamed branch is created
// in the module containing the direct contribution statements".
//
// This is the clause's source_driver example, with the same one change
// §5.5.4's fixture needed. The LRM writes the paths as `top.drv.x`, into a
// design the example does not show; as a run fixture that is unsatisfiable by
// any conforming compiler — nothing named `top` exists to elaborate against, so
// the reference does not resolve and the `//! xfail` could never turn into an
// XPASS. §5.5.5 prints the resolvable shape, so the child is instantiated here
// and the paths are `drv.x` / `drv.y`: still nets in another module instance,
// still one unnamed branch created per contribution, resolvable in one file.
//
// The nets in the other instance belong to a design this file does not
// describe, so their solved values are not something a fixture can write down.
// What §5.6.8.1 fixes and this pins is that the local unnamed branch keeps its
// own source: V(m) is driven to vref by the first line, and the three
// hierarchical sources are on other branches (m-to-ground versus m-to-drv.y),
// so none of them may move it. Held off that solution at V(m) = 0.25 the
// source's residual is 0.25 - 1.25 = -1.0, exact in binary — the same idiom
// potential_source.va uses, because the runner forces unknowns rather than
// solving and a probe therefore reads the declared bias, not the source value.
//
// The port `p` is not in source_driver, whose port list is empty. It arrived here
// because the device contract refused a device with zero terminals, and it stays
// because it is now load-bearing for a different reason: it is what the child
// instance `drv` is wired to, and the §5.6.8.1 contributions under test name nets
// inside that instance. (The contract no longer refuses one — see
// ch06_hierarchy/module_definition.va — so a portless variant would run today,
// but it would have no child to contribute into.)
//
//! lrm 5.6.8.1
//! bias V(m) = 0.25
`include "check.vh"
module ch5_hier_contribution(p);
  parameter real vref = 1.25;
  inout p;
  electrical p, m;
  ch5_hier_contribution_drv drv(p);
  analog begin
    V(m) <+ vref;

    // Creates an unnamed voltage source branch of 1.8 volts between the net
    // drv.x and implicit ground.
    V(drv.x) <+ 1.8;

    // Creates an unnamed voltage source branch of 1.2 volts between nets
    // drv.x and drv.y.
    V(drv.x, drv.y) <+ 1.2;

    // Creates an unnamed voltage source branch of 0.9 volts between the local
    // net m and drv.y.
    V(m, drv.y) <+ 0.9;

    `CHECKX("the local unnamed branch keeps its own source residual", V(m) - vref, -1.0);
    I(p) <+ 0.0;
  end
endmodule

// The instance the hierarchical paths resolve through. It contributes nothing
// to x and y itself, so every source on them is one this file created.
module ch5_hier_contribution_drv(t);
  inout t;
  electrical t, x, y;
  analog I(t) <+ 0.0;
endmodule
