// §5.10.3.1 cross() with dir = 0: "If the direction indicator is set to 0 or is
// not specified, the event and timestep control occur on both positive and
// negative crossings". Both directions still means NO direction in dc — the
// same clause says cross() "will not generate events for non-transient
// analyses, such as ac, dc, or noise analyses".
//
// So at V(p)=0.6 the sampled value would be 0.6, but no event occurs and `x`
// keeps the zero §3.2 gives a real variable. This file pins only that dc
// sentence; dir 0 firing on both a rising and a falling crossing in a
// transient is event_cross_rising_and_falling.va.
//
//! lrm 5.10.3.1
//! bias V(p) = 0.6
`include "check.vh"
module ch5_cross_any(p);
  inout p; electrical p; real x;
  analog begin
    `CHECK("the value a firing would have sampled", V(p), 0.6, 1e-15);
    @(cross(V(p), 0)) x = V(p);
    `CHECK("cross(expr, 0) generates no event in dc either", x, 0.0, 0.0);
    I(p) <+ x;
  end
endmodule
