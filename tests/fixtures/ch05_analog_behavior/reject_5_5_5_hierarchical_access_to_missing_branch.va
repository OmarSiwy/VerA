// §5.5.5: "A module is allowed to access the potential and flow of a branch in
// another module instance using an access function providing that value is
// available in the other instance. If it is not available, then an error
// shall be reported. Reasons why it would be unavailable are:
// — The branch does not exist in the other instance".
//
// Instance a1 of ch5_hier_src declares nets x, y and the branch b; it has no
// branch or net called `nosuch`, so `V(top_hier_missing.a1.nosuch)` names
// nothing and the clause requires an error.
//
// VerA reports E0901 "hierarchical name names nothing in the elaborated
// design: ... names no net", which is true of `nosuch`. The legal form of the
// clause's own example, `V(top.a1.b)` on the existing named branch through
// the top module's name, is hierarchical_named_branch_access.va.
//
//! lrm 5.5.5
//! lrm 5.5.5:1
//! reject-only E0901
//! neighbour hierarchical_named_branch_access.va
`include "disciplines.vams"
module ch5_hier_src();
  electrical x, y;
  branch (x, y) b;
  analog V(b) <+ 1.0;
endmodule

module top_hier_missing(p, n);
  inout p, n;
  electrical p, n;
  ch5_hier_src a1();

  analog I(p, n) <+ V(top_hier_missing.a1.nosuch);   // illegal: no such branch
endmodule
