// §5.4.2 a current-controlled voltage source: same sensed flow as the CCCS,
// but the output is a POTENTIAL contribution, so 2.0 is a transresistance in
// ohms and the source states V(op,on) - 2*I(sense) = 0.
//
// With the sense branch held at 2 mA the source value is 2 * 2m = 4 mV, and at
// V(op)=0.1, V(on)=0 the branch potential is 0.1 V, so the residual is
// 0.1 - 0.004 = 0.096.
//
// `flowZ28cpZ2ccnZ29` is `flow(cp,cn)` under the codegen's identifier mangling
// (Z28 `(`, Z2c `,`, Z29 `)`), which is what tb.zig's `ix()` looks up. `sweep`
// rather than `bias` because `bias` splits its line on commas.
//
//! lrm 5.4.2
//! bias V(op) = 0.1
//! sweep flowZ28cpZ2ccnZ29 = 2m
`include "check.vh"
module ch5_ccvs(op, on, cp, cn);
  inout op, on, cp, cn; electrical op, on, cp, cn;
  branch (cp, cn) sense;
  analog begin
    `CHECK("CCVS source value 2 ohm * I(sense)", 2.0 * I(sense), 4.0e-3, 1e-18);
    `CHECK("source residual V(op,on) - 2*I(sense)", V(op, on) - 2.0 * I(sense), 0.096, 1e-15);
    V(sense) <+ 0.0;
    V(op, on) <+ 2.0 * I(sense);
  end
endmodule
