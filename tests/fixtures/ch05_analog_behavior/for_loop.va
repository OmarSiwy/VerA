// §5.9.2 the `for` loop: the initial assignment runs once, then the condition
// is evaluated BEFORE each pass and the step assignment AFTER each pass. With
// `i = 0`, `i < 3`, `i = i + 1` the body runs for i = 0, 1, 2 — three passes —
// and the loop exits with `i` holding the first value that failed the test.
//
// So x accumulates V(p) exactly three times, and 3 * 0.25 = 0.75 is exact in
// binary floating point (0.25 is a power of two), which is why the bias is 0.25
// and the tolerance is zero.
//
//! lrm 5.9.2
//! bias V(p) = 0.25
//! lrm 5.9.2:1001
`include "check.vh"
module ch5_for(p);
  inout p; electrical p; integer i; real x;
  analog begin
    x = 0.0;
    for (i = 0; i < 3; i = i + 1) x = x + V(p);
    `CHECK("for (i=0; i<3; i=i+1) runs its body three times", x, 0.75, 0.0);
    `CHECKI("the loop exits with i at the first value that failed i<3", i, 3);
    I(p) <+ x;
  end
endmodule
