// §5.4.1/§5.4.2 the four controlled sources, all driven off one sensed branch.
//
// §5.4.2 makes `I(sensed)` a solver unknown of its own, so the testbench can
// hold it the way it holds a node potential; §5.4.1 makes `V(sensed)` the
// potential of the branch's node pair, cp - cn.
//
// At V(cp)=0.7, V(cn)=0.2 the sensed potential is 0.5 V, and the sensed flow is
// held at 1 mA:
//
//   VCVS  2.0 * 0.5   = 1.0 V
//   VCCS  3m  * 0.5   = 1.5 mA
//   CCVS  4.0 * 1m    = 4.0 mV
//   CCCS  5.0 * 1m    = 5.0 mA
//
// `flowZ28cpZ2ccnZ29` is the §5.4.2 branch-flow unknown `flow(cp,cn)` under the
// codegen's identifier mangling (Z28 `(`, Z2c `,`, Z29 `)`). It has to be
// spelled that way here because tb.zig's `ix()` looks the directive name up in
// the generated enum, and `bias` splits its line on commas — so a `sweep` of
// one point is the only way to hold a branch current.
//
// On tolerances: 0.7 - 0.2 is 0.49999999999999994, not 0.5 — the subtraction is
// exactly rounded but its operands are not exact in binary. So the two products
// that carry that factor are one or two ulp off their decimal want, and the
// right form is a RELATIVE tolerance: 3m * 0.49999999999999994 is
// 1.4999999999999998e-3, which sat only 4.6x inside its old absolute 1e-18.
//
// The two products taken off the swept branch flow carry no such factor and are
// bit-exact, so those stay CHECKX — but NOT for the reason "1e-3 times a small
// integer is exact", which is false in general: 1e-3 is not representable and 5
// is not a power of two. 4.0*1e-3 is exact because scaling by 4 only shifts the
// exponent. 5.0*1e-3 == 5e-3 holds because the single rounding of
// 5*double(1e-3) happens to land on double(5e-3) — checked, not derived. Change
// either coefficient and the CHECKX has to be re-verified, not assumed.
//
//! lrm 5.4.1
//! lrm 5.4.2
// §5.6.2.1 "The four controlled sources": the clause prints one skeleton
// (`branch (ps,ns) in; branch (p,n) out;`) and the four statements above,
// and says "Each statement creates a unique controlled source" — the four
// answers asserted here are exactly those four statements' values.
//! lrm 5.6.2
//! lrm 5.6.2.1
//! bias V(cp) = 0.7, V(cn) = 0.2
//! sweep flowZ28cpZ2ccnZ29 = 1m
`include "check.vh"
module ch5_controlled_sources(op, on, cp, cn);
  inout op, on, cp, cn; electrical op, on, cp, cn;
  branch (cp, cn) sensed;
  analog begin
    `CHECKR("named branch potential is its node difference", V(sensed), 0.5, 1e-15);
    `CHECKR("VCVS: 2 * V(cp,cn)", 2.0 * V(cp, cn), 1.0, 1e-15);
    `CHECKR("VCCS: 3m * V(cp,cn)", 3m * V(cp, cn), 1.5e-3, 1e-15);
    `CHECKX("CCVS: 4 ohm * I(sensed)", 4.0 * I(sensed), 4.0e-3);
    `CHECKX("CCCS: 5 * I(sensed)", 5.0 * I(sensed), 5.0e-3);
    V(op, on) <+ 2.0 * V(cp, cn);
    I(op, on) <+ 3m * V(cp, cn);
    V(sensed) <+ 4.0 * I(sensed);
    I(op, on) <+ 5.0 * I(sensed);
  end
endmodule
