// §5.10 held state for a variable whose ONLY writes inside an event body are
// not assignment statements. Three writers that are assignments in everything
// but spelling:
//
//   §4.7.2.3 Output arguments: "At the end of the execution of the analog
//   user-defined function, the last value assigned to the output argument is
//   then assigned to the corresponding analog variable reference that was
//   passed into the function."
//
//   §9.13.1 $random: "If the random_seed argument is specified it is an inout
//   argument; that is, a value is passed to the function and a different value
//   is returned. The variable should be initialized by the user prior to
//   calling $random and only updated by the system function."
//
//   §9.5.4.2 $sscanf: "Both functions read characters, interpret them
//   according to a format, and store the results."
//
// and the rule that the value so stored survives: §5.6.1.3, "UNLIKE
// VARIABLES, the contributed value for a branch is only valid for the current
// iteration", with §5.10's "the execution of the procedural statement is
// skipped unless the analog event has occurred" — at a point where the event
// does not fire nothing writes the variable, so it reads what the last write
// left. Fixtures 04, 07 and 08 pin that for assignment targets and for an
// inout copy-out on the spine; this pins the three writers under an `@`.
//
// THE DERIVATION.
//
//   b: `@(initial_step) a = dbl(1.0, b);` fires at t = 0 only (§5.10.2, the
//   first point of the analysis). dbl assigns its output y = 2.0 * x = 2.0, so
//   b = 2.0 from t = 0 on, and nothing else writes it: b = 2, 2, 2. (a = 1.0,
//   the return value, is an ordinary target and is not the point.)
//
//   k: `@(initial_step) n = $sscanf("42", "%d", k);` stores 42 into k at t = 0
//   and never again: k = 42, 42, 42.
//
//   seed: declared `integer seed = 7;` (A.2.2.1, the user's initialization
//   §9.13.1 asks for) and written ONLY as $random's seed, once per
//   `timer(0, 1n)` occurrence, i.e. at t = 0, 1n, 2n (§5.10.3.3). The update is
//   IEEE 1364-2005 §17.9.3's: Table 17-17 maps $random to
//   `rtl_dist_uniform(seed, LONG_MIN, LONG_MAX)`, which calls `uniform` once,
//   whose only write to the seed is `*seed = 69069 * (*seed) + 1;` on a 32-bit
//   `long` (§9.13.2: "the seed argument shall be an integer", 32 bits by §3.2).
//   So each draw maps s -> 69069 s + 1 mod 2^32, read back as signed:
//
//     69069 * 7 + 1                          =            483 484
//     69069 * 483 484 + 1  = 33 393 756 397;  - 7 * 2^32  = 3 328 985 325
//                                             - 2^32      = -965 981 971
//     69069 * -965 981 971 + 1 = -66 719 408 754 998; + 15 535 * 2^32
//                                             = 2 908 188 362 - 2^32
//                                             = -1 386 778 934
//
//   `entry` records the seed the event FOUND and `leave` the seed it LEFT:
//
//     t      entry          leave
//     0      7              483 484
//     1n     483 484        -965 981 971
//     2n     -965 981 971   -1 386 778 934
//
// Without retention the seed restarts at its declared 7 at every evaluation
// and every row reads 7 -> 483 484: the stream §9.13.1 promises ("shall always
// return the same stream of values given the same initial random_seed")
// degenerates into one value repeated. Without retention of an output actual,
// b reads 0 at 1n and 2n, and k reads 0 likewise.
//
//! lrm 5.10
//! lrm 5.6.1.3
//! lrm 4.7.2.3
//! lrm 9.13.1
//! lrm 9.5.4.2
//! lrm 9.5.4.2:1
//! lrm 9.13.1:3
//! analysis tran
//! time 0, 1n, 2n
`include "check.vh"
module a03_held_through_writers(p);
  inout p; electrical p;
  real a, b;
  integer n, k, r, entry, leave;
  integer seed = 7;

  analog function real dbl;
    input x; output y;
    real x, y;
    begin
      y = 2.0 * x;
      dbl = x;
    end
  endfunction

  analog begin
    @(initial_step) begin
      a = dbl(1.0, b);
      n = $sscanf("42", "%d", k);
    end
    @(timer(0, 1n)) begin
      entry = seed;
      r = $random(seed);
      leave = seed;
    end
    `CHECKX("b, written only by an output actual at t = 0, holds", b, 2.0);
    `CHECKI("k, written only by $sscanf at t = 0, holds", k, 42);
    `CHECKI("the seed each draw finds", entry,
            ($abstime < 0.5n) ? 7 : (($abstime < 1.5n) ? 483484 : -965981971));
    `CHECKI("the seed each draw leaves", leave,
            ($abstime < 0.5n) ? 483484 : (($abstime < 1.5n) ? -965981971 : -1386778934));
    I(p) <+ 0.0;
  end
endmodule
