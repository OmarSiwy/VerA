// §5.10.3.1 cross(). "The cross() function will not generate events for
// non-transient analyses, such as ac, dc, or noise analyses" — it can only
// generate an event after simulation time has advanced from zero.
//
// So at this single dc point the event cannot fire, whatever V(c) is, and
// `held` keeps the zero §3.2 gives a real variable. The bias is chosen so
// that a firing would be visible: V(p)=0.4, and V(c) sits above the threshold
// — exactly the case §5.10.3.2 says above() WOULD fire on and cross() must not.
//
//! lrm 5.10.3.1
//! bias V(c) = 1.25, V(p) = 0.4
`include "check.vh"
module ch5_cross(p, c);
  inout p, c; electrical p, c; real held;
  analog begin
    `CHECK("the value a firing would have sampled", V(p), 0.4, 1e-15);
    @(cross(V(c), +1, 1p)) held = V(p);
    `CHECK("cross() generates no event in dc", held, 0.0, 0.0);
    I(p) <+ held;
  end
endmodule
