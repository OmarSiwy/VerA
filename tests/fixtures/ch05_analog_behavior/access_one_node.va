// LRM 5.4.1 Example 2: "V(n1) does the same from n1 to the global reference
// node (ground)" — the one-argument access function names the unnamed branch
// from the net to ground, so its potential IS the node potential. Held at
// 0.7 V, the probe must read 0.7 V.
//
//! lrm 5.4.1
//! lrm 5.4.1:1000
//! bias V(p) = 0.7
`include "check.vh"
module ch5_access_one(p);
  inout p; electrical p;
  analog begin
    `CHECK("V(p) is the p-to-ground branch potential", V(p), 0.7, 1e-15);
    I(p) <+ V(p);
  end
endmodule
