// LRM 5.2.1: an analog initial block initializes variables before the analog
// block runs; LRM 3.2 starts an integer at 0, so `mode` reading 1 is the
// initial block's doing. The 0.0*V(p) term makes the contribution independent
// of the bias (LRM 4.2.3 multiplication by zero), so at V(p) = 1.5 the
// contributed flow is still the integer 1 converted to real (LRM 4.2.1.2).
//
//! lrm 5.2.1
//! lrm 4.2.1.2
//! bias V(p) = 1.5
`include "check.vh"
module ch5_initial_integer(p);
  inout p; electrical p; integer mode;
  analog initial mode = 1;
  analog begin
    `CHECKI("analog initial set the integer", mode, 1);
    `CHECK("bias-independent contribution", mode + 0.0*V(p), 1.0, 1e-15);
    I(p) <+ mode + 0.0*V(p);
  end
endmodule
