// §5.5.1, on the access functions: "The potential and flow access functions
// can also be used to access the potential or flow of a named or unnamed
// branch. ... Note V cannot be used as an access function because there is a
// parameter called V declared in the module."
//
// The clause's own `measure1` example declares `parameter real V = 1.1;` and
// then writes `potential(p)`, because inside that module the name V is the
// parameter: a module-scope declaration hides the access-function name, and a
// real parameter cannot be called. This file does what the note says cannot
// be done, `V(p, n)` with a parameter V in scope.
//
// With the parameter renamed (`parameter real R = 1.1;`) the same module
// compiles (probed), so the only error is the use of the hidden name.
//
// VerA accepts this file and treats `V(p, n)` as the electrical potential
// access, ignoring the parameter that shadows it.
//
//! lrm 5.5.1
//! reject not an access function
//! xfail VerA accepts `V(p, n)` in a module that declares `parameter real V`, reading it as the potential access; §5.5.1 says "V cannot be used as an access function because there is a parameter called V declared in the module"
`include "disciplines.vams"
module ch5_parameter_V_hides_access(p, n);
  inout p, n;
  electrical p, n;
  parameter real V = 1.1;

  analog I(p, n) <+ V(p, n);    // illegal: V names the parameter here
endmodule
