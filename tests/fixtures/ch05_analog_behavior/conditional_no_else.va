// LRM 5.8.2: an if with no else does nothing when the guard is false. At
// V(c) = -0.5 V the strict `>` is false, so the 1 mA contribution is skipped
// and the branch flow stays 0. LRM 4.2.5 makes the guard an integer 0, and
// LRM 2.6.2 makes the `m` scale factor 1e-3, so the amount that would have been
// contributed is 0.001 A.
//
//! lrm 5.8.2
//! bias V(c) = -0.5
`include "check.vh"
module ch5_if_no_else(p, c);
  inout p, c; electrical p, c;
  analog begin
    `CHECKI("guard is false, so the contribution is skipped", V(c) > 0.0, 0);
    `CHECKX("the m scale factor is 1e-3", 1m, 0.001);
    if (V(c) > 0.0) I(p) <+ 1m;
  end
endmodule
