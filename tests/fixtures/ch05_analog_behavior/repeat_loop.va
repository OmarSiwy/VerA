// §5.9.1 `repeat()` executes its statement a fixed number of times, and the
// count expression is evaluated ONCE before the first iteration. Three passes of
// `x = x + V(p)` starting from zero leave x = 3*V(p).
//
// At V(p) = 0.25 that is 0.75, and every partial sum (0.25, 0.5, 0.75) is exact
// in IEEE 754, so a two-pass or four-pass loop cannot round its way to the same
// answer.
//
//! lrm 5.9.1
//! bias V(p) = 0.25
`include "check.vh"
module ch5_repeat(p);
  inout p; electrical p; real x;
  analog begin
    x = 0.0;
    repeat (3) x = x + V(p);
    `CHECKX("repeat(3) runs its body exactly three times", x, 0.75);
    I(p) <+ x;
  end
endmodule
