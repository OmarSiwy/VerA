// LRM 6.2: a module may have multiple analog blocks, and "the behavior of
// multiple analog blocks shall be defined by assuming they internally combine
// into a single analog block IN THE ORDER that the analog blocks appear in the
// module description (i.e. they are concatenated in order)".
//
// `order` witnesses that concatenation: the first block sets it to 1 and the
// second adds 2, so the second block sees 3. Concatenated the other way round —
// or with the first block dropped — the second block would see 0 + 2 = 2, and
// with the second block's own statement dropped it would see 1.
//
//! lrm 5.2
//! lrm 6.2
//! lrm 6.2:8
//! lrm 6.2:7
//! lrm 6.9.1
//! lrm 6.9.1:1
//! lrm 6.9.1:2
//! lrm 6.9.1:3
//! lrm 5.2:1002
`include "check.vh"
module ch5_multiple_blocks(p, n);
  inout p, n; electrical p, n; integer order;
  analog begin
    order = 1;
    I(p, n) <+ 1.0;
  end
  analog begin
    order = order + 2;
    `CHECKI("analog blocks concatenate in source order", order, 3);
    I(p, n) <+ V(p, n);
  end
endmodule
