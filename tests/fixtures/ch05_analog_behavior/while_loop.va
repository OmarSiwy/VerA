// LRM 5.9.1 while(), the executing case: the guard is re-evaluated before each
// pass and the body runs until it is False.
//
// i counts 0, 1, 2 and the loop exits at i = 3 -- three passes, so x accumulates
// V(p) three times. Biased at V(p) = 0.25 that is 3 * 0.25 = 0.75, exact in
// binary. An off-by-one in the guard gives 0.5 or 1.0, and a loop that hoisted
// the guard would not terminate at all.
//
// (5.9 forbids contribution statements inside a loop, so the contribution is
// where it has to be: after the loop, of the accumulated variable.)
//
//! lrm 5.9.1
//! bias V(p) = 0.25
//! lrm 5.9.1:1001
`include "check.vh"
module ch5_while(p);
  inout p; electrical p;
  integer i; real x;
  analog begin
    i = 0; x = 0.0;
    while (i < 3) begin x = x + V(p); i = i + 1; end
    `CHECKI("i < 3 from i = 0 runs the body three times", i, 3);
    `CHECKX("so x accumulates 3 * 0.25 V", x, 0.75);
    I(p) <+ x;
  end
endmodule
