// §5.5.3, last sentence: "The abstol attribute of a nature may also be accessed
// simply by using the nature's identifier as the appropriate argument to the
// ddt(), idt(), or idtmod() operators described in 4.5." §4.5.3 gives ddt its
// optional second argument as `abstol_expression | nature_identifier`.
//
// Annex D.1 is what makes that form reachable: the nature identifiers it
// declares are the only ones a fixture can name without declaring its own, and
// `Voltage` — the potential nature of `electrical` — is one of them. So this is
// the D.1 half of the rule: a standard nature name, used as a value-carrying
// argument rather than as a discipline binding.
//
// The value is fixed by §4.5.3: "In DC analysis, ddt() returns zero (0)"
// (ch4-expressions.html:469). The tolerance argument selects an abstol for the
// solver; it cannot change the operator's result, which is the second check —
// the same expression with and without the nature must agree. §4.5.3 fixes BOTH
// sides of that agreement at 0.0, so both are written as CHECKX against the
// digits rather than as one CHECKEQ relating them: two independent literals are
// strictly stronger than an equality that also holds when both drift together.
// The operator-output metadata also checks the nature's actual abstol. A
// derived nature with 9 nV prevents ignoring the nature argument from passing
// merely because Voltage happens to match an implementation default.
//
//! lrm D.1
//! lrm 5.5.3
//! lrm 4.5.3
//! analysis dc
//! bias V(p) = 0.7
//! lrm 5.5.3:1002
//! abstol ddt$0 = 1e-6
//! abstol ddt$1 = 9e-9
//! checks 5
`include "check.vh"
`include "disciplines.vams"
nature argument_voltage : Voltage;
  abstol = 9n;
endnature
module ch5_nature_ddt_arg(p);
  inout p; electrical p;
  real standard_value, derived_value, default_value;
  analog begin
    standard_value = ddt(V(p), Voltage);
    derived_value = ddt(V(p), argument_voltage);
    default_value = ddt(V(p));
    `CHECKX("ddt() with a nature as its abstol argument is 0 in DC", standard_value, 0.0);
    `CHECKX("a derived nature changes the tolerance, not the DC value", derived_value, 0.0);
    `CHECKX("ddt() with no nature argument is 0 in DC, so the nature does not change the value", default_value, 0.0);
    I(p) <+ ddt(V(p), Voltage);
  end
endmodule
