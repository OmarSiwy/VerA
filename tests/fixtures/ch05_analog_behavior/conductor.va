// LRM 5.6.3 linear conductor: I(cond) <+ G * V(cond). The parameter takes its
// LRM 3.4 declared default, and LRM 2.6.2 makes `1m` = 1e-3, so G = 0.001 S.
// At V(p) = 1.0 and V(n) = 0.4 the branch potential is 0.6 V (LRM 5.4.1), hence
// I = 0.001 * 0.6 = 600 uA.
//
// 1.0 - 0.4 rounds to exactly 0.6 and 0.001 * 0.6 rounds to exactly the double
// nearest 6.0e-4, so the product is bit-identical to the want and the check is
// CHECKX. It used to carry a relative tolerance of 1e-12 — 5534 ulp of slack on
// an operation with none.
//
//! lrm 5.6.3
//! lrm 5.4.1
//! bias V(p) = 1.0, V(n) = 0.4
`include "check.vh"
module ch5_conductor(p, n);
  inout p, n; electrical p, n; parameter real g = 1m;
  analog begin
    `CHECKX("the parameter default carries its scale factor", g, 0.001);
    `CHECKX("Ohm's law for the conductor", g * V(p, n), 6.0e-4);
    I(p, n) <+ g * V(p, n);
  end
endmodule
