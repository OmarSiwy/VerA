// LRM 5.6.3 linear conductor: I(cond) <+ G * V(cond). The parameter takes its
// LRM 3.4 declared default, and LRM 2.5.1 makes `1m` = 1e-3, so G = 0.001 S.
// At V(p) = 1.0 and V(n) = 0.4 the branch potential is 0.6 V (LRM 5.4.1), hence
// I = 0.001 * 0.6 = 600 uA.
//
//! bias V(p) = 1.0, V(n) = 0.4
`include "check.vh"
module ch5_conductor(p, n);
  inout p, n; electrical p, n; parameter real g = 1m;
  analog begin
    `CHECKX("the parameter default carries its scale factor", g, 0.001);
    `CHECKR("Ohm's law for the conductor", g * V(p, n), 6.0e-4, 1e-12);
    I(p, n) <+ g * V(p, n);
  end
endmodule
