// §5.6.1.2 two charges meeting at one pin stay two charge states.
//
// §5.6.1.2: the reactive part of a contribution is the charge (or flux) whose
// time derivative the simulator takes; §5.6.1 accumulates contributions to a
// node. A host that tapes ONE charge per node row therefore sums the gate's
// qgs and qgd before it looks at them, and a truncation check that SPICE runs
// on each (mos1trun.c) runs on the sum. VerA's `q` returns one charge per
// `ddt` site instead, with `q_stamps` saying which rows each enters, so the
// gate row is still `qgs + qgd` (the row the host stamps) while the host can
// check `qgs` and `qgd` apart.
//
// THE SITES, in source order (§1.3.1.2: +charge at hi, −charge at lo; each
// line lists its rows in the order of `U`, ports first as declared):
//
//   0  I(g,s) <+ ddt(cgs*V(g,s))                     g+ s-
//   1  I(g,d) <+ ddt(cgd*V(g,d))                     g+ d-
//   2  I(d,s) <+ ddt(c1*V(d,s)) + ddt(c2*V(d,s)*V(d,s))
//      — ONE statement, two additive `ddt` terms, so two sites:  s- d+
//   3  the second term of that statement                          s- d+
//
// So row g is stamped by sites 0 and 1 and row s by 0, 2 and 3 — the
// per-site split this fixture exists for. All four are checked (no
// `vera_lte`).
//
// The value check is the other half: the charges still add up to the row a
// per-row host would have taped. At the bias below, with the charges
// qgs = cgs*0.5, qgd = cgd*(0.5 - 1.0) (the gate row) — a CHECK on the model's
// own variables, since the device cannot read its own `q`:
//   qg = 1e-12*0.5 + 2e-12*(-0.5) = -5e-13.
//! lrm 5.6.1.2
//! lrm 5.6.1
//! bias V(g) = 0.5, V(s) = 0.0, V(d) = 1.0
//! print none
//! qsite g+ s- lte
//! qsite g+ d- lte
//! qsite s- d+ lte
//! qsite s- d+ lte
`include "check.vh"
module charge_sites_two_on_one_pin(g, s, d);
  inout g, s, d; electrical g, s, d;
  parameter real cgs = 1e-12, cgd = 2e-12, c1 = 3e-12, c2 = 4e-12;
  real qgs, qgd;
  analog begin
    qgs = cgs * V(g, s);
    qgd = cgd * V(g, d);
    I(g, s) <+ ddt(qgs);
    I(g, d) <+ ddt(qgd);
    I(d, s) <+ V(d, s) / 1e3 + ddt(c1 * V(d, s)) + ddt(c2 * V(d, s) * V(d, s));
    `CHECK("gate charge is qgs + qgd", qgs + qgd, -5e-13, 1e-27);
  end
endmodule
