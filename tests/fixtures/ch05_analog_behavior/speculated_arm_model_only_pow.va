// §5.8.1: an `if` on V(a, c) whose arms each hold a §4.3.2 `pow`, the
// junction-charge shape of a diode. The else arm's pow(1 - fc, -(1 + m))
// reads only parameters, but after ifconv's `.speculate` it is guarded by
// the branch condition, which reads the solve, so it must stay out of
// `setup` (which has no x). Before the fix the device did not compile:
// "use of undeclared identifier 'x'".
//
// The checks, by hand: V(a, c) = 0.1 < fc * vj = 0.5, so the first arm runs:
// q = cj0 * vj / (1 - m) * (1 - (1 - 0.1)^0.5) = 2 * (1 - sqrt(0.9)) = 0.10263340389897246.
//! lrm 5.8.1
//! lrm 4.3.2
//! bias V(a) = 0.1, V(c) = 0.0
//! checks 1
`include "check.vh"
module speculated_arm_model_only_pow(a, c);
  inout a, c;
  electrical a, c;
  parameter real cj0 = 1.0;
  parameter real vj = 1.0;
  parameter real m = 0.5;
  parameter real fc = 0.5;
  real v, q;
  analog begin
    v = V(a, c);
    if (v < fc * vj)
      q = cj0 * vj / (1 - m) * (1 - pow(1 - v / vj, 1 - m));
    else
      q = cj0 * pow(1 - fc, -(1 + m)) * (v - fc * vj) + cj0 * vj / (1 - m) * (1 - pow(1 - fc, 1 - m));
    `CHECKEQ("the first arm's charge at V = 0.1", q, 0.10263340389897246, 1e-12);
    I(a, c) <+ 1e-3 * q;
  end
endmodule
