// §5.5.2: "Verilog-AMS HDL allows ports, nets, and branches to be arranged as
// vectors, however, the access functions can only be applied to scalars or
// individual elements of a vector. The scalar element of a vector is selected
// with an index, e.g., V(in[1]) accesses the voltage in[1]."
//
// `I(bus)` below applies the flow access function to the whole two-element
// vector. There is no single branch for it to name: a vector net is one node
// per element (§3.6.3). The legal element access is vector_access.va.
//
//! lrm 5.5.2
//! reject-only E0351
//! neighbour vector_access.va
//! lrm 5.5.2:1001
`include "disciplines.vams"
module ch5_access_function_on_whole_vector(p, n);
  inout p, n; electrical p, n;
  electrical [1:0] bus;
  analog I(bus) <+ V(p, n);
endmodule
