// LRM 5.6.2 / 5.4.2.2: a flow source whose value does not depend on any probe
// is a constant current source. The `0.0*V(p,n)` term keeps the branch
// potential in the expression without letting it change the value, so the
// contributed flow is `1u` = 1e-6 A (LRM 2.5.1 scale factor) at EVERY point of
// the sweep — that bias-independence is the whole claim, and it is why the
// check is repeated over two very different branch potentials.
//
//! sweep V(p) = 0.0, 2.0
`include "check.vh"
module ch5_const_i(p, n);
  inout p, n; electrical p, n;
  analog begin
    `CHECKR("the source is independent of its branch potential", 1u + 0.0*V(p, n), 1.0e-6, 1e-12);
    I(p, n) <+ 1u + 0.0*V(p, n);
  end
endmodule
