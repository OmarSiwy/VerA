// §5.10.3.1: cross() generates "a monitored analog event to detect threshold
// crossings in analog signals when the expression crosses zero (0)". A §3.3
// string variable has no numeric value to cross zero with (3.3: "A string
// cannot be assigned to an integral type"), unlike a string LITERAL, which
// §2.7 makes an unsigned integer constant (the neighbour,
// cross_string_literal_is_an_integer.va, monitors "s" = 115 and never fires).
// The grammar does not separate the two (A.8.3's analog_expression derives
// both), so this is the clause's type rule, not a syntax one
// (specification/Vague_Decisions.md VD-107).
//
// VerA refuses the string-typed operand with E0517, the 5.10.3 event-argument
// code; the code is pinned.
//
//! lrm 5.10.3.1
//! lrm 3.3
//! reject-only E0517
//! reject-only is a string
//! neighbour cross_string_literal_is_an_integer.va
`include "check.vh"
module ch5_cross_string_operand(p);
  inout p; electrical p; integer fired, control;
  string s;
  analog begin
    @(cross(s)) fired = fired + 1;              // illegal: a string-typed value
    @(cross(V(p))) control = control + 1;
    `CHECKI("cross of the literal s monitors the constant 115 and never fires", fired, 0);
    `CHECKI("cross(V(p)) fires once, at the first point past its crossing", control, ($abstime > 0.5n) ? 1 : 0);
    I(p) <+ V(p);
  end
endmodule
