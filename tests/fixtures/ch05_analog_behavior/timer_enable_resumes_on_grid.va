// §5.10.3.3: enable returning nonzero resumes timer "as if it had never
// been disabled". The absolute timer(1,2) grid is 1,3,5,7,9 seconds.
// Solved V(en) enables 1, suppresses 3 and 5, then enables 7 and 9.
// Thus counts at declared times 0,1,3,5,7,9 are 0,1,1,1,2,3.
// The event schedule advances while disabled; re-enable must not restart it.
//
// Integer seconds make every declared point and start+k*period exact in f64.
// The previous nanosecond scale demanded delivery at literal 7n, one ULP
// before the closed-form 1n+3*2n deadline. §5.10.3.3 permits at or just
// beyond the event; that demand tested rounding, not enable. Six declared
// points each assert one count, hence checks = 6.
//
// Explicit time_tol=0 selects the simulator's suitable tolerance and places
// enable in argument 4. The emitted-host tests follow actual deadlines to
// exercise floating-point scheduling separately from this fixed-grid test.
//
//! lrm 5.10.3.3
//! lrm 5.10.3.3:2
//! analysis tran
//! time 0, 1, 3, 5, 7, 9
//! checks 6
//! wave V(en) = 1, 1, 0, 0, 1, 1
//! bias V(p) = 0
//! print none
//! lrm 5.10.3.3:1005
`include "check.vh"
module a10_timer_enable_resume(p, en);
  inout p, en;
  electrical p, en;
  integer fired;
  analog begin
    @(timer(1, 2, 0, V(en) > 0.5)) fired = fired + 1;
    `CHECKEQ("a re-enabled timer resumes on the absolute grid it never left", fired,
             ($abstime < 0.5) ? 0 : (($abstime < 6) ? 1 : (($abstime < 8) ? 2 : 3)), 0.0);
    I(p) <+ 0.0;
    I(en) <+ 0.0;
  end
endmodule
