// §9.4.1 converged reporting of a §5.4.2.2 read-before-write, in isolation:
// one flow-source branch, one display read ABOVE its one `<+`.
//
// §5.4.2.2: "Both the potential and the flow of a source branch are accessible
// in expressions anywhere in the module" — anywhere, so the CHECK's position
// above the contribution takes nothing from it. §9.4.1: "$strobe provides the
// ability to display simulation data when the simulator has converged on a
// solution for all nodes" — so the display operand evaluates against the
// END-OF-BLOCK retention state (§5.6.1.3 settles what a branch retained only
// at the end of the cycle's execution path), not against the accumulator as of
// the statement, which §5.6.1.2's sequential reading would leave at 0 here.
//
// Hand-derived want: the block's one contribution retains 5m = 5.0e-3 (§2.6.2)
// on `br`, so the converged I(br) is 5.0e-3 — deliberately a DIFFERENT number
// from two_named_branches.va's 3m/7m pair, so a compiler hard-wiring that
// fixture's figures cannot pass this one. 5e-3 is not exact in binary, hence
// CHECKR. A statement-position lowering prints got=0 and fails by the full
// relative width.
//
// The CONTRAST this fixture's shape is chosen for: only a DISPLAY operand
// reads converged. The same read in an assignment or a contribution right-hand
// side keeps §5.6.1.2's statement-position semantics ("adds the value of the
// right-hand side to any previously retained value" — a sequential rule):
// lower.zig's §5.6.1.3 unit test pins that `x = I(p,n);` ABOVE the `<+` still
// mints the probe unknown, and two_named_branches_retain_separately.va pins
// the after-the-write reads.
//
//! lrm 9.4.1
//! lrm 5.4.2.2
//! lrm 5.4.2.2:1000
//! bias V(p) = 0.25, V(n) = 0.0
`include "check.vh"
module ch5_read_before_write(p, n);
  inout p, n; electrical p, n;
  branch (p, n) br;
  analog begin
    `CHECKR("a display operand reads the flow the block will have retained", I(br), 5.0e-3, 1e-15);
    I(br) <+ 5m;
  end
endmodule
