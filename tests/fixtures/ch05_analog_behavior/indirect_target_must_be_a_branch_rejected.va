// §5.6.7, Syntax 5-6:
//
//     indirect_contribution_statement ::= branch_lvalue : indirect_expression == analog_expression ;
//     branch_lvalue ::= branch_probe_function_call
//
// The left of the `:` names the branch quantity the constraint solves for, so
// it must be a probe of a branch: `V(out)` in the clause's own opamp example.
// `x` below is a real variable. It is not a branch_probe_function_call, and a
// variable is not an unknown of the circuit. The legal form is
// indirect_contribution.va.
//
//! lrm 5.6.7
//! reject-only E0413
//! neighbour indirect_contribution.va
`include "disciplines.vams"
module ch5_indirect_target_must_be_a_branch(p, n);
  inout p, n; electrical p, n;
  real x;
  analog x : V(p, n) == 0;
endmodule
