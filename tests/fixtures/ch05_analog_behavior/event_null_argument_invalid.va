// §5.10.3.1, the last sentence of the argument list: "If either or both
// tolerances are defined, then the direction shall also be defined."
//
// The call supplies a time_tol but elides the direction, so the dir slot is
// null and that sentence is violated. The reason is what makes the tolerances
// useful at all: a tolerance is the window around a crossing whose DIRECTION
// selects which crossings count, so a tolerance without a direction narrows
// nothing.
//
// DELIBERATELY NOT CITED: §5.10's "Null arguments are not allowed in analog
// events." Read alone it would condemn this file twice over, but the LRM
// refutes that reading in §5.10.3.1's own `sh` example — `@(cross(V(smpl) -
// thresh, dir, , , en === 1'b1))`, two elided slots in a module printed as
// legal — and Syntax 5-16 types those slots analog_expression_or_null. Elision
// as such is permitted, so the only rule this file stands on is the
// tolerance-needs-a-direction sentence, and the diagnostic has to be about the
// missing DIRECTION and not about the comma.
//
// event_cross_any.va is the legal way to say "either direction" — dir written
// as 0, not left out — and must keep compiling.
//
// No VerA code exists for this, so the expectation is the phase label: the file
// must not compile at all.
//
//! lrm 5.10.3.1
//! reject DiagnosticsReported
module ch5_event_null_argument(p);
  inout p; electrical p; real x;
  analog begin
    x = 0.0;
    @(cross(V(p) - 1.0, , 1n)) x = 1.0;
    I(p) <+ x;
  end
endmodule
