// §5.10.3.3 the fourth argument of timer(): "If enable argument is specified
// and it is zero, then timer() is inactive, meaning that it does not generate
// events as long as enable is zero."
//
// `enabled` is declared and never assigned, so §3.2 fixes it at 0. The
// unguarded timer(0.0, 1n) would fire at t = 0, 1n and 2n and toggle `state` to
// 1, 0, 1; disabled, it fires at none of them and `state` keeps the 0.0 §3.2
// gives a real. The three declared timepoints are the first three fires the
// enable has to suppress.
//
// FAILS TODAY — known VerA defect, not a wrong want. The `.timer` arm of
// `updateState` in src/backend/codegen.zig reads args[0] and args[1] only; the
// enable argument (args[3]) is never read, so a disabled timer still fires.
//
//! lrm 5.10.3.3
//! analysis tran
//! time 0, 1n, 2n
`include "check.vh"
module ch5_timer_enable(p);
  inout p; electrical p; real state; integer enabled;
  analog begin
    @(timer(0.0, 1n, 1p, enabled)) state = 1.0 - state;
    `CHECKI("an integer never assigned defaults to 0", enabled, 0);
    `CHECK("timer() with enable = 0 generates no events", state, 0.0, 0.0);
    V(p) <+ transition(state, 0.0, 1p);
  end
endmodule
