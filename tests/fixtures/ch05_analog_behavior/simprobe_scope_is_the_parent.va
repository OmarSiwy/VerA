// §9.16, the RESOLUTION rule, which is a statement about scope and not about
// spelling:
//
//   "To resolve the value, the simulator will look for an instance called
//    inst_name IN THE PARENT OF THE CURRENT INSTANCE i.e. A SIBLING of the
//    instance containing the $simprobe() expression."
//
// The name is therefore resolved RELATIVE to the caller, one level up. That has
// two consequences, and this file pins both, because a flat path lookup from the
// top of the design gets each of them wrong in the opposite direction.
//
// THE DESIGN. Three levels, so that "relative to the caller" and "absolute from
// the top" are distinguishable at all:
//
//   a10_scope_top
//     └── u_mid : a10_scope_mid
//           ├── u_a : a10_scope_dev  #(.gain(3.0))
//           └── u_m : a10_scope_mon   <- both probes are written here
//
//   CLAIM 1  $simprobe("u_a", "gain")  -> 3.0
//            `u_a` is a sibling of `u_m`: same parent, `u_mid`. This is the
//            clause's normal case, and the answer is the override on the
//            instantiation, exactly.
//
//   CLAIM 2  $simprobe("u_mid.u_a", "gain", -1.0) -> -1.0
//            `u_mid.u_a` is NOT an instance in `u_m`'s parent — the instances
//            there are `u_a` and `u_m`, and neither is named `u_mid.u_a`. The
//            clause gives the outcome for that: "If either the inst_name or
//            param_name cannot be resolved, and the optional expression is not
//            supplied, then an error shall be generated. If the optional
//            expression is supplied, its value will be returned in lieu of
//            raising an error." So the required answer is the fallback, -1.0,
//            and -1.0 is chosen precisely because it is NOT 3.0: a tool that
//            resolves this string has resolved a path from the top of the
//            design, which is the very thing the sibling rule excludes.
//
// Claim 2 is the sharper of the two. Claim 1 alone is satisfiable by accident
// (a top-level probe whose caller happens to sit at the root resolves under
// either reading); only a caller that is NOT at the root separates them, which
// is why the monitor is buried one level down.
//
// WHY BOTH FAIL TODAY, in opposite directions. `Lower.lowerSimprobe`
// (src/analog/lower.zig) concatenates `inst_name`, `Elaborate.sep` and `param_name`
// and looks the result up in the flattened parameter table, whose keys are paths
// from the top. So claim 1 looks up `u_a.gain` while the elaborated key is
// `u_mid.u_a.gain` and misses, returning -1.0 where 3.0 is required; and claim 2
// looks up `u_mid.u_a.gain`, HITS, and returns 3.0 where -1.0 is required. The
// clause's own comment in that function calls the computed-name case a ceiling;
// this is the other half — the name is a literal and the SCOPE is wrong.
//
//! lrm 9.16
//! analysis dc
//! bias V(p) = 0.75, V(n) = 0.25
`include "check.vh"
module a10_scope_top(p, n);
  inout p, n;
  electrical p, n;
  a10_scope_mid u_mid(p, n);
endmodule

module a10_scope_mid(a, b);
  inout a, b;
  electrical a, b;
  a10_scope_dev #(.gain(3.0)) u_a(a, b);
  a10_scope_mon u_m(a, b);
endmodule

module a10_scope_dev(c, d);
  inout c, d;
  electrical c, d;
  parameter real gain = 1.0;
  analog I(c, d) <+ gain * V(c, d);
endmodule

module a10_scope_mon(c, d);
  inout c, d;
  electrical c, d;
  real sibling, not_a_sibling;
  analog begin
    sibling = $simprobe("u_a", "gain", -1.0);
    not_a_sibling = $simprobe("u_mid.u_a", "gain", -1.0);
    `CHECKX("a sibling of the CALLER resolves, at any depth", sibling, 3.0);
    `CHECKX("a path from the top is not a sibling, so it takes the fallback",
            not_a_sibling, -1.0);
    I(c, d) <+ 0.0 * V(c, d);
  end
endmodule
