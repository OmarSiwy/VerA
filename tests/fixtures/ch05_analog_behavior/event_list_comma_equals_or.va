// §5.10.1 makes comma and keyword or interchangeable for event lists.
// A one-shot timer triggers at 1 ns while V(c) remains negative; the rising
// crossing triggers later while the timer is inactive. Each spelling must
// count both independent events. A retained nonzero sample checks the body.
// V(c) rises through zero only between 1n and 2n, so the wants are written
// per declared time: 0 events at 0, the timer's at 1n, both at 2n.
//
//! lrm 5.10.1
//! lrm 5.10.1:1001
//! lrm 5.10.3.1
//! lrm 5.10.3.3
//! analysis tran
//! bias V(p) = 0.7
//! wave V(c) = -1.0, -1.0, 1.0
//! time 0, 1n, 2n
`include "check.vh"
module ch5_event_comma(p, c);
  inout p, c; electrical p, c; real held; integer comma_events, or_events;
  analog begin
    @(cross(V(c), +1), timer(1n, 0.0)) begin
      held = V(p);
      comma_events = comma_events + 1;
    end
    @(cross(V(c), +1) or timer(1n, 0.0)) or_events = or_events + 1;
    `CHECK("the timer half of a comma event list fires on its own",
           held - (($abstime >= 1n) ? 0.7 : 0.0), 0.0, 1e-15);
    `CHECKI("the comma list triggers from each event independently", comma_events,
            ($abstime > 1.5n) ? 2 : (($abstime >= 1n) ? 1 : 0));
    `CHECKI("the keyword or has the same two independent triggers", or_events,
            ($abstime > 1.5n) ? 2 : (($abstime >= 1n) ? 1 : 0));
    I(p) <+ held;
  end
endmodule
