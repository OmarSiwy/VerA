// §5.4.1 Access functions, Example 2 and its restatement:
//
//   "There can only be ONE unnamed branch between any two nets or between a net
//    and implicit ground (in addition to any number of named branches)."
//
// and §5.5.1, which adds a second way to spell the access function for the same
// branch:
//
//   "Signals on nets and branches can be accessed only by either the access
//    functions of the discipline associated with them OR BY THE GENERIC POTENTIAL
//    OR FLOW ACCESS FUNCTIONS."
//
// Put together: `I(m,g)`, `I(g,m)`, `flow(m,g)` and `flow(g,m)` are four
// spellings of ONE branch — two access names crossed with two directions — and
// §5.6.1.1 fixes the sign, "the branch is directed from the first net of the
// access function to the second net". So contributions written in different
// spellings land on the same retained value, with the reversed ones subtracting.
//
// tests/fixtures/ch05_analog_behavior/generic_access.va pins the generic names
// on a NAMED branch, where identity is trivial — the branch has one name. The
// unnamed case, where identity has to be recovered from the terminal pair, has
// no fixture anywhere, and neither does the reversed-direction accumulation.
//
// THE CIRCUIT:
//
//     s --[ 1k ]-- m ---( two contributions to the one unnamed branch (m,g) )--- g
//    3.0 V                                                                      0.0 V
//
//     I(m, g)    <+ 1m       directed m -> g
//     flow(g, m) <+ 0.5m     the same branch, named generically and reversed
//
// BY HAND. One branch, so §5.6.1.2 accumulates and §5.6.1.1's direction makes
// the second term negative in the first term's sense:
//
//   I(m,g) = 1.0e-3 - 0.5e-3 = 0.5e-3 A
//
// Kirchhoff at m, with the 1 kohm as its only other path:
//
//   (3.0 - V(m))/1000 = 0.5e-3   =>   V(m) = 3.0 - 0.5 = 2.5 V exactly
//
// IF THE FOUR SPELLINGS MADE MORE THAN ONE BRANCH the node voltage is unchanged
// — two parallel current sources of 1 mA and -0.5 mA deliver the same 0.5 mA to
// the node — so V(m) alone proves nothing, and that is why the probe is asserted
// too: `I(m,g)` reads 0.5 mA if there is one branch and 1.0 mA if the reversed
// contribution went somewhere else. The two together are the claim.
//
// CORRECTED AFTER REVIEW. The file is named "under every spelling" but only two
// of the four spellings it names were ever read back — `flow(m,g)` and
// `I(g,m)`, the two crossed cases, were asserted nowhere, so an implementation
// that got branch identity right for the two written forms and wrong for the
// two crossed ones passed. All four are now asserted. The last two assertions
// are the weak ones and are kept only as context: `V(m) = 2.5` holds even if
// the spellings made separate branches (the header says so above), and
// `potential(m,g)` is then algebraically implied by it — that pair pins §5.5.1's
// generic NAME resolving, not §5.4.1's one-branch rule.
//
// THIS FIXTURE PASSES TODAY in all six assertions. It is pinning evidence for
// behaviour the plan lists under "multiple access names" with no test behind
// it; the discriminating content is the first four lines, not the last two.
//
//! lrm 5.4.1
//! lrm 5.5.1
//! lrm 5.6.1.1
//! lrm 5.6.1.2
//! lrm 5.4.1:1000
//! lrm 5.6.1.1:1000
//! lrm 5.6.1.2:1000
//! bias V(s) = 3.0
//! bias V(g) = 0.0
//! solve
//! lrm 5.4.1:1001
//! lrm 5.4.1:1002
`include "check.vh"
module a02_one_unnamed_branch(s, g);
  inout s, g;
  electrical s, g, m;
  analog begin
    I(s, m) <+ V(s, m)/1000.0;
    I(m, g) <+ 1m;
    flow(g, m) <+ 0.5m;

    // All four spellings the header names are read back, because the file's
    // claim is that they are four names for ONE retained value. Asserting only
    // two of the four left the crossed cases — discipline access function with
    // the reversed terminals, generic access function with the declared
    // terminals — resolvable to anything at all.
    `CHECK("the reversed, generically spelled contribution subtracts on the same branch",
           I(m, g), 0.5e-3, 1e-15);
    `CHECK("read back the other way round it is the negation, not a second branch",
           flow(g, m), -0.5e-3, 1e-15);
    `CHECK("the generic flow name in the declared direction is the same value again",
           flow(m, g), 0.5e-3, 1e-15);
    `CHECK("and the discipline access function reversed is its negation, not a third branch",
           I(g, m), -0.5e-3, 1e-15);
    `CHECK("and the 1 kohm drops 0.5 V carrying it", V(m), 2.5, 1e-12);
    `CHECK("the generic potential name is the same quantity", potential(m, g), 2.5, 1e-12);
  end
endmodule
