// §5.5.4 Creating unnamed branches using hierarchical net references:
//
//   "An access function in a module can have one or more hierarchical net
//    references to nets in other module instances. In these cases, a new
//    unnamed branch is created in the module containing the access function
//    call."
//
// The clause's example strobes three probes — `V(top.drv.a)`,
// `V(top.drv.a, top.drv.b)` and `V(a, top.drv.a)` — covering the three shapes:
// one hierarchical net against ground, two hierarchical nets, and a local net
// against a hierarchical one. `hierarchical_access_unsupported.va` transcribes
// that example, but its only CHECK reads the LOCAL source (and its strobes print
// without asserting), so none of the three hierarchical reads is actually
// pinned. This file pins all three, on a solved operating point.
//
// The path is `drv.a`, not `top.drv.a`, for the reason the sibling file gives:
// §5.5.5 prints the resolvable shape, and a fixture cannot name a `top` it does
// not instantiate.
//
// THE CIRCUIT. The child pins its own nets, V(drv.a) = 1.0 and V(drv.b) = 0.25.
// The parent pins its local net, V(a) = 2.5. Nothing else is connected, so the
// solve reproduces those three values and the probes answer, by hand:
//
//   V(drv.a)           = 1.0
//   V(drv.a, drv.b)    = 1.0 - 0.25 = 0.75
//   V(a, drv.a)        = 2.5 - 1.0  = 1.5
//
// Each is exact in binary. The new unnamed branches are PROBES (§5.4.2.1): only
// their potential is read, so they draw no flow and cannot move the child's
// nodes — which is what makes the child's own numbers the right oracle.
//
//! lrm 5.5.4
//! lrm 5.4.1
//! lrm 5.5.4:1000
//! solve
`include "check.vh"
module ch5_hier_net_probes(g);
  inout g;
  electrical g, a;
  ch5_hier_net_probes_drv drv(g);
  analog begin
    V(a) <+ 2.5;
    `CHECKX("a hierarchical net against implicit ground", V(drv.a), 1.0);
    `CHECKX("two hierarchical nets of one instance", V(drv.a, drv.b), 0.75);
    `CHECKX("a local net against a hierarchical net", V(a, drv.a), 1.5);
    I(g) <+ 0.0;
  end
endmodule

module ch5_hier_net_probes_drv(t);
  inout t;
  electrical t, a, b;
  analog begin
    V(a) <+ 1.0;
    V(b) <+ 0.25;
    I(t) <+ 0.0;
  end
endmodule
