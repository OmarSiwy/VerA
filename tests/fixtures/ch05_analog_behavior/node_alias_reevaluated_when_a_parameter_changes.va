// §9.20 Analog Node Alias System Functions, the sentence that makes the alias a
// RUNTIME binding rather than an elaboration-time one:
//
//   "It shall be an error for the $analog_node_alias() and $analog_port_alias()
//    system functions to be used outside the analog initial block. Along with
//    their enclosing analog initial block scopes, both system functions shall be
//    RE-EVALUATED EACH SWEEP POINT OF A DC SWEEP AS NEEDED (see 5.2.1 and 8.2
//    for details)."
//
// and §5.2.1, which spells out when "as needed" bites:
//
//   "The analog initial block is executed once for each analysis, and can be
//    executed for each sub-task of parameter sweep analysis (such as dc sweep).
//    IF A PARAMETER OR VARIABLE THAT IS REFERENCED FROM AN analog initial BLOCK
//    IS CHANGED DURING A SUB-TASK OF A PARAMETER SWEEP ANALYSIS, THEN THE
//    analog initial BLOCK SHALL BE RE-EXECUTED so that the new value is taken
//    into account."
//
// The alias below is chosen by the parameter `sel`, so re-execution is not
// optional here — it is the clause's own trigger condition, word for word.
//
// The `if` is legal under §9.20's own restriction: "shall not be used inside
// conditional (if, case, or ?:) statements UNLESS the conditional expression
// controlling the statement consists of terms which can not change during the
// course of a simulation." A parameter cannot change during a simulation; it
// changes BETWEEN the sub-tasks of a parameter sweep, which is exactly the case
// §5.2.1 hands the re-execution rule to. tests/fixtures/ch09_system_tasks/
// node_alias_nonconstant_conditional_rejected.va pins the other side of that
// same sentence, so this file and that one must both hold at once.
//
// THE TOPOLOGY. The child has two nets the parent's design drives to different
// potentials and one local net `n1` that nothing drives:
//
//   V(a) <+ 2.0     V(b) <+ 5.0     n1 aliased to one or the other
//
// §9.20: the aliased net "shall refer to the same circuit matrix position" as
// its target, so V(n1) is the target's potential and nothing else. Without an
// alias `n1` is an isolated node and reads 0.
//
// BY HAND — two sweep points, two answers, both read off the two sources:
//
//   sel = 0   ->  n1 aliased to ...ch1.a  ->  V(n1) = 2.0 V
//   sel = 1   ->  n1 aliased to ...ch1.b  ->  V(n1) = 5.0 V
//
// folded onto one literal with the parameter itself: `V(n1) - sel*3.0` is 2.0 at
// both points, so one assertion carries both and a compiler that answers the
// same number twice fails at whichever point it is wrong. The second assertion
// keeps §9.20's return value honest — 1 at both points, because both strings
// resolve; a build that re-evaluated but lost the resolution would read 0 and
// silently fall back to "a normal continuous node declared in the module".
//
// OBSERVED BEFORE THE FIX: `got=2 want=2 ok=1` at point 0 and `got=-1 want=2 ok=0` at
// point 1 — V(n1) is still 2.0 there, so the folded expression reads 2 - 3 =
// -1. The alias is resolved once, during elaboration, and the second sweep
// point reuses the first point's binding. `status` reads 1 at both points, so
// the failure is silent — the model's own return-value check, which §9.20
// explicitly encourages ("the user is encouraged to check the return value"),
// cannot detect it.
//
// DIAGNOSIS (2026-09-23). It is worse than a stale binding. `bindAlias`
// (src/analog/lower/hier_name.zig) edits the compile-time map `node_voltages` while
// the statement is being LOWERED, and lowering visits both arms of the `if`. So
// the arm lowered last, the `else`, wins whatever `sel` is. A copy of this file
// with the DEFAULT changed to `sel = 1` and no sweep at all still reads
// V(n1) = 2.0 (got=-1 want=2). The alias condition is never evaluated, not even
// against the declared default. `status` hides it because both arms resolve.
// FIXED 2026-09-24: an alias call under a parameter condition is recorded with
// the conditions that chose it, and a potential probe of the net is a select
// over the candidates on those conditions, re-evaluated against the card
// (`lower_hier_name.aliasProbe`). A contribution to such a net, a flow through
// it or a `ddx` with respect to it is refused (E0812), not routed.
//
//! lrm 9.20
//! lrm 9.20:8
//! lrm 5.2.1
//! lrm 5.2.1:2
//! lrm 9.20:10
//! lrm 9.20:11
//! bias V(g) = 0.0
//! psweep sel = 0, 1
//! solve
`include "check.vh"
module a02_alias_resweep(g);
  inout g;
  electrical g;
  parameter integer sel = 0 from [0:1];
  a02_alias_resweep_checker #(.sel(sel)) ch1();
  analog begin
    I(g) <+ 0.0;
  end
endmodule

module a02_alias_resweep_checker;
  electrical a, b, n1;
  parameter integer sel = 0 from [0:1];
  integer status;
  analog initial begin
    if (sel) status = $analog_node_alias(n1, "a02_alias_resweep.ch1.b");
    else status = $analog_node_alias(n1, "a02_alias_resweep.ch1.a");
  end
  analog begin
    V(a) <+ 2.0;
    V(b) <+ 5.0;
    `CHECKI("both hierarchical references resolve, at both sweep points", status, 1);
    `CHECK("the alias is re-evaluated, so it follows the swept parameter",
           V(n1) - sel*3.0, 2.0, 1e-12);
  end
endmodule
