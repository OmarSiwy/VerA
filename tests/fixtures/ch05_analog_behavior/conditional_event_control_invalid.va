// §5.8: "Event control statements (e.g.: timer, cross) cannot be used inside
// conditional statements unless the conditional expression is a constant
// expression", and §5.10.3.1 repeats it for cross() specifically: it "shall not
// be used inside an if, case, casex, or casez statement unless the conditional
// expression is a genvar expression".
//
// `V(c) > 0.5` is neither: a probe comparison is re-evaluated at every Newton
// iteration, at operating points the detector never sees. Note this is STRICTER
// than §5.8.1's rule for analog operators, which conditional_filter_invalid.va
// pins — `if (analysis("dc"))` licenses a filter but still not an event.
//
// The guarded statement is a plain assignment, and event_cross_enable.va shows
// the legal way to write the same intent: the event on the spine of the block
// with the condition inside its body.
//
//! lrm 5.8
//! lrm 5.10.3.1
//! reject E0707
module ch5_conditional_event_control(p, c);
  inout p, c; electrical p, c; real x;
  analog begin
    x = 0.0;
    if (V(c) > 0.5) @(initial_step) x = 1.0;
    I(p) <+ x;
  end
endmodule
