// §5.11 break "can only be used in a loop", and §4.7.1 makes an analog
// function's body its own scope: the loop a `break` can name is a loop of the
// FUNCTION's body, never the loop the call site happens to sit in. VerA
// inlines calls (§4.7.3), so this is exactly the caller-capture hazard the
// §4.7.1 variable isolation already guards against, restated for the jump
// targets.
//
// The function's own `while` runs to `lim` and breaks; the caller's `while`
// must still complete all four passes. Derived by hand:
//
//     count_to(25) = 25 per call, 4 calls  ->  acc = 100
//
// A lowering that let the function's `break` bind the CALLER's loop exits it
// on the first pass instead: acc = 25, silently. Its sibling
// jump_in_function_outside_loop_invalid.va pins the diagnostic for the
// function that has no loop of its own.
//
//! lrm 5.11
//! lrm 4.7.1
//! bias V(p) = 1.0
`include "check.vh"
module ch5_jump_in_function_binds_function_loop(p);
    inout p; electrical p;
    integer j, acc;

    analog function integer count_to;
        input lim;
        integer lim, i;
        begin
            count_to = 0;
            i = 0;
            while (i < 100) begin
                if (i >= lim) break; // binds the function's own while
                count_to = count_to + 1;
                i = i + 1;
            end
        end
    endfunction

    analog begin
        acc = 0;
        j = 0;
        while (j < 4) begin
            acc = acc + count_to(25);
            j = j + 1;
        end
        `CHECKI("a break in the callee never leaves the caller's loop", acc, 100);
        I(p) <+ acc * 1.0e-6;
    end
endmodule
