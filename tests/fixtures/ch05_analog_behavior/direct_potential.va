// §5.4.1 a potential contribution to a conservative branch. Two rules pinned:
//
//   §1.3.1.2/§5.4.1  the branch potential is the + node minus the - node, so
//                    reversing the bias reverses its sign. At V(p)=0.25,
//                    V(n)=1.0 the branch potential is 0.25 - 1.0 = -0.75.
//   §5.4.1           `V(p,n) <+ 0.75` states the equation V(p,n) - 0.75 = 0,
//                    so probing away from the solution measures the mismatch:
//                    -0.75 - 0.75 = -1.5.
//
//! lrm 5.4.1
//! bias V(p) = 0.25, V(n) = 1.0
`include "check.vh"
module ch5_direct_potential(p, n);
  inout p, n; electrical p, n;
  analog begin
    `CHECK("branch potential is p minus n", V(p, n), -0.75, 1e-15);
    `CHECK("potential-source residual V(p,n) - 0.75", V(p, n) - 0.75, -1.5, 1e-15);
    V(p, n) <+ 0.75;
  end
endmodule
