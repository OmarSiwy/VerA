// §5.10.3.2: "the cross() function can only generate an event after the
// simulation time has advanced from zero." V(p) is already 0.5 V above the
// threshold at t = 0 and stays there, so a cross() that evaluated its
// initialization point would report an event at zero; n_p must stay 0. V(q)
// starts at -1 V and is +1 V at the next point, so the same monitor must fire
// once there: the rule suppresses the time-zero event, not crossings in
// general. The threshold expression V(p) - 0.5 is 0.5 at every point, with no
// zero crossing to detect.
//
//! lrm 5.10.3.2
//! lrm 5.10.3.2:1002
//! analysis tran
//! time 0, 1n, 2n
//! wave V(p) = 1.0, 1.0, 1.0
//! wave V(q) = -1.0, 1.0, 1.0
//! checks 6
`include "check.vh"
module ch5_cross_at_zero(p, q);
  inout p, q; electrical p, q;
  integer n_p, n_q;
  analog begin
    @(cross(V(p) - 0.5, +1)) n_p = n_p + 1;
    @(cross(V(q), +1)) n_q = n_q + 1;
    `CHECKI("a signal already above threshold at t=0 did not cross at zero", n_p, 0);
    `CHECKI("the crossing after time advanced fired once", n_q - (V(q) > 0.0), 0);
    I(p) <+ 0.0;
    I(q) <+ 0.0;
  end
endmodule
