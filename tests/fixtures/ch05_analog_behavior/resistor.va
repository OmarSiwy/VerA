// §5.6.3 "Resistor and conductor", the canonical direct contribution: a probe of the branch potential
// drives a flow source on the same branch (Ohm's law). The default resistance is
// written with the §2.6.2 scale factor `k`, which Table 2-1 gives as 1e3, so
// `1k` must be 1000.0 to the last bit.
//
// At V(p) = 1.5, V(n) = 0.25 the branch potential is 1.25 V and the flow is
// 1.25/1000 = 1.25 mA.
//
//! lrm 5.6.3
//! bias V(p) = 1.5, V(n) = 0.25
`include "check.vh"
module ch5_resistor(p, n);
  inout p, n; electrical p, n; parameter real r = 1k from (0:inf);
  analog begin
    `CHECKX("scale factor k is 1e3", r, 1000.0);
    `CHECKX("branch potential is the node difference", V(p, n), 1.25);
    `CHECKR("Ohm's law flow", V(p, n) / r, 1.25e-3, 1e-15);
    I(p, n) <+ V(p, n) / r;
  end
endmodule
