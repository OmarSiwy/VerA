// §5.4.2.1: "If no value is specified for either the potential or the flow, the
// branch is a probe... Using both the potential and the flow of a probe branch
// is illegal."
//
// The unnamed branch (a,b) is never contributed to, so it is a probe. §5.4.2.1
// then fixes ONE of its two quantities at zero — "the branch potential of a flow
// probe is zero, the branch flow of a potential probe is zero" — and which one
// is decided by which the module reads. Reading both asks for two zeros at once
// and there is no branch that satisfies it.
//
// The contrast is source_probe_both.va: that branch IS contributed to, so
// §5.4.2.2's "both the potential and the flow of a source branch are accessible"
// applies and reading both is legal. potential_probe.va and flow_probe.va read
// one each. This file differs from all three only in reading both of a branch
// that has no source.
//
// No VerA code exists for this, so the expectation is the phase label: the file
// must not compile at all.
//
//! lrm 5.4.2.1
//! reject DiagnosticsReported
//! xfail VerA does not classify an unnamed branch as a probe, so it never notices that both quantities of one were read; the module compiles
module ch5_probe_both_quantities(a, b);
  inout a, b; electrical a, b;
  analog I(a) <+ V(a, b) + I(a, b);
endmodule
