// §5.10.3.3 requires the next timer event to use the latest start_time
// and period values from the analog-block evaluation. The default event
// time may be at or just beyond the requested time; this fixed-grid harness
// includes every requested instant and observes events on those points.
//
// DERIVATION: start_time=0, and per=2 ns at the 0 and 2 ns points.
// Events there produce counts 1 and 2. At 4 ns V(ctl)=1, so per becomes
// 4 ns; the event at 4 ns gives count 3 and the next is at 8 ns.
// The 6 ns point keeps count 3; 8 ns gives count 4. Thus 1,2,3,3,4.
// A period frozen at 2 ns would also fire at 6 ns and fail that check.
//
// This example does not distinguish absolute-grid scheduling from adding
// a period to the last event: their deadlines coincide on this waveform.
// timer_runtime_drift.va and tests/fixtures/ch05_analog_behavior/timer_host.zig cover the wider schedule.
//
//! lrm 5.10.3.3
//! analysis tran
//! time 0, 2n, 4n, 6n, 8n
//! wave V(ctl) = 0, 0, 1, 1, 1
//! bias V(p) = 0
//! print none
//! lrm 5.10.3.3:1004
`include "check.vh"
module a10_timer_dynamic_period(p, ctl);
  inout p, ctl;
  electrical p, ctl;
  real per;
  integer fired;
  analog begin
    per = (V(ctl) > 0.5) ? 4n : 2n;
    @(timer(0, per)) fired = fired + 1;
    `CHECKEQ("the next event uses the LATEST period, not the first one", fired,
             ($abstime < 1n) ? 1 : (($abstime < 3n) ? 2 : (($abstime < 7n) ? 3 : 4)), 0.0);
    I(p) <+ 0.0;
    I(ctl) <+ 0.0;
  end
endmodule
