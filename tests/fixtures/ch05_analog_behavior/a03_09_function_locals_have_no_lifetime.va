// §4.7.2.1 the analog user-defined function identifier variable:
//
//   "This internal variable is initialized to zero (0) if the inherited type is
//    numerical ... If this internal variable is not assigned during the
//    execution of the analog user-defined function, then the analog
//    user-defined function will return the variables default initial value."
//
// §4.7.2.3 output arguments:
//
//   "All output arguments of an analog user-defined function are initialized,
//    zero (0) if numeric, empty string ('') if a string, WHICH IN TURN MEANS
//    THAT THE ARGUMENT PASSED TO IT IS RESET TO ZERO (0) or the empty string
//    accordingly."
//
// Initialized on every execution — so nothing inside a function has a lifetime
// that spans calls, and the boundary of the row's held state is the function
// interface. §4.7.1 backs this from the other side ("shall not use ...
// contribution statements or event control statements"): a function body can
// never contain an `@`, so a function-local can never be a §5.10 held variable.
//
// THIS FIXTURE IS THE ANTI-SYMMETRIC PARTNER OF 08. There, a held variable's
// value crossed the function boundary and came back. Here it is destroyed by
// crossing it, and that destruction is what §4.7.2.3 requires.
//
// THE DERIVATION, part 1 — the identifier variable resets between calls.
// `accum` runs `for (i = 0; i < 2; i = i + 1) accum = accum + x;` over a zero
// start, so accum(1.0) = 0 + 1 + 1 = 2. Called twice in one evaluation, the
// second call must also return 2, not 4: if the identifier variable carried
// over, the second call would start at 2 and reach 4. Both are asserted, and
// 2 and 2 is the answer at every timepoint — this half is not time-dependent.
// `i` is a function LOCAL and its reset is implied by the same arithmetic: a
// carried-over i = 2 would make the loop body run zero times and return 0.
//
// THE DERIVATION, part 2 — an output argument zeroes what is passed to it.
// `h` is a held module variable: two one-shot timers (§5.10.3.3) set it to
// 10.0 at t = 1n and t = 3n. It is then passed as the OUTPUT argument of
// `ignore`, which never assigns that formal. §4.7.2.3 makes the pass itself a
// reset, so at the end of every evaluation h is 0 — including t = 1n and t = 3n
// where the event had just written 10, and including t = 2n and t = 4n where
// the retained value would otherwise have been 10:
//
//     t = 0     h = 0    -> ignore resets it       h = 0
//     t = 1n    h = 10   -> ignore resets it       h = 0
//     t = 2n    h = 0 retained                     h = 0
//     t = 3n    h = 10   -> ignore resets it       h = 0
//     t = 4n    h = 0 retained                     h = 0
//
// A flat 0 is a weak-looking want, so the fixture makes it a strong one by
// asserting `hi` as well: `hi` is the value of h read on the line BEFORE the
// call, which is 10 at exactly the two event points. The pair (hi, h) reads
// (0,0), (10,0), (0,0), (10,0), (0,0) — an implementation that never ran the
// events reads hi = 0 everywhere and fails, one that skipped the §4.7.2.3
// reset reads h = 10 and fails, and one that reset h before the events rather
// than at the call reads hi = 0 and fails.
//
// THE DERIVATION, part 3 — the output formal is zero INSIDE the function too.
// §4.7.2.3's first sentence is about the formal, not only about the caller:
// "All output arguments of an analog user-defined function are initialized,
// zero (0) if numeric". So `ignore` returns `z + y` — the literal 5.0 plus its
// own output formal — and 5.0 is the answer only if `y` reads 0 on entry. The
// caller passes `h`, which is 10.0 at t = 1n and t = 3n, so an implementation
// that copied the caller's value IN to an output formal (treating `output` as
// if it were §4.7.2.4's `inout`) returns 15.0 at exactly those two points.
// Earlier this file asserted `dd = 5.0` from a function whose whole body was
// `ignore = z`, which is 5.0 in any compiler that has functions at all and
// pinned nothing; the `+ y` is what gives the assertion its content.
//
// OBSERVED TODAY: this fixture PASSES, and it is the only file in this row that
// pins the function-lifetime clauses at all. Kept as a guard rail: fixture 08's
// copy-out path and this reset path meet in the same held slot.
//
//! lrm 4.7.2.1
//! lrm 4.7.2.3
//! lrm 5.10.3.3
//! analysis tran
//! time 0, 1n, 2n, 3n, 4n
`include "check.vh"
module a03_function_locals(p);
  inout p; electrical p;
  real r1, r2, h, hi, dd;

  analog function real accum;
    input x;
    real x;
    integer i;
    begin
      for (i = 0; i < 2; i = i + 1) accum = accum + x;
    end
  endfunction

  // Declares an output formal and never assigns it: §4.7.2.3's reset is the
  // only thing that reaches the caller's variable.
  analog function real ignore;
    input z;
    output y;
    real z, y;
    begin
      // §4.7.2.3: `y` is an output formal, so it is initialized to 0 here no
      // matter what the caller's variable held. Reading it is the assertion.
      ignore = z + y;
    end
  endfunction

  analog begin
    @(timer(1n, 0.0)) h = 10.0;
    @(timer(3n, 0.0)) h = 10.0;
    hi = h;
    dd = ignore(5.0, h);
    r1 = accum(1.0);
    r2 = accum(1.0);
    `CHECKX("the identifier variable starts at 0 on every call", r1, 2.0);
    `CHECKX("so a second call in the same evaluation returns the same value", r2, 2.0);
    `CHECKEQ("the event did write the held variable", hi,
             (($abstime == 1n) || ($abstime == 3n)) ? 10.0 : 0.0, 0.0);
    `CHECKX("and passing it as an output argument resets it to zero", h, 0.0);
    `CHECKX("and the output formal reads 0 inside the function, though h was 10 there", dd, 5.0);
    I(p) <+ 0.0;
  end
endmodule
