// A VerA limit, not an LRM rule (specification/Vague_Decisions.md §7). §5.4.3 makes
// `I(<u1.a>)` the flow into instance u1 through its port a. VerA reads it as
// the sum of u1's own flow contributions at the net the port is joined to
// (`lower/expr.zig` `instancePortFlow`). A potential source's current is a
// solver unknown instead, whose static retention codegen decides, so an
// instance that drives the port through one is refused by name (E0997)
// rather than read as a partial sum.
//
// port_access_hierarchical_instance.va is the legal neighbour: the same read
// of an instance whose branch at the port is a flow source.
//
//! lrm 5.4.3
//! reject-only E0997
//! neighbour port_access_hierarchical_instance.va
`include "check.vh"
module pah_v(a);
  inout a; electrical a;
  analog V(a) <+ 0.5;
endmodule
module pah_g(a);
  inout a; electrical a;
  parameter real r = 1k;
  analog I(a) <+ V(a) / r;
endmodule
module pah_top(p);
  inout p; electrical p;
  pah_v u1(p);
  pah_g #(.r(1k)) u2(p);
  analog begin
    `CHECKR("u1 drives its port through a potential source", I(<u1.a>), 0.0, 1e-12);
  end
endmodule
