// VerA's batch contract (tools/contract.zig, the lead protocol's batch key),
// not an LRM rule: a batch of operating points shares the `Model` row and the
// `SimState`, and each point has its OWN `Instance`. This module reads all
// three kinds of per-instance value an `eval` can read as a value:
//
//   h, n       §5.10 retained (held) variables, assigned by an event: a real
//              (read per point) and an integer (a per-point decision);
//   $prev(V)   VerA's `path_prev` latch (the value at the last accepted
//              solve), the Meyer averaging mos1 uses;
//   c*ddt(V)   a solve-dependent capacitance, which plants a `path_prev` and
//              a `path_acc` latch (§5.6.1.2's charge, capacitance form);
//
// and branches on the integer, so it is `batch_ok`, `batch_lead` and
// `batch_inst`. The testbench's batch check gives each of its four points a
// different instance (every real field moved apart) and asserts every
// residual and charge equals that point's own scalar evaluation, bit for bit.
// Before `batch_inst`, every point read point 0's instance and the check
// failed on the `h`, `n` and latch terms.
//
// The value check: at the dc point V(a, b) = 0.75, `initial_step` fires
// (§5.10.2, the first point of the analysis), so h = 0.75 exactly and n = 3.
`include "check.vh"
module batch_per_instance_state(a, b);
  inout a, b; electrical a, b;
  real h, c;
  integer n;
  analog begin
    @(initial_step) begin
      h = V(a, b);
      n = 3;
    end
    c = 1e-12 * (1.0 + V(a, b) * V(a, b));
    I(a, b) <+ c * ddt(V(a, b));
    I(a, b) <+ 1e-3 * (V(a, b) + $prev(V(a, b)) + h);
    if (n > 2) I(a, b) <+ 1e-6 * V(a, b);
    `CHECK("initial_step stores the first point's bias in the held h", h, 0.75, 0.0);
    `CHECKI("and 3 in the held n", n, 3);
  end
endmodule
//! lrm 5.10.2
//! analysis dc
//! bias V(a) = 0.75, V(b) = 0.0
//! checks 2
