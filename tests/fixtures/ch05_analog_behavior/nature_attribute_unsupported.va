// §5.5.3 "the attributes for a net or a branch can be accessed by using the
// hierarchical referencing operator (.) to the potential or flow for the net or
// branch", Syntax 5-4:
//
//     nature_attribute_reference ::=
//         net_identifier . potential_or_flow . nature_attribute_identifier
//
// This is the clause's own twocap example, both lines of it: the unnamed branch
// (a,b) taking a.potential.abstol and the named branch cap taking
// n1.potential.abstol.
//
// The abstol argument to ddt() (§4.5.3) is a tolerance hint for the solver's
// time step; it does not change the value ddt() returns. §4.5.3 "In DC
// analysis, ddt() returns zero (0)", so the contributed flows are exactly zero
// whatever c and abstol are, and an implementation that let the extra argument
// leak into the result would report a nonzero number against a deliberately
// nonzero branch potential. The selected abstol comes from the nature
// declaration; this fixture checks access and the DC result, not its value.
//
// The bias pair is 0.75/0.25 and not the 0.7/0.2 that reads more naturally,
// because 0.7 - 0.2 in IEEE-754 double is 0.49999999999999994 — one ulp below
// 0.5 — and the first check is a bit-exact CHECKX. Both operands here are
// negative powers of two, so the difference is 0.5 exactly (see
// controlled_sources.va, which hits the same rounding from the other side and
// pays for it with a relative tolerance).
//
// This language test does not exercise VPI relationships. Its former
// §11.6.2 citation belongs to ch11_vpi/analog_objects.c, which
// traverses nature and discipline handles in the in-process VPI host.
//
//! lrm A.8.9
//! lrm 5.5.3
//! lrm A.8.9:1000
//! bias V(a) = 0.75, V(b) = 0.25, V(n1) = 0.5, V(n2) = 0.125
//! lrm 5.5.3:1001
`include "check.vh"
module ch5_nature_attribute(a, b, n1, n2);
  inout a, b, n1, n2;
  electrical a, b, n1, n2;
  branch (n1, n2) cap;
  parameter real c = 1p;
  analog begin
    `CHECKR("net potential attribute carries Voltage abstol", a.potential.abstol, 1e-6, 1e-12);
    `CHECKR("net flow attribute carries Current abstol", a.flow.abstol, 1e-12, 1e-12);
    `CHECKR("named branch potential attribute is accessible", cap.potential.abstol, 1e-6, 1e-12);
    `CHECKR("named branch flow attribute is accessible", cap.flow.abstol, 1e-12, 1e-12);
    `CHECKX("the probed branch potential is nonzero", V(a, b), 0.5);
    `CHECKX("ddt() with a net-attribute abstol is still zero in dc", ddt(V(a, b), a.potential.abstol), 0.0);
    `CHECKX("and so is the named-branch form", ddt(V(cap), n1.potential.abstol), 0.0);
    I(a, b) <+ c*ddt(V(a, b), a.potential.abstol);
    I(cap)  <+ c*ddt(V(cap), n1.potential.abstol);
  end
endmodule
