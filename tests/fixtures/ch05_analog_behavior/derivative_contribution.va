// §5.4.1 a capacitor written as a flow contribution of a time derivative.
//
// §4.5.3: "In DC analysis, ddt() returns zero (0)." That is the one value this
// fixture can pin without inventing an integration formula — the LRM does not
// fix the transient integration method, so a want for dq/dt at a nonzero
// timestep would be an implementation's answer, not the standard's.
//
// The bias makes the assertion restricting: V(p,n) is 1.25 V, so an
// implementation that let ddt() pass its argument through (or returned C*V)
// would report 1.25 rather than 0.
//
//! lrm 5.4.1
//! lrm 4.5.3
//! bias V(p) = 1.5, V(n) = 0.25
//! lrm 5.6.1:1001
`include "check.vh"
module ch5_derivative(p, n);
  inout p, n; electrical p, n;
  analog begin
    `CHECK("the argument is nonzero", V(p, n), 1.25, 1e-15);
    `CHECKX("ddt() returns exactly zero in dc", ddt(V(p, n)), 0.0);
    I(p, n) <+ 2p * ddt(V(p, n));
  end
endmodule
