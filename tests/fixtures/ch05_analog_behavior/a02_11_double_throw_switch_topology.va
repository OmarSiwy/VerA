// §5.6.5 Switch branches:
//
//   "Contribution to a branch may be switched between potential and a flow
//    during a simulation. ... As a result, contribution statements are allowed
//    within conditional statements but are not allowed within event control
//    statements."
//
// together with the rule for the arm that does not execute. Both clauses state
// it, in different words, and the quoted form below is §5.6.1.3's, not §5.4.4's
// — §5.4.4 reads "If a value is not assigned to a branch, and it is not a probe
// branch, the branch flow is set to zero (0)", while §5.6.1.3 is the per-
// iteration form this fixture actually relies on:
//
//   "If a branch is not contributed to, directly or indirectly, for any
//    particular iteration, and it is not a branch probe, it shall be treated as
//    a flow source with a value of 0"
//
// i.e. an open circuit, decided afresh at each sweep point. `//! lrm 5.6.1.3` is
// declared below so the quote and the recorded cite agree.
//
// tests/fixtures/ch05_analog_behavior/switch_branch_solved.va pins ONE branch
// alternating between potential and flow. This file pins the case the plan calls
// conditional topology: TWO branches in complementary arms, so the closed one
// and the open one swap identity between sweep points and the matrix has two
// genuinely different structures rather than one structure with two row
// contents. A single-pole double-throw relay is the smallest circuit that needs
// that.
//
// THE CIRCUIT — an ideal 4 V source feeding two loaded arms through 1 kohm each,
// with a shorting switch across one series resistor or the other:
//
//                    +--[ 1k ]--o a --[ 1k ]-- gnd
//     4 V --- s -----|          (shorted by V(s,a) <+ 0 when V(c) > 0.5)
//                    +--[ 1k ]--o b --[ 3k ]-- gnd
//                               (shorted by V(s,b) <+ 0 otherwise)
//
// BY HAND, both states, all four numbers exact in binary:
//
//   V(c) = 1.0, arm a closed
//     a is shorted to the source:      V(a) = 4.0 V
//     b is the untouched 1k/3k divider: V(b) = 4.0 * 3/(1+3) = 3.0 V
//
//   V(c) = 0.0, arm b closed
//     a is the untouched 1k/1k divider: V(a) = 4.0 * 1/(1+1) = 2.0 V
//     b is shorted to the source:       V(b) = 4.0 V
//
// Each assertion folds both states onto ONE literal with a §4.2.5 relational —
// an integer 1 or 0 — the way switch_branch_solved.va does:
//
//   V(a) + (V(c) < 0.5)*2.0    closed: 4 + 0 = 4;   open: 2 + 2 = 4
//   V(b) + (V(c) > 0.5)*1.0    closed: 3 + 1 = 4;   open: 4 + 0 = 4
//
// WHICH LINE CATCHES WHICH FAILURE — corrected after review; the sentence that
// used to sit here named the wrong point. Re-derived by substituting each wrong
// topology into both folded expressions at both sweep points:
//
//                          V(c)=1.0 point        V(c)=0.0 point
//   correct     V(a),V(b)   4.0, 3.0  -> 4, 4     2.0, 4.0  -> 4, 4
//   both arms shorted       4.0, 4.0  -> 4, 5     4.0, 4.0  -> 6, 4
//   neither arm shorted     2.0, 3.0  -> 2, 4     2.0, 3.0  -> 4, 3
//
// So each wrong topology is caught by ONE line at EACH point, and it is not the
// same line at both: shorting both arms reds line 2 (reads 5) at the V(c)=1.0
// point and line 1 (reads 6) at the V(c)=0.0 point, and shorting neither reds
// line 1 (reads 2) at the first point and line 2 (reads 3) at the second. Both
// lines and both sweep points are load-bearing; dropping either point leaves one
// of the two wrong topologies caught by only a single assertion.
//
// THIS FIXTURE PASSES TODAY. It is written because the two-branch case has no
// coverage anywhere in tests/fixtures/ and the plan lists conditional topology
// as unfinished; it is also the regression guard for fixtures 01 and 02, both of
// which add rows to the same matrix assembly.
//
//! lrm 5.6.5
//! lrm 5.6.5:1
//! lrm 5.6.5:2
//! lrm 5.4.4
//! lrm 5.6.1.3
//! lrm 5.6.1.3:1
//! lrm 4.2.5
//! lrm 5.4.4:1000
//! bias V(g) = 0.0
//! sweep V(c) = 1.0, 0.0
//! solve
`include "check.vh"
module a02_double_throw(c, g);
  inout c, g;
  electrical c, g, s, a, b;
  analog begin
    V(s) <+ 4.0;
    I(s, a) <+ V(s, a)/1000.0;
    I(s, b) <+ V(s, b)/1000.0;
    I(a) <+ V(a)/1000.0;
    I(b) <+ V(b)/3000.0;

    if (V(c) > 0.5) V(s, a) <+ 0.0;
    else V(s, b) <+ 0.0;

    `CHECK("arm a is shorted to the source, or left as a 1k/1k divider",
           V(a) + (V(c) < 0.5)*2.0, 4.0, 1e-12);
    `CHECK("and arm b is the other way round, on a 1k/3k divider",
           V(b) + (V(c) > 0.5)*1.0, 4.0, 1e-12);
    I(g) <+ 0.0;
  end
endmodule
