// §2.9 VerA's `vera_timepoint` statement attribute: the statement runs on the
// first evaluation of a timepoint, and every later evaluation at that time
// (the Newton iterations, the testbench's lane checks, the §9.4 strobe below)
// reads back what it assigned from a per-instance cache.
//
// §2.9: "An attribute_instance can appear in the Verilog-AMS description as a
// prefix attached to a declaration, a module item, a statement, or a port
// connection." And: "If a value is not specifically assigned to the
// attribute, then its value shall be 1." §2.9 leaves an attribute's meaning
// to the tool; this one is VerA's (specification/Vague_Decisions.md §6).
//
// WHY. A transmission line's convolution walks its whole accepted history
// once per timepoint (ngspice's `cache_t`); without a cache the walk reruns
// on every Newton iteration. The values it reads are the time, the card and
// the held (§5.10) history, none of which an iteration moves.
//
// The strobe runs at the accepted solution, after `eval` filled the cache at
// that time, so every value printed below is read back from the cache. The
// hand derivation, on a grid of exact binary times:
//
//   k counts the firings of timer(0, 1): t = 0, 1, 2. The statement reads k
//   before the `@(timer)` below raises it, so k = ceil(t):
//       t = 0 -> 0, 0.5 -> 1, 1 -> 1, 1.5 -> 2, 2 -> 2.
//   w = 10 k + t                      0, 10.5, 11, 21.5, 22
//   e[i] = (i + 1) w (a runtime-indexed, memory-backed array), so e[2] = 3 w
//   m = k + 100, an integer cached by a second statement whose value is
//   written out (`= 1`, a constant)   100, 101, 101, 102, 102
//
// `wu` is the same expression outside the statement, uncached: the identity
// `w == wu` says the cache returns what the statement computes, at every
// point and not only the first. Four verdicts at five points. The values
// change from point to point, so the hand derivation above is asserted with
// CHECKEQ against its own formula in $abstime rather than as digits.
//! lrm 2.9
//! lrm 2.9:3
//! analysis tran
//! time 0, 0.5, 1, 1.5, 2
//! checks 20
`include "check.vh"
module vera_timepoint_cache(p, n);
  inout p, n; electrical p, n;
  integer k, i, m;
  real w, wu;
  real e[0:2];
  analog begin
    (* vera_timepoint *) begin
      w = 10.0 * k + $abstime;
      for (i = 0; i < 3; i = i + 1) e[i] = (i + 1) * w;
    end
    (* vera_timepoint = 1 *) m = k + 100;
    wu = 10.0 * k + $abstime;
    I(p, n) <+ V(p, n) / 1k + 1u * w;
    `CHECKEQ("the cached value is the statement's value", w, wu, 0.0);
    `CHECKEQ("w = 10 ceil(t) + t", w, 10.0 * ceil($abstime) + $abstime, 0.0);
    `CHECKEQ("a cached array element, e[2] = 3 w", e[2], 3.0 * w, 0.0);
    `CHECKEQ("a cached integer, m = ceil(t) + 100", m, ceil($abstime) + 100.0, 0.0);
    @(timer(0, 1.0)) k = k + 1;
  end
endmodule
