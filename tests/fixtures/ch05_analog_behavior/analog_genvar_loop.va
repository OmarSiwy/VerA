// §5.9.3 Syntax 5-12, the analog_for statement:
//
//     for ( genvar_initialization ; genvar_expression ; genvar_iteration )
//        analog_statement
//
// and §5.5.2 "The index must be a constant expression, though it may include
// genvar variables. Genvar variables can only be assigned to as the iteration
// index of for loops; they allow signal access within looping constructs."
//
// This is §5.9.3's own genvarexp example with width fixed at 3 so the sum has
// digits. The loop is statically unrolled, so `tmp` ends at
//
//     V(dt[1]) + V(dt[2]) + V(dt[3]) = 0.5 + 0.25 + 0.125 = 0.875
//
// exact in binary. A loop that ran one iteration short reads 0.75, one that
// started at k = 0 reads 0.875 plus an out-of-range element.
//
// §4.5.3 "In DC analysis, ddt() returns zero (0)", so the three per-iteration
// ddt() instances the LRM writes into the body contribute exactly nothing here;
// that is asserted too, because §4.5.15 gives each unrolled instance its own
// operator state and a shared one would still read zero in dc — the digits that
// discriminate are `tmp`'s.
//
//! lrm 5.9.3
//! bias V(dt[1]) = 0.5, V(dt[2]) = 0.25, V(dt[3]) = 0.125
//! xfail VerA has no vector nets or genvar loops: `input [1:width] dt` dies at E0208 (expected an identifier: found `[`)
`include "check.vh"
module ch5_genvar(out, dt);
  parameter integer width = 3;
  output out;
  input [1:width] dt;
  electrical out;
  electrical [1:width] dt;
  genvar k;
  real tmp;
  analog begin
    tmp = 0.0;
    for (k = 1; k <= width; k = k + 1) begin
      tmp = tmp + V(dt[k]);
      V(out) <+ ddt(V(dt[k]));
    end
    `CHECKX("the analog_for sums V(dt[1..3]) over the genvar", tmp, 0.875);
    `CHECKX("ddt() in the unrolled body is zero in dc", ddt(V(dt[2])), 0.0);
  end
endmodule
