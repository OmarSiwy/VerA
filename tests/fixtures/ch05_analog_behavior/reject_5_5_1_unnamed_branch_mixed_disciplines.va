// §5.5.1: "When the potential and flow access functions are used on an
// unnamed branch composed of two nets – the discipline of both nets must be
// the same."
//
// `potential(p, t)` builds an unnamed branch between `p` (electrical) and `t`
// (thermal). The generic `potential` access is used precisely so that no
// discipline-specific access name is involved; the only defect is that the two
// nets' disciplines differ. `potential(p)` alone is legal.
//
// VerA reports E0355 "incompatible disciplines: `p` is of discipline
// `electrical` and `t` is of discipline `thermal`".
//
//! lrm 5.5.1
//! lrm 5.5.1:5
//! reject-only E0355
`include "disciplines.vams"
module ch5_unnamed_branch_mixed(p, t);
  inout p, t;
  electrical p;
  thermal t;

  analog I(p) <+ potential(p, t);   // illegal: p and t differ in discipline
endmodule
