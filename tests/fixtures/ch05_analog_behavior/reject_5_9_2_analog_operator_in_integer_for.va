// §5.9.2: "In the case of analog_for statement the control mechanism shall
// consist of genvar_initialization and genvar_expressions to adhere to the
// restrictions associated with the use of analog operators."
//
// The loop here is controlled by `integer i`, not a genvar, and its body
// calls ddt(), an analog operator. Declaring `genvar i;` instead makes the
// same loop legal, and VerA compiles that form (probed).
//
// VerA reports E0514 "analog operator under a condition that can change during
// the solve: `ddt`" — an integer loop bound is a run-time condition, which is
// what the genvar requirement exists to exclude.
//
//! lrm 5.9.2
//! lrm 5.9.2:1
//! reject-only E0514
//! neighbour analog_genvar_loop.va
`include "disciplines.vams"
module ch5_analog_operator_in_integer_for(p, n);
  inout p, n;
  electrical p, n;
  integer i;
  real x;

  analog begin
    x = 0.0;
    for (i = 0; i < 2; i = i + 1)       // illegal control: i is not a genvar
      x = x + ddt(V(p, n));
    I(p, n) <+ x;
  end
endmodule
