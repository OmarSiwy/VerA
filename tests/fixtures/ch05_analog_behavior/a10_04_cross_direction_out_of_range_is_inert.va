// §5.10.3.1: dir values other than -1, 0 and +1 generate no cross event
// and do not control the timestep. A literal dir=2 tests that permitted
// inactive mode without violating any parameter range constraint.
//
// DERIVATION: V(p)-1 takes -1, -0.5, +0.5 over the listed grid, so an
// enabled rising or both-direction monitor would see a crossing. Here the
// body must never execute: the analog-context defaults n=0 and held=0
// remain unchanged at every point. This checks event suppression only;
// the fixed-grid harness does not assert the absence of timestep requests.
//
//! lrm 5.10.3.1
//! analysis tran
//! time 0, 1n, 2n
//! wave V(p) = 0, 0.5, 1.5
//! print none
//! lrm 5.10.3.1:1001
`include "check.vh"
module a10_cross_dir_out_of_range(p);
  inout p;
  electrical p;
  integer n;
  real held;
  analog begin
    @(cross(V(p) - 1.0, 2)) begin
      n = n + 1;
      held = V(p);
    end
    `CHECKI("a dir outside -1/0/+1 generates no event", n, 0);
    `CHECKX("so the guarded statement never ran and its variable is untouched", held, 0.0);
    I(p) <+ 0.0;
  end
endmodule
