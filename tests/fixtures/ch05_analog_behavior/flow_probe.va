// §5.4.2 probing the FLOW of a branch that carries a potential source. The
// branch flow is then an unknown of its own, and `V(sense) <+ 2.0*I(sense)` is
// Ohm's law written the other way round: a 2 ohm resistor stated as "the
// potential is twice the flow".
//
// Hold that unknown at 20 mA and the branch potential the model contributes is
// 2 * 0.02 = 0.04 V. (The unknown is spelled from the node pair with its
// punctuation escaped by codegen — the named branch is an alias for (p,n).)
//
//! lrm 5.4.2
//! sweep flowZ28pZ2cnZ29 = 0.02
`include "check.vh"
module ch5_flow_probe(p, n);
  inout p, n; electrical p, n; branch (p, n) sense;
  analog begin
    `CHECK("flow probe on a named branch reads the branch-flow unknown", I(sense), 2.0e-2, 1e-15);
    `CHECK("the contributed potential is 2 ohm times that flow", 2.0 * I(sense), 4.0e-2, 1e-15);
    V(sense) <+ 2.0 * I(sense);
  end
endmodule
