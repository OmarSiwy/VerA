// LRM 5.9.1: "while() executes a statement until an expression becomes False.
// If the expression starts out False, the statement is not executed at all",
// and the expression "shall be evaluated once before the execution of any
// statement".
//
// i starts at 0 and the guard is i < 0, which is false on entry. So the body
// never runs and i is still 0. A do-while -- a loop that tests after the body --
// leaves 1, which is exactly what this assertion refuses.
//
//! lrm 5.9.1
//! lrm 5.9.1:1001
`include "check.vh"
module ch5_while_false(p);
  inout p; electrical p;
  integer i;
  analog begin
    i = 0;
    while (i < 0) i = i + 1;
    `CHECKI("a while whose guard starts False runs zero times", i, 0);
    I(p) <+ i;
  end
endmodule
