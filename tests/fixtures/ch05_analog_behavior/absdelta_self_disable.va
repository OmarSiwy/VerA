// §5.10.3.4 says an enable of zero generates no events. An enabled monitor
// initializes at zero, then the 0.1 V/ns ramp changes by delta = 0.25 V at
// 2.5 ns. That event disables the monitor, so no later threshold can fire.
// This catches a coordinator that queues a whole ramp before executing any
// monitor body. The permitted first-event window is delta +/- expr_tol:
// 1u / (0.1 V/ns) = 1e-5 ns, plus half a 1 fs digital tick = 0.5e-6 ns.
// Three final-step assertions give checks = 3.
//! lrm 5.10.3.4
//! lrm 8.4.6
//! lrm 8.4.6:1000
//! lrm 8.4.6:1001
//! analysis tran
//! time 0, 10n
//! wave V(p) = 0.0, 1.0
//! checks 3
//! lrm 5.10.3.4:1011
`timescale 1ns/1fs
`include "check.vh"
module ch5_absdelta_self_disable(p);
  inout p; electrical p;
  integer en, n;
  real at, sampled;
  initial begin en = 1; n = 0; at = -1; sampled = 0; end
  always @(absdelta(V(p), 0.25, 1p, 1u, en)) begin
    n = n + 1;
    at = $realtime;
    sampled = V(p);
    if (n == 2) en = 0;
  end
  analog begin
    @(final_step) begin
      `CHECKI("self-disable prevents later interpolated events", n, 2);
      `CHECK("first delta event time in ns", at, 2.5, 1.05e-5);
      `CHECK("the event samples the interpolated signal", sampled, 0.25, 1.05u);
    end
    I(p) <+ 0.0;
  end
endmodule
