// §5.10.3.1: "expr_tol and time_tol are absolute tolerances ... They represent
// the maximum allowable error between the true crossing point and when the
// event triggers. The event shall occur after the threshold crossing, and
// while the signal remains in the box defined by actual crossing and expr_tol
// and time_tol." and, under Figure 5-6, "If expr_tol is specified, time_tol
// shall also be specified and both tolerances shall be satisfied at the
// crossing."
//
// THE RAMP. `//! wave` walks V(p) along one straight line, 0.1 V/ns (0 V at 0,
// 0.6 V at 6 ns); every declared point lies on it. cross(V(p) - 0.375, +1)
// therefore has exactly one zero, rising, at
//
//     t_c = 2n + (0.375 - 0.2) / (0.1 V/ns) = 3.75 ns.
//
// THE BOX. time_tol = 1n is deliberately loose; expr_tol = 1u is tight. "Both
// tolerances shall be satisfied", so the event must lie after t_c with the
// expression no more than 1 uV past zero, which on this slope is
//
//     1e-6 V / 1e8 V/s = 1e-14 s = 10 fs after t_c.
//
// So at the event: 0 <= V(p) - 0.375 <= 1u, and |$abstime - 3.75n| <= 10 fs.
// A tool that honoured time_tol alone could fire anywhere in (3.75n, 4.75n],
// at the 4n grid point for instance, where the expression is 0.025 V: that is
// the error this file catches. Everything is read once, at @(final_step), so
// the verdicts do not depend on which extra points a tool adds.
//
// A second crossing at 0.525 V (5.25 ns) reverses which tolerance binds:
// time_tol=1 ps, expr_tol=0.1 V (1 ns on this slope). It must occur within
// 1 ps. Using a distinct later crossing keeps the first crossing's tight
// expression tolerance from forcing the second event's time accidentally.
//
// WHY THE `always`. VerA's pure analog testbench is a fixed grid that inserts
// no point; only its mixed-signal runner places solver-chosen
// points. The digital monitor of the same crossing makes this module a mixed
// one, and its count (§7.3.5, one rising crossing, one event) is checked too.
//
//! lrm 5.10.3.1
//! lrm 5.10.3.1:6
//! lrm 5.10.3.1:5
//! lrm 7.3.5
//! analysis tran
//! time 0, 2n, 4n, 6n
//! wave V(p) = 0.0, 0.2, 0.4, 0.6
//! checks 8
//! lrm 5.10.3.1:1004
`timescale 1ns/1ps
`include "check.vh"
module b3_cross_expr_tol_and_time_tol_both_hold(p);
  inout p; electrical p;
  integer n_dig;
  integer n_ev;
  real t_ev, e_ev;
  integer n_time, n_time_dig;
  real t_time, e_time;
  initial begin n_dig = 0; n_time_dig = 0; end
  always @(cross(V(p) - 0.375, +1, 1n, 1u)) n_dig = n_dig + 1;
  always @(cross(V(p) - 0.525, +1, 1p, 0.1)) n_time_dig = n_time_dig + 1;
  analog begin
    @(cross(V(p) - 0.375, +1, 1n, 1u)) begin
      n_ev = n_ev + 1;
      t_ev = $abstime;
      e_ev = V(p) - 0.375;
    end
    @(cross(V(p) - 0.525, +1, 1p, 0.1)) begin
      n_time = n_time + 1;
      t_time = $abstime;
      e_time = V(p) - 0.525;
    end
    @(final_step) begin
      `CHECKI("one rising crossing is one analog event", n_ev, 1);
      `CHECKI("at the event the expression is past zero by no more than expr_tol",
              (e_ev >= 0.0) && (e_ev <= 1u), 1);
      `CHECK("so the event lies within expr_tol/slope = 10 fs of the 3.75 ns crossing",
             t_ev, 3.75e-9, 1e-14);
      `CHECKI("and the digital monitor of the same crossing fires once", n_dig, 1);
      `CHECKI("the time-limited crossing is one analog event", n_time, 1);
      `CHECKI("the second expression remains in its specified box",
              (e_time >= 0.0) && (e_time <= 0.1), 1);
      `CHECK("time_tol independently limits the later crossing to 1 ps",
              t_time, 5.25e-9, 1e-12);
      `CHECKI("the time-limited digital crossing fires once", n_time_dig, 1);
    end
    I(p) <+ 0.0;
  end
endmodule
