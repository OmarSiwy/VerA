// §4.7.1, the restrictions on an analog user-defined function: it "shall not
// use contribution statements or event control statements". §5.6.7's title is
// "Indirect branch contribution statements", and it sits under §5.6
// "Contribution statements": the indirect form is one of them, an alternative
// way of assigning "values ... to analog signals".
//
// `f` below contains `V(p) : V(n) == 0`. A function is a pure value
// computation (the same list says it "shall not use access functions" and
// "shall not use analog filter functions"), and a constraint on the netlist has
// no meaning inside one. The same statement also uses access functions; VerA
// reports the contribution, which is the rule pinned. The legal indirect
// assignment, in the analog block, is indirect_contribution.va.
//
//! lrm 4.7.1
//! lrm 5.6.7
//! lrm 4.7.1:3
//! reject-only E0410
//! neighbour indirect_contribution.va
`include "disciplines.vams"
module ch5_indirect_contribution_in_function(p, n);
  inout p, n; electrical p, n;
  analog function real f;
    input a;
    real a;
    begin
      V(p) : V(n) == 0;
      f = a;
    end
  endfunction
  analog I(p, n) <+ f(1.0) * V(p, n);
endmodule
