// §5.10.3.4: a time_tol below the time precision is ignored and the precision
// is used instead. Here 0.1 ns becomes 1 ns. On the 1 V/ns ramp delta = 0.25 V
// with expr_tol = 1 V allows an event 0..1.25 ns after the previous event;
// the effective time_tol narrows this to 1..1.25 ns. The first event rounds
// to digital time 1 ns. By 4 ns there are 3 or 4 delta events, plus the
// initialization event, and their rounded times cannot coincide.
// Three final-step assertions give checks = 3.
//! lrm 5.10.3.4
//! analysis tran
//! time 0, 4n
//! wave V(p) = 0.0, 4.0
//! checks 3
//! lrm 5.10.3.4:1002
`timescale 1ns/1ns
`include "check.vh"
module ch5_absdelta_time_precision(p);
  inout p; electrical p;
  integer n, spaced;
  real first, last;
  initial begin n = 0; spaced = 1; first = -1; last = 0; end
  always @(absdelta(V(p), 0.25, 0.1n, 1.0)) begin
    n = n + 1;
    if (n == 2) first = $realtime;
    if (n > 1 && $realtime - last < 1.0) spaced = 0;
    last = $realtime;
  end
  analog begin
    @(final_step) begin
      `CHECKI("event count is within the permitted timing windows", n >= 4 && n <= 5, 1);
      `CHECKX("sub-precision time_tol uses the 1 ns precision", first, 1.0);
      `CHECKI("events are at least one digital tick apart", spaced, 1);
    end
    I(p) <+ 0.0;
  end
endmodule
