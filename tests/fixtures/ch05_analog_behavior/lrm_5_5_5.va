// §5.5.5 "A module is allowed to access the potential and flow of a branch in
// another module instance using an access function providing that value is
// available in the other instance." §6.7.1's first bullet grants the NAME:
// "Potential and flow access for named and unnamed branches (including port
// branches) can be done hierarchically." This fixture probes a named branch of
// a child instance from the parent, via V() and I().
//
// Elaboration flattens `submod`'s declarations under the instance path, so the
// child's `branch (p, n) b` is the flat design's branch `submod.b` over the
// parent's own (p, n) — the child's ports are BOUND to them, not copied. The
// child's `V(b) <+ 1.34` therefore retains a potential on that branch
// (§5.6.1.2), making it a potential source whose row is V(p,n) - 1.34 = 0 and
// whose current is a solver unknown pinned by that row.
//
// The numbers: the harness holds p at 1.34 V and n at 0 V, so the probed
// branch potential V(submod.b) = V(p) - V(n) is exactly the source's own
// 1.34 — the row is AT its solution. The branch current is an unknown no
// directive names, and an unknown the harness is not told about is held at 0,
// so I(submod.b) reads 0.0 exactly.
//
//! lrm 5.5.5
//! lrm 6.7.1
//! lrm 6.7.1:1
//! bias V(p) = 1.34, V(n) = 0.0
//! lrm 5.5.5:1001
`include "check.vh"
module lrm_5_5_5_top(p, n);
  inout p, n; electrical p, n;
  lrm_5_5_5_submod submod(p, n);
  analog begin
    `CHECK("hierarchical access to named branch potential", V(submod.b), 1.34, 1e-15);
    `CHECK("hierarchical access to named branch flow", I(submod.b), 0.0, 1e-15);
    I(p, n) <+ V(submod.b);
  end
endmodule

module lrm_5_5_5_submod(p, n);
  inout p, n; electrical p, n;
  branch (p, n) b;
  analog begin
    V(b) <+ 1.34;
  end
endmodule
