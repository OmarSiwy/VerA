// §5.5.5 "A module is allowed to access the potential and flow of a branch in
// another module instance using an access function providing that value is
// available in the other instance." This fixture tests hierarchical access to a
// named branch in a submodule instance via V() and I() access functions.
//
//! lrm 5.5.5
//! bias V(top.submod.b) = 1.34
//! xfail VerA has no hierarchical net access: E0901 rejects `submod.b` because elaboration flattens a child's nets without publishing them under the instance path, so §5.5.5's `V(submod.b)` names nothing. The parser accepts the path (no index, no $root — see the parser ceiling); what is missing is the elaborated name table that would resolve it
`include "check.vh"
module lrm_5_5_5_top(p, n);
  inout p, n; electrical p, n;
  lrm_5_5_5_submod submod(p, n);
  analog begin
    `CHECK("hierarchical access to named branch potential", V(submod.b), 1.34, 1e-15);
    `CHECK("hierarchical access to named branch flow", I(submod.b), 0.0, 1e-15);
    I(p, n) <+ V(submod.b);
  end
endmodule

module lrm_5_5_5_submod(p, n);
  inout p, n; electrical p, n;
  branch (p, n) b;
  analog begin
    V(b) <+ 1.34;
  end
endmodule
