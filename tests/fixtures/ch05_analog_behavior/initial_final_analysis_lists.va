// LRM 5.10.2 and Table 5-1: the optional analysis list on `initial_step` /
// `final_step` names the analyses the global event is ACTIVE for. This runs a dc
// analysis, so:
//   @(initial_step("dc", "tran"))   active   -> state = 1.0
//   @(final_step("tran", "noise"))  inactive -> the 0.0 is NOT applied
// leaving state = 1.0. A compiler that ignored the analysis list would run the
// final_step arm too and leave 0.0; one that ignored initial_step's list would
// leave the LRM 3.2 initial 0.0 as well. Only honouring both gives 1.0.
//
//! lrm 5.10.2
//! lrm 5.10.2:1000
//! analysis dc
`include "check.vh"
module ch5_initial_final_analysis_lists(p);
  inout p; electrical p; real state;
  analog begin
    @(initial_step("dc", "tran")) state = 1.0;
    @(final_step("tran", "noise")) state = 0.0;
    `CHECKX("dc is in initial_step's list and not in final_step's", state, 1.0);
    I(p) <+ state + 0.0 * V(p);
  end
endmodule
