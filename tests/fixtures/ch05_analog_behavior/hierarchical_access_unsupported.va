// §5.5.4 "An access function in a module can have one or more hierarchical net
// references to nets in other module instances. In these cases, a new unnamed
// branch is created in the module containing the access function call."
//
// This is the clause's signal_monitor example, with one change forced by the
// suite's contract. The LRM prints the paths as `top.drv.a`, an absolute path
// into a design the example does not show; a run fixture that spells it that
// way is one NO conforming compiler can ever make green, because there is no
// `top` to elaborate against and the reference is unresolvable rather than
// merely unimplemented — the `//! xfail` would then be permanent and would
// launder the gap instead of marking it. §5.5.5 prints the resolvable form of
// the same idea (`module top; A a1(); B b1(); endmodule`, with B reading
// `V(top.a1.b)`), so an instance is what turns the example into a test. Here
// the child is instantiated by the referencing module itself and the paths are
// `drv.a` / `drv.b`: still "nets in other module instances", still one unnamed
// branch created per access, and now resolvable inside one file.
//
// What the other instance's nets are holding is a property of a design this
// file does not fix, so there are no digits to write for V(drv.a); §5.5.4 fixes
// only that the reference is legal and creates the unnamed branch in THIS
// module. The assertion pins the consequence that is local and checkable: the
// three probe-only hierarchical branches must not disturb the local source, so
// its residual is still V(a) - refv = 0.5 - 2.3. That subtraction lands one ulp
// off -1.8 (0.5 is exact, 2.3 is not), hence CHECK at 1e-15 and not CHECKX. A
// probe that stamped into the local branch, or an unnamed branch created in the
// child instead of here, moves it.
//
// The port `p` is not in signal_monitor, which has no port list. It arrived here
// because the device contract refused a device with zero terminals, and it stays
// because it is now load-bearing for a different reason: it is what the child
// instance `drv` is wired to, and the §5.5.4 reference under test is a reference
// into that instance. (The contract no longer refuses one — see
// ch06_hierarchy/module_definition.va — so a portless variant would run today,
// but it would have no child to read from.)
//
//! lrm 5.5.4
//! bias V(a) = 0.5
`include "check.vh"
module ch5_hier_access(p);
  parameter real refv = 2.3;
  inout p;
  electrical p, a;
  ch5_hier_access_drv drv(p);
  analog begin
    V(a) <+ refv;

    // Creates an unnamed branch in this module between net drv.a and
    // implicit ground.
    $strobe("voltage at drv.a = %g volts", V(drv.a));

    // Creates an unnamed branch between nets drv.a and drv.b.
    $strobe("voltage diff in drv = %g volts", V(drv.a, drv.b));

    // Creates an unnamed branch between local net a and drv.a.
    $strobe("voltage diff from ref in drv = %g volts", V(a, drv.a));

    `CHECK("a hierarchical probe does not disturb the local source", V(a) - refv, -1.8, 1e-15);
    I(p) <+ 0.0;
  end
endmodule

// The instance the hierarchical paths resolve through. Its nets are called `a`
// and `b` on purpose: §5.5.4's example is built around `a` and `drv.a` being
// different nets, and a compiler that resolved the path against the parent's
// scope would collapse them.
module ch5_hier_access_drv(t);
  inout t;
  electrical t, a, b;
  analog begin
    V(a) <+ 1.0;
    V(b) <+ 0.25;
    I(t) <+ 0.0;
  end
endmodule
