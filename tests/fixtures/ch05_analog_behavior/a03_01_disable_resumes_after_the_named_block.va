// A.6.5 `disable_statement ::= disable hierarchical_block_identifier ;`, which
// A.6.4 admits as an alternative of `analog_event_statement` and NOT of
// `analog_statement`:
//
//   analog_event_statement ::=
//         { attribute_instance } analog_loop_statement
//       | ... | { attribute_instance } disable_statement
//       | { attribute_instance } event_trigger | { attribute_instance } ;
//
// So `@(<event>) disable <named_block>;` is the one legal spelling, and it is
// the only case this row has to make work. tests/fixtures/annex_c/27 and
// annex_a/18 already pin the ILLEGAL spelling (a bare `disable` on the analog
// spine, E0401). Nothing anywhere pins the legal one, because VerA answers it
// with E0402 "`disable` is not implemented".
//
// WHAT DISABLING A BLOCK MEANS. §5.3 states the fall-through rule the disable
// has to interrupt: "The statements within the block shall be executed in
// sequence, one after another in the given order and the control shall pass out
// of the block after the last statement is executed." `disable seg` passes
// control out of `seg` EARLY — the statements of `seg` after the disable are
// skipped, and the statements after `seg` are not: control passed out of the
// block, which is where it was going anyway.
//
// THE DERIVATION. `a` is recomputed from scratch every evaluation (it is
// assigned outside any `@`, so §5.10 retention does not apply to it):
//
//     a = 1                       1
//     begin : seg
//       a = a + 10                11
//       @(initial_step) disable seg
//       a = a + 100               111   -- inside seg, skipped when disabled
//     end
//     b = a + 1000
//
//   t = 0     initial_step fires (§5.10.2: "If no analysis list is specified,
//             the initial_step global event is active during the solution of
//             the first point ... of every analysis"), so the disable executes:
//               a = 11,   b = 11 + 1000 = 1011
//   t = 1n    initial_step does not fire, the block runs to its end:
//               a = 111,  b = 111 + 1000 = 1111
//
// Both `b` values matter and they carry different claims. `b` is assigned
// AFTER `seg`, so its assertion is the whole point of this file: a disable that
// aborted the enclosing analog block instead of just `seg` would leave `b` at
// its §3.2 default 0 at t = 0, and 1011 says it did not. `a` pins the other
// half — 111 at t = 0 would mean the disable was a no-op.
//
// The oracle is `$abstime == 0.0`, which is the same partition of the run as
// "initial_step fired", stated from the clock instead of from the event; both
// arms are hand-written literals, so nothing here is VerA reproducing itself.
//
// OBSERVED TODAY: error[E0402]: `disable` is not implemented.
//
//! inherited IEEE 1364-2005 10.3
//! lrm 5.3
//! lrm 5.3:1
//! lrm 5.10
//! lrm 5.10.2
//! analysis tran
//! time 0, 1n
`include "check.vh"
module a03_disable_resumes(p);
  inout p; electrical p;
  real a, b;
  analog begin
    a = 1.0;
    begin : seg
      a = a + 10.0;
      @(initial_step) disable seg;
      a = a + 100.0;
    end
    b = a + 1000.0;
    `CHECKEQ("the disable skips the rest of seg and only the rest of seg",
             a, ($abstime == 0.0) ? 11.0 : 111.0, 0.0);
    `CHECKEQ("and control passes OUT of seg, so the statement after it still runs",
             b, ($abstime == 0.0) ? 1011.0 : 1111.0, 0.0);
    I(p) <+ 0.0;
  end
endmodule
