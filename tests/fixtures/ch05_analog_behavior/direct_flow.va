// §5.4.1 a flow contribution: the branch flow is a function of the branch
// potential. Nothing overrides `g`, so it holds its §3.4 declared default of
// 1m. At V(p)=2.0, V(n)=0.5 the branch potential is 1.5 V and the contributed
// flow is 1m * 1.5 = 1.5 mA.
//
//! lrm 5.4.1
//! bias V(p) = 2.0, V(n) = 0.5
`include "check.vh"
module ch5_direct_flow(p, n);
  inout p, n; electrical p, n; parameter real g = 1m;

  analog begin
    `CHECK("branch potential is the node difference", V(p, n), 1.5, 1e-15);
    `CHECK("flow at the declared default g = 1m", g * V(p, n), 1.5e-3, 1e-18);
    I(p, n) <+ g * V(p, n);
  end
endmodule
