// §5.4.1 a flow source: the contribution names the FLOW of the branch, so the
// value is the current forced through it and it does not depend on the branch
// potential. The `0.0*V(p,n)` term is there to make that dependence expressible
// and then zero it, so biasing the branch cannot move the source.
//
// `2m` is the §2.6 scale factor `m` = 1e-3, so the contributed flow is 2.0e-3 A
// regardless of the 1 V held across the branch.
//
//! lrm 5.4.1
//! bias V(p) = 1.0
`include "check.vh"
module ch5_flow_source(p, n);
  inout p, n; electrical p, n;
  analog begin
    `CHECK("branch potential the source must ignore", V(p, n), 1.0, 1e-15);
    `CHECK("2m is 2e-3 A and the flow source is potential-independent", 2m + 0.0*V(p, n), 2.0e-3, 1e-18);
    I(p, n) <+ 2m + 0.0*V(p, n);
  end
endmodule
