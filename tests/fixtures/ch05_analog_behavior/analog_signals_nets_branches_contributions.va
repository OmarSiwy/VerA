// One circuit that exercises the three parent clauses of Clause 5's middle
// third together, each by what its own sentence says:
//
// §5.4 Analog signals: "Analog signals are distinguished from digital signals
//   in that an analog signal has a discipline with a continuous domain. ...
//   This section describes analog branch assignments, signal access
//   mechanisms, and operators." Every signal below is `electrical`
//   (continuous), and each is both accessed and assigned.
//
// §5.5 Accessing net and branch signals and attributes: "The methods for
//   accessing signal and attributes of nets and branches are described in this
//   section." Both methods appear: a NET access, `V(b)` / `V(c, b)` (§5.5.1's
//   unnamed-branch form), and a NAMED BRANCH access, `I(br)` / `V(br)`.
//
// §5.6 Contribution statements: "The branch contribution statement is used in
//   the analog block to describe continuous-time behavior between a module's
//   analog nets and ports. CONTRIBUTION STATEMENTS MAY BE DESCRIBED IN DIRECT
//   OR INDIRECT FORM." Both forms appear, and both change the solution — which
//   is the only way a fixture can tell a contribution that was honoured from one
//   that merely compiled.
//
// THE CIRCUIT (every unknown free, `//! solve`):
//
//     a --[ br: I(br) <+ V(br)/1k ]-- b --[ I(b) <+ V(b)/1k ]-- gnd
//     V(a) <+ 1.0                       c : V(c) : V(c, b) == 0.25
//
// BY HAND.
//   direct   V(a) <+ 1.0 pins          V(a)      = 1.0
//   KCL at b: V(a,b)/1k = V(b)/1k  =>  V(b)      = 0.5
//   the named branch carries           I(br)     = (1.0 - 0.5)/1000 = 0.5e-3
//   and its potential is               V(br)     = 0.5
//   indirect: drive V(c) so that       V(c, b)   = 0.25  =>  V(c) = 0.75
//
// Every value is a short binary fraction or a ratio of them. The node c has no
// other connection, so the only thing that can put 0.75 on it is the solver
// honouring the indirect equation; and the only thing that can make I(br) half
// a milliamp is the direct flow contribution on the named branch.
//
//! lrm 5.4
//! lrm 5.5
//! lrm 5.6
//! lrm 5.6:1
//! lrm 5.6.1
//! lrm 5.6.1:1
//! solve
//! lrm 5.6.1:1001
`include "check.vh"
module ch5_signals_and_contributions(a, b, c);
  inout a, b, c;
  electrical a, b, c;
  branch (a, b) br;
  analog begin
    V(a) <+ 1.0;
    I(br) <+ V(br) / 1000.0;
    I(b) <+ V(b) / 1000.0;
    V(c) : V(c, b) == 0.25;
    `CHECK("a direct potential contribution pins its net", V(a), 1.0, 1e-12);
    `CHECK("a net access reads the divided node", V(b), 0.5, 1e-12);
    `CHECK("a named-branch potential access", V(br), 0.5, 1e-12);
    `CHECK("a named-branch flow access reads the direct flow contribution", I(br), 0.5e-3, 1e-15);
    `CHECK("an indirect contribution drives its target until the equation holds", V(c), 0.75, 1e-12);
    `CHECK("and the probed quantity takes the equation's value", V(c, b), 0.25, 1e-12);
  end
endmodule
