// §5.10.3.3 timer(), the sentence that lets a start_time MOVE:
//
//   "If the start_time or period expressions change value during the evaluation
//    of the analog block, the next event will be scheduled based on the latest
//    value of the start_time and period."
//
// together with the one-shot rule it modifies: "If the period expression
// evaluates to a value less than or equal to 0.0, the timer shall trigger only
// once at the specified start_time (if the start_time is in the future with
// respect to the current simulation time)."
//
// "Scheduled based on the latest value" does not say "later than before": a
// start_time that moves EARLIER schedules the next event earlier, and the event
// scheduled from the old value is gone. And a one-shot that has fired is armed
// again by a new start_time in the future — "only once at the specified
// start_time" is once per start_time, since the next event follows the latest
// one. This is the LTRA wavefront timer (ARPice models/native/ltra.va,
// `@(timer(tnext))`), which re-aims one one-shot at each new wavefront.
//
// THE DERIVATION. `ts` is held (event-assigned). Two helper one-shots move it:
// at 1n from 5n to 3n (EARLIER, before the main timer has fired), and at 4n
// from 3n to 6n (after it fired at 3n). Both new values are in the future of
// the time they are set at.
//
//   t = 0    ts = 5n    main timer scheduled at 5n          fired = 0
//   t = 1n   ts -> 3n   re-scheduled EARLIER, 5n dropped    fired = 0
//   t = 2n                                                  fired = 0
//   t = 3n   main timer fires                               fired = 1
//   t = 4n   ts -> 6n   the spent one-shot is re-armed      fired = 1
//   t = 5n   the dropped 5n schedule does NOT fire          fired = 1
//   t = 6n   main timer fires                               fired = 2
//   t = 7n                                                  fired = 2
//
// Expected: 0, 0, 0, 1, 1, 1, 2, 2. The rows that carry the claim are 3n (a
// schedule that only ever moves later still waits for 5n and reads 0) and 6n
// (a fired one-shot parked for good reads 1). 5n reads 1, not 2: the old
// schedule is replaced, not kept beside the new one. Every time is a declared
// grid point, so no timepoint has to be inserted.
//
//! lrm 5.10.3.3
//! lrm 5.10.3.3:4
//! analysis tran
//! time 0, 1n, 2n, 3n, 4n, 5n, 6n, 7n
//! bias V(p) = 0
//! print none
//! lrm 5.10.3.3:1004
`include "check.vh"
module a10_timer_start_rearmed_earlier(p);
  inout p;
  electrical p;
  real ts;
  integer fired;
  analog begin
    @(initial_step) ts = 5n;
    @(timer(1n, 0.0)) ts = 3n;
    @(timer(4n, 0.0)) ts = 6n;
    @(timer(ts, 0.0)) fired = fired + 1;
    `CHECKEQ("the next event follows the latest start_time, earlier or later", fired,
             ($abstime < 2.5n) ? 0 : (($abstime < 5.5n) ? 1 : 2), 0.0);
    I(p) <+ 0.0;
  end
endmodule
