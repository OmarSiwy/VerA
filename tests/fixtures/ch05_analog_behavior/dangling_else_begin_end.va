// §5.8.2: "If that association is not desired, a begin-end shall be used to
// force the proper association." The second of the clause's two printed
// variants; dangling_else.va is the first, and the pair only means anything
// read together — same values of i, j and index, opposite answers.
//
// The begin-end closes the inner if, so the else now belongs to the OUTER one:
//
//   index = -1: the outer if is false, so its else runs and result is j = 5.0.
//               In dangling_else.va the identical index reads -1.0.
//
//   index =  1: the outer if is true, the inner test 3 > 5 fails and the inner
//               if has no else of its own, so nothing assigns and result keeps
//               the -1.0 sentinel. In dangling_else.va that same index reads
//               5.0.
//
// Both answers are the exact mirror of the other file's, which is what makes
// this a test of the binding rule rather than of if-else in general: a compiler
// with either binding hard-wired fails exactly one of the two fixtures.
//
//! lrm 5.8.2
//! lrm 5.8.2:2
`include "check.vh"
module ch5_dangling_else_begin_end(p);
  inout p; electrical p;
  real i, j, result_outer_false, result_outer_true;
  integer index;
  analog begin
    i = 3.0; j = 5.0;

    result_outer_false = -1.0;
    index = -1;
    if (index > 0) begin
      if (i > j)
        result_outer_false = i;
    end
    else result_outer_false = j;

    result_outer_true = -1.0;
    index = 1;
    if (index > 0) begin
      if (i > j)
        result_outer_true = i;
    end
    else result_outer_true = j;

    `CHECKX("begin-end rebinds the else to the outer if, which is false", result_outer_false, 5.0);
    `CHECKX("with the outer if true the inner if has no else, so nothing runs", result_outer_true, -1.0);
    I(p) <+ 0.0;
  end
endmodule
