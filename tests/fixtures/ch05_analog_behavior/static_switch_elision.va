// Static zero-short switches retain the resistor current when its auxiliary
// flow equation is removed. A source-level current probe keeps its own row.
//! lrm 5.6.5
//! lrm 5.4.2
//! solve
//! bias V(p) = 1.0, V(n) = 0.0
//! psweep rs = 0.0, 1000.0
`include "check.vh"
module static_switch_elision(p, n);
  inout p, n; electrical p, n, ai, oi;
  parameter real rs = 1000.0 from [0:inf);
  real observed;
  analog begin
    observed = I(p, oi);
    I(ai, n) <+ V(ai, n) / 1000.0;
    I(oi, n) <+ V(oi, n) / 1000.0;
    if (rs > 0.0) I(p, oi) <+ V(p, oi) / rs;
    else V(p, oi) <+ 0.0;
    if (rs > 0.0) begin
      I(p, ai) <+ V(p, ai) / rs;
      I(p, ai) <+ ddt(2e-9 * V(p, ai));
    end else V(p, ai) <+ 0.0;
    `CHECK("unobserved branch gives the series divider", V(ai, n) * (1.0 + rs / 1000.0), 1.0, 1e-12);
    `CHECK("observed branch gives the same divider", V(oi, n) * (1.0 + rs / 1000.0), 1.0, 1e-12);
    `CHECK("observed branch current survives zero and positive resistance", observed * (1000.0 + rs), 1.0, 1e-12);
  end
endmodule
