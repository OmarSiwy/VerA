// LRM 5.3: a NAMED sequential block may carry block item declarations, and those
// locals are ordinary storage the block's statements read and write. `scale` is
// a block-local parameter at its declared default of 2.0 (LRM 3.4: a parameter
// with no override takes its default), so at V(p) = 3.0 the local is
// 2.0 * 3.0 = 6.0.
//
//! lrm 5.3.2
//! lrm 5.3.1
//! lrm 5.3.1:1000
//! bias V(p) = 3.0
`include "check.vh"
module ch5_named_block(p);
  inout p; electrical p;
  analog begin : calc
    parameter real scale = 2.0;
    real local_value;
    local_value = scale * V(p);
    `CHECKX("block-local parameter scales the probe", local_value, 6.0);
    I(p) <+ local_value;
  end
endmodule
