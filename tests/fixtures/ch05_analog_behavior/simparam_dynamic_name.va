// §9.15, the sentence that says a simulation-parameter query does not have to
// be spelled out in the source at compile time:
//
//   "$simparam() queries the simulator for a real-valued simulation parameter
//    named param_name. THE ARGUMENT param_name IS A STRING VALUE, EITHER A
//    STRING LITERAL, A STRING PARAMETER, OR A STRING VARIABLE."
//
// and, for the string-valued sibling, "$simparam$str is similar to $simparam.
// However it is used for returning string-valued simulation parameters."
//
// A STRING VARIABLE is the case this file pins, because it is the one a
// compile-time name table cannot serve: the name is only known when the analog
// block runs. §9.16's `$simprobe` example in the same clause set is written the
// same way ("parameter string inst"), so this is the intended idiom and not a
// corner.
//
// FOUR CLAIMS, each with a value the LRM plus one directive fixes:
//
//  1. `$simparam$str(nm)` with nm = "analysis_type" returns the current analysis
//     type. Table 9-28 requires the name ("shall be supported by
//     $simparam$str", no "if they support it" escape, unlike Table 9-27's
//     numeric side) and defines it as "the type of the current analysis (e.g.,
//     dc, tran, ac)"; §4.6.1 fixes those spellings and `//! analysis dc`
//     declares which one this run is. Expected: "dc" — the SAME string the
//     literal-argument form must return, which is claim 2.
//
//  2. `$simparam$str("analysis_type")` — the literal form, in the same module,
//     so the two spellings are compared against each other and not merely each
//     against the LRM. A tool that answers "dc" to the literal and "" to the
//     variable has not implemented the clause; it has implemented a constant
//     folder.
//
//  3. `$simparam(nm, 2.5)` with nm holding a name no simulator can know returns
//     the fallback: "If param_name is not known, and the optional expression is
//     not supplied, then an error is generated. If the optional expression is
//     supplied, its value is returned if param_name is not known and no error is
//     generated." Expected: 2.5, exactly and as a real.
//
//  4. The name is chosen BY THE SOLUTION — `nm` is assigned from a ternary on a
//     probe — and the query still answers "dc". Nothing in §9.15 narrows "a
//     string variable" to one whose value a compiler can fold: the clause's
//     companion function §9.16 is introduced as "dynamic monitoring", and a
//     monitor that can only read names its compiler already knew is not one.
//     V(p) is pinned at 0.5 by the `bias` line, so the ternary selects
//     "analysis_type" and the required answer is the same "dc" as claims 1 and
//     2. This is the claim that separates a real dynamic name from a folded one.
//
// §3.3's Table 3-3 makes a string comparison an integer — "Str1 == Str2
// Equality. Checks whether the two strings are equal. Result is 1 if they are
// equal and 0 if they are not." — so the string claims stay unconditional
// operands (`CHECKI`) rather than branches. (There is no §3.3.1; ch3 runs
// 3.2 → 3.3 → 3.4, and Table 3-3 sits inside §3.3 itself. An earlier draft of
// this header cited §3.3.1, which does not exist.)
//
// WHAT HAPPENS TODAY, and it splits exactly at claim 4. `Gen.emitSysCall`
// (lib/backend/codegen.zig) reads the name with `self.strArg(args, 0) orelse ""`
// — a CONSTANT string argument. Claims 1-3 survive that because `nm` is
// assigned a literal and constant propagation recovers it before codegen, so
// they are pins: they hold the folded path in place. Claim 4's name is not
// foldable, the name seen is the empty string, the emitted answer is the literal
// `""`, and the comparison reads 0.
//
//! lrm 9.15
//! lrm 9.15:4
//! analysis dc
//! bias V(p) = 0.5, V(n) = 0.0
`include "check.vh"
module a10_simparam_dynamic_name(p, n);
  inout p, n;
  electrical p, n;
  string nm;
  string got;
  real fallback;
  analog begin
    nm = "analysis_type";
    got = $simparam$str(nm);
    `CHECKI("a string VARIABLE names the parameter, and the answer is the analysis type",
            got == "dc", 1);
    `CHECKI("the literal spelling of the same query must agree with it",
            $simparam$str("analysis_type") == "dc", 1);
    nm = "a10_no_such_simparam";
    fallback = $simparam(nm, 2.5);
    `CHECKX("an unknown dynamic name returns the fallback expression verbatim",
            fallback, 2.5);
    nm = (V(p) > 0.25) ? "analysis_type" : "a10_no_such_simparam";
    got = $simparam$str(nm);
    `CHECKI("a name the SOLUTION chose is still a string variable, and still resolves",
            got == "dc", 1);
    I(p, n) <+ 0.0 * V(p, n);
  end
endmodule
