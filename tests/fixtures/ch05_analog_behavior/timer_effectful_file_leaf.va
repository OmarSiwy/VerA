// §5.10.3.3 uses the final rate, while §4.2.2 preserves each source call's
// effects. An input-only analog function still writes file state, so it is
// not safe to recompute merely because its formal direction is input.
// The descriptor stays unchanged: preserve that call's original result as
// rate becomes 1.5 in the second event. Integer-second deadlines 0,2,3,6
// give four fires. One source call per accepted point gives 1,2,3,4 lines;
// repeating the function to compute the final period would add extra lines.
// Each of four points checks both counts, giving checks = 8. Refusal neighbor:
// timer_changed_effectful_file_function_input_rejected.va changes a call input.
//! lrm 4.2.2
//! lrm 5.10.3.3
//! lrm 9.5.9
//! lrm 9.5.4.1
//! lrm 9.5.4.1:1000
//! analysis tran
//! time 0, 2, 3, 6
//! checks 8
`include "check.vh"
module timer_effectful_file_leaf(p);
  inout p; electrical p;
  analog function real one_write;
    input f; integer f;
    begin $fwrite(f, "x\n"); one_write = 1; end
  endfunction
  real rate;
  integer fd, rfd, fires, lines, k, code;
  string line;
  analog begin
    @(initial_step) begin rate = 1; fd = $fopen("timer_effectful_leaf.log", "w"); end
    @(timer(0, 2 * rate * one_write(fd))) begin
      fires = fires + 1;
      if (fires == 2) rate = 1.5;
    end
    $fflush(fd);
    rfd = $fopen("timer_effectful_leaf.log", "r");
    lines = 0;
    for (k = 0; k < 8; k = k + 1) begin
      code = $fgets(line, rfd);
      if (code > 0) lines = lines + 1;
    end
    $fclose(rfd);
    if ($abstime < 1) begin
      `CHECKI("initial timer event", fires, 1);
      `CHECKI("one initial file write", lines, 1);
    end else if ($abstime < 2.5) begin
      `CHECKI("body-changing timer event", fires, 2);
      `CHECKI("two calls leave two file writes", lines, 2);
    end else if ($abstime < 4) begin
      `CHECKI("event on the new absolute grid", fires, 3);
      `CHECKI("three calls leave three file writes", lines, 3);
    end else begin
      `CHECKI("subsequent event on the new grid", fires, 4);
      `CHECKI("four calls leave four file writes", lines, 4);
    end
    I(p) <+ 0;
  end
endmodule
