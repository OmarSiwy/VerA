// §5.9, the third of three blanket restrictions on repeat/while/non-genvar-for:
// "Contribution statements are not allowed". Only the §5.9.3 analog_for is
// exempt — its trip count is fixed at elaboration, so the set of branches it
// stamps is known before the solve. A runtime loop's is not, and the number of
// equations may not depend on data.
//
// for_loop.va is the same loop with the contribution moved out after it, which
// is the legal way to write this and must keep compiling.
//
// No VerA code exists for this, so the expectation is the phase label: the file
// must not compile at all.
//
//! lrm 5.9
//! reject DiagnosticsReported
//! xfail VerA allows a contribution inside a runtime `for`/`while`/`repeat`; it unrolls nothing and stamps the branch once per iteration, warning only W0650
module ch5_loop_contribution(p);
  inout p; electrical p; integer i;
  analog begin
    for (i = 0; i < 2; i = i + 1) I(p) <+ 1m;
  end
endmodule
