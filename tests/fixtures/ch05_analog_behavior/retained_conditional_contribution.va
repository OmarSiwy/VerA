// §5.4.4 "Unassigned sources": a contribution under a conditional applies only
// where the arm executes, and a branch that is not contributed to and is not a
// probe has "the branch flow set to zero (0)" (§5.6.1.3 restates it per
// iteration: such a branch "shall be treated as a flow source with a value of
// 0", and prints the same equivalence as its Example 1 — the guarded
// contribution behaves as if it had an `else` arm contributing zero). So the
// flow of this branch is exactly (guard) * 1m, with the guard the §4.2.5
// integer 1 or 0.
//
// At V(c) = 0.5 the guard holds, so the retained flow is 1 * 1m = 1e-3 (`m` is
// Table 2-1's 1e-3). The complementary guard V(c) < 0.0 is false there, and its
// product is the zero flow source the same rule names.
//
// SCOPE. Read what the assertions below actually compute: each is a §4.2.5
// relational — an integer 1 or 0 — multiplied by a biased probe. The
// contribution statement on the last line takes no part in any of them, and
// deleting it changes no `ok=` column. So this file illustrates Example 1 and
// pins §4.2.5 and the switch-branch shape of §5.6.5; it does NOT observe a
// retained branch value, because nothing inside a module can. §5.6.1.3's own
// numeric rule — 1, then 2, then 3, then 4, answer 7.0 — is value_retention.va.
//! lrm 4.2.5
//! lrm 5.4.4
//! lrm 5.6.5
//! bias V(c) = 0.5
`include "check.vh"
module ch5_retained(p, n, c);
  inout p, n, c; electrical p, n, c;
  analog begin
    `CHECKI("the guard is the integer 1 above threshold", V(c) > 0.0, 1);
    `CHECKR("retained flow while the guard holds", (V(c) > 0.0) * 1m, 1.0e-3, 1e-15);
    `CHECKX("an uncontributed branch is a zero flow source", (V(c) < 0.0) * 1m, 0.0);
    if (V(c) > 0.0) I(p, n) <+ 1m;
  end
endmodule
