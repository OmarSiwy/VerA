// §5.10 / §3.2 a variable keeps its value between evaluations: a held
// integer, a held scalar real and a held memory-backed array, each assigned
// under an `if`, read after it.
//
//   §3.2 "a variable keeps its value from one evaluation to the next"
//
// THE BUG THIS ROW PINS (ARPice models/native/txl.va: `ok`, `h1`, `ff`, `gg`
// and the history arrays assigned in conditional branches). `y` is assigned
// under `mode == 1`, a card-only condition, so the backend's `pruneHeld`
// (lib/backend/codegen/plan/setup.zig) drops its slot and renumbers the rows
// after it. It rewrote each survivor's seed argument, but a held array's seed
// is its `anew`, which carries no row: its row lives in `mem_arrays[].held`,
// which kept the old number, and the argument write landed in an unrelated
// `extra` word. Here `arr`'s stale row 2 was past the end of the two kept rows
// (an index-out-of-bounds in codegen); in txl.va it named another row, and the
// overwritten word made an `integer` seed load a `real` array's field
// (`const t0: i64 = inst.txl__held__p3_o`), which did not compile.
//
// THE DERIVATION. k = 0 at t = 0, 1 after.
//
//     t = 0    ok = 3, arr[0] = 5.0 (both assigned), y = 2.0   -> 3, 5, 2
//     t = 1n   nothing assigned under $abstime; ok and arr[0] held -> 3, 5, 2
//
// `y` is the §3.2 value of an assignment the card always takes: 2.0 at both.
// Three checks at two points: 6.
//
//! lrm 5.10
//! lrm 3.2
//! analysis tran
//! time 0, 1n
//! checks 6
`include "check.vh"
module a03_held_array_after_pruned_scalar(p, n);
  inout p, n; electrical p, n;
  parameter integer mode = 1;
  integer ok, k;
  real y;
  real arr[0:3];
  analog begin
    k = ($abstime > 0.5n) ? 1 : 0;
    if ($abstime < 0.5n) ok = 3;
    if (mode == 1) y = 2.0;
    if ($abstime < 0.5n) arr[k] = 5.0;
    `CHECKI("held integer assigned under an if", ok, 3);
    `CHECKX("card-invariant scalar (its slot is pruned)", y, 2.0);
    `CHECKX("held array element assigned under an if", arr[0], 5.0);
    I(p, n) <+ V(p, n);
  end
endmodule
