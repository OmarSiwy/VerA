// LRM 5.3: statements in a sequential block execute in the order they are
// written, and a nested begin/end is part of that same sequence — it introduces
// no new timing and, being unnamed, no new scope, so the inner blocks see and
// update the enclosing `x`. Reading in order: x = 1.0, then x = x + V(p), so at
// V(p) = 0.5 the innermost block sees 1.5. A nested block hoisted out of order
// would leave 0.5 (the assignment lost) or 1.0 (the addition lost).
//
//! lrm 5.3.1
//! lrm 5.3
//! lrm 5.3:1
//! lrm 5.3.1:1000
//! bias V(p) = 0.5
`include "check.vh"
module ch5_nested_blocks(p);
  inout p; electrical p; real x;
  analog begin
    x = 1.0;
    begin
      x = x + V(p);
      begin
        `CHECKX("the innermost block sees the outer sequence's result", x, 1.5);
        I(p) <+ x;
      end
    end
  end
endmodule
