// §5.4.4 "Unassigned sources": "If a value is not assigned to a branch, and it
// is not a probe branch, the branch flow is set to zero (0)", printed as
//
//     if (closed) V(p,n) <+ 0;
//
// being equivalent to the same with `else I(p,n) <+ 0;`. So the `else` of a
// switch branch is optional. (§5.6.1.3 prints the identical pair as its Example
// 1; §5.4.4 is where the rule is stated as a rule, so it leads.) This fixture
// is the else-less form, biased so the arm does NOT run: V(c) = 0.2 does not
// clear the 0.5 threshold, so `taken` stays 0. Execute the arm anyway and it
// is 1.
//
// The second assertion is §5.4.1: the branch potential is the potential
// difference of its nets, 0.75 - 0.25 = 0.5, contributed to or not. Both
// operands are exact in binary, so the difference is exact.
//
// SCOPE. Neither assertion reads the implied zero flow — nothing inside a
// module can, and the runner forces unknowns rather than solving. What they do
// pin is the observable half of §5.4.4's equivalence: which arm of the switch
// branch ran (§5.6.5), and that the branch potential is what §5.4.1 says
// whether or not the arm contributed. The contribution inside the arm takes no
// part in either, and deleting it changes no `ok=` column. §5.6.1.3's own
// numeric rule — 1, then 2, then 3, then 4, answer 7.0 — is value_retention.va.
//! lrm 5.4.4
//! lrm 5.4.1
//! lrm 5.6.5
//! bias V(c) = 0.2, V(p) = 0.75, V(n) = 0.25
`include "check.vh"
module ch5_unassigned_arm(p, n, c);
  inout p, n, c; electrical p, n, c;
  integer taken;
  analog begin
    taken = 0;
    if (V(c) > 0.5) begin
      taken = 1;
      V(p, n) <+ 0.0;
    end
    `CHECKI("V(c)=0.2 is below 0.5, so the sole arm never contributes", taken, 0);
    `CHECKX("the uncontributed branch still measures the node difference 0.75-0.25", V(p, n), 0.5);
  end
endmodule
