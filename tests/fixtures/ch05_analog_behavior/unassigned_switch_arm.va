// LRM 5.6.1.3 Example 1: the `else` of a switch branch is optional --
//
//     if (closed) V(p,n) <+ 0;
//
// is equivalent to the same with `else I(p,n) <+ 0;`, because a branch that is
// not contributed to during an iteration "shall be treated as a flow source with
// a value of 0". This fixture is the else-less form, biased so the arm does NOT
// run: V(c) = 0.2 does not clear the 0.5 threshold, so `taken` stays 0. Execute
// the arm anyway and it is 1.
//
// The second assertion is 5.4.1: the branch potential is the potential
// difference of its nets, 0.75 - 0.25 = 0.5, contributed to or not. Both
// operands are exact in binary, so the difference is exact.
//
//! bias V(c) = 0.2, V(p) = 0.75, V(n) = 0.25
`include "check.vh"
module ch5_unassigned_arm(p, n, c);
  inout p, n, c; electrical p, n, c;
  integer taken;
  analog begin
    taken = 0;
    if (V(c) > 0.5) begin
      taken = 1;
      V(p, n) <+ 0.0;
    end
    `CHECKI("V(c)=0.2 is below 0.5, so the sole arm never contributes", taken, 0);
    `CHECKX("the uncontributed branch still measures the node difference 0.75-0.25", V(p, n), 0.5);
  end
endmodule
