// AMS §2.9: arbitrary attributes preserve the circuit. The C application
// reads metadata in each original instance and then runs an op analysis.
// On its own, solve both ideal sources and assert the same exact voltages.
//! lrm 2.9
//! solve
//! checks 2
`include "check.vh"
(* module_attr = 3 *) module b26_analog_attributes;
  parameter BASE = 10;
  (* conversion_attr = $clog2(16) *) real tagged;
  electrical p, q;
  branch (p) bp;
  branch (q) bq;
  (* instance_attr = BASE + 1 *) attribute_load #(.R(2)) a(p);
  (* instance_attr = BASE + 2 *) attribute_load #(.R(4)) b(q);
  analog begin
    `CHECKX("decorated circuit first source", V(bp), 1.25);
    `CHECKX("decorated circuit second source", V(bq), 2.5);
    V(bp) <+ 1.25;
    V(bq) <+ 2.5;
  end
endmodule

(* child_attr = 7 *) module attribute_load(p);
  (* port_attr = R *) inout p;
  electrical p;
  parameter R = 1;
  (* variable_attr = $rtoi(2.0 * $itor(R)) *) real saved;
  (* process_attr = R *) analog begin
    (* statement_attr = R + 1 *) saved = V(p);
    I(p) <+ saved / R;
  end
endmodule
