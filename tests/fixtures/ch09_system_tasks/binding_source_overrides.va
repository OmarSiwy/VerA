// AMS §9.19 (physical 264): the return value is one if the parameter
// was overridden by defparam or an instance parameter assignment, zero otherwise.
// Each gain stays numerically 1.0. Named, ordered and defparam assignments of
// that SAME value must still report one; the unmodified declaration reports zero.
// This tests source instantiation, not the runner's //! param convention.
// A value-versus-default comparison fails all three explicit override cases.
//! lrm 9.19
//! lrm 9.19:4
//! checks 8
`include "check.vh"
module audit_binding_source_overrides;
  audit_binding_default_child untouched();
  audit_binding_source_child #(.gain(1.0)) named();
  audit_binding_source_child #(1.0) ordered();
  audit_binding_source_child deferred();
  defparam deferred.gain = 1.0;
endmodule
module audit_binding_source_child;
  parameter real gain = 1.0;
  analog begin
    `CHECKI("explicit source override, independent of parameter value", $param_given(gain), 1);
    `CHECKX("every instance retains the same numeric parameter value", gain, 1.0);
  end
endmodule
module audit_binding_default_child;
  parameter real gain = 1.0;
  analog begin
    `CHECKI("unmodified source declaration", $param_given(gain), 0);
    `CHECKX("default instance retains the same numeric parameter value", gain, 1.0);
  end
endmodule
