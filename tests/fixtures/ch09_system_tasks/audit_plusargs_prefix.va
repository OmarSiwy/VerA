// AMS §9.12 extends IEEE 1364-2005 §17.10.1 to analog context.
// "returns a nonzero integer" for a prefix match; no promise of exactly 1.
// Invocation supplies +HELLO: HEL and HELLO match; HELLOx and lowercase
// hello do not. Normalize matched status with != 0 to avoid overconstraint.
//! lrm 9.12
//! plusargs +HELLO +unused=3
//! checks 4
//! xfail PLUSARGS-001: runtime codegen returns zero without searching argv
`include "check.vh"
module audit_plusargs_prefix(p, n);
  inout p, n; electrical p, n;
  integer found;
  analog begin
    found = $test$plusargs("HEL");
    `CHECKI("prefix found", found != 0, 1);
    found = $test$plusargs("HELLO");
    `CHECKI("whole name found", found != 0, 1);
    found = $test$plusargs("HELLOx");
    `CHECKI("longer query absent", found, 0);
    found = $test$plusargs("hello");
    `CHECKI("case differs", found, 0);
    I(p,n) <+ V(p,n);
  end
endmodule
