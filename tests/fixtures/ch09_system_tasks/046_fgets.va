// §9.5.1: "If a file cannot be opened (either the file does not exist and the
// type specified is r ... ), a zero is returned for the mcd or fd." No
// fixture.dat exists beside the testbench, so this open MUST yield 0 — the one
// $fopen result the LRM names outright.
//
// §9.5.4.1 then fixes the read: "If an error occurs reading from the file, then
// code is set to zero." A $fgets on a descriptor that was never opened is that
// error, so code is 0 and not the character count of a successful read.
//
`include "check.vh"
module ch09_atomic_fgets(p, n);
  inout p, n; electrical p, n;
  integer fd, code; string text;
  analog begin
    fd = $fopen("fixture.dat", "r");
    code = $fgets(text, fd);
    `CHECKI("open r of a missing file returns 0", fd, 0);
    `CHECKI("a failed $fgets returns 0", code, 0);
    I(p,n) <+ V(p,n) + code;
  end
endmodule
