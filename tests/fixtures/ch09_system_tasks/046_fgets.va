// §9.5.4.1: "code = $fgets( str, fd ); reads characters from the file specified
// by fd into the string variable, str until a newline character is read AND
// TRANSFERRED TO str, or an EOF condition is encountered. If an error occurs
// reading from the file, then code is set to zero. Otherwise, the number of
// characters read is returned in code."
//
// So the return is a CHARACTER COUNT, and the count is where the newline rule
// becomes checkable: this fixture writes its own four-byte line "abc\n", and
// "abc" is three characters. A $fgets that stopped at the newline and left it
// in the stream — the C `fgets`-minus-delimiter behaviour a naive port ships —
// returns 3. The LRM says 4.
//
// The file is created here rather than assumed: the previous version of this
// fixture opened a name it did not own, asserted fd == 0 for a missing file,
// and then asserted `code == 0` for "a failed $fgets" — a pair of claims an
// implementation returning 0 unconditionally satisfies, and which broke the day
// a sibling fixture created the same shared name. Every §9.5 fixture now owns
// its filename.
//
//! lrm 9.5.4.1
//! xfail VerA has no file-descriptor surface: codegen.zig `void_tasks` lowers the whole §9.5 family to the constant `S.con(0.0)`, so $fopen answers 0 and $fgets reads nothing and returns 0
`include "check.vh"
module ch09_atomic_fgets(p, n);
  inout p, n; electrical p, n;
  integer fd, code; string text;
  analog begin
    fd = $fopen("ch09_046_fgets.dat", "w");
    $fwrite(fd, "abc\n");
    $fclose(fd);
    fd = $fopen("ch09_046_fgets.dat", "r");
    code = $fgets(text, fd);
    $fclose(fd);
    `CHECKI("§9.5.4.1 $fgets returns the character count, newline included", code, 4);
    I(p,n) <+ V(p,n) + code;
  end
endmodule
