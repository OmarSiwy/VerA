// AMS §7.3.1 Table 7-1: "Access of discrete bit groupings with greater
// than 31 bits is illegal." The constant parameter makes WIDTH-1:0 a
// 32-bit grouping, so this analog access is E0222 even though the parser
// cannot determine the width from two literal bounds. The 31-bit legal
// neighbour is exercised in clog2_reg_analog_conversion.va.
//! lrm 7.3.1
//! lrm 7.3.1:1
//! reject-only E0222
//! neighbour clog2_reg_analog_conversion.va
module reject_clog2_reg_width;
  parameter integer WIDTH = 32;
  reg [WIDTH-1:0] value;
  integer result;
  analog result = $clog2(value);
endmodule
