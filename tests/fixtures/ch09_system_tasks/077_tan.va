// LRM 9.14 / Table 4-14: $tan is an alias of the 4.3.1 operator tan, argument
// in RADIANS. At V(p,n) = 0.5 V, tan(0.5) = sin(0.5)/cos(0.5) =
// 0.479425538604203 / 0.8775825618903728 = 0.5463024898437905.
//
//! lrm 9.14
//! bias V(p) = 0.5
`include "check.vh"
module ch09_atomic_tan(p, n);
  inout p, n; electrical p, n;
  analog begin
    `CHECK("$tan(0.5 rad)", $tan(V(p,n)), 0.5463024898437905, 1e-15);
    I(p,n) <+ V(p,n) + $tan(V(p,n));
  end
endmodule
