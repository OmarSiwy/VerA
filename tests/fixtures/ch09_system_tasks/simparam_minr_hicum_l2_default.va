// §9.15: "If the optional expression is supplied, its value is returned if
// param_name is not known and no error is generated." HICUM/L2 3.2.0
// (hicumL2_v320.va:77 and :812) declares the CMC minimum branch resistance
// through its `MPRcz` macro, reproduced here byte for byte:
//
//   `define MPRcz(nam,def,uni,des) (*units=uni, desc=des*) parameter real nam=def from[0.0:inf);
//   `MPRcz( minr, $simparam("minr", 1.0e-3), "Ohm", "minimum branch resistance")
//
// VerA publishes no `minr`, so the default is 1.0e-3 Ohm, inside [0, inf).
// The model then gates each series resistor on `r >= minr` (:1401-1410):
// with rbx = 5e-4 Ohm the branch is shorted (5e-4 < 1e-3), so `on` is 0.
// Before the fix `minr` read 0 (W1050) and `on` was 1. 2 checks.
//! lrm 9.15
//! nowarn
//! bias V(p) = 1.0, V(n) = 0.0
//! checks 2
`include "check.vh"
`define MPRcz(nam,def,uni,        des) (*units=uni,                  desc=des*) parameter real    nam=def from[0.0:inf);
module ch09_simparam_minr_hicum(p, n);
  inout p, n; electrical p, n;
// minr as defined by CMC guidelines
`MPRcz( minr, $simparam("minr", 1.0e-3), "Ohm",       "minimum branch resistance")
  parameter real rbx = 5e-4;
  integer on;
  analog begin
    on = (rbx >= minr && rbx > 0.0);
    `CHECKX("minr is its $simparam fallback", minr, 1.0e-3);
    `CHECKI("a 5e-4 Ohm resistor is below minr", on, 0);
    I(p, n) <+ V(p, n) / 1k;
  end
endmodule
