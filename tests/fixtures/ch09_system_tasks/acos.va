// LRM 9.14 / Table 4-14: $acos is an alias of the 4.3.1 operator acos, which
// returns RADIANS in [0, pi]. cos(60 deg) = 1/2, so acos(0.5) is exactly
// pi/3 = 1.0471975511965979 — twice asin(0.5), and the complement of it about
// pi/2, which is the identity that fixes the branch.
//
//! lrm 9.14
`include "check.vh"
module ch09_atomic_acos(p, n);
  inout p, n; electrical p, n;
  analog begin
    `CHECK("$acos(0.5) is pi/3 radians", $acos(0.5), 1.0471975511965979, 1e-15);
    I(p,n) <+ V(p,n) + $acos(0.5);
  end
endmodule
