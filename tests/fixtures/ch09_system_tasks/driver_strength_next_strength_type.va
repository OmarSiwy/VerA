// §9.22.4 "$driver_strength returns the current strength contribution of a
// specific driver to the strength of the signal. ... The strength value is
// returned as two strengths, bits 5-3 for strength0 and bits 2-0 for strength1
// ... If the value returned is 0 or 1, strength0 returns the high-end of the
// strength range and strength1 returns the low-end of the strength range."
//
// §9.23.3 "$driver_next_strength returns the strength associated with the
// pending state of the driver, if there is one. If there is no pending state,
// it returns the current strength. ... The pending strength value is returned
// as an integer between 0 and 7."
//
// §9.23.4 "$driver_type returns an integer value with its bits set according to
// the system header file "driver_access.vams" ... A simulator that cannot
// provide proper information for a given driver type should return 0
// (`DRIVER_UNKNOWN)."
//
// The positive half of all three. 110/113/114_*_connectmodule_rejected.va pin
// that an ordinary module may not call them; this file calls them where §9.22
// says they belong — a connect module — on a net with one ordinary driver.
// The design is driver_delay_and_next_state.va's, cut down to a driver
// with nothing pending.
//
// HAND DERIVATION. One driver, `dr.o`, a `reg` assigned 1'b0 by a blocking
// assignment at t = 0 with no delay: current state 0, default strength strong
// (IEEE 1364 §7.10: a reg drives strong0/strong1), nothing pending. Driver
// index 0 is the only legal index (§9.22.1, 0..N-1 with N = 1). Sampled at
// t = 25, long after time zero has settled:
//
//   $driver_strength     bits 5-3 = strength0 = the high end of a strong-0
//                        range = St0 = 6 (Figure 9-3: St0 is B5 B4 B3 = 1 1 0).
//                        strength1 is not asserted: for a value-0 driver the
//                        LRM's "low end of the strength range" has no reading
//                        in the strength1 field that the figure pins down.
//   $driver_next_strength  no pending state, so the current strength: strong,
//                        6 on the 0..7 scale.
//   $driver_type         a reg driver is `DRIVER_BEHAVIORAL, the driver_access
//                        .vams bit 4 = 16 that the annex-D include fixture pins
//                        independently, or 0 if the simulator cannot say. Any
//                        other value names a driver kind this design does not
//                        contain: a primitive (2), UDP (4), continuous assign
//                        (8), kernel-added (256), wor (512) or wand (1024), or
//                        any bit outside that set. The check accepts exactly
//                        those two values.
//
// All integers, so every comparison is exact. `//! checks 3` makes the count
// exact, so a connect module that never runs fails on the count, not silence.
//
//! lrm 9.22.4
//! lrm 9.23.3
//! lrm 9.23.4
//! lrm 9.22.4:1000
//! lrm 9.23.3:1000
//! lrm 9.23.4:1000
//! lrm 9.23:1000
//! analysis tran
//! time 0, 40n
//! checks 3

`timescale 1ns/1ns
`include "disciplines.vams"
`include "check.vh"

connectrules ch09_ds_rules;
  connect ch09_ds_c2e merged input ddiscrete, output electrical;
endconnectrules

connectmodule ch09_ds_c2e(d, a);
  input d;
  output a;
  ddiscrete d;
  electrical a;

  initial begin
    #25 `CHECKI("§9.22.4 strength0 of a strong-0 driver is St0 = 6", ($driver_strength(d, 0) >> 3) & 7, 6);
    `CHECKI("§9.23.3 no pending state: next strength is the current, strong = 6", $driver_next_strength(d, 0), 6);
    `CHECKI("§9.23.4 a reg driver is DRIVER_BEHAVIORAL (16) or DRIVER_UNKNOWN (0)",
            ($driver_type(d, 0) == 0) || ($driver_type(d, 0) == 16), 1);
    #1 $finish(0);
  end

  analog V(a) <+ 0.0;
endmodule

module ch09_ds_drv(o);
  output o;
  ddiscrete o;
  reg o;
  initial o = 1'b0;
endmodule

module ch09_ds_load(a);
  inout a;
  electrical a;
  electrical g;
  ground g;
  analog I(a, g) <+ V(a, g) / 1.0e3;
endmodule

module ch09_ds_top;
  electrical net;

  ch09_ds_drv  dr(.o(net));
  ch09_ds_load ld(.a(net));
endmodule
