// §9.4.1 $strobe prints its arguments at the end of the current simulation
// time — for the ACCEPTED solution, not for whatever the body last happened to
// hold. So the value %g sees is the branch potential at the operating point,
// and §1.3.1 makes that the difference of the two node potentials:
// 0.75 - 0.25 = 0.5 V, exact in binary floating point (both are dyadic).
//
// The check is itself a $strobe, so it exercises the task under test: if the
// hoisted display unit read a stale or zeroed node value, the digits move.
//
//! lrm 9.4.1
//! bias V(p) = 0.75, V(n) = 0.25
`include "check.vh"
module ch09_display_strobe(p, n);
  inout p, n; electrical p, n;
  analog begin
    `CHECK("$strobe sees the accepted branch potential", V(p,n), 0.5, 1e-15);
    $strobe("v=%g", V(p,n));
    I(p,n) <+ V(p,n);
  end
endmodule
