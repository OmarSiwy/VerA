// NONCONFORMING ACCEPTANCE SNAPSHOT: $driver_delay is valid only in the digital context of a connectmodule.
//
// Table 9-20 marks $driver_delay "No" in the analog context, so the call site is
// nonconforming — but §9.23.1 names the answer for exactly this situation, and
// it is not zero:
//
//     "$driver_delay returns the delay, from current simulation time, after
//      which the pending state or strength becomes active. If there is no
//      pending value on a signal, it returns the value minus one (-1.0)."
//
// `p` is an analog port of a flat design that contains no digital drivers at all
// — that is what 107_driver_count.va pins, $driver_count(p) == 0 — so there is
// no driver to hold a pending value, and the "no pending value" branch is the
// only one that can apply. The delay is exactly -1.0.
//
// -1.0 is a SENTINEL and not a delay: §9.23.1 says a real delay is measured
// forward "from current simulation time", so every genuine answer is >= 0 and no
// genuine answer can be confused with this one. A 0 here would mean "the pending
// value matures right now", which is a different and wrong claim about a signal
// that has no driver.
`include "check.vh"

//! bias V(p) = 0.5

module ch09_atomic_driver_delay(p, n);
  inout p, n; electrical p, n;
  analog begin
    `CHECKX("§9.23.1: no pending value on the signal, so the delay is the sentinel -1.0",
            $driver_delay(p,0), -1.0);
    I(p,n) <+ V(p,n) + $driver_delay(p,0);
  end
endmodule
