// §9.15, the one-argument form: "$vt can optionally have temperature (in Kelvin
// units) as an input argument and returns the thermal voltage (kT/q) at the
// given temperature."
//
// The ambient is set to 350 K precisely so it is NOT the argument: $vt(300.0)
// must ignore it and answer for 300 K. kT/q at 300 K =
// 1.3806503e-23 * 300 / 1.602176462e-19 = 0.025852026903638286 V with the
// NIST1998 constants Annex D.2 selects by default; the FIVE constant sets in
// D.2 (NIST2018, NIST2010, SPICE, OLD and the NIST1998 `else default — see
// annex-d-stddefs.html:363,371,390) spread by at most 3.04e-5 relative and the
// LRM mandates none of them, so
// rtol 1e-4 pins four significant figures without picking a vintage. Answering
// for the 350 K ambient instead would give 0.03016, off by 17%.
//
// The second check needs no constants at all: kT/q is linear in T, so doubling
// the argument must double the result exactly.
//
//! lrm 9.15
//! lrm 9.15:1002
//! temp 350
`include "check.vh"
module ch09_atomic_vt_temperature(p, n);
  inout p, n; electrical p, n;
  analog begin
    `CHECKR("kT/q at the argument, not the ambient", $vt(300.0), 0.025852026903638286, 1e-4);
    `CHECKEQ("kT/q is linear in T", $vt(600.0), 2.0*$vt(300.0), 1e-15);
    I(p,n) <+ V(p,n) + $vt(300.0);
  end
endmodule
