// §9.5.1, the multichannel descriptor's bound: "The multichannel descriptor
// mcd is a 32-bit integer in which a single bit is set indicating which file
// is opened. The least significant bit (bit 0) of an mcd always refers to the
// standard output. ... The most significant bit (bit 31) of a multichannel
// descriptor is reserved and shall always be cleared, limiting an
// implementation to at most 31 files opened for output via multichannel
// descriptors."
//
// A RESOURCE LIMIT, and CLAUSE-AUDIT §5.4 lists it as stated (VerA's
// `file_kernels.zf_max` = 30, bits 1..30) and failing loudly (EMFILE, a zero
// descriptor) but untested — "no fixture opens 31 channels". This one does.
//
// THE BOUND, BY HAND. 31 files = bit 0 (standard output, always open) plus
// bits 1..30 — so the 30th user open is the last one the bit layout can
// express, and the 31st user open would need bit 31, which "shall always be
// cleared". Its only conforming answer is §9.5.1's failure value: "If a file
// cannot be opened ... a zero is returned for the mcd or fd. Applications can
// call $ferror to determine the cause of the most recent error." That is the
// loud failure: a zero the model can test, and a nonzero §9.5.7 errno (the
// value is unspecified and is not asserted).
//
// What is asserted:
//   - every one of opens 1..30 is a single set bit, never bit 0, never bit 31
//     ((m & (m - 1)) == 0 and 1 < m < 2^31);
//   - they are 30 DIFFERENT bits: their OR is bits 1..30, 32'h7FFF_FFFE =
//     2147483646, exactly;
//   - open 31 returns 0, and $ferror then reports a nonzero errno.
// (The first two are VerA's stated bound: §9.5.1's NOTE lets an operating
// system allow fewer. The third is the clause's own ceiling and holds for
// every conforming tool.) All 30 are then closed through their OR'd mcd, which
// §9.5.1 allows: "$fclose ... closes the file(s) specified by the
// multichannel descriptor mcd".
//
//! lrm 9.5.1
//! lrm 9.5.1:1
//! lrm 9.5.7
`include "check.vh"
module ch09_mcd_channels_exhausted_at_bit_31(p, n);
  inout p, n; electrical p, n;
  integer k, m, all, singles, extra, code;
  string name, why;
  analog begin
    @(initial_step) begin
      all = 0;
      singles = 0;
      for (k = 1; k <= 30; k = k + 1) begin
        $sformat(name, "ch09_222_%0d.log", k);
        m = $fopen(name);
        if (m > 1 && (m & (m - 1)) == 0) singles = singles + 1;
        all = all | m;
      end
      $sformat(name, "ch09_222_%0d.log", 31);
      extra = $fopen(name);
      code = $ferror(extra, why);
      $fclose(all);
    end
    `CHECKI("opens 1..30 are each a single bit above bit 0", singles, 30);
    `CHECKI("and are thirty different bits, 1..30", all, 2147483646);
    `CHECKI("§9.5.1 the 31st output channel would need bit 31: zero", extra, 0);
    `CHECKI("§9.5.7 and the cause is reported", code != 0, 1);
    I(p, n) <+ V(p, n);
  end
endmodule
