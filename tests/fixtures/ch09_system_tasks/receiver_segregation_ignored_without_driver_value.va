// §9.22.6 Receiver Net Resolution, the DEFAULT case, verbatim:
//
//   "By not specifying the receiver value directly in the connect module
//    driver, receiver segregation will be ignored, which is the default case.
//    ... The default is equivalent of assign d_receivers = d_drivers; Where
//    the value passed to the receivers through driver receiver segregation is
//    the value being driven without delay or any impact from analog
//    connections to the net. This is essentially bypassing driver receiver
//    segregation."
//
// A connect module that does NOT assign its digital port does not leave the
// receivers undefined or at z, and does not route them through the analog
// kernel: the ordinary receivers read the ordinary driver's resolved value
// directly. The design below is m04_14_receiver_default_bypass.va's, reduced
// to what the clause needs.
//
// HAND DERIVATION — one ordinary driver, one ordinary receiver, no receiver
// assignment in the connect module, so d_receivers = d_drivers throughout.
//
//   t=0   the driver's reg is unassigned: 1'bx.
//   t=1   the connect module reads $driver_count(d) -> 1, which also proves the
//         inserted connect module exists and sees only the ordinary driver.
//   t=5   receiver samples -> 1'bx.   (a connect module driving its own
//                                      receiver value would not be x here)
//   t=10  driver := 1'b1.
//   t=20  receiver samples -> 1'b1.
//   t=30  driver := 1'b0.
//   t=40  receiver samples -> 1'b0.
//
// Every sample is at least 5 ticks after the assignment that determines it, so
// no intra-timestep ordering is asserted. CHECKI is a $strobe, which prints at
// the end of its time step, so each $finish is one tick after the last sample.
// The t=5 sample writes `i === 1'bx` against 1 because `==` against x is x and
// prints ok=x, which the harness counts as a failure.
//
// `//! checks 4` makes the count exact: a tool that never inserts the connect
// module, or never runs one of the asserting processes, fails on the count
// rather than passing on silence.
//
//! lrm 9.22.6:1001
//! analysis tran
//! time 0, 50n
//! checks 4
`timescale 1ns/1ns
`include "disciplines.vams"
`include "check.vh"

connectrules ch09_rcv_rules;
  connect ch09_rcv_c2e merged inout ddiscrete, inout electrical;
endconnectrules

connectmodule ch09_rcv_c2e(d, a);
  input d;
  output a;
  ddiscrete d;
  electrical a;

  // NO `assign d = ...;` -> §9.22.6's default, d_receivers = d_drivers.
  integer n;
  initial begin
    #1;
    n = $driver_count(d);
    `CHECKI("the connect module sees the one ordinary driver", n, 1);
  end

  analog V(a) <+ 0.0;
endmodule

module ch09_rcv_drv(o);
  output o;
  ddiscrete o;
  reg o;
  initial begin
    #10 o = 1'b1;
    #20 o = 1'b0;
  end
endmodule

module ch09_rcv_ear(i);
  input i;
  ddiscrete i;
  initial begin
    #5  `CHECKI("§9.22.6 the default receiver reads the unassigned driver", (i === 1'bx), 1);
    #15 `CHECKI("§9.22.6 and reads a one directly from the driver", i, 1);
    #20 `CHECKI("§9.22.6 and reads a zero directly from the driver", i, 0);
    #1 $finish(0);
  end
endmodule

module ch09_rcv_load(a);
  inout a;
  electrical a;
  electrical g;
  ground g;
  analog I(a, g) <+ V(a, g) / 1.0e3;
endmodule

module ch09_rcv_top;
  electrical net;

  ch09_rcv_drv  dr(.o(net));
  ch09_rcv_ear  ear(.i(net));
  ch09_rcv_load ld(.a(net));
endmodule
