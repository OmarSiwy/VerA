// §9.5.1.1 Opening and Closing Files During Multiple Analyses, in full:
//
//   "Verilog AMS HDL supports multiple analyses during the same simulation
//    process (see Clause 8). If a file is opened in a write mode in the first
//    analysis and reopened in that write mode in following analysis, then
//    content written from the following analyses shall be appended to the
//    content written during the previous analyses."
//
// This is the one place Verilog-AMS overrides C's "w" ("Truncate to zero
// length or create for writing", Table 9-24): across an analysis boundary a
// "w" reopen does NOT discard what the earlier analyses wrote. §9.3 announces
// it — "Verilog-AMS extends this to allows multiple analyses ... Because of
// this extension, the behavior of a particular system task or function during
// different analysis types and between different analyses will be stated in
// the relevant section" — and for $fopen this is that section.
//
// THE ANALYSES. `//! sweep V(p) = 1, 2, 3` with a `//! time` walk runs three
// transient analyses in one process: the testbench restarts the time walk at
// dt = 0 with a fresh State for each sweep point, and §5.10.2's initial_step
// fires on the first point of each (the runner's own statement of what an
// analysis is here). So `@(initial_step)` below runs once per analysis, and
// each time it opens the SAME file "w" and writes one line "x\n".
//
// THE DIGITS, BY HAND. After analysis k has written, the file holds the k
// lines of analyses 1..k — appended, per the clause — so a read-back counts k
// lines. The sweep value IS k (1, 2, 3) — held by `//! sweep`, so the fixture
// states it, not the device — and the check is `lines - k`, want 0:
//
//   analysis 1: 1 line    analysis 2: 2 lines    analysis 3: 3 lines
//
// A tool that truncates on every "w" (plain C) reads 1, 1, 1 and fails the
// second and third analyses; one that never truncates at all would fail the
// FIRST analysis whenever the file survives from an earlier run — which is why
// the fixture's first analysis also asserts exactly 1: the first open of a
// process is still Table 9-24's truncate.
//
// The count is taken by §9.5.4.1 `$fgets`, which returns 0 at EOF; ten tries
// bound the loop far above the three lines that can exist.
//
// ASSERTED AT t = 1e-3 ONLY, the second point of each analysis. §9.5.9: "If a
// file is being written to during an iterative solve, then the file write
// operations shall not be performed unless the iteration is accepted." The
// `@(initial_step)` write runs inside the t = 0 solve, so a read in that SAME
// evaluation cannot see it yet: the t = 0 count is k-1 lines plus whatever an
// implementation does with the "w" open's truncation before acceptance, which
// no clause fixes. By t = 1e-3 the t = 0 point has been accepted and its line
// written, so the count is k. One check per analysis: three in all.
// (Reconciler, 2026-10-08: an earlier revision also asserted k at t = 0.)
//
//! lrm 9.5.1.1
//! lrm 9.5.1.1:1
//! lrm 9.3
//! lrm 9.5.1
//! lrm 9.5.4.1
//! lrm 9.5.9
//! lrm 9.5.9:1
//! bias V(n) = 0
//! sweep V(p) = 1, 2, 3
//! time 0, 1e-3
//! checks 3
`include "check.vh"
module ch09_write_mode_reopen_appends_across_analyses(p, n);
  inout p, n; electrical p, n;
  integer fd, rfd, lines, code, k;
  string s;
  analog begin
    @(initial_step) begin
      fd = $fopen("ch09_219_analyses.log", "w");
      $fwrite(fd, "x\n");
      $fclose(fd);
    end
    rfd = $fopen("ch09_219_analyses.log", "r");
    lines = 0;
    for (k = 0; k < 10; k = k + 1) begin
      code = $fgets(s, rfd);
      if (code > 0) lines = lines + 1;
    end
    $fclose(rfd);
    if ($abstime > 0.0)
      `CHECKX("§9.5.1.1 analysis k's \"w\" reopen appends: k lines after analysis k (lines - k)",
              lines - V(p), 0.0);
    I(p, n) <+ V(p, n);
  end
endmodule
