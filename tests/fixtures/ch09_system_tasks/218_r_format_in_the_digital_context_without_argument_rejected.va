// §9.4.7: "the %r (or %R) format specifier may be used ON REAL EXPRESSIONS in
// the digital context." The permission is for %r applied to an expression;
// the pairing rule that says the expression must be there is §9.4.3's, and it
// is stated for the format text, not for a context: "For each % character
// (except %m, %% and %l) that appears in a string, a corresponding expression
// argument shall be supplied after the string."
//
// So in the digital context %r is a CONSUMING conversion like %e/%f/%g, and
// `$fwrite(fd, "%r")` supplies nothing for it. The analog-context twin of this
// rule is 161_display_argument_pairing_rejected.va; this file is the first to
// pin it where §9.4.7 put %r. The same statement with `, 1500.0` is
// 217_r_format_in_the_digital_context.va, which compiles and runs.
//
// VerA used to accept the digital call at compile time and fail only when the
// digital kernel reached it. It now reports E0810 "not enough arguments for
// the format specifiers" at compile time, from the same check the analog
// context uses.
//
//! lrm 9.4.7
//! lrm 9.4.3
//! lrm 9.4.3:1
//! lrm 9.4
//! lrm 9.4.1
//! lrm 9.4.1:2
//! reject-only E0810
//! reject 1 consuming format specifiers but 0 arguments follow it
//! neighbour 217_r_format_in_the_digital_context.va
`include "disciplines.vams"
module ch09_r_format_digital_without_argument(p, n);
  inout p, n; electrical p, n;
  integer fd;
  initial begin
    fd = $fopen("ch09_218_r_format.log", "w");
    $fwrite(fd, "%r");                   // illegal: %r consumes an expression
    $fclose(fd);
  end
  analog I(p, n) <+ V(p, n);
endmodule
