// §9.18/Table 9-29 restricts $vflip to +1 or -1, including paramset
// assignments (§6.3.6). The legal geometry_paramset.va assigns -1 and
// resolves (-1)*(-1) to +1; this isolated value 2 is not a flip.
// A.1.9: a paramset needs >= 1 paramset_item_declaration (corrected 2026-10-08)
//! lrm 6.3.6
//! lrm 9.18
//! lrm 9.18:1000
//! reject-only E0890
//! neighbour geometry_paramset.va
module geometry_vflip_bad;
  geometry_vflip_ps child();
endmodule
paramset geometry_vflip_ps geometry_vflip_child;
  parameter real unused_item = 0;
  .$vflip = 2;
endparamset
module geometry_vflip_child;
  analog $display("flip=%g", $vflip);
endmodule
