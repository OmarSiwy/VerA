// §9.5.7:
//
//   integer errno;
//   errno = $ferror( fd, str );
//
// "A string description of type of error encountered by the most recent file
// I/O operation is written into str, which should be at least 640 bits wide.
// ... If the most recent operation did not result in an error, then the value
// returned shall be zero, and the string variable str shall be empty."
//
// The clause calls the second argument "the string variable str" and requires
// it to be EMPTY after a clean operation. A real cannot be empty and cannot
// hold a description, so `$ferror(fd, r)` has no conforming outcome: the
// "shall be empty" half is unsatisfiable. With `r` declared `string` the file
// compiles (probed) — 053_ferror.va is that file, running.
//
// No errno digit appears here or anywhere in this directory: §9.5.7 fixes no
// value, only zero-versus-nonzero.
//
// VerA reports E0813 "`$ferror` writes into a `string` variable, and this one
// is real".
//
//! lrm 9.5.7
//! reject-only E0813
//! reject `$ferror` writes into a `string` variable, and this one is real
//! neighbour 053_ferror.va
`include "disciplines.vams"
module ch09_ferror_into_real(p, n);
  inout p, n; electrical p, n;
  integer fd, code;
  real r;
  analog begin
    @(initial_step) begin
      fd = $fopen("ch09_204.log", "w");
      code = $ferror(fd, r);             // illegal: str is a string variable
    end
    I(p, n) <+ V(p, n);
  end
endmodule
