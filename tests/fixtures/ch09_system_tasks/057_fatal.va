// §9.7.3 $fatal: "shall generate a run-time fatal assertion error, which
// terminates the simulation with an errorcode", the first argument being the
// §9.7.1 finish_number and the rest a $display-style message. A fatal has no
// return value, and its effect — terminating the run — is not something the
// device can read back, so there is no number on that side of the rule.
//
// The guard is the number. §4.2.5 makes a relational an integer, 1 or 0, and `>`
// is STRICT, so the bias is placed exactly on the threshold: V(p,n) = 1.0 - 0 =
// 1.0, both operands exact in binary, and 1.0 > 1.0 is false. That is the whole
// point of the operating point chosen here — §9.7.3 says $fatal "terminates the
// simulation without checking whether the iteration would be rejected", so the
// only bias at which this fixture can be observed at all is one where the guard
// is false.
//
// A `>` lowered as `>=` fires the fatal at this bias and turns the 0 into a 1.
//
//! bias V(p) = 1.0
`include "check.vh"
module ch09_atomic_fatal(p, n);
  inout p, n; electrical p, n;
  analog begin
    if (V(p,n) > 1.0) $fatal(1, "fatal voltage=%g", V(p,n));
    `CHECKI("strict > is false exactly at the threshold, so $fatal is not reached", V(p, n) > 1.0, 0);
    I(p,n) <+ V(p,n);
  end
endmodule
