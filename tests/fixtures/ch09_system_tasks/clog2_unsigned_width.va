// AMS §9.14 imports IEEE 1364-2005 §17.11.1: "The argument shall be treated
// as an unsigned value"; zero returns zero. AMS §3.2 makes an integer
// 32 bits. IEEE §5.4.1 keeps a self-determined sized expression's width.
//
// HAND DERIVATION. An integer -1 has unsigned value 2**32-1, whose ceiling
// log is 32. Four-bit signed f is 15 -> 4; -8'sd1 is 255 -> 8. Four-bit
// f+1 wraps to 0 -> 0, while 7+1 is bit pattern 8 -> 3. At 64 bits all
// ones -> 64 and the isolated high bit -> 63; a 128-bit signed -1 -> 128,
// including when carried through an inferred parameter and its alias.
// Zero and one -> 0; 8 -> 3 and 9 -> 4. The dependent default follows the
// amount override from 8 to -1, so its answer changes from 3 to 32.
// An explicit $rtoi(8.9) produces 8 -> 3; the invalid real-operand neighbours
// are reject_clog2_real.va and reject_clog2_real_default.va. The separate
// unresolved nested narrow-arithmetic case is tracked in ROADMAP, not assumed
// correct by these single-operation boundary checks.
//! lrm 3.2
//! lrm 6.3.4
//! lrm 9.14
//! bias V(p) = -1, V(n) = 0
//! param amount = -1
//! checks 21
`include "check.vh"
module clog2_unsigned_width(p, n);
  inout p, n; electrical p, n;
  parameter integer amount = 8;
  localparam integer dependent = $clog2(amount);
  localparam integer folded_four = $clog2(4'shf);
  localparam integer folded_unary = $clog2(-8'sd1);
  localparam integer folded_wrap = $clog2(4'hf + 4'h1);
  localparam integer folded_wide = $clog2(128'shffffffffffffffffffffffffffffffff);
  parameter wide_value = 128'shffffffffffffffffffffffffffffffff;
  localparam wide_alias = wide_value;
  localparam integer folded_wide_param = $clog2(wide_value);
  integer value;
  analog begin
    value = $rtoi(V(p, n));
    `CHECKI("runtime integer -1 is unsigned 32 bits", $clog2(value), 32);
    `CHECKI("signed four-bit all ones", $clog2(4'shf), 4);
    `CHECKI("sized unary minus keeps eight bits", $clog2(-8'sd1), 8);
    `CHECKI("four-bit addition discards carry", $clog2(4'hf + 4'h1), 0);
    `CHECKI("four-bit sign bit is unsigned eight", $clog2(4'sh7 + 4'sh1), 3);
    `CHECKI("64-bit all ones", $clog2(64'hffffffffffffffff), 64);
    `CHECKI("64-bit isolated high bit", $clog2(64'h8000000000000000), 63);
    `CHECKI("zero", $clog2(0), 0);
    `CHECKI("one", $clog2(1), 0);
    `CHECKI("exact power of two", $clog2(8), 3);
    `CHECKI("next value rounds up", $clog2(9), 4);
    `CHECKI("folded four-bit operand", folded_four, 4);
    `CHECKI("folded unary operand", folded_unary, 8);
    `CHECKI("folded arithmetic operand", folded_wrap, 0);
    `CHECKI("dependent default follows signed override", dependent, 32);
    `CHECKI("explicit conversion from real", $clog2($rtoi(8.9)), 3);
    `CHECKI("folded wider signed literal", folded_wide, 128);
    `CHECKI("runtime wider signed literal", $clog2(128'shffffffffffffffffffffffffffffffff), 128);
    `CHECKI("wider parameter alias retains exact extension", $clog2(wide_alias), 128);
    `CHECKI("wider dependent default retains exact extension", folded_wide_param, 128);
    value = -2147483648;
    `CHECKI("integer minimum is unsigned 2**31", $clog2(value), 31);
    I(p, n) <+ V(p, n);
  end
endmodule
