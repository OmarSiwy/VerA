// IEEE §§5.4.1, 5.5.2 and 17.11.1 (AMS §9.14): a self-determined 33-bit
// all-ones sum with 1 wraps to 0, so $clog2 would be 0. Folding must not make
// wider arithmetic look supported when emitted arithmetic erases those bits.
// E0893 is the same named limit as the runtime neighbour. Legal <=32-bit
// arithmetic and wide carrier-only forms run in clog2_nested_contexts.va.
//! lrm 9.14
//! reject-only E0893
//! neighbour clog2_nested_contexts.va
module reject_clog2_wide_arithmetic_default;
  localparam integer result = $clog2(33'h1ffffffff + 33'h1);
  analog begin end
endmodule
