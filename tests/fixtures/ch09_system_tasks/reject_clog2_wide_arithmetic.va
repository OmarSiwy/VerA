// IEEE §§5.4.1, 5.5.2 and 17.11.1 (AMS §9.14) require the sum to retain
// 40 bits: (2**31-1)+1 is 2**31, so $clog2 is 31. The existing analog MIR
// arithmetic wraps at 32 bits; treating that negative carrier as width 40
// would incorrectly report 40. E0893 names the bounded implementation limit.
// Legal wide literals, aliases and bitwise expressions run in
// clog2_nested_contexts.va; its <=32-bit arithmetic also runs.
//! lrm 9.14
//! reject-only E0893
//! neighbour clog2_nested_contexts.va
module reject_clog2_wide_arithmetic;
  parameter p = 40'h7fffffff;
  integer result;
  analog result = $clog2(p + 40'h1);
endmodule
