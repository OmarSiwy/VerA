// §9.5.3 $sformat takes the §9.4.1 argument list, which names no bound. VerA
// compiles a call into Zig format calls of at most 32 arguments each, so 32
// conversions is the widest call that is one of them
// (sformat_33_conversions.va is the first that is two). This pins that it
// formats every value.
//
// HAND DERIVATION. The arguments are 0, 1, ..., 9, 0, 1, ... (i mod 10 for i =
// 0..31), each through %0d (a zero width drops IEEE 1364 §17.1.1.3's
// automatic field, so each prints its digit alone), so the string is those 32 digits in order:
// "01234567890123456789012345678901". The check compares the string itself (§4.2.5 string equality).
//
//! lrm 9.5.3
//! bias V(p) = 0
`include "check.vh"
module sformat_32_conversions(p, n);
  inout p, n; electrical p, n;
  string s;
  analog begin
    $sformat(s, "%0d%0d%0d%0d%0d%0d%0d%0d%0d%0d%0d%0d%0d%0d%0d%0d%0d%0d%0d%0d%0d%0d%0d%0d%0d%0d%0d%0d%0d%0d%0d%0d",
      0, 1, 2, 3, 4, 5, 6, 7, 8, 9, 0, 1, 2, 3, 4, 5, 6, 7, 8, 9, 0, 1, 2, 3, 4, 5, 6, 7, 8, 9, 0, 1);
    `CHECKI("32 conversions in one $sformat", s == "01234567890123456789012345678901", 1);
    I(p,n) <+ V(p,n);
  end
endmodule
