// §9.2 Table 9-11 lists $cosh as supported in the analog context; §4.3
// Table 4-15 defines it as C `cosh(x)` = (e^x + e^-x)/2, for all x. §4.3 makes
// the `$` and traditional spellings the same function.
//
// cosh(0.5) = 1.1276259652063807, and cosh is EVEN and never below 1 — the two
// properties that separate it from sinh(0.5) = 0.5210953054937474.
//
//! lrm 9.14
//! bias V(p) = 0.5
`include "check.vh"
module ch09_atomic_cosh(p, n);
  inout p, n; electrical p, n;
  analog begin
    `CHECK("$cosh(0.5)", $cosh(V(p,n)), 1.1276259652063807, 1e-15);
    `CHECK("cosh is even", $cosh(-V(p,n)), 1.1276259652063807, 1e-15);
    `CHECK("traditional cosh() is the same function", cosh(V(p,n)), 1.1276259652063807, 1e-15);
    I(p,n) <+ V(p,n) + $cosh(V(p,n));
  end
endmodule
