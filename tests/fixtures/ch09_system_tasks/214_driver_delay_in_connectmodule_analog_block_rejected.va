// §9.23: "Verilog-AMS HDL extends IEEE Std 1364-2005 Verilog HDL so that a set
// of supplementary driver access functions are supported IN THE DIGITAL
// CONTEXT OF CONNECTMODULES." §9.2 Table 9-20 gives each of the four the same
// two cells:
//
//   Task/function name   | digital context of connectmodule | analog context of connectmodule
//   $driver_delay        | Yes                              | No
//
// So being inside a connect module is necessary and not sufficient: the call
// also has to be in the connect module's digital half. 111_driver_delay_-
// connectmodule_rejected.va pins the first condition (an ordinary module);
// this file pins the second. The connect module below is a real one — the
// `connectrules` insert it on `net`, where a ddiscrete driver meets an
// electrical load, so its analog block is elaborated and lowered — and it
// calls `$driver_delay` from that analog block.
//
// ch07_mixed_signal/m04_15_driver_delay_and_next_state.va is the same design
// shape with the call in the connect module's `initial` block, where Table
// 9-20 says Yes; it compiles and runs.
//
// Before this file VerA reported this call as E0818, "can only be called from
// a connect module ... This is a `module`" — true of neither the source nor
// the rule. It now reports §9.2's analog-context code E0806, naming the
// connect module's analog block.
//
//! lrm 9.23
//! lrm 9.23.1
//! lrm 9.2
//! lrm 9.2:1000
//! lrm 9.23:1000
//! reject-only E0806
//! reject `$driver_delay` in the analog block of a connect module
//! neighbour ../ch07_mixed_signal/m04_15_driver_delay_and_next_state.va
`timescale 1ns/1ns
`include "disciplines.vams"

connectrules ch09_214_rules;
  connect ch09_214_c2e merged input ddiscrete, output electrical;
endconnectrules

connectmodule ch09_214_c2e(d, a);
  input d;
  output a;
  ddiscrete d;
  electrical a;
  analog V(a) <+ $driver_delay(d, 0);    // illegal: Table 9-20 analog cell is No
endmodule

module ch09_214_drv(o);
  output o;
  ddiscrete o;
  reg o;
  initial o = 1'b0;
endmodule

module ch09_214_load(a);
  inout a;
  electrical a;
  electrical g;
  ground g;
  analog I(a, g) <+ V(a, g) / 1.0e3;
endmodule

module ch09_214_top;
  electrical net;
  ch09_214_drv  dr(.o(net));
  ch09_214_load ld(.a(net));
endmodule
