// §9.18: "$mfactor is the shunt multiplicity factor of the instance, that is,
// the number of identical devices that should be combined in parallel and
// modeled." Its value is combined from the top of the hierarchy down, and
// Table 9-29 gives the rule: top-level value 1.0, resolved value
// $mfactor_specified * $mfactor_hier, allowed values $mfactor > 0.
//
// This module is elaborated on its own, so it IS the top of the hierarchy and
// nothing multiplies into it: the resolved value is the top-level value, 1.0,
// exactly. Zero would violate the "> 0" column, and any other number would be a
// multiplicity nobody specified.
//
//! lrm 9.18
//! lrm 9.18:1000
`include "check.vh"
module ch09_atomic_mfactor(p, n);
  inout p, n; electrical p, n;
  analog begin
    `CHECKX("Table 9-29 top-level $mfactor", $mfactor, 1.0);
    I(p,n) <+ V(p,n) + $mfactor;
  end
endmodule
