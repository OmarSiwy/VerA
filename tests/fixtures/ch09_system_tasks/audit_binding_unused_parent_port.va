// AMS §9.19 (physical 264–265): a port explicitly connected to a net is
// connected even if that net has no other connections. The source's twoclk
// example additionally distinguishes a child's binding from an omitted parent
// port. Here outer is omitted at the parent instance, yet inner is explicitly
// bound to outer at the child instance: parent=0, child=1. No voltage bias is
// evidence for these flags; the source connection lists determine them.
// The second child leaves inner explicitly blank by name, giving zero.
//! lrm 9.19
//! lrm 9.19:6
//! checks 3
`include "check.vh"
module audit_binding_unused_parent_port;
  audit_binding_unused_parent parent();
  audit_binding_absent_leaf absent(.inner());
endmodule
module audit_binding_unused_parent(outer);
  inout outer; electrical outer;
  audit_binding_unused_leaf leaf(.inner(outer));
  analog `CHECKI("omitted parent port is not connected", $port_connected(outer), 0);
endmodule
module audit_binding_unused_leaf(inner);
  inout inner; electrical inner;
  analog `CHECKI("child connection is local to its own instantiation", $port_connected(inner), 1);
endmodule
module audit_binding_absent_leaf(inner);
  inout inner; electrical inner;
  analog `CHECKI("explicit blank named connection", $port_connected(inner), 0);
endmodule
