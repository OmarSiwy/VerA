// §9.15: "$temperature does not take any input arguments and returns the
// circuit's ambient temperature in Kelvin units." Table 9-12 makes it legal in
// the analog context.
//
// The testbench sets the ambient to 350 K, deliberately off the 300.15 K
// default, so a build that ignores the setting or answers with a hard-wired
// nominal fails. The Kelvin claim is the second check: Annex D.2 fixes
// `P_CELSIUS0 = 273.15, so a reading in Kelvin is 350 - 273.15 = 76.85 degrees
// Celsius. A $temperature that answered in Celsius would land on 350 there.
//
//! lrm 9.15
//! lrm 9.15:1001
//! temp 350
`include "check.vh"
module ch09_atomic_temperature(p, n);
  inout p, n; electrical p, n;
  analog begin
    `CHECK("ambient temperature, as set", $temperature, 350.0, 1e-12);
    `CHECK("and it is Kelvin, not Celsius", $temperature - 273.15, 76.85, 1e-12);
    I(p,n) <+ V(p,n) + $temperature;
  end
endmodule
