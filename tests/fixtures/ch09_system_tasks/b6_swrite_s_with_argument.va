// §9.4.5: "For each %s specification which appears in a string, a
// corresponding argument shall follow the string in the argument list."
//
// The legal half of b6_swrite_s_without_argument_rejected.va: the same call
// with the argument supplied. §9.5.3 makes $swrite the $fwrite formatter
// writing into a string variable, so the text is checkable: "<%s>" with the
// string "x" is "<x>".
//
//! lrm 9.4.5
//! lrm 9.5.3
//! checks 1
`include "check.vh"
module b6_swrite_s_with_argument(p, n);
  inout p, n; electrical p, n;
  string t;
  analog begin
    $swrite(t, "<%s>", "x");
    `CHECKI("§9.4.5 the %s takes the argument after the string", t == "<x>", 1);
    I(p, n) <+ V(p, n);
  end
endmodule
