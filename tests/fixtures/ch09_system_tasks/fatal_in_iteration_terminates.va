// §9.7.3: "$fatal terminates the simulation without checking whether the
// iteration would be rejected." The display tasks are held back to the
// accepted point (§9.4.6: "All the display tasks, except $debug, shall not
// display output unless an iteration has been accepted"), and `$fatal` must
// not inherit that gate: a fatal reached while the Newton solver is still
// iterating has already happened, whatever the solver would have done with
// the iterate.
//
// THE OBSERVABLE IS WHEN THE RUN ENDS. `exp(V) - 2 = 0` from the bias's
// initial 0 V takes several Newton iterations (V=1, then ln 2), so the first
// iterate is not the accepted one. The `$debug` line runs at the first
// iterate (§9.4.1 `$debug` is the one display task allowed there) and prints
// `$simparam("iteration")`; the `$fatal` fires at the SECOND iterate, which is
// still not converged (Newton: V=1, then ln 2), so it is an iteration the
// solver would have kept working from. A device that only performs `$fatal`
// at the accepted point sees iteration 4 or so, never calls it, and the run
// exits 0 — but `//! exit 1` requires the fatal's errorcode. The `$debug`
// column also keeps the fixture assertable, and its want is `VERA_PW(1)` so
// `--perturb` moves it like any CHECK.
//
//! lrm 9.7.3
//! lrm 9.7.3:1001
//! exit 1
//! checks 1
//! solve
//! print none
//! bias V(p) = 0
`include "check.vh"
module ch09_fatal_in_iteration_terminates(p, n);
  inout p, n; electrical p, n;
  analog begin
    $debug("first Newton iteration got=%0d want=%0d ok=%d",
           $simparam("iteration"), `VERA_PW(1), ($simparam("iteration") == `VERA_PW(1)));
    if ($simparam("iteration") == 2) $fatal(1, "fatal at the second iterate");
    `CHECKI("a run that reached the accepted point should have ended at the fatal", $simparam("iteration"), -1);
    I(p, n) <+ exp(V(p, n)) - 2.0;
  end
endmodule
