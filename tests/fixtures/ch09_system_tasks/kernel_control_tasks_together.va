// §9.17: "Verilog AMS HDL adds a set of tasks and functions to control the
// analog solver's behavior on a signals and instances called the analog kernel
// control tasks." Table 9-14 names the three: $discontinuity (§9.17.1),
// $limit (§9.17.3) and $bound_step (§9.17.2).
//
// What the clause's own sentence promises is CONTROL OF THE SOLVER'S
// BEHAVIOUR — how it steps, how it iterates — and each subclause says in its
// own words that the equations' SOLUTION is not what it changes:
//
//   §9.17.1 "This task does not directly specify the behavior of the module."
//   §9.17.2 "The $bound_step() statement shall be ignored during a non
//            time-domain analysis."
//   §9.17.3 "On any iteration where the output value is not the same as the
//            value of the access function (within appropriate tolerances), the
//            simulator is prevented from terminating the iteration."
//
// So the observable contract is: a model that calls all three, in the places
// the clauses allow, converges where $limit's output equals its argument —
// the root of the UNLIMITED equation. A tool that let one of them leak into
// the answer would fail here.
//
// THE CIRCUIT. One nonlinear conductance, `//! solve` freeing p:
//
//   I(p,n) = v + v^3 - 10 = 0   ->   v = 2 exactly   (2 + 8 = 10; v + v^3 is
//                                    strictly increasing, so 2 is the only
//                                    real root)
//
// The cubic is evaluated at `$limit(V(p,n))` — Syntax 9-12's first form, where
// "the simulator is responsible for determining if limiting should be applied
// and what the return value is on a given iteration" — so whether this tool
// limits or not, the iteration may only stop where the output equals V(p,n).
// `$bound_step(1e-6)` bounds a timestep that a DC point does not take, and
// `$discontinuity(0)` under `@(initial_step)` announces a value discontinuity
// on the first point. None of the three has a way to move the root.
//
// A cubic and not a diode ON PURPOSE: an exponential from a zero start needs
// limiting to converge at all, and §9.17.3 lets a conforming simulator
// "simply choose to have $limit() return the value of its first argument" —
// so a diode here would test the solver's damping, which is not what §9.17
// promises. Plain Newton converges on this cubic from v = 0.
//
// 1e-9 relative is far above a converged Newton point's error and far below
// anything a leaked limit or step bound would move.
//
//! lrm 9.17
//! lrm 9.17.1
//! lrm 9.17.2
//! lrm 9.17.2:4
//! lrm 9.17.3
//! lrm 9.17.3:1
//! solve
//! bias V(n) = 0
`include "check.vh"
module ch09_kernel_control_tasks_together(p, n);
  inout p, n; electrical p, n;
  real vd;
  analog begin
    @(initial_step) $discontinuity(0);
    $bound_step(1.0e-6);
    vd = $limit(V(p, n));
    I(p, n) <+ vd + vd * vd * vd - 10.0;
    `CHECKR("the kernel control tasks leave the solution at the cubic's root",
            V(p, n), 2.0, 1e-9);
  end
endmodule
