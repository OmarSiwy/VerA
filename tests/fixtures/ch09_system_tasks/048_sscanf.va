// §9.5.4.2: `code = $sscanf( str, format, args )` — "$sscanf reads from the
// string str", so nothing here depends on the filesystem, on the working
// directory, or on a file a sibling fixture may have left behind.
//
// The input is the literal "42" and the format is the single conversion "%d",
// which "matches an optionally signed decimal number, consisting of the optional
// sign from the set + or -, followed by a sequence of characters from the set
// 0,1,2,3,4,5,6,7,8,9, and _". Both characters of the input match, so `value`
// receives the converted item: 42.
//
// The return is fixed by the same subclause: "the number of successfully matched
// and assigned input items is returned in code". One conversion specification,
// one successful assignment, so code is 1 — not the character count (2), and not
// the EOF the same paragraph reserves for input that ends "before the first
// matching failure or conversion".
//
//! lrm 9.5.4.2
//! xfail VerA has no string-scanning surface: codegen.zig `void_tasks` lowers $sscanf to the constant `S.con(0.0)`, so it returns 0 and never writes its output argument — `value` keeps its initial 0. Nothing here touches the filesystem, so this gap is the formatter alone, not the missing descriptor table
`include "check.vh"
module ch09_atomic_sscanf(p, n);
  inout p, n; electrical p, n;
  integer code, value;
  analog begin
    code = $sscanf("42", "%d", value);
    `CHECKI("$sscanf assigned the converted item", value, 42);
    `CHECKI("$sscanf returned the number of assigned items", code, 1);
    I(p,n) <+ V(p,n) + code + value;
  end
endmodule
