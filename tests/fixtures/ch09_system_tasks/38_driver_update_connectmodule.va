// §9.22.4 driver_update. Table 9-19 marks `@(driver_update)` supported in the
// DIGITAL context of a connectmodule, and §9.22 paragraph 3 makes a connect
// module the only place any of this family may be called from: "Driver access
// functions can only be called from connect modules."
//
// So a connectmodule with `always @(driver_update d)` is the one context in
// which the construct is legal, and a compiler must ACCEPT it. The previous
// expectation here was `//! reject NoModule` — VerA's phase label for "no
// ordinary module in this file", not an LRM rule — which demanded a diagnostic
// against the legal case and cited no clause at all.
//
// §9.22.4 in full: "always @(driver_update clock) statement; causes the
// statement to execute any time a driver of the signal clock is updated. Here,
// an update is defined as the addition of a new pending value to the driver.
// This is true whether or not there is a change in the resolved value of the
// signal."
//
// WHAT IS ASSERTED, AND WHY IT IS NOT THE TRIGGER. The clause defines a TRIGGER,
// and how often it fires depends on how many drivers the elaborated netlist puts
// on `d` — a property of the instantiating design, not of this source. Counting
// firings here would pin the harness, not the LRM. The positive semantics of
// §9.22.6 (a real connectmodule instance, $driver_count == N, the 0..N-1 loop)
// need a driven connectmodule and still have no fixture.
//
// What IS assertable is ACCEPTANCE, and this file used to duck it. It carried
// `//! xfail` with no `//! reject` and no `CHECK` at all — which routes to
// `unasserted`, never to XPASS, so the marker could not fire on the day the gap
// closed. That is a TODO wearing an xfail. So the file now also carries an
// ordinary module with a real assertion in it. The assertion is deliberately
// about nothing but a branch potential (0.75 - 0.25 = 0.5, both operands exact
// in binary): its whole job is to be a verdict that EXISTS, so that "this source
// file, connectmodule and all, was accepted, elaborated and run" becomes a
// green/red the runner can see. Today VerA stops at NoModule and the whole file
// fails, which is the XFAIL below; the day connectmodule support lands, the run
// goes green, the XPASS fires, and the marker has to go.
//
//! lrm 9.22.4
//! bias V(p) = 0.75, V(n) = 0.25
//! xfail VerA has no `connectmodule` design element (E0201 on the keyword) and no digital driver state, which is what §9.22.4 defines @(driver_update) over — the one context in which the event is legal is the one thing VerA does not have. A discrete-time scheduler, not a hierarchy gap
`include "check.vh"
connectmodule ch09_driver_update_connectmodule(d, a);
  input d; output a;
  logic d;
  electrical a;
  always @(driver_update d) $strobe("driver updated");
endconnectmodule

module ch09_driver_update_host(p, n);
  inout p, n; electrical p, n;
  analog begin
    `CHECK("the file carrying the §9.22.4 connectmodule compiles and runs",
           V(p,n), 0.5, 1e-15);
    I(p,n) <+ V(p,n);
  end
endmodule
