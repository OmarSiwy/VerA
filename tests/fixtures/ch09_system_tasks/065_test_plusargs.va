// §9.12 / Table 9-9 makes IEEE 1364's `$test$plusargs` legal in the analog
// context; IEEE 1364 §17.10 defines it as a search of the invocation's plusarg
// list, returning nonzero when a plusarg starts with the given string and ZERO
// when none does.
//
// The testbench is run with no command-line arguments at all, so no plusarg
// begins with "feature" and the answer is 0 — a fact about the run, not about
// the compiler. A build that answered 1 here would silently enable every
// `+define`-style feature switch in every model.
//
//! lrm 9.2
//! lrm 9.12
//! lrm 9.2:1000
//! lrm 9.12:1000
`include "check.vh"
module ch09_atomic_test_plusargs(p, n);
  inout p, n; electrical p, n;
  integer enabled;
  analog begin
    enabled = $test$plusargs("feature");
    `CHECKI("no +feature on the command line", enabled, 0);
    I(p,n) <+ V(p,n) + enabled;
  end
endmodule
