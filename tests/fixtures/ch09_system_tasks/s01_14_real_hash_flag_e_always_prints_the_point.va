// §9.4.3: the real conversions of Table 9-23 "have the full formatting
// capabilities available in the C language". C11 7.21.6.1p6 lists five flag
// characters, and '#' is one of them:
//
//   '#'  "The result is converted to an ``alternative form''. ... For a, A,
//        e, E, f, F, g, and G conversions, the result of converting a
//        floating-point number always contains a decimal-point character,
//        even if no digits follow it."
//
// So '#' matters to %e exactly when the precision is 0, where C otherwise
// prints no point (p8: "if the precision is zero and the # flag is not
// specified, no decimal-point character appears"). It used to be read as the
// conversion LETTER (#41): `%#.0e` printed the value, then a literal "e".
//
// HAND DERIVATION (%e: one digit, `.precision` fractional digits, then the
// exponent, signed, at least two digits):
//
//   %.0e   of 2.0   2 = 2e0, no fractional digit, no '#':  -> "2e+00"
//                   (the neighbour: the same field without the flag)
//   %#.0e  of 2.0   the same digits, '#' adds the point:   -> "2.e+00"
//   %#.0E  of 31.0  31 = 3.1e1; zero fractional digits round 3.1 to 3
//                   (below the half); 'E' spells the marker upper case:
//                                                         -> "3.E+01"
//   %#e    of 1.5   default precision 6 already prints a point, so '#'
//                   changes nothing:                       -> "1.500000e+00"
//   %#10.0e| of 2.0 "2.e+00" is six characters; width 10 right-justifies
//                   it with four spaces:                   -> "    2.e+00|"
//
//! lrm 9.4.3
//! lrm 9.5.3
//! print none
`include "check.vh"
module s01_real_hash_flag_e(p, n);
  inout p, n; electrical p, n;
  string plain, alt, upper, dflt, wide;
  analog begin
    $sformat(plain, "%.0e",     2.0);
    $sformat(alt,   "%#.0e",    2.0);
    $sformat(upper, "%#.0E",    31.0);
    $sformat(dflt,  "%#e",      1.5);
    $sformat(wide,  "%#10.0e|", 2.0);

    `CHECKI("§9.4.3/C11 %.0e prints no point without '#' (neighbour)", (plain == "2e+00"), 1);
    `CHECKI("§9.4.3/C11 '#' on %.0e always prints the point", (alt == "2.e+00"), 1);
    `CHECKI("§9.4.3/C11 '#' on %.0E: the point, then the upper-case marker", (upper == "3.E+01"), 1);
    `CHECKI("§9.4.3/C11 '#' on %e with a precision changes nothing", (dflt == "1.500000e+00"), 1);
    `CHECKI("§9.4.3/C11 '#' and a width: the point is inside the field", (wide == "    2.e+00|"), 1);

    I(p,n) <+ V(p,n);
  end
endmodule
