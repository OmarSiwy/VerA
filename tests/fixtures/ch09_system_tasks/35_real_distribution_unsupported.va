// DEBT — this rejection is NOT conformance.
// The LRM permits what VerA refuses here. The substrings below record
// CURRENT behavior so the suite stays green on it; they do not claim it
// is right. `zig build ledger` counts this rule against VerA.
//
// VAMS-9.13.2-04  (ch9-system.html)
// The system functions shall always return the same value given the same seed.
//
//! reject E0801
//! reject $rdist_uniform
// EXPECT: error
module ch09_real_distribution_unsupported(p, n);
  inout p, n; electrical p, n;
  integer seed;
  analog I(p,n) <+ $rdist_uniform(seed, 0.0, 1.0);
endmodule
