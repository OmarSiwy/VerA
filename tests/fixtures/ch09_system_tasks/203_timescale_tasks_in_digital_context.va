// §9.6 "Verilog AMS HDL does not extend the timescale tasks defined in IEEE Std
// 1364 Verilog."
//
// So $printtimescale and $timeformat keep their IEEE 1364 §17.3 meaning in the
// DIGITAL context — the positive half this file pins.
// 154_timescale_pla_queue_analog_rejected.va is the clause's only other cite
// and pins the other half (not callable from the analog block).
//
// IEEE 1364-2005 §17.3.2: `$timeformat(units_number, precision_number,
// suffix_string, minimum_field_width)` sets how `%t` prints a time: in units of
// 10**units_number seconds, with precision_number fractional digits, followed
// by the suffix, right-justified in at least minimum_field_width characters.
//
// DERIVATION. `timescale 1ns/1ns, so at #5 `$time` is 5 (ns). After
// $timeformat(-12, 0, " ps", 0) the time is printed in picoseconds with no
// fraction and no padding: 5 ns = 5000 ps -> "5000 ps". After
// $timeformat(-9, 2, "ns", 0) it is "5.00ns". Each formatted string is compared
// with its literal in the digital block, and the analog block reads the two
// integer verdicts through §7.3.1 Table 7-1 at t = 10n. $printtimescale is
// called too; it prints and returns nothing, so its only claim here is that the
// digital context accepts it.
//
// Both verdicts are set to 0 at time zero so the analog block's time-zero read
// is defined (§7.3.2).
//
//! lrm 9.6
//! analysis tran
//! time 0, 10n
//! print none
//! xfail the mixed-signal runner's digital engine does not implement $printtimescale, $sformat or $swrite (E1100 "digital system task `$printtimescale` is not implemented"), so the digital context cannot run the IEEE 1364 §17.3 timescale tasks §9.6 leaves to it
`timescale 1ns/1ns
`include "check.vh"
module ch09_timescale_tasks_in_digital_context(out);
  inout out;
  electrical out;
  integer ps_ok, ns_ok;
  reg [8*8:1] s;   // an IEEE 1364 §4.2.3 string held in a reg, 8 characters wide

  initial begin
    ps_ok = 0; ns_ok = 0;
  end

  initial begin
    #5;
    $printtimescale;
    $timeformat(-12, 0, " ps", 0);
    $sformat(s, "%t", $time);
    ps_ok = (s == "5000 ps");
    $timeformat(-9, 2, "ns", 0);
    $sformat(s, "%t", $time);
    ns_ok = (s == "5.00ns");
  end

  analog begin
    if ($abstime > 7n) begin
      `CHECKI("§9.6 $timeformat(-12, 0, \" ps\", 0) prints 5 ns as \"5000 ps\"", ps_ok, 1);
      `CHECKI("§9.6 $timeformat(-9, 2, \"ns\", 0) prints 5 ns as \"5.00ns\"", ns_ok, 1);
    end
    V(out) <+ 0.0;
  end
endmodule
