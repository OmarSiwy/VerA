// An engine limit, not a language rule: §9.21.1 names the data file of a
// $table_model call and bounds nothing about its size. VerA reads the file when
// the model compiles and stops at 16 MiB (specification/Vague_Decisions.md), so a larger
// file is refused with E1013 rather than treated as a file that is not there
// (which defers the error to the first lookup at run time).
//
// /dev/zero is a file every POSIX host has and that never ends, so it stands in
// for a file past any bound without committing one to the tree.
//
//! reject-only E1013
module table_model_file_over_16mib_rejected(p, n);
  inout p, n; electrical p, n;
  analog I(p,n) <+ $table_model(V(p,n), "/dev/zero", "1L");
endmodule
