// §9.7.1 $finish, EXECUTED: "If $finish is called during an accepted
// iteration, then the simulator shall exit after the current solution is
// complete." 055_finish.va keeps the call behind a guard the bias makes false
// and can only document that; this fixture is the positive half, and the sweep
// is what makes termination observable in a transcript the run must survive
// to print:
//
//   point 0, V(p) = 1.0:  the check prints `ok=1` (1.0 < 1.5), then $finish
//                         runs — level 2 prints its Table 9-25 diagnostic —
//                         and the run EXITS with status 0.
//   point 1, V(p) = 2.0:  never solved. Had the exit not happened, this point
//                         would print the same check with got 2.0 < 1.5 = 0
//                         against want 1 — a hard `ok=0`.
//
// So the fixture fails in exactly the two wrong worlds: a $finish that is
// dropped (the pre-fix behaviour — the second point prints ok=0) and a
// $finish that fires before its position among the prints (the first point's
// ok=1 line never appears and the fixture asserts nothing). The `2` is Syntax
// 9-5's diagnostic argument, not an exit status — §9.7.1 exits the run it
// ACCEPTED, so the process status is 0 and the harness has no status line to
// record.
//
//! lrm 9.7.1
//! lrm 9.7.1:2
//! sweep V(p) = 1.0, 2.0
`include "check.vh"
module ch09_finish_terminates(p, n);
  inout p, n; electrical p, n;
  analog begin
    `CHECKI("printed at the first point only: $finish ends the run before the second", V(p) < 1.5, 1);
    $finish(2);
    I(p,n) <+ V(p,n);
  end
endmodule
