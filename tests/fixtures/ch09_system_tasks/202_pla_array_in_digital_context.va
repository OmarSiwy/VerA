// §9.8 "Verilog AMS HDL does not extend the PLA modeling tasks defined in IEEE
// Std 1364 Verilog."
//
// So the tasks keep their IEEE 1364 §17.5 meaning in the DIGITAL context — the
// positive half this file pins. 154_timescale_pla_queue_analog_rejected.va is
// the clause's only .va cite and pins the other half (not callable from the
// analog block). The PLA logic itself is transcribed from
// ieee1364/17_system_tasks/audit_pla_sync_array_logic.v, whose derivation this repeats; what is
// new here is that the result crosses into a Verilog-AMS analog block.
//
// IEEE 1364-2005 §17.5: with ascending ranges, personality row k selects the
// inputs whose bit is 1, and output bit k is the AND (resp. OR) of the selected
// inputs.
//
// DERIVATION. personality[1] = 2'b11 (both inputs), personality[2] = 2'b10
// (input 1 only); inputs = 2'b10, i.e. input1 = 1, input2 = 0:
//
//   AND row1 = 1 & 0 = 0,  row2 = 1  -> yand = 2'b01 = 1
//   OR  row1 = 1 | 0 = 1,  row2 = 1  -> yor  = 2'b11 = 3
//
// The analog block reads both 2-bit regs through §7.3.1 Table 7-1 as the
// integers 1 and 3 at t = 10n. They are set to 0 at time zero so the analog
// block's time-zero read is defined (§7.3.2), and the PLA calls run one tick
// later.
//
//! lrm 9.8
//! lrm 9.8:1000
//! analysis tran
//! time 0, 10n
//! print none
`timescale 1ns/1ns
`include "check.vh"
module ch09_pla_array_in_digital_context(out);
  inout out;
  electrical out;
  reg [1:2] personality [1:2];
  reg [1:2] inputs;
  reg [1:2] yand, yor;

  initial begin
    yand = 2'b00; yor = 2'b00;
  end

  initial begin
    #1;
    personality[1] = 2'b11;
    personality[2] = 2'b10;
    inputs = 2'b10;
    $sync$and$array(personality, inputs, yand);
    $sync$or$array(personality, inputs, yor);
  end

  analog begin
    if ($abstime > 5n) begin
      `CHECKI("§9.8 $sync$and$array: rows (1&0, 1) = 2'b01", yand, 1);
      `CHECKI("§9.8 $sync$or$array: rows (1|0, 1) = 2'b11", yor, 3);
    end
    V(out) <+ 0.0;
  end
endmodule
