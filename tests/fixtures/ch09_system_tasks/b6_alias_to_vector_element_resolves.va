// §9.20: "The hierarchical_reference_string shall refer to a scalar continuous
// node or a scalar element of a continuous vector node", and "The return value
// for both system functions shall be one (1) if the hierarchical_reference_string
// points to a valid continuous node", aliased "to the same circuit matrix
// position".
//
// The legal half of b6_alias_to_whole_vector_returns_zero.va: the same
// two-element vector, named by element. bus[1] is driven to 1.25 V and bus[0]
// to 0.75 V, so the voltage read through the alias says WHICH element it is.
//
//   $analog_node_alias(n1, "b6_ave_top.bus[1]") = 1,  V(n1) = 1.25
//   $analog_node_alias(n0, "b6_ave_top.bus[0]") = 1,  V(n0) = 0.75
//
//! lrm 9.20
//! lrm 9.20:17
//! lrm 9.20:10
//! lrm 9.20:11
//! bias V(g) = 0.0
//! solve
//! checks 4
`include "check.vh"

module b6_ave_top(g);
  inout g; electrical g;
  electrical [1:0] bus;
  b6_ave_checker ch1();
  analog begin
    I(g) <+ 0.0;
    V(bus[1]) <+ 1.25;
    V(bus[0]) <+ 0.75;
  end
endmodule

module b6_ave_checker;
  electrical n1, n0;
  integer s1, s0;
  analog initial begin
    s1 = $analog_node_alias(n1, "b6_ave_top.bus[1]");
    s0 = $analog_node_alias(n0, "b6_ave_top.bus[0]");
  end
  analog begin
    `CHECKI("§9.20 a scalar element of a vector node is a valid reference", s1, 1);
    `CHECKI("§9.20 so is the other element", s0, 1);
    `CHECKX("§9.20 n1 is bus[1]'s matrix position", V(n1), 1.25);
    `CHECKX("§9.20 n0 is bus[0]'s matrix position", V(n0), 0.75);
  end
endmodule
