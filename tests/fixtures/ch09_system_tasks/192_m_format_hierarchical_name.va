// §9.4.4 Hierarchical Name Format, verbatim and in full:
//
//   "The %m format specifier does not accept an argument. It causes the display
//    task to print the hierarchical name of the module, task, function, or named
//    block which invokes the system task containing the format specifier. This
//    is useful when there are many instances of the module which call the system
//    task. One obvious application is timing check messages in a flip-flop or
//    latch module; the %m format specifier pinpoints the module instance
//    responsible for generating the timing check message."
//
// TWO RULES ARE IN THAT PARAGRAPH, and the clause is the only place either one
// is stated. Rule one is the FIRST SENTENCE: `%m` and the argument list are
// independent. §9.4.1's pairing sentence ("For each % character which appears in
// a string, a corresponding expression argument shall be supplied after the
// string") therefore does NOT count it — the text here carves it out by name,
// which is why the clause bothers to say "does not accept an argument" at all.
// Rule two is the rest: what it PRINTS.
//
// RULE ONE IS A COMPILE-TIME CLAIM and the file deciding it is this one:
// `$sformat(t, "%m")` supplies no argument at all and `$sformat(u, "%m%d", 7)`
// gives the two conversions one operand between them. A compiler that counted
// `%m` as a conversion awaiting an operand refuses BOTH: it reports one and two
// missing arguments respectively (§9.4.3's pairing check is the one VerA runs,
// `lower.checkFormatPairing`). So the two assertions below are unreachable for
// such a compiler, and that is the point of putting them in this file.
//
// RULE TWO IS PINNED AGAINST A LITERAL. The invoking module here is the design's
// only instance — the root — so its hierarchical name IS its module identifier,
// and that identifier is text in THIS file rather than in VerA's testbench.
// Hand derivation, all three from the module declaration on line 55:
//
//   $sformat(t, "%m")        -> "ch09_m_format_hierarchical_name"
//   $sformat(u, "%m%d", 7)   -> that name ++ "7"   = "..._name7"
//   $sformat(v, "%d%m", 7)   -> "7" ++ that name   = "7ch09_..."
//
// The two sides of each comparison are BUILT DIFFERENTLY and that is what makes
// them worth writing: `u` puts an operand BEFORE the name and `v` puts one after
// it, so an implementation that lets `%m` swallow the operand, or that prints a
// placeholder, disagrees with its own other spelling. A compiler that never
// implemented `%m` prints the two characters `%m` and reads got=%m want=ch09_…
// (ok=0) on all three lines.
//
// WHAT IS NOT ASSERTED, deliberately: the name of a NON-root instance. §9.4.4's
// motivating case is "many instances of the module", and the instance path of a
// module compiled alone is a property of the netlist that instantiates it, not
// of this source. Pinning it here would pin the harness. The root module's own
// name is the one `%m` value that IS a property of the source.
//
//! lrm 9.4.4
//! lrm 9.4.1
//! lrm 9.4.3
//! lrm 9.5.3
//! print none
`include "check.vh"
module ch09_m_format_hierarchical_name(p, n);
  inout p, n; electrical p, n;
  string t, u, v;
  analog begin
    $sformat(t, "%m");
    `CHECKI("%m with no argument prints the invoking module's hierarchical name",
            t == "ch09_m_format_hierarchical_name", 1);
    $sformat(u, "%m%d", 7);
    `CHECKI("%m takes no argument, so the %d after it still consumes 7",
            u == "ch09_m_format_hierarchical_name7", 1);
    $sformat(v, "%d%m", 7);
    `CHECKI("an operand before %m is consumed by the %d, and the name follows it",
            v == "7ch09_m_format_hierarchical_name", 1);
    I(p,n) <+ V(p,n);
  end
endmodule
