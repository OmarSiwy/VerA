// §9.15 Table 9-28 "cwd" through the host's string table (ESPice #10), and
// a branch it drives.
//
// "Table 9-28 gives a list of simulation string parameter names that shall
// be supported by $simparam$str." Table 9-28: "cwd" is "The current working
// directory in which the simulator was started".
//
// The directory is the host's, so it reaches the device as host data. This
// testbench uses the channel a GPU host can use (`contract.host_strings`):
// the bytes in a host table, the `Model` row only the index
// (`Model.cwd_idx__`), and it leaves the `Instance.cwd` slice at "". A
// working directory is never the empty string, so the device sees a
// nonempty `cwd` exactly when it read the table; its digits are the host's
// filesystem and are not asserted.
//
// The branch: g = 1/R = 1/1000 = 1e-3 S when `cwd` is nonempty, else 0, and
// I(p,n) <+ g·V(p,n). With V(p,n) = 1 V the branch carries 1e-3 A, and its
// conductance dI/dV(p) is g (§4.5.14: g does not depend on V(p)).
// 1.0/1000.0 and the literal 1.0e-3 are the same double.
//
// Wrong implementations: a device that reads only the Instance slice, or a
// host that never publishes the table, gives g = 0 and fails both checks.
//
// No invalid form beside it: a name outside Table 9-28 is E0811
// (simparam_str_unknown_name_rejected.va), whatever the channel.
//
//! lrm 9.15
//! lrm 9.15:4
//! bias V(p) = 1.0
//! bias V(n) = 0.0
`include "check.vh"
module simparam_str_cwd_host_table(p, n);
    inout p, n;
    electrical p, n;
    parameter real R = 1000.0 from (0:inf);
    string cwd;
    real g;

    analog begin
        cwd = $simparam$str("cwd");
        g = (cwd == "") ? 0.0 : 1.0 / R;
        `CHECKX("Table 9-28 cwd reached the device, so the branch conducts", g, 1.0e-3);
        `CHECK("the branch's conductance is that g", ddx(g * V(p, n), V(p)), 1.0e-3, 1e-18);
        I(p, n) <+ g * V(p, n);
    end
endmodule
