// §9.21 supplies its own oracle — the data, the query point AND the answer —
// and it is the only place in the chapter that does.
//
// §9.21.5 prints the twelve-row sample set below verbatim as an array-source
// example, and Figure 9-2's caption states the lookup: "the same isolines with
// a lookup at x1=3.5; the isolines yh and yl bracketing y1=0.25 are interpolated
// at x1, producing intermediate points which are then interpolated in y to
// yield f(x1,y1)=2.0."
//
// Recomputed by hand from the printed rows, with the default control string
// (no control string is given, "and so the function defaults to performing
// linear interpolation and linear extrapolation in both dimensions"):
//
//   y=0.0 isoline  x: 1  2  3  4  5  6      f: 0.5 1.0 1.5 2.0 2.5 3.0
//   y=0.5 isoline  x: 1  3  5               f: 1.0 2.0 3.0
//   y=1.0 isoline  x: 1  2  4               f: 1.5 2.0 3.0
//
//   at x = 3.5 on the y=0.0 isoline: between (3.0, 1.5) and (4.0, 2.0)
//                                    -> 1.5 + 0.5*(2.0-1.5) = 1.75
//   at x = 3.5 on the y=0.5 isoline: between (3.0, 2.0) and (5.0, 3.0)
//                                    -> 2.0 + 0.25*(3.0-2.0) = 2.25
//   in y at 0.25, halfway between the two isolines: (1.75 + 2.25)/2 = 2.0
//
// The y=1.0 isoline takes no part: 0.25 lies between 0.0 and 0.5, so those two
// bracket it and the third is never consulted. That is the point of including
// it — a lookup that averaged all three isolines, or picked the nearest one,
// gives a different number.
//
// 2.0 is exact in binary floating point and every intermediate above is a
// dyadic rational, so nothing here rounds and CHECKX is the right form.
//
// The argument order is the LRM's own: `$table_model(0, V(a,b), y, x, f_xy)`,
// with the OUTERMOST independent variable first — "y is the outermost
// independent variable in the sample set while x is the innermost".
//
// §9.21.5 initializes the arrays inside `@(initial_step)`, "ensuring that they
// do not change after the first call to $table_model". This device is one flat
// analog block evaluated at a single operating point, so the assignments sit
// straight in it, as 131_table_model_array_control.va already does.
//
//! lrm 9.21
//! lrm 9.21.5
//! xfail VerA refuses $table_model with E0801 (no isoline interpolator); Table 9-18 marks it analog-context Yes
`include "check.vh"
module ch09_table_model_lrm_sample_set(p, n);
  inout p, n; electrical p, n;
  real y[0:11], x[0:11], f_xy[0:11];
  real f;
  analog begin
    // y=0.0 isoline
    y[0] =0.0; x[0] =1.0; f_xy[0] =0.5;
    y[1] =0.0; x[1] =2.0; f_xy[1] =1.0;
    y[2] =0.0; x[2] =3.0; f_xy[2] =1.5;
    y[3] =0.0; x[3] =4.0; f_xy[3] =2.0;
    y[4] =0.0; x[4] =5.0; f_xy[4] =2.5;
    y[5] =0.0; x[5] =6.0; f_xy[5] =3.0;
    // y=0.5 isoline
    y[6] =0.5; x[6] =1.0; f_xy[6] =1.0;
    y[7] =0.5; x[7] =3.0; f_xy[7] =2.0;
    y[8] =0.5; x[8] =5.0; f_xy[8] =3.0;
    // y=1.0 isoline
    y[9] =1.0; x[9] =1.0; f_xy[9] =1.5;
    y[10]=1.0; x[10]=2.0; f_xy[10]=2.0;
    y[11]=1.0; x[11]=4.0; f_xy[11]=3.0;
    f = $table_model(0.25, 3.5, y, x, f_xy);
    `CHECKX("§9.21 Figure 9-2: f(3.5, 0.25) on the LRM sample set", f, 2.0);
    I(p,n) <+ V(p,n) + f;
  end
endmodule
