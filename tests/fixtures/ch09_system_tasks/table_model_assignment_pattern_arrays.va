// §9.21.5: "Arrays may also be specified directly via an array assignment
// pattern." So the data source can be written inline, '{...} per column, with
// no array variable at all.
//
// Two samples, x = 1, 2 and f = 10, 20. The control string is omitted, so
// Table 9-32's first row applies: linear interpolation (a05_07). Inside the
// region:
//
//   f(1.5)  = 10 + (1.5  - 1)/(2 - 1) * (20 - 10) = 15.0
//   f(1.25) = 10 + (1.25 - 1)/(2 - 1) * (20 - 10) = 12.5
//
// Every operand is a binary fraction, so both are exact.
//
//! lrm 9.21.5
//! lrm 9.21.5:2
//! bias V(p) = 1.5, V(n) = 0.0
//! checks 2
`include "check.vh"
module b6_table_model_assignment_pattern_arrays(p, n);
  inout p, n; electrical p, n;
  real f, g;
  analog begin
    f = $table_model(V(p, n), '{1.0, 2.0}, '{10.0, 20.0});
    g = $table_model(1.25, '{1.0, 2.0}, '{10.0, 20.0});
    `CHECKX("§9.21.5 inline assignment-pattern columns, linear at 1.5", f, 15.0);
    `CHECKX("§9.21.5 the same columns at 1.25", g, 12.5);
    I(p, n) <+ V(p, n) + f;
  end
endmodule
