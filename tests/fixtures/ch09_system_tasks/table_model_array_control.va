// §9.21 / §9.21.1, the ARRAY data source. Table 9-18 marks $table_model
// `Yes  Yes`, so this must compile and run green; the reject that used to stand
// here demanded the opposite of the table it cited.
//
//   table_data_source ::= file_name | table_model_array
//   table_model_array ::= 1st_dim_array_identifier [, ...], output_array_identifier
//
// §9.21.1: "When the data source is a sequence of 1-D arrays the isolines are
// laid out in conceptually the same way with each array being just as a column
// in the file format described above." So `xs` is the independent column and
// `fs` the dependent one, and the table below is one dimension of two samples —
// exactly the "minimum data requirement ... at least two points per dimension".
//
// The samples are on the line f(x) = 2x, chosen so the answer is exact:
//
//     xs = { 1.0, 3.0 }        fs = { 2.0, 6.0 }
//
// with linear interpolation (Table 9-30 character `1`) a lookup at x = 2.0
// lands halfway between the two samples, so f = 2.0 + (6.0 - 2.0)/2 = 4.0.
// Control string "1LL;1" is Table 9-32's linear/linear-both-ends form with
// dependent selector 1. Every point is distinct in its independent value, as
// §9.21 requires.
//
// §9.21.1's OTHER array shape: "Arrays may be specified directly via the
// concatenation operator or via array variable names." The second check writes
// the same two columns as constant concatenations, with the same data and
// control string, so it must return the same 4.0. A lowering that reads only
// array variables, or folds `{...}` to one operand, fails there while the
// identifier form still passes.
//
//! lrm 9.21
//! lrm 9.21.1
//! lrm 9.21.1:3
//! lrm 9.21:8
//! bias V(p) = 2.0
`include "check.vh"
module ch09_table_model_array_control(p, n);
  inout p, n; electrical p, n;
  real xs[0:1], fs[0:1];
  real f, g;
  analog begin
    xs[0] = 1.0; fs[0] = 2.0;
    xs[1] = 3.0; fs[1] = 6.0;
    f = $table_model(V(p,n), xs, fs, "1LL;1");
    `CHECKX("§9.21 linear interpolation halfway between the two samples", f, 4.0);
    g = $table_model(V(p,n), {1.0, 3.0}, {2.0, 6.0}, "1LL;1");
    `CHECKX("§9.21.1 the concatenation-operator form of the same columns", g, 4.0);
    I(p,n) <+ V(p,n) + f;
  end
endmodule
