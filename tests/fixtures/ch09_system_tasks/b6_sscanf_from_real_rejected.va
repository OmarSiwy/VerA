// §9.5.4.2: "$sscanf reads from the string str (which shall be a string
// variable, string parameter, or string literal)."
//
// `src` is a real variable here: none of the three. A real holds no
// characters to scan (§3.3's string type is the only analog-context carrier
// of text), so there is no reading under which this call is legal.
//
// The neighbour b6_sscanf_reads_a_string_variable.va is this file with `src`
// declared `string` and assigned "42". E0813 is the code VerA gives the same
// rule's siblings ($swrite/$fgets/$ferror into a non-string).
//
//! lrm 9.5.4.2
//! lrm 9.5.4.2:1
//! reject-only E0813
//! neighbour b6_sscanf_reads_a_string_variable.va
`include "check.vh"
module b6_sscanf_from_real_rejected(p, n);
  inout p, n; electrical p, n;
  real src;
  integer k, code;
  analog begin
    src = 42.0;
    code = $sscanf(src, "%d", k);        // illegal: str is a real variable
    `CHECKI("§9.5.4.2 %d read the decimal number from the string variable", k, 42);
    `CHECKI("§9.5.4.2 one item was assigned", code, 1);
    I(p, n) <+ V(p, n);
  end
endmodule
