// §9.22.4 driver_update. Table 9-19 marks `@(driver_update)` supported in the
// DIGITAL context of a connectmodule, and §9.22 paragraph 3 makes a connect
// module the only place any of this family may be called from: "Driver access
// functions can only be called from connect modules."
//
// So a connectmodule with `always @(driver_update d)` is the one context in
// which the construct is legal, and a compiler must ACCEPT it. The previous
// expectation here was `//! reject NoModule` — VerA's phase label for "no
// ordinary module in this file", not an LRM rule — which demanded a diagnostic
// against the legal case and cited no clause at all.
//
// §9.22.4 in full: "always @(driver_update clock) statement; causes the
// statement to execute any time a driver of the signal clock is updated. Here,
// an update is defined as the addition of a new pending value to the driver.
// This is true whether or not there is a change in the resolved value of the
// signal."
//
// WHAT IS ASSERTED, AND WHY IT IS NOT THE TRIGGER. The clause defines a TRIGGER,
// and how often it fires depends on how many drivers the elaborated netlist puts
// on `d` — a property of the instantiating design, not of this source. Counting
// firings here would pin the harness, not the LRM. The positive semantics of
// §9.22.6 (a real connectmodule instance, $driver_count == N, the 0..N-1 loop)
// need a driven connectmodule and still have no fixture.
//
// What IS assertable is ACCEPTANCE, and this file used to duck it. It carried
// `//! xfail` with no `//! reject` and no `CHECK` at all — which routes to
// `unasserted`, never to XPASS, so the marker could not fire on the day the gap
// closed. That is a TODO wearing an xfail. So the file now also carries an
// ordinary module with a real assertion in it. The assertion is deliberately
// about nothing but a branch potential (0.75 - 0.25 = 0.5, both operands exact
// in binary): its whole job is to be a verdict that EXISTS, so that "this source
// file, connectmodule and all, was accepted, elaborated and run" becomes a
// green/red the runner can see. That is the assertion, and it is green now.
//
// ONE LINE OF THIS FIXTURE WAS ITSELF WRONG, and it is corrected above rather
// than implemented: it used to close the connect module with
// `endconnectmodule`, WHICH IS NOT A KEYWORD OF THIS LANGUAGE. A.1.2 gives a
// connect module no production of its own —
//
//     module_declaration ::= { attribute_instance } module_keyword
//         module_identifier [ module_parameter_port_list ] list_of_ports ;
//         { module_item } endmodule
//     module_keyword ::= module | macromodule | connectmodule
//
// — so the terminator is `endmodule`, and annex B's reserved list confirms it
// by containing `endconnectrules` and no `endconnectmodule` at all. §7.6's own
// three examples ("connectmodule d2a (in, out); … endmodule") print it that
// way. Making a compiler accept the invented spelling would have been the suite
// teaching VerA a dialect; the fixture had to move.
//
//! lrm 9.22.5
//! bias V(p) = 0.75, V(n) = 0.25
`include "check.vh"
connectmodule ch09_driver_update_connectmodule(d, a);
  input d; output a;
  logic d;
  electrical a;
  always @(driver_update d) $strobe("driver updated");
endmodule

module ch09_driver_update_host(p, n);
  inout p, n; electrical p, n;
  analog begin
    `CHECK("the file carrying the §9.22.4 connectmodule compiles and runs",
           V(p,n), 0.5, 1e-15);
    I(p,n) <+ V(p,n);
  end
endmodule
