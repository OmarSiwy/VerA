// §9.4.3, the parenthesis that 161_display_argument_pairing_rejected.va reads
// for the count and that nothing read for the RENDERING:
//
//   "For each % character (except %m, %% and %l) that appears in a string, a
//    corresponding expression argument shall be supplied after the string."
//
// Three specifiers consume no argument. `%%` and `%m` were already exercised by
// 06_display_formats.va; `%l` was not, and it was the one the two halves of the
// compiler disagreed about — the pairing check skipped it, the formatter ate an
// operand for it. A skipped operand is not a cosmetic difference: every
// conversion AFTER the `%l` shifts left by one, the last one runs out of
// arguments, and the transcript is silently full of the wrong numbers.
//
// So the format below puts `%l` BETWEEN two consuming specifiers, which is the
// only position where the slip is observable: at the front the wrong operand is
// merely mislabelled, at the back there is nothing left to shift.
//
// HOW A TRANSCRIPT BECOMES A NUMBER. §9.5.3 `$sformat` is the same §9.4.3
// formatter writing into a string variable, and §9.5.4.2 `$sscanf` reads the
// result back — the round trip 06_display_formats.va uses for %h and %o. The
// scan format `"%d %*s %d"` skips the middle field, because what `%l` prints is
// not a number a fixture can pin: Table 9-22 defines it as "library.cell", and
// VerA compiles a source file rather than a library-mapped design, so there is
// no library to name. What IS pinned is that the middle field consumed no
// argument, which the two integers either side state exactly:
//
//   correct   "42 <cell> 7"   ->  first=42  second=7   count=2
//   slipped   "42 7 0"        ->  first=42  second=0   count=2
//
// The count is 2 and not 3 in both cases — "a suppressed field is matched and
// not assigned" — so it is the SECOND value, not the count, that carries the
// claim. It is asserted anyway so a scan that fell over entirely cannot be
// mistaken for a scan that read a zero.
//
// The pairing rule itself is satisfied here (two consuming specifiers, two
// arguments), which is what keeps this a running fixture rather than a second
// copy of the 161 reject.
//
//! lrm 9.4.3
//! lrm 9.5.3
//! lrm 9.5.4.2
//! lrm 9.5.4.2:1
//! lrm 9.5.4.2:5
`include "check.vh"
module ch09_display_library_binding(p, n);
  inout p, n; electrical p, n;
  string text;
  integer first, second, count;
  analog begin
    $sformat(text, "%d %l %d", 42, 7);
    count = $sscanf(text, "%d %*s %d", first, second);
    `CHECKI("§9.4.3 the specifier before %l still gets the first argument", first, 42);
    `CHECKI("§9.4.3 %l consumes no argument, so the next specifier gets the second", second, 7);
    `CHECKI("§9.5.4.2 a suppressed field is not counted, so two items were assigned", count, 2);
    I(p,n) <+ V(p,n) + first + second + count;
  end
endmodule
