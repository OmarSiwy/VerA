// §9.2 Table 9-11 lists `$ln` as supported in the analog context, and §4.3.1
// Table 4-14 defines it as the natural logarithm — the C `log(x)`, domain x > 0.
//
// ln(2) = 0.69314718055994530941723... The correctly rounded IEEE-754 double is
// 0.6931471805599453; the tolerance is ~1.5 ulp at that magnitude.
//
// Table 4-14 also says the Verilog system-function spelling `$ln(x)` and the
// traditional Verilog-AMS spelling `ln(x)` are the SAME function — an identity
// with no value of its own, hence CHECKEQ.
//
// §9.14's sentence quantifies over the whole table: "All of these functions,
// except $clog2, are aliases of the analog math operators described in 4.3.1."
// math_system_names.va checks 16 of the pairs; the ten below are the rest, so
// the two files together cover every function except $clog2. Same function
// means the same bits, hence tolerance 0.0.
//
//! lrm 9.14
//! lrm 9.14:1001
`include "check.vh"
module ch09_atomic_ln(p, n);
  inout p, n; electrical p, n;
  analog begin
    `CHECK("$ln(2.0) is the natural log", $ln(2.0), 0.6931471805599453, 1e-15);
    `CHECKEQ("Table 4-14: $ln(x) is ln(x)", $ln(7.5), ln(7.5), 0.0);
    `CHECKEQ("Table 9-11: $ln1p(x) is ln1p(x)", $ln1p(0.25), ln1p(0.25), 0.0);
    `CHECKEQ("Table 9-11: $expm1(x) is expm1(x)", $expm1(0.25), expm1(0.25), 0.0);
    `CHECKEQ("Table 9-11: $asin(x) is asin(x)", $asin(0.5), asin(0.5), 0.0);
    `CHECKEQ("Table 9-11: $acos(x) is acos(x)", $acos(0.5), acos(0.5), 0.0);
    `CHECKEQ("Table 9-11: $atan(x) is atan(x)", $atan(0.5), atan(0.5), 0.0);
    `CHECKEQ("Table 9-11: $sinh(x) is sinh(x)", $sinh(0.5), sinh(0.5), 0.0);
    `CHECKEQ("Table 9-11: $cosh(x) is cosh(x)", $cosh(0.5), cosh(0.5), 0.0);
    `CHECKEQ("Table 9-11: $asinh(x) is asinh(x)", $asinh(0.5), asinh(0.5), 0.0);
    `CHECKEQ("Table 9-11: $acosh(x) is acosh(x)", $acosh(2.0), acosh(2.0), 0.0);
    `CHECKEQ("Table 9-11: $atanh(x) is atanh(x)", $atanh(0.5), atanh(0.5), 0.0);
    I(p,n) <+ V(p,n) + $ln(2.0);
  end
endmodule
