// §9.5.4.2's control-string rules say nothing about lines, and one of them says
// so explicitly:
//
//   "The control string can contain the following:
//      White space characters (SPACES, TABS, NEWLINES, or formfeeds) that,
//      except in one case described below, cause input to be read up to the next
//      nonwhite space character. ..."
//
// A newline is therefore ordinary white space on both sides of the scan: in the
// control string it matches a run of white space, and in the input it is skipped
// as "white space leading an input field". A single $fscanf can consequently
// satisfy directives from more than one line, which is the case a reader built
// around $fgets cannot express at all.
//
// THE FILE. "12\n34\n" — six bytes:
//
//   offset  0   1   2    3   4   5
//   byte   '1' '2' '\n' '3' '4' '\n'
//
// HAND DERIVATION for the single call $fscanf(fd, "%d %d", a, b):
//
//   %d     field "12" at offsets 0-1, stops on the '\n' at 2   -> a = 12
//   ' '    the control string's space matches the '\n' at 2     (a newline is
//          white space; it "causes input to be read up to the next nonwhite
//          space character")
//   %d     field "34" at offsets 3-4, stops on the '\n' at 5   -> b = 34
//
//   "The number of successfully matched and assigned input items is returned in
//    code" -> 2.  The trailing '\n' at offset 5 is "left unread unless matched
//   by a directive", and no directive remains, so $ftell is 5 and not 6.
//
// The second half of the file is the same rule under a directive that is NOT
// white space: an ordinary character in the control string "must match the next
// character of the input stream". Scanning "7,8\n" with "%d,%d" therefore
// matches both items — the comma directive consumes the comma — and stops at the
// newline, position 3.  That pair keeps the first claim honest: it shows the
// scanner is reading directives rather than splitting on delimiters.
//
// THE FAILURE THIS CATCHES. A reader that loads one line and scans within it
// satisfies the comma case and fails the newline case: the second %d finds
// nothing after "12", so it returns 1 with b untouched.
//
//! lrm 9.5.4.2
//! lrm 9.5.5
//! lrm 9.5.4.2:4
//! print none
`include "check.vh"
module s01_fscanf_multiline(p, n);
  inout p, n; electrical p, n;
  integer fd, code, pos, a, b, code2, pos2, x, y;
  analog begin
    fd = $fopen("s01_09_lines.dat", "w");
    $fwrite(fd, "12\n34\n");
    $fclose(fd);

    fd = $fopen("s01_09_lines.dat", "r");
    code = $fscanf(fd, "%d %d", a, b);
    pos = $ftell(fd);
    $fclose(fd);

    fd = $fopen("s01_09_comma.dat", "w");
    $fwrite(fd, "7,8\n");
    $fclose(fd);

    fd = $fopen("s01_09_comma.dat", "r");
    code2 = $fscanf(fd, "%d,%d", x, y);
    pos2 = $ftell(fd);
    $fclose(fd);

    `CHECKI("§9.5.4.2 white space in the control string matches a newline", code, 2);
    `CHECKI("§9.5.4.2 the first item comes from the first line", a, 12);
    `CHECKI("§9.5.4.2 the second item comes from the second line", b, 34);
    `CHECKI("§9.5.5 the trailing newline is left unread, so the position is 5", pos, 5);

    `CHECKI("§9.5.4.2 an ordinary character directive matches the input character", code2, 2);
    `CHECKI("§9.5.4.2 and both fields around it convert", x + 10 * y, 87);
    `CHECKI("§9.5.5 the scan stops before the newline, at offset 3", pos2, 3);

    I(p,n) <+ V(p,n) + a + b + x + y;
  end
endmodule
