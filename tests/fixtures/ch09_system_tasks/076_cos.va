// LRM 9.14 / Table 4-14: $cos is an alias of the 4.3.1 operator cos, argument
// in RADIANS. At V(p,n) = 0.5 V, cos(0.5 rad) = 0.8775825618903728, the value
// of 1 - 0.5^2/2 + 0.5^4/24 - 0.5^6/720 + ...  A degree reading would give
// 0.99996, which is why the check is tight rather than to two places.
//
//! lrm 9.14
//! bias V(p) = 0.5
`include "check.vh"
module ch09_atomic_cos(p, n);
  inout p, n; electrical p, n;
  analog begin
    `CHECK("$cos(0.5 rad)", $cos(V(p,n)), 0.8775825618903728, 1e-15);
    I(p,n) <+ V(p,n) + $cos(V(p,n));
  end
endmodule
