// §9.13.2, the rule that belongs to $rdist_uniform alone:
//
//   "In $rdist_uniform, the start and end arguments are real inputs which BOUND
//    the values returned. The START VALUE SHALL BE SMALLER THAN THE END VALUE."
//
// It is separate from the greater-than-zero rule of 150 because it is a
// relation between two arguments rather than a domain on one, and because
// $rdist_uniform is the one distribution the LRM lets take negative arguments —
// "bound the values returned" is all the arguments mean, so their signs are
// free and only their order is not.
//
// An interval with start above end is empty; there is no value for a uniform
// draw to return from it, which is why the LRM makes the order a "shall" rather
// than silently swapping the pair.
//
// 119_dist_uniform.va is the legal neighbour and quotes this same sentence
// before passing arguments in the right order.
//
// A reject, so there is nothing to run and no `want` to write.
//
//! lrm 9.13.2
//! reject smaller than the end value
//! xfail VerA refuses the whole §9.13 family with E0801 at the function name, so the start/end pair is never compared
module ch09_rdist_uniform_start_end_rejected(p, n);
  inout p, n; electrical p, n;
  integer seed;
  real x;
  analog begin
    seed = 1;
    x = $rdist_uniform(seed, 5.0, 1.0);
    I(p,n) <+ V(p,n) + x;
  end
endmodule
