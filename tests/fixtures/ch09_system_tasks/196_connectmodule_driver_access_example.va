// §9.22.7 Connect module example using driver access functions. The clause's
// prose, verbatim:
//
//   "Using the example shown in Figure 9-4, a connect module can be created
//    using driver access functions to accurately model the effects of multiple
//    drivers on an interface.
//
//    The connect module below takes advantage of much of the mixed-signal
//    language including driver access functions. This module effectively adds
//    another parallel resistor from output to ground whenever a digital output
//    connected to the net goes high, and another parallel resistor from output
//    to rail (supply) whenever a digital output connected to the net goes low.
//    If this is used as the connect module in Figure 9-4, not only is the delay
//    from digital outputs to the digital input a function of the value of the
//    capacitor, for a given capacitance it takes approximately half the time
//    (since two gates are driving the signal rather than one)."
//
// and the module below is the example itself, line for line as the clause prints
// it — `c2e`, the two gates `d1`/`d3` of Figure 9-4 driving `n1` with their
// connect module adding one impedance per driven level. Nothing is added to it,
// nothing is renamed, and no line is reordered: an LRM example is a source form
// the language promises, and the claim is the weakest one that promise supports
// — that it COMPILES. The one thing the fixture adds is the ordinary module at
// the end, and that is a format requirement rather than a claim: VerA reports
// E1001 ("source contains no module declaration") for a file whose only module
// is a connect module, exactly as several ch07 fixtures note (see
// connectmodule_accepted.va, which adds a host for the same reason).
//
// WHAT THE EXAMPLE EXERCISES, and why this is the chapter's densest single
// source: `always @(driver_update(d))` (§9.22.5), `$driver_count` (§9.22.1) and
// `$driver_state` (§9.22.3) in the loop it drives, `assign d=out;` (§9.22.6's
// rule 2, the receiver value), three `branch` declarations, a `ground` terminal,
// `initial` and `always` blocks in a connect module, and three `cross()` events
// feeding `out`. It is also the only place in the LRM where a driver access
// function is used on the value ANOTHER driver access function returned
// (`$driver_state(d,i)` indexed by a `for` counter bounded by `$driver_count(d)`),
// which is why the worked example and not a paraphrase is worth a file.
//
// WHY IT CARRIES `xfail`, MEASURED NOT GUESSED. Two constructs in the example
// are refused today, and they are in the order VerA reports them:
//
//   line 87  `assign d=out;`  E0205 "unsupported module item: found `assign`",
//                             note "LRM annex A.1.4" — the continuous assignment
//                             of §9.22.6, unwritable in any module;
//   line 104 `out = 1'bx;`    E0130 "literal requires digital value support in
//                             the execution backend" — the four-state literal of
//                             §2.6.1 in a connect module's `always` block.
//
// Both are VerA's, not the LRM's. The second only becomes visible when the first
// is fixed, so this file stays xfail through that step and the reason above says
// which line is which. Behind both is the larger fact that a connect module is
// never inserted (§7.8) and never lowered, so nothing in the example can RUN even
// once it parses: §9.22.7 is the whole mixed-signal row in one file.
//
// WHAT IS ASSERTED. The host module's branch potential, the same acceptance
// verdict 38_driver_update_connectmodule.va and 195_receiver_net_resolution_-
// assign.va use: 0.75 - 0.25 = 0.5, exact in binary, and it exists only if the
// whole file — example included — was accepted, elaborated and run.
//
//! lrm 9.22.7
//! lrm 9.22.5
//! lrm 9.22.6
//! lrm 9.22
//! bias V(p) = 0.75, V(n) = 0.25
//! xfail the LRM's own §9.22.7 example is refused twice over: `assign d=out;` is E0205 (unsupported module item, the §9.22.6 spelling), and behind it `out = 1'bx;` is E0130 (no four-state literal in the execution backend)
`include "check.vh"
connectmodule c2e(d,a);
    input d;
    output a;

    ddiscrete d;
    electrical a, rail, gnd;

    reg out;
    ground gnd;
    branch (rail,a)pull_up;
    branch (a,gnd)pull_down;
    branch (rail,gnd)power;
    parameter real impedance0 = 120.0;
    parameter real impedance1 = 100.0;
    parameter real impedanceOff = 1e6;
    parameter real vt_hi = 3.5;
    parameter real vt_lo = 1.5;
    parameter real supply = 5.0;
    integer i, num_ones, num_zeros;

    assign d=out;
    initial begin
        num_ones = 0;
        num_zeros = 0;
    end

    always @(driver_update(d)) begin
        num_ones = 0;
        num_zeros = 0;
        for ( i = 0; i < $driver_count(d); i=i+1)
            if ( $driver_state(d,i) == 1 )
                num_ones = num_ones + 1;
            else
                num_zeros = num_zeros + 1;
    end

    always @(cross(V(a) - vt_hi, -1) or cross(V(a) - vt_lo, +1))
        out = 1'bx;
    always @(cross(V(a) - vt_hi, +1))
        out = 1'b1;
    always @(cross(V(a) - vt_lo, -1))
        out = 1'b0;

    analog begin
        // Approximately one impedance1 resistor to rail per high output
        // connected to the digital net
        V(pull_up) <+ 1/((1/impedance1)*num_ones+(1/impedanceOff)) *
            I(pull_up);
        // Approximately one impedance0 resistor to ground per low output
        // connected to the digital net
        V(pull_down) <+ 1/((1/impedance0)*num_zeros+(1/impedanceOff)) *
            I(pull_down);
        V(power) <+ supply;
    end
endmodule

module ch09_connectmodule_driver_access_example_host(p, n);
  inout p, n; electrical p, n;
  analog begin
    `CHECK("the file carrying the §9.22.7 example compiles and runs",
           V(p,n), 0.5, 1e-15);
    I(p,n) <+ V(p,n);
  end
endmodule
