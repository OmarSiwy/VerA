// §9.7.3: "If $error is executed within an analog initial block, then the
// message is issued and the initialization continues. However, the simulation
// shall not proceed past initialization."
//
// Two halves, one file:
//
//   initialization continues: the statements after the $error run, so
//     `stage` reaches 2 and the $display check after it prints ok=1;
//   no simulation: the analog block never runs, so its check (stage = 2
//     against want 0, ok=0) never prints.
//
// So exactly one verdict. $display, not $strobe, for the reason given in
// b6_finish_in_analog_initial_skips_simulation.va.
//
// THE EXIT STATUS. §9.7.3 calls $error "a run-time error" and this run ends
// because of it; the LRM gives no digit. 1 is VerA's status for a run that an
// error ended (173_fatal_terminates.va floors $fatal at 1 so an error can
// never read as success; a05_12 and E0601 exit 1), so a run stopped by $error
// takes it too.
//
//! lrm 9.7.3
//! lrm 9.7.3:10
//! lrm 9.7.3:1003
//! lrm 5.2.1
//! exit 1
//! checks 1
`include "check.vh"
`ifdef VERA_PERTURB
`define CHECKI_NOW(NAME, GOT, WANT) $display("%s got=%d want=%d ok=%d", NAME, GOT, (WANT) + 1, ((GOT) == (WANT) + 1))
`else
`define CHECKI_NOW(NAME, GOT, WANT) $display("%s got=%d want=%d ok=%d", NAME, GOT, WANT, ((GOT) == (WANT)))
`endif
module b6_error_in_analog_initial_stops_after_initialization(p, n);
  inout p, n; electrical p, n;
  integer stage;
  analog initial begin
    stage = 1;
    $error("analog initial reports an error");
    stage = 2;
    `CHECKI_NOW("initialization continues past $error", stage, 2);
  end
  analog begin
    `CHECKI("never printed: the simulation does not proceed past initialization", stage, 0);
    I(p, n) <+ V(p, n);
  end
endmodule
