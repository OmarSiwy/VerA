// §9.21.3 Table 9-32, one of its example control strings, verbatim:
//
//   "I,1CC,1CC;3"   Ignore column 1, linear interpolation and constant
//                   extrapolation in all dimensions, interpolation applies to
//                   dependent variable 3. There are at least 6 column in the
//                   data file.
//
// ("6 column" is the published wording.) The count is not decoration, it is
// §9.21.2's selector rule applied: "The dependent variable selector is a column
// number allowing us to specify which dependent variable in the data source we
// wish to interpolate. This number runs 1 though M with M being the total
// number of dependent variables specified in the data source." Here the
// control string spends column 1 on I and columns 2-3 on the two dimensions,
// so dependent 3 is column 3 + 3 = 6.
//
// a05_two_dependents.tbl has FOUR columns (y, x, f1, f2 — see its header), so
// under this control string it has 4 - 3 = 1 dependent and selector 3 is
// outside 1..M. The same file under "1LL,1LL;2" is read and interpolated by
// a05_07_file_multiple_dependents.va, so the data source is not the fault;
// the example's own "at least 6 columns" is.
//
// Two table inputs, because the ignored column is not a dimension: Table 9-32's
// "3,D,I,1;3" row numbers its dimensions 3, 2 and 1 across four sub-strings.
//
// VerA reports E0815 "dependent selector 3 names no dependent column".
//
//! lrm 9.21.3
//! lrm 9.21.2
//! lrm 9.21.2:1002
//! reject-only E0815
//! reject dependent selector 3 names no dependent column
//! neighbour a05_07_file_multiple_dependents.va
`include "disciplines.vams"
module ch09_table_model_example_selector_beyond_columns(p, n);
  inout p, n; electrical p, n;
  analog I(p, n) <+ $table_model(0.5, 1.5, "a05_two_dependents.tbl", "I,1CC,1CC;3");
endmodule
