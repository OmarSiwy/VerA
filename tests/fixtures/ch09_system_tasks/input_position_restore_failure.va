// Host-only input for AMS 9.5.9:1002; no standalone fixture credit.
// The host creates profile_input.dat with "41 73\n", accepts initialization,
// then rejects the first positive-time iteration after it reads 41.
// A healthy retry must read 41 again. The fault variant must disable both
// backing-store restoration AND buffered replay before rejecting the trial.
`include "disciplines.vams"
module input_position_restore_failure(p, n);
  inout p, n;
  electrical p, n;
  integer fd, matched, sample;
  analog begin
    @(initial_step) fd = $fopen("profile_input.dat", "r");
    if ($abstime > 0.0) matched = $fscanf(fd, "%d", sample);
    I(p, n) <+ V(p, n) + sample;
  end
endmodule
