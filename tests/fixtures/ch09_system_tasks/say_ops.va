// §9.4 the display tasks of a DEVICE, which cannot print: its `say` records
// each task it runs into a host's `contract.Say`, and the host renders the
// records (`contract.formatSay`). Driven by tests/fixtures/ch09_system_tasks/say_host.zig, compiled for
// NVPTX and AMDGCN by tests/fixtures/ch09_system_tasks/say_gpu.zig. Sites, in source order:
//   0  $strobe("v = %g", V(p, n))             one value
//   1  $write("%d|%5.2f|", k, 0.5)            two values, no newline
//   2  $display("%s=%h", "k", k + 252)        "k" spliced into the format
//   3  $warning("hot %g > %g", V(p, n), lim)  only when V(p, n) > lim
//   4  $display                               a bare newline
// Not sites: `$monitor` (W0850) and `$error` (the status channel).
`include "disciplines.vams"
module say_ops(p, n);
  inout p, n;
  electrical p, n;
  parameter real lim = 1.0;
  integer k;
  analog begin
    k = 3;
    $strobe("v = %g", V(p, n));
    $write("%d|%5.2f|", k, 0.5);
    $display("%s=%h", "k", k + 252);
    if (V(p, n) > lim) $warning("hot %g > %g", V(p, n), lim);
    $display;
    $monitor("%g", V(p));
    if (V(p, n) > 10 * lim) $error("far over %g", lim);
    I(p, n) <+ V(p, n) / 1k;
  end
endmodule
