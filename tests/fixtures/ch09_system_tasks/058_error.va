// §9.7.3 $error: "shall be a run-time error", one of the three non-fatal
// severity tasks, and §9.7.3 adds that a non-fatal severity task "called during
// a rejected iteration shall have no effect". It returns nothing and its message
// goes to the simulator's log, so the rule pins no value on that side.
//
// The guard does carry one. §4.2.5 makes a relational an integer, 1 or 0, and
// `>` is STRICT, so the bias is put exactly on the threshold: V(p,n) = 1.0 - 0 =
// 1.0, both operands exact in binary, and 1.0 > 1.0 is false. This is the
// accepted-iteration operating point at which the severity task is NOT raised,
// which is what makes the fixture observable at all.
//
// A `>` lowered as `>=` raises the error at this bias and turns the 0 into a 1.
//
// WHAT THIS FIXTURE DOES NOT PROVE. $error is never executed, and cannot be: doing
// so is what ends the run, and this suite reads its verdict off a transcript the
// run has to survive to print. So the assertion below is about the OPERATING
// POINT — that the bias sits below the guard, i.e. that `>` is strict — and not
// about §9.7. It documents why the call is not reached. 060_info.va and
// 059_warning.va are the two tasks of this family that CAN be called
// unconditionally, and they are, with the assertion placed after the call.
//
//! lrm 9.7.3
//! lrm 9.7.3:3
//! bias V(p) = 1.0
`include "check.vh"
module ch09_atomic_error(p, n);
  inout p, n; electrical p, n;
  analog begin
    if (V(p,n) > 1.0) $error("voltage=%g", V(p,n));
    `CHECKI("strict > is false exactly at the threshold, so $error is not raised", V(p, n) > 1.0, 0);
    I(p,n) <+ V(p,n);
  end
endmodule
