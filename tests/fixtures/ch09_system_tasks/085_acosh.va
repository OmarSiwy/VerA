// §9.2 Table 9-11 lists $acosh as supported in the analog context; §4.3
// Table 4-15 defines it as C `acosh(x)`, the arc-hyperbolic cosine, with the
// domain x >= 1 — which is why the fixture feeds it abs(V) + 1. §4.3 makes the
// `$` and traditional spellings the same function.
//
// acosh(x) = ln(x + sqrt(x^2 - 1)), so at V(p,n) = 0.5 the argument is 1.5 and
// acosh(1.5) = ln(1.5 + sqrt(1.25)) = 0.9624236501192069.
//
//! lrm 9.14
//! bias V(p) = 0.5
`include "check.vh"
module ch09_atomic_acosh(p, n);
  inout p, n; electrical p, n;
  analog begin
    `CHECK("$acosh(1.5)", $acosh(abs(V(p,n)) + 1.0), 0.9624236501192069, 1e-15);
    `CHECK("acosh is ln(x + sqrt(x*x - 1))", ln(1.5 + sqrt(1.5 * 1.5 - 1.0)), 0.9624236501192069, 1e-15);
    `CHECK("acosh(1) is 0, the left edge of the domain", $acosh(1.0), 0.0, 1e-15);
    I(p,n) <+ V(p,n) + $acosh(abs(V(p,n)) + 1.0);
  end
endmodule
