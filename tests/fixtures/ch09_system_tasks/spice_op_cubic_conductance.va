// The device of spice_op_gmin_stepping.sp: a two-terminal conductance whose
// current is k·v³, so its conductance 3k·v² is EXACTLY zero at v = 0. Two of
// them in series from a source leave the middle node with no conductance at
// the SPICE cold start (every node at 0 V), so a Newton solve's first matrix
// has an all-zero row and is singular: the operating point needs §9.15's
// `gmin` ("Minimum conductance placed in parallel with nonlinear branches",
// Table 9-27), which gmin stepping places and then removes. The deck owns
// that half.
//
// WHAT THIS FILE ASSERTS ON ITS OWN. The constitutive law, at a bias where
// the conductance is not zero. §4.5.6: "ddx() returns the partial derivative
// of the expression with respect to the unknown". At V(p, n) = 0.5 with the
// default k = 1e-3:
//
//     I = k·v³          = 1e-3 · 0.125 = 1.25e-4 A
//     dI/dV(p) = 3k·v²  = 3e-3 · 0.25  = 7.5e-4 S
//
// Bands of 1e-18 against values above 1e-4: only a wrong law moves them.
//
//! lrm 4.5.6
//! bias V(p) = 0.5, V(n) = 0.0
//! checks 2
`include "check.vh"
module spice_op_cubic_conductance(p, n);
    inout p, n;
    electrical p, n;
    parameter real k = 1e-3 from (0:inf);
    real v;

    analog begin
        v = V(p, n);
        `CHECK("k·v³ at v = 0.5", k * v * v * v, 1.25e-4, 1e-18);
        `CHECK("its conductance 3k·v², which is zero at v = 0", ddx(k * v * v * v, V(p)), 7.5e-4, 1e-18);
        I(p, n) <+ k * v * v * v;
    end
endmodule
