// LRM 9.14 / Table 4-14: $sin is an alias of the 4.3.1 operator sin, whose
// argument is in RADIANS (4.3.1 lists no degree form). At V(p,n) = 0.5 V the
// argument is the number 0.5, and sin(0.5 rad) = 0.479425538604203 — the value
// of the Taylor series 0.5 - 0.5^3/6 + 0.5^5/120 - ... A degree reading would
// give 0.0087, three orders out.
//
//! lrm 9.14
//! bias V(p) = 0.5
`include "check.vh"
module ch09_atomic_sin(p, n);
  inout p, n; electrical p, n;
  analog begin
    `CHECK("$sin(0.5 rad)", $sin(V(p,n)), 0.479425538604203, 1e-15);
    I(p,n) <+ V(p,n) + $sin(V(p,n));
  end
endmodule
