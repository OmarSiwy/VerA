// §4.2.3 skips evaluation and its runtime domain errors; §9.13.2
// still requires an error for the same numeric arguments when executed.
//! lrm 4.2.3
//! lrm 9.13.2
//! lrm 4.2.3:4
`include "check.vh"
module ch09_rng_short_circuit(p,n);
  inout p,n; electrical p,n;
  parameter real mean = 0;
  integer seed, i, count;
  real value;
  analog begin
    seed = 7;
    value = 0 && $rdist_exponential(seed,0);
    `CHECKI("literal false and", value, 0);
    value = 1 || $rdist_exponential(seed,0);
    `CHECKI("literal true or", value, 1);
    value = 0 ? $rdist_exponential(seed,0) : 2;
    `CHECKX("literal false conditional", value, 2);
    value = 1 ? 3 : $rdist_erlang(seed,0,0);
    `CHECKX("literal true conditional", value, 3);
    if (0) value = $rdist_exponential(seed,0);
    for (i=0; i<0; i=$rdist_exponential(seed,0)) value=0;
    if (mean > 0) value = $rdist_exponential(seed,mean);
    `CHECKI("skipped calls preserve seed", seed, 7);
    value = $dist_uniform(seed,5,1);
    `CHECKX("integer reversed bounds use reference result", value, 5);
    `CHECKI("integer reversed bounds preserve seed", seed, 7);
    value = $dist_uniform(seed,3,3);
    `CHECKX("integer equal bounds use reference result", value, 3);
    count = 0;
    for (i=0; i<2; i=$dist_uniform(seed,1,3)) count=count+1;
    `CHECKI("live random for step uses two reference draws", count, 2);
    `CHECKI("live random for step preserves seed progression", seed, -965981971);
    I(p,n) <+ V(p,n);
  end
endmodule
