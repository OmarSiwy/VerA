// §9.21.2: "Each sub-string associated with interpolation control has at most
// 3 characters. The first character controls interpolation and obeys Table
// 9-30."
//
// The control string "1LLL" is one sub-string of four characters: `1` (linear
// interpolation) followed by three extrapolation characters. Three characters,
// "1LL", is the longest legal form and compiles in the same call (probed).
// The data (three sorted sample points in a single dimension) is legal.
//
// VerA reports E0815 "`1LLL`: a control sub-string carries at most 2
// extrapolation characters" — 1 interpolation + 2 extrapolation = 3.
//
//! lrm 9.21.2
//! lrm 9.21.2:2
//! lrm 9.21.2:1001
//! reject-only E0815
//! neighbour a05_03_cubic_spline_mixed_ends.va
`include "disciplines.vams"
module ch9_control_substring_too_long(p, n);
  inout p, n;
  electrical p, n;

  analog I(p, n) <+ $table_model(V(p, n), '{0.0, 1.0, 2.0}, '{0.0, 1.0, 4.0}, "1LLL");
endmodule
