// IEEE 1364-2005 §17.11.1 (AMS §9.14) requires 63: assignment into 128
// bits zero-extends the unsigned initializer 2**63. Its i64 carrier is
// negative, which alone cannot distinguish zero extension from sign
// extension. E0893 names this analog representation limit instead of
// inventing an answer of 128. Legal neighbours in clog2_unsigned_width.va
// exercise a 64-bit high bit and an exact 128-bit signed parameter alias.
//! lrm 9.14
//! reject-only E0893
//! neighbour clog2_unsigned_width.va
module reject_clog2_wide_widening;
  parameter [127:0] widened = 64'h8000000000000000;
  integer result;
  analog result = $clog2(widened);
endmodule
