// #77: §9.4.3 Table 9-22's %h/%o/%b "display in hexadecimal/octal/binary
// format" an expression's bit pattern, and IEEE 1364-2005 §17.1.1.3 sizes it:
// "the values written to the output ... are sized automatically ... In other
// radices, leading zeros are always displayed", unless a zero follows the `%`.
// The size is the expression's, IEEE 1364-2005 §5.4.1 Table 5-22: "Unsized
// constant number: Same as integer"; `i op j` for + - * / % & | ^ ^~:
// max(L(i), L(j)); `op i` for + - ~: L(i); `i << j`: L(i); `i?j:k`:
// max(L(j), L(k)). §3.2: an integer variable holds "-2^31 to 2^31-1", 32
// bits, so every expression below is 32 bits wide: 8 hex digits, 11 octal
// digits (ceil(32/3)), 32 binary digits. VerA printed the 64-bit carrier or
// the minimal digits for every operator here until #77.
//
// HAND DERIVATION, integer i = 255 (0x000000ff):
//   %h  i - 300          -45 = 2^32 - 45 = 0xffffffd3     "ffffffd3"
//   %h  i * 1            255                              "000000ff"
//   %h  -i               2^32 - 255 = 0xffffff01          "ffffff01"
//   %b  i & 3            3: thirty 0s, then 11
//   %h  (i > 3) ? i : 0  the true arm, 255                "000000ff"
//   %o  i + 1            256 = 4*64 = 0o400               "00000000400"
//   %h  ~i               ~0x000000ff = 0xffffff00         "ffffff00"
//   %h  i << 4           255*16 = 4080 = 0xff0            "00000ff0"
//   %h  255              an unsized literal, an integer   "000000ff"
//   %0h i * 1            §17.1.1.3's override: no size    "ff"
//   %d  i * 1            the same width under %d (#61): 11 columns,
//                        2147483648's 10 digits and a sign: 8 spaces, "255"
// The digital context prints the same text (iverilog agrees). There is no
// invalid input: a radix conversion takes any integer operand, so the legal
// neighbour is %0h, the clause's own override.
//! lrm 9.4.3
//! lrm 3.2
//! inherited IEEE 1364-2005 17.1.1.3
//! inherited IEEE 1364-2005 5.4.1
//! print none
//! checks 11
`include "check.vh"
module analog_radix_of_integer_expression_is_32_bits(p, n);
    inout p, n; electrical p, n;
    integer i; string t;
    analog begin
        i = 255;
        $sformat(t, "%h", i - 300);
        `CHECKI("%h of i - 300 is the 32-bit pattern of -45", t == "ffffffd3", 1);
        $sformat(t, "%h", i * 1);
        `CHECKI("%h of i * 1 keeps 32-bit leading zeros", t == "000000ff", 1);
        $sformat(t, "%h", -i);
        `CHECKI("%h of -i is the 32-bit pattern of -255", t == "ffffff01", 1);
        $sformat(t, "%b", i & 3);
        `CHECKI("%b of i & 3 is 32 binary digits", t == "00000000000000000000000000000011", 1);
        $sformat(t, "%h", (i > 3) ? i : 0);
        `CHECKI("%h of a ?: over two integers is 32 bits", t == "000000ff", 1);
        $sformat(t, "%o", i + 1);
        `CHECKI("%o of i + 1 is 11 octal digits", t == "00000000400", 1);
        $sformat(t, "%h", ~i);
        `CHECKI("%h of ~i is 32 bits", t == "ffffff00", 1);
        $sformat(t, "%h", i << 4);
        `CHECKI("%h of i << 4 is 32 bits", t == "00000ff0", 1);
        $sformat(t, "%h", 255);
        `CHECKI("%h of an unsized literal is an integer's 32 bits", t == "000000ff", 1);
        $sformat(t, "%0h", i * 1);
        `CHECKI("%0h overrides the automatic size", t == "ff", 1);
        $sformat(t, "[%d]", i * 1);
        `CHECKI("%d of i * 1 is an integer's 11 columns", t == "[        255]", 1);
        I(p, n) <+ V(p, n);
    end
endmodule
