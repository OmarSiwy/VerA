// §9.5.4.2: white space in the control string "causes input to be read up to
// the next nonwhite space character", and "white space leading an input field
// is ignored". No length bound. VerA used to scan a file through a 4096-byte
// window and end the run when a scan needed to look further (E1011); a scan
// that reads to the end of a full window now runs again over a wider one
// (#29).
//
// HAND DERIVATION. The file holds "5\n", then 5000 spaces, then "7\n".
//   t = 0:  $fscanf(fd, "%d", v) reads 5 and returns 1.
//   t = 1n: the next %d skips the newline and the 5000 spaces, then reads 7:
//           it returns 1 and v is 7. A tool that stopped at its window would
//           return EOF (-1) there.
//
//! lrm 9.5.4.2
//! analysis tran
//! time 0, 1n
//! checks 4
`include "check.vh"
module fscanf_window_over_4096(p, n);
  inout p, n; electrical p, n;
  integer fd, c, v;
  analog begin
    @(initial_step) begin
      fd = $fopen("fscanf_window_over_4096.dat", "w");
      $fwrite(fd, "5\n");
      $fwrite(fd, "%2500s", " ");
      $fwrite(fd, "%2500s", " ");
      $fwrite(fd, "7\n");
      $fclose(fd);
      fd = $fopen("fscanf_window_over_4096.dat", "r");
    end
    c = $fscanf(fd, "%d", v);
    `CHECKI("one item each time", c, 1);
    `CHECKI("5, then 7 past 5000 bytes of white space", v, ($abstime == 0) ? 5 : 7);
    I(p, n) <+ V(p, n);
  end
endmodule
