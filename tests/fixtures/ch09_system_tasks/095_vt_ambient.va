// §9.15: "$vt can optionally have temperature (in Kelvin units) as an input
// argument and returns the thermal voltage (kT/q) at the given temperature.
// $vt without the optional input temperature argument returns the thermal
// voltage using $temperature."
//
// With the ambient at 350 K, kT/q = 1.3806503e-23 * 350 / 1.602176462e-19 =
// 0.030160698054244664 V, using the NIST1998 k and q that Annex D.2 selects
// when no `PHYSICAL_CONSTANTS_* macro is defined. The LRM does not mandate a
// CODATA vintage, and the FIVE sets D.2 offers (NIST2018, NIST2010, SPICE, OLD
// and the NIST1998 `else default — annex-d-stddefs.html:363,371,390) spread by
// at most 3.04e-5 relative, so the check is written at rtol 1e-4: still four
// significant figures, and blind to the choice of constants.
//
// The second check is the LRM sentence itself — the no-argument form must be
// the one-argument form applied to $temperature — which is an identity with no
// value of its own to write down.
//
//! lrm 9.15
//! lrm 9.15:1002
//! temp 350
`include "check.vh"
module ch09_atomic_vt_ambient(p, n);
  inout p, n; electrical p, n;
  analog begin
    `CHECKR("kT/q at the 350 K ambient", $vt, 0.030160698054244664, 1e-4);
    `CHECKEQ("bare $vt is $vt($temperature)", $vt, $vt($temperature), 1e-15);
    I(p,n) <+ V(p,n) + $vt;
  end
endmodule
