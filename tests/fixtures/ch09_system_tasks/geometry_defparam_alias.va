// §6.3.6 permits hierarchical system parameters in defparam statements;
// §6.3 gives defparam precedence over an instance's named assignment.
// §3.4.7 permits aliases for these parameters. Here the outer coordinates
// are (2,-4), angle 300, flips (-1,-1), and mfactor 2. The leaf's named
// values are replaced, BEFORE combining with its parent, by (-3,6,100,
// -1,-1,3), so its answers are (-1,2,40,+1,+1,6). The x override uses only
// its alias spelling in both mechanisms; specifying both spellings is the
// separate geometry_alias_duplicate_rejected.va neighbour.
//! lrm 3.4.7
//! lrm 6.3
//! lrm 6.3.1
//! lrm 6.3.6
//! lrm 9.18
//! lrm 6.3.6:2
//! lrm 6.3:1
//! lrm 9.18:1000
//! checks 6
`include "check.vh"
module geometry_defparam_top;
  geometry_defparam_outer #(.$xposition(2), .$yposition(-4), .$angle(300),
                           .$hflip(-1), .$vflip(-1), .$mfactor(2)) outer();
endmodule
module geometry_defparam_outer;
  geometry_defparam_leaf #(.placement_x(90), .$yposition(90), .$angle(90),
                          .$hflip(1), .$vflip(1), .$mfactor(90)) leaf();
  defparam leaf.placement_x = -3, leaf.$yposition = 6,
           leaf.$angle = 100, leaf.$hflip = -1,
           leaf.$vflip = -1, leaf.$mfactor = 3;
endmodule
module geometry_defparam_leaf;
  aliasparam placement_x = $xposition;
  analog begin
    `CHECKX("defparam x alias replaces, then adds", $xposition, -1.0);
    `CHECKX("defparam y replaces, then adds", $yposition, 2.0);
    `CHECKX("defparam angle replaces, then wraps", $angle, 40.0);
    `CHECKX("defparam horizontal flip", $hflip, 1.0);
    `CHECKX("defparam vertical flip", $vflip, 1.0);
    `CHECKX("defparam mfactor", $mfactor, 6.0);
  end
endmodule
