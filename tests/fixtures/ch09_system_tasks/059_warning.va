// §9.7 / Table 9-4: `$warning` is a simulation-control message task, supported
// in the analog context and in no other. It returns nothing, so what a check can
// pin here is the operating point that decides whether it fires at all.
//
// §5.4.1 makes V(p,n) the potential DIFFERENCE of the two nodes, in the order
// named: at V(p) = 2.0 V and V(n) = 0.5 V it is exactly 1.5 V (both operands and
// the result are exact in IEEE-754). The first check pins that order.
//
// WHAT AN UNCONDITIONAL CALL PROVES, AND WHY IT IS UNCONDITIONAL. §9.7.3 gives
// these two tasks no return value, so there is no digit for them and the only
// observable the LRM fixes is that the RUN CONTINUES past them. The way to test
// that is to call them unconditionally and put an assertion AFTER the call: the
// `ok=` line only appears if execution got there, so a tool that terminated on
// $warning would print nothing and the fixture would fail.
//
// The previous shape put the call under `if (V(p,n) > 1.0)` and then asserted
// the guard. That asserts that `>` is strict — arithmetic, not §9.7 — and under
// the drop that then applied to a display task under an `if` (W0851, since
// lifted) the task did not run at all. $error and $fatal still have to be guarded, because
// executing them is what they are FOR; these two do not.
//
//! lrm 9.2
//! lrm 9.7.3
//! lrm 9.2:1000
//! lrm 9.7.3:4
//! bias V(p) = 2.0, V(n) = 0.5
`include "check.vh"
module ch09_atomic_warning(p, n);
  inout p, n; electrical p, n;
  analog begin
    `CHECKX("branch potential is V(p) - V(n), in that order", V(p,n), 1.5);
    $warning("voltage=%g", V(p,n));
    `CHECKX("§9.7.3: the run continues past $warning, so this line is reached",
            V(p,n)*2.0, 3.0);
    I(p,n) <+ V(p,n);
  end
endmodule
