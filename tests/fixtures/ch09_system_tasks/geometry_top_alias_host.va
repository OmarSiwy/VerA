// §3.4.7 permits aliases of §9.18's hierarchical system parameters. A host
// model-card override of the alias changes the original system value and
// the value inherited by its children. The supplied geometry is
// (4,-2,350,-1,-1); the child's local (2,3,20,-1,-1) resolves to
// (6,1,10,+1,+1). Equations use the ORIGINAL system names, as §3.4.7 requires.
// Two aliases of x share its one storage; the card uses the first spelling.
//! lrm 3.4.7
//! lrm 9.18
//! lrm 9.18:1000
//! param placement_x = 4
//! param placement_y = -2
//! param rotation = 350
//! param horizontal = -1
//! param vertical = -1
//! checks 10
`include "check.vh"
module geometry_top_alias;
  aliasparam placement_x = $xposition;
  aliasparam second_x_name = $xposition;
  aliasparam placement_y = $yposition;
  aliasparam rotation = $angle;
  aliasparam horizontal = $hflip;
  aliasparam vertical = $vflip;
  geometry_top_alias_leaf #(.$xposition(2), .$yposition(3), .$angle(20),
                           .$hflip(-1), .$vflip(-1)) leaf();
  analog begin
    `CHECKX("host top x", $xposition, 4.0);
    `CHECKX("host top y", $yposition, -2.0);
    `CHECKX("host top angle", $angle, 350.0);
    `CHECKX("host top hflip", $hflip, -1.0);
    `CHECKX("host top vflip", $vflip, -1.0);
  end
endmodule
module geometry_top_alias_leaf;
  analog begin
    `CHECKX("host inherited x", $xposition, 6.0);
    `CHECKX("host inherited y", $yposition, 1.0);
    `CHECKX("host inherited angle", $angle, 10.0);
    `CHECKX("host inherited hflip", $hflip, 1.0);
    `CHECKX("host inherited vflip", $vflip, 1.0);
  end
endmodule
