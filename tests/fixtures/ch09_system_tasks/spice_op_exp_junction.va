// The device of spice_op_source_stepping.sp: an ideal exponential junction,
// i = is·(exp(v/vt) - 1), with a fixed vt and NO `$limit` (§9.17.3), so a
// Newton step that lands far above the knee is not pulled back: from the
// SPICE cold start, a 5 V source through 1 ohm puts the first iterate near
// 5 V, where exp(5/0.025) ~ 1e87, and each Newton step then comes down only
// about vt. The deck needs §9.15's `sourceScaleFactor` (source stepping)
// to reach the knee; this file pins the law the deck's arithmetic uses.
//
// WHAT THIS FILE ASSERTS ON ITS OWN, at V(a, c) = 0.6 with is = 1e-14 and
// vt = 0.025 (python3 math.exp):
//
//     i      = 1e-14·(exp(0.6/0.025) - 1) = 2.648912212884338e-4 A
//     di/dV  = 1e-14·exp(0.6/0.025)/0.025  = 1.0595648851937351e-2 S
//
// (0.6/0.025 rounds to 24 - 4e-15, as it does in the device.) Relative
// bands of 1e-12: §4.3.1's exp is within an ulp or two here.
//
//! lrm 4.5.6
//! bias V(a) = 0.6, V(c) = 0.0
//! checks 2
`include "check.vh"
module spice_op_exp_junction(a, c);
    inout a, c;
    electrical a, c;
    parameter real is = 1e-14 from (0:inf);
    parameter real vt = 0.025 from (0:inf);
    real i;

    analog begin
        i = is * (exp(V(a, c) / vt) - 1.0);
        `CHECKR("is·(exp(v/vt) - 1) at 0.6 V", i, 2.648912212884338e-4, 1e-12);
        `CHECKR("and its conductance is·exp(v/vt)/vt", ddx(i, V(a)), 1.0595648851937351e-2, 1e-12);
        I(a, c) <+ i;
    end
endmodule
