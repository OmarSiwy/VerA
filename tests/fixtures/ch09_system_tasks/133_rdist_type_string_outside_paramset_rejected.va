// §9.13.2, the same scope rule one clause over. Syntax 9-9 gives every
// $rdist_* form an optional trailing type_string —
//
//   $rdist_normal ( seed , mean_expression ,
//                   standard_deviation_expression [, type_string] )
//   type_string ::= "global" | "instance"
//
// — and §9.13.2 fences it in the same words as §9.13.1: "The type_string
// provides support for Monte-Carlo analysis and shall only be used in calls to
// a distribution function from within a paramset."
//
// 132 pins the $arandom half; this one pins the distribution half, because a
// compiler could plausibly police one and not the other. Ordinary module, so
// the violation is visible in the source alone.
//
// Nothing is asserted, for the same reason as 132: an illegal call site has no
// result, and the legal in-paramset use needs paramset support first.
//
//! lrm 9.13.2
//! reject within a paramset
//! xfail VerA refuses the whole §9.13 family with E0801 and never reaches the type_string scope rule
module ch09_rdist_type_string_outside_paramset(p, n);
  inout p, n; electrical p, n;
  integer seed;
  real a;
  analog begin
    seed = 7;
    a = $rdist_normal(seed, 0.0, 1.0, "global");
    I(p,n) <+ V(p,n) + a;
  end
endmodule
