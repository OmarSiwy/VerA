// §9.21.1: "The numbers shall be real or integer." b6_table_not_a_number.tbl
// breaks that: its first data row's dependent is `abc`.
//
// WHEN THE ERROR IS DUE. §9.21.1: "The state of the data source is captured
// on the first call to the table model function." Before the first call there
// is no captured data set and nothing to be in error, the reading
// a05_08_file_loaded_on_first_executed_call.va settles for a missing file
// (and a05_13 for duplicate points: an error "at the call"). So:
//
//   point 0, V(p) = 0.5: the guard V(p,n) > 1.0 is false, no call, no
//     capture. The check prints ok=1 (0.5 < 1.0).
//   point 1, V(p) = 1.5: the first call captures the file, finds `abc`, and
//     the run ends with an error. Had it gone on, the check would print
//     1.5 < 1.0 = 0, ok=0.
//
// The status is the suite's for a run-time error, 1 (a05_12).
//
//! lrm 9.21.1
//! lrm 9.21.1:2
//! lrm 9.21.1:1001
//! exit 1
//! sweep V(p) = 0.5, 1.5
//! checks 1
`include "check.vh"
module b6_table_non_numeric_entry_errors_at_first_call(p, n);
  inout p, n; electrical p, n;
  real f;
  analog begin
    `CHECKI("printed at the first point only: the second point's first call captures a bad data set",
            V(p, n) < 1.0, 1);
    f = 0.0;
    if (V(p, n) > 1.0) f = $table_model(V(p, n), "b6_table_not_a_number.tbl");
    I(p, n) <+ V(p, n) + f;
  end
endmodule
