// §9.11 conversion system functions in the analog context. The extension is
// FOUR names in two pairs: "Verilog AMS HDL extends the conversion functions
// defined in IEEE Std 1364 Verilog so that $bitstoreal and $realtobits, $rtoi
// and $itor can be used in the analog context." Table 9-8 (printed p.221,
// physical p.234) says the same row by row — `$bitstoreal Yes Yes`,
// `$realtobits Yes Yes`, `$rtoi Yes Yes`, `$itor Yes Yes`. The only analog "No"
// cells in the family are `$signed` and `$unsigned`, pinned as rejects in
// 134/135 and not exercised here. ($rtoi and $itor are legal here and
// unimplemented by VerA — a gap in the compiler, pinned by the M04 row
// (tests/fixtures/ch07_mixed_signal/m04_SPEC.md), not a rule this folder can
// assert. 061/062 used to claim the opposite and were removed; see COVERAGE.md
// §s9.11.)
//
// $realtobits yields the 64-bit IEEE-754 PATTERN of the real and $bitstoreal
// maps that pattern back, so the pair is the identity on any real: bit-exact,
// hence CHECKX rather than a tolerance. The bias is 3.7 because it is not
// representable in binary — an implementation that routed the pattern through
// a narrower carrier, or truncated it, loses the mantissa and fails on the .7
// where it would survive an integral bias.
//
//! lrm 9.11
//! bias V(p) = 3.7
`include "check.vh"
module ch09_conversion_functions(p, n);
  inout p, n; electrical p, n;
  real x;
  analog begin
    `CHECKX("§9.11 $bitstoreal of $realtobits is the identity on 3.7",
            $bitstoreal($realtobits(V(p,n))), 3.7);
    x = $bitstoreal($realtobits(V(p,n)));
    `CHECKX("and the round trip survives being stored in a real", x, 3.7);
    I(p,n) <+ x;
  end
endmodule
