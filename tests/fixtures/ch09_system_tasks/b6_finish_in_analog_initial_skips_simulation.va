// §9.7.1: "If $finish is called from an analog initial block, the simulator
// shall exit without performing the simulation."
//
// The analog initial block runs before any solution exists (§5.2.1). It sets
// `stage` to 1, reports that with $display (not $strobe, which waits for a
// converged solution that this run must never produce), then calls $finish.
// The analog block's check would read stage = 1 against want 0, ok=0, if the
// simulation ran at all. So the transcript holds exactly one verdict, the
// initial block's.
//
// CHECKI_NOW is check.vh's CHECKI with $display, defined here for that reason
// and moved by --perturb the same way.
//
// The exit status is VerA's for $finish, 0 (172_finish_terminates.va).
//
//! lrm 9.7.1
//! lrm 9.7.1:4
//! lrm 5.2.1
//! checks 1
`include "check.vh"
`ifdef VERA_PERTURB
`define CHECKI_NOW(NAME, GOT, WANT) $display("%s got=%d want=%d ok=%d", NAME, GOT, (WANT) + 1, ((GOT) == (WANT) + 1))
`else
`define CHECKI_NOW(NAME, GOT, WANT) $display("%s got=%d want=%d ok=%d", NAME, GOT, WANT, ((GOT) == (WANT)))
`endif
module b6_finish_in_analog_initial_skips_simulation(p, n);
  inout p, n; electrical p, n;
  integer stage;
  analog initial begin
    stage = 1;
    `CHECKI_NOW("analog initial runs up to its $finish", stage, 1);
    $finish(0);
  end
  analog begin
    `CHECKI("never printed: $finish in analog initial skips the simulation", stage, 0);
    I(p, n) <+ V(p, n);
  end
endmodule
