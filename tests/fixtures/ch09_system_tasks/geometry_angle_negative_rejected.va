// §9.18/Table 9-29 requires a specified angle >= 0; §6.3.6 permits defparam
// to supply that value but does not relax its domain. -0.5 violates the lower
// bound. geometry_parameter_sweep.va supplies the legal zero/fractional cases,
// and geometry_defparam_alias.va exercises legal defparam angle composition.
//! lrm 6.3.6
//! lrm 9.18
//! lrm 9.18:1000
//! reject-only E0890
//! neighbour geometry_defparam_alias.va
//! neighbour geometry_parameter_sweep.va
module geometry_negative_angle_top;
  geometry_negative_angle_child child();
  defparam child.$angle = -0.5;
endmodule
module geometry_negative_angle_child;
  analog $display("angle=%g", $angle);
endmodule
