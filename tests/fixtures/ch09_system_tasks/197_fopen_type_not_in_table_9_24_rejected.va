// §9.5.1: "type is a string expression containing a character string of one
// of the forms in Table 9-24 that indicates how the file should be opened."
// Table 9-24 lists exactly fifteen forms — "r", "rb", "w", "wb", "a", "ab",
// "r+", "r+b", "rb+", "w+", "w+b", "wb+", "a+", "a+b", "ab+" — and nothing
// else defines a mode.
//
// "x" is none of them. It is also not a near miss that a lenient reader could
// map onto one: it contains none of r, w or a, so the only way to accept it is
// to invent a mode the clause does not have. VerA did exactly that until this
// fixture: `file_kernels.zFOpen` sends a type with no r/w/a to writing, so the
// call compiled and truncated the file.
//
// Only a LITERAL type can be judged before the run, and this one is literal.
// The same statement with "w" compiles (probed).
//
// VerA reports E0889 "$fopen type is not one of Table 9-24's forms".
//
//! lrm 9.5.1
//! lrm 9.5.1:1003
//! reject-only E0889
//! neighbour 07_file_open_close.va
`include "disciplines.vams"
module ch09_fopen_type_not_in_table(p, n);
  inout p, n; electrical p, n;
  integer fd;
  analog begin
    @(initial_step) fd = $fopen("ch09_197.dat", "x");   // illegal: no such type
    I(p, n) <+ V(p, n);
  end
endmodule
