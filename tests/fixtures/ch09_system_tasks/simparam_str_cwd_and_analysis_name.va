// §9.15: "Table 9-28 gives a list of simulation string parameter names that
// shall be supported by $simparam$str":
//   "analysis_name"  The name of the current analysis (e.g., tran1, mydc)
//   "cwd"            The current working directory in which the simulator
//                    was started
// Both describe the host's run, not the design, so the host writes them
// (tools/contract.zig: `contract.host_strings` at the `Model` row's
// `cwd_idx__`/`analysis_name_idx__`, which this testbench uses, or the
// `Instance.cwd`/`analysis_name` slices). This
// testbench names its analysis with the second word of `//! analysis`, so
// "analysis_name" must read "mydc", while "analysis_type" still reads the
// kind, "dc" (23_simparam_string.va): the two rows are different strings.
// A working directory is never the empty string, so "cwd" must read
// something; its digits are the host's filesystem and are not asserted.
// The name may also be a string variable (§9.15: "a string literal, a string
// parameter, or a string variable"), read when the call runs.
// Wrong implementations: answering "" for both (the defect this pins) fails
// the first, third and fourth checks; answering analysis_type for
// analysis_name fails the first.
//! lrm 9.15
//! lrm 9.15:4
//! analysis dc mydc
//! checks 4
`include "check.vh"
module simparam_str_cwd_and_analysis_name(p, n);
  inout p, n; electrical p, n;
  string an, at, cwd, which, dyn;
  analog begin
    an = $simparam$str("analysis_name");
    at = $simparam$str("analysis_type");
    cwd = $simparam$str("cwd");
    which = "analysis_name";
    dyn = $simparam$str(which);
    `CHECKI("Table 9-28 analysis_name is the host's name for the analysis", an == "mydc", 1);
    `CHECKI("analysis_type is the kind, a different row", at == "dc", 1);
    `CHECKI("Table 9-28 cwd is a directory, never empty", cwd == "", 0);
    `CHECKI("a string-variable name reads the same row", dyn == "mydc", 1);
    I(p, n) <+ 0.0 * V(p, n);
  end
endmodule
