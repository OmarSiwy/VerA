// §9.21.2 / Table 9-32, the LAST row, verbatim:
//
//     "C,,3"   Data is 3D, equivalent to "1CC, 1LL, 3LL".
//
// Three things have to hold at once for that equivalence to be true, and this
// fixture asserts all three on one data set:
//   1. a sub-string with NO interpolation character keeps the default `1`
//      (linear) — "C" is an extrapolation-only sub-string, not an unknown mode;
//   2. a sub-string given as ONE extrapolation character applies it to BOTH
//      ends ("When one extrapolation method character is given, the specified
//      extrapolation method will be used for both ends");
//   3. an EMPTY sub-string is the full default `1LL`, and a trailing `3` is
//      cubic with the default `LL`.
//
// DATA: the 2x2x2 corner set of the affine function
//
//     f(z,y,x) = 4z + 2y + x        z,y,x in {0,1}
//
// laid out §9.21.1-style, outermost (z) first, innermost (x) last, giving the
// eight rows f = 0..7. Eight points is exactly §9.21's minimum for three
// dimensions ("the product of at least two points per dimension (2^N for N
// dimensions)").
//
// WHY THE CUBIC INNER DIMENSION IS STILL HAND-COMPUTABLE. With two samples and
// the default `LL` ends, the natural cubic has M0 = M1 = 0 (both end second
// derivatives are zero and there is no interior knot), so the segment
// degenerates to the straight line through the two samples. The whole lookup is
// therefore trilinear, and on an affine f it is EXACT:
//
//     f(0.5, 0.5, 0.5) = 4(0.5) + 2(0.5) + 0.5 = 3.5
//
// THE OUTER `C`. Table 9-31: "The constant extrapolation method returns the
// table endpoint value", i.e. the outer coordinate is pinned to the end isoline
// and the remaining dimensions still interpolate inside it:
//
//     f(2, 0.5, 0.5)  -> z clamped to 1 -> 4 + 1 + 0.5 = 5.5
//     f(-1, 0.5, 0.5) -> z clamped to 0 -> 0 + 1 + 0.5 = 1.5
//
// Linear extrapolation in z instead would give 4*2 + 1 + 0.5 = 9.5 and
// 4*(-1) + 1 + 0.5 = -2.5, so these two wants are what separates `C` from the
// default.
//
// THE MIDDLE, EMPTY SUB-STRING. It must still be `1LL`, so y EXTRAPOLATES
// linearly and reproduces the affine function past its last isoline:
//
//     f(0.5, 2, 0.5) = 2 + 4 + 0.5 = 6.5
//
// (constant extrapolation in y would give 2 + 2 + 0.5 = 4.5 — the empty
// sub-string must not inherit the neighbouring `C`).
//
//! lrm 9.21.2
//! lrm 9.21.3
//! lrm 9.21.3:1000
`include "check.vh"
module a05_control_default_filling(p, n);
  inout p, n; electrical p, n;
  real zc[0:7], yc[0:7], xc[0:7], fc[0:7];
  analog begin
    zc[0]=0.0; yc[0]=0.0; xc[0]=0.0; fc[0]=0.0;
    zc[1]=0.0; yc[1]=0.0; xc[1]=1.0; fc[1]=1.0;
    zc[2]=0.0; yc[2]=1.0; xc[2]=0.0; fc[2]=2.0;
    zc[3]=0.0; yc[3]=1.0; xc[3]=1.0; fc[3]=3.0;
    zc[4]=1.0; yc[4]=0.0; xc[4]=0.0; fc[4]=4.0;
    zc[5]=1.0; yc[5]=0.0; xc[5]=1.0; fc[5]=5.0;
    zc[6]=1.0; yc[6]=1.0; xc[6]=0.0; fc[6]=6.0;
    zc[7]=1.0; yc[7]=1.0; xc[7]=1.0; fc[7]=7.0;
    `CHECK("\"C,,3\" interior: 2-point natural cubic is linear, so 4z+2y+x is exact",
           $table_model(0.5, 0.5, 0.5, zc, yc, xc, fc, "C,,3"), 3.5, 1e-12);
    `CHECK("outer `C` clamps above the last isoline to the endpoint value",
           $table_model(2.0, 0.5, 0.5, zc, yc, xc, fc, "C,,3"), 5.5, 1e-12);
    `CHECK("outer `C` clamps below the first isoline to the endpoint value",
           $table_model(-1.0, 0.5, 0.5, zc, yc, xc, fc, "C,,3"), 1.5, 1e-12);
    `CHECK("the EMPTY middle sub-string is 1LL, so y still extrapolates linearly",
           $table_model(0.5, 2.0, 0.5, zc, yc, xc, fc, "C,,3"), 6.5, 1e-12);
    `CHECK("the spelled-out equivalent gives the same interior value",
           $table_model(0.5, 0.5, 0.5, zc, yc, xc, fc, "1CC,1LL,3LL"), 3.5, 1e-12);
    I(p, n) <+ V(p, n);
  end
endmodule
