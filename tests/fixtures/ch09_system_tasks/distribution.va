// §9.13: "Verilog-AMS HDL extends the probabilistic distribution functions so
// that they are supported in the analog context." Table 9-10 lists all 17 names
// and every row reads `Yes  Yes` — digital context AND analog context. So this
// file must COMPILE and run green; a compiler that refuses the call is the one
// that is wrong, which is why the expectation is a run and not a reject.
//
// The value is not free — §9.13.3 binds this family to the IEEE 1364 §17.9.3
// C listing (Table 9-26), and random_ieee1364_digits.va pins that stream
// digit for digit. This fixture keeps the clause-local claim: §9.13.2's
// repeatability, "The system functions shall always return the same value
// given the same seed." Two seeds initialized to the same integer must agree,
// and that holds for any conforming implementation of the listing.
//
// The $dist_* family is the IEEE 1364 §17.9 integer form, carried into the
// analog context unchanged by §9.13; Table 9-10 marks it analog Yes.
//
// A SECOND rule, and the one that makes this fixture more than a stub test.
// §9.13.2 makes the seed an inout: "If it is an integer variable, then it is an
// inout argument; that is, a value is passed to the function and A DIFFERENT
// VALUE IS RETURNED. The variable is initialized by the user and only updated by
// the system function. This ensures the desired distribution is achieved upon
// successive calls." So after the call `sa` shall no longer read 7. Without that
// check the only assertion here is `a == b`, which a `return 0` stub satisfies
// perfectly; with it, a constant-returning implementation fails.
//
// §9.13's second half, the names it ADDS to the IEEE 1364 family: the real
// `$rdist_*` forms and `$arandom`. Table 9-10 marks every one of them
// analog-Yes, so a call in this block must compile and update its inout seed
// like `$dist_normal` above. `$rdist_uniform` also has a fixed value domain —
// uniform between start and end — which the interval check pins.
//
//! lrm 9.13.2
//! lrm 9.13.2:4
//! lrm 9.13
//! lrm 9.13:1000
`include "check.vh"
module ch09_distribution(p, n);
  inout p, n; electrical p, n;
  integer sa, sb, su, sr;
  integer a, b, ra;
  real ru;
  analog begin
    sa = 7; sb = 7;
    a = $dist_normal(sa, 0, 1);
    b = $dist_normal(sb, 0, 1);
    `CHECKI("§9.13.2 $dist_normal repeats on the same seed", a == b, 1);
    `CHECKI("§9.13.2 the seed is inout: a DIFFERENT value is returned", sa != 7, 1);
    `CHECKI("and both seeds advanced the same way from the same start", sa == sb, 1);
    su = 7;
    ru = $rdist_uniform(su, 0.0, 10.0);
    `CHECKI("§9.13 the real $rdist_* form runs in the analog context and advances its seed", su != 7, 1);
    `CHECKI("§9.13 $rdist_uniform stays inside its [start, end] interval", (ru >= 0.0) && (ru <= 10.0), 1);
    sr = 7;
    ra = $arandom(sr);
    `CHECKI("§9.13 $arandom runs in the analog context and advances its seed", sr != 7, 1);
    I(p,n) <+ V(p,n) + a + b + sa + sb;
  end
endmodule
