// §9.20: the return value is one (1) only if the hierarchical_reference_string
// points to a valid continuous node, and for $analog_port_alias the resolved
// reference must additionally BE a port; any violation returns zero (0). The
// string names `$root.top.dev.p`, a port of an instance `dev` inside an instance
// `top` (§6.7). This compilation elaborates this module as the top level and
// instantiates nothing, so neither instance exists and the status is 0.
//
//! lrm 9.20
//! lrm 9.20:10
`include "check.vh"

module ch09_atomic_analog_port_alias(p, n);
  inout p, n; electrical p, n;
  electrical local_node; integer status;
  analog initial begin
    status = $analog_port_alias(local_node, "$root.top.dev.p");
  end
  analog begin
    `CHECKI("$analog_port_alias on an unresolvable hierarchical reference", status, 0);
    I(p,n) <+ V(local_node) + status * 0.0;
  end
endmodule
