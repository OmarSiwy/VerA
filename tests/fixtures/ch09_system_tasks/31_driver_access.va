// §9.22 defines a driver as "a process which assigns a value to the signal, or
// a connection of the signal to an output port of a module instance or
// simulation primitive", and then fences the whole family off in paragraph 3,
// verbatim:
//
//   "The driver access functions described here only access drivers found in
//    ordinary modules and not to those found in connect modules. Driver access
//    functions can only be called from connect modules."
//
// Two rules, and they are not in tension: the functions REPORT on drivers found
// in ordinary modules, but they may only be CALLED from a connect module. 107
// and 109..114 pin each name one at a time; this file pins the aggregate — the
// §9.22.1/§9.22.2/§9.22.3 trio in one ordinary module — because a compiler that
// diagnosed only the first call site would still be wrong about the rest.
//
// Nothing is asserted. The count and the indexed queries have no defined answer
// here: §9.22.2 and §9.22.3 take a driver_index "between 0 and N-1", and an
// ordinary module's continuous node has N = 0, so that range is empty. Writing
// a number into it would pin the host's convenience, not the LRM.
//
// $receiver_count is deliberately absent: the §9.22.1 note reads
// "Non-normative: $receiver_count is not a subclause of 9.22 in Verilog-AMS
// 2.4", so there is no clause to cite and nothing to require.
//
//! lrm 9.22
//! reject connect module
//! xfail VerA has no `connectmodule` design element and no digital driver state — the two things §9.22/§9.23 are defined over — so it cannot tell a legal call site from an illegal one; it lowers the whole driver-access family to a constant (codegen.zig driver_queries) instead of refusing the call
module ch09_driver_access(p, n);
  inout p, n; electrical p, n;
  real info;
  analog begin
    info = $driver_count(p);
    info = info + $driver_state(p, 0) + $driver_strength(p, 0);
    I(p,n) <+ V(p,n) + info;
  end
endmodule
