// §9.22 defines a driver as "a process which assigns a value to the signal, or
// a connection of the signal to an output port of a module instance or
// simulation primitive", and then fences the whole family off in paragraph 3,
// verbatim:
//
//   "The driver access functions described here only access drivers found in
//    ordinary modules and not to those found in connect modules. Driver access
//    functions can only be called from connect modules."
//
// Two rules, and they are not in tension: the functions REPORT on drivers found
// in ordinary modules, but they may only be CALLED from a connect module. 107
// and 109..114 pin each name one at a time; this file pins the aggregate — the
// §9.22.1/§9.22.3/§9.22.4 trio in one ordinary module — because a compiler that
// diagnosed only the first call site would still be wrong about the rest.
//
// Nothing is asserted. The count and the indexed queries have no defined answer
// here: §9.22.3 and §9.22.4 take a driver_index "between 0 and N-1", and an
// ordinary module's continuous node has N = 0, so that range is empty. Writing
// a number into it would pin the host's convenience, not the LRM.
//
// $receiver_count is absent for a different reason. §9.22.2 (printed p.262,
// physical p.275) makes it normative — "receiver_count_function ::=
// $receiver_count ( signal_name )", Syntax 9-18 — but VerA does not implement
// it, so a call written here would pin a missing feature rather than the
// paragraph-3 call-site rule this file exists for. That gap is pinned by the
// M04 row (tests/fixtures/ch07_mixed_signal/m04_SPEC.md at 8b1514d4). A header once claimed
// the function had no subclause to cite; the subclause exists and the claim is
// withdrawn — see tests/fixtures/ch09_system_tasks/COVERAGE.md at 8b1514d4 §s9.22.2.
//
//! lrm 9.22
//! reject connect module
//! reject E0818
module ch09_driver_access(p, n);
  inout p, n; electrical p, n;
  real info;
  analog begin
    info = $driver_count(p);
    info = info + $driver_state(p, 0) + $driver_strength(p, 0);
    I(p,n) <+ V(p,n) + info;
  end
endmodule
