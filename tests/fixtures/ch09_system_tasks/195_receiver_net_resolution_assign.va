// §9.22.6 Receiver net resolution, verbatim and in full:
//
//   "As a result of driver receiver segregation, the drivers and receivers are
//    separated so that any analog connected to a mixed net has the opportunity
//    to influence the value driving the digital receivers. Since a single
//    digital port is used in the connect module, the user must specify the value
//    that the receivers will see. By not specifying the receiver value directly
//    in the connect module driver, receiver segregation will be ignored, which
//    is the default case. This assignment of the receiver value is done via the
//    assign statement in which the digital port will be used to read the driver
//    values as well as to set the receiver value.
//
//    1. The default is equivalent of assign d_receivers = d_drivers;
//       Where the value passed to the receivers through driver receiver
//       segregation is the value being driven without delay or any impact from
//       analog connections to the net. This is essentially bypassing driver
//       receiver segregation.
//    2. Anything else is done explicitly, such as:
//
//         reg out; // value of out determined in CM, see example in 9.22.7
//         assign d = out;
//
//       In this case, the digital port of the connect module will drive the
//       receivers with a value determined in the connect module. This value may
//       potentially be different from the value of the drivers of the connect
//       module digital port."
//
// THE CLAUSE IS A CHOICE WITH TWO ANSWERS, and it says which form selects which.
// Rule 1 is the ABSENCE of an assignment — the connect module not driving its
// digital port at all, so §7.9's segregation is bypassed and the receivers see
// the ordinary drivers. Rule 2 is the `assign` statement, which is the only
// spelling the clause offers for "the connect module decides": `d` is read for
// the driver values AND written to set the receiver value. Both are source
// forms, and the file below is rule 2's, quoted from the clause's own snippet
// (with `reg out;` above it, since `out` is what the connect module decides
// with). Rule 1 is the same file with those two lines deleted; ch07_mixed_-
// signal/m04_14_receiver_default_bypass.va is its runtime half, and the two
// transcripts there are exact complements.
//
// WHY THE ASSERTION IS NOT ABOUT THE RECEIVER. "the digital port of the connect
// module will drive the receivers with a value determined in the connect
// module" is a statement about an INSTANTIATED, RESOLVED net — §7.9's
// segregation is §7.8's insertion phase's work, and a connect module compiled
// alone is never elaborated as a device (§7.6; the header of
// 38_driver_update_connectmodule.va works through that in full). So the
// assertion is ACCEPTANCE, in the ordinary module that makes this file a
// compilable design: its whole job is to be a verdict that exists, so that "this
// source, connect module and all, was accepted, elaborated and run" is a
// green/red the runner can see. 0.75 - 0.25 = 0.5, both operands exact in
// binary, so the number is exact rather than tolerated.
//
// WHY IT CARRIES `xfail`. The `assign` statement does not parse anywhere in VerA
// — E0205, "unsupported module item: found `assign`", note "LRM annex A.1.4"
// (annex_c_analog_subset/23_continuous_assign_rejected.va is green on the same
// diagnostic in a plain module). So rule 2 cannot be written at all: there is no
// connect module in this language that can set the value its receivers see, and
// §9.22.6's whole subject is that assignment. Rule 1 is therefore also the only
// answer a VerA design can give, which is the default — and "the default is
// always taken" is not the same rule as "the default is taken when nothing is
// assigned".
//
// WHEN IT GOES GREEN. A continuous assignment on a connect module's digital port
// is the whole ask; the connect module then has to be inserted for the value to
// reach a receiver, which is ch07's M03/M04 row and not this file's.
//
//! lrm 9.22.6
//! lrm 9.22
//! bias V(p) = 0.75, V(n) = 0.25
//! xfail §9.22.6's only spelling for the receiver value is `assign d = out;`, and `assign` is E0205 ("unsupported module item") everywhere in VerA, connect module or not — so rule 2 cannot be written and rule 1's bypass is the only answer available
`include "check.vh"
connectmodule ch09_receiver_net_resolution(d, a);
  input d; output a;
  ddiscrete d;
  electrical a;
  reg out;
  assign d = out;
endmodule

module ch09_receiver_net_resolution_host(p, n);
  inout p, n; electrical p, n;
  analog begin
    `CHECK("the file carrying the §9.22.6 connectmodule compiles and runs",
           V(p,n), 0.5, 1e-15);
    I(p,n) <+ V(p,n);
  end
endmodule
