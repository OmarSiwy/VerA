// §9.4.1: "The special character string %% indicates the display of the
// percent sign character (%)", and Table 9-21 (§9.4.2) lists it: `%%`, "The %
// character". §9.4.3 then exempts it from the pairing rule: "For each %
// character (except %m, %% and %l) that appears in a string, a corresponding
// expression argument shall be supplied after the string."
//
// This is the legal neighbour of s01_20_percent_escape_with_width_rejected.va,
// which writes something between the two characters (#42).
//
// HAND DERIVATION (each `%%` becomes one `%` and takes no argument; `%d` of
// an unsized literal, a 32-bit `integer`, is IEEE 1364 §17.1.1.3's 11-column
// field, 10 spaces before a one-digit value):
//
//   "100%%"          -> "100%"
//   "%d%%" of 5      %d prints 5, then the escape:            -> "          5%"
//   "%%d"            the escape, then an ordinary `d`; no
//                    conversion is left, so no argument:      -> "%d"
//   "%%%d" of 7      the escape, then %d of 7:                -> "%          7"
//
//! lrm 9.4.2
//! lrm 9.5.3
//! print none
`include "check.vh"
module s01_percent_escape(p, n);
  inout p, n; electrical p, n;
  string a, b, c, d;
  analog begin
    $sformat(a, "100%%");
    $sformat(b, "%d%%", 5);
    $sformat(c, "%%d");
    $sformat(d, "%%%d", 7);

    `CHECKI("§9.4.2 %% prints one percent sign", (a == "100%"), 1);
    `CHECKI("§9.4.2 %% after a conversion", (b == "          5%"), 1);
    `CHECKI("§9.4.3 %% consumes no argument, and the d after it is text", (c == "%d"), 1);
    `CHECKI("§9.4.2 %% before a conversion", (d == "%          7"), 1);

    I(p,n) <+ V(p,n);
  end
endmodule
