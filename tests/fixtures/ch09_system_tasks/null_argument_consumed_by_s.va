// A null argument that a format conversion consumes. §9.4.1: "Any null
// argument produces a single space character in the display. (A null argument
// is characterized by two adjacent commas (,,) in the argument list.)" §9.4.5:
// "For each %s specification which appears in a string, a corresponding
// argument shall follow the string in the argument list", and §9.4.3 counts a
// null argument as an argument that follows. The LRM gives the null argument
// one rendering, the space, and says nothing of a conversion consuming one.
// VerA's reading (specification/Vague_Decisions.md VD-101): `%s` prints that space,
// since `%s` prints its argument as text; a conversion that needs a value
// (`%d`, `%e`, ...) is refused, null_argument_consumed_by_d_rejected.va.
//
// DERIVATION. §9.5.3 makes $swrite the $fwrite formatter writing into a string
// variable. Every string argument opens a format run (§9.4.3).
//
//   $swrite(t, "<%s>", , "x")   "<%s>" takes the null: "< >"; then "x" = "< >x"
//   $swrite(u, "[%s|%s]", "a", ) "a", then the null:   "[a| ]"
//
// A tool that dropped the null argument lets "<%s>" take "x" ("<x>"), and
// leaves the second call's second %s with no argument at all.
//
//! lrm 9.4.1
//! lrm 9.4.5
//! lrm 9.5.3
//! lrm 9.4.1:1001
//! checks 2
`include "check.vh"
module null_argument_consumed_by_s(p, n);
  inout p, n; electrical p, n;
  string t, u;
  analog begin
    $swrite(t, "<%s>", , "x");
    $swrite(u, "[%s|%s]", "a", );
    `CHECKI("%s prints a null argument as its one space", t == "< >x", 1);
    `CHECKI("a trailing null argument is the second %s's space", u == "[a| ]", 1);
    I(p, n) <+ V(p, n);
  end
endmodule
