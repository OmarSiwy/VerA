// §9.5.3: "$sformat always interprets its second argument, and only its second
// argument, as a format string. This format argument can be a static string
// ... or can be a string variable whose content is interpreted as the format
// string." Then: "The remaining arguments to $sformat are processed using any
// format specifiers in the format_string, until all such format specifiers are
// used up. If not enough arguments are supplied for the format specifiers or
// too many are supplied, then the application shall issue a warning and
// continue execution."
//
// THE FORMAT. A string variable chosen by the operating point, so no compiler
// can call the mismatch static (§9.5.3: "If the format_string is a string
// variable, it might not be possible to determine its value at compile
// time"): the else arm "<%d>%d" would be exact for the two arguments. At the
// bias V(p,n) = 1.0 > 0.5 the format is "<%d>": one specifier, two arguments,
// one too many.
//
// THE DIGITS. The one %d is processed with the first argument, 7, so the
// string starts "<7>". What happens to the surplus 9 is not fixed (the clause
// says the specifiers are "used up", then warns), so the scan below reads only
// the prefix: "<%d>" matches '<', 7, '>' on "<7>" and on "<7>9" alike.
//
//   k = 7, count = 1
//
// Both checks print after the $sformat, so their presence is the "continue
// execution". The warning is a run-time message this harness cannot read.
//
//! lrm 9.5.3
//! lrm 9.5.3:2
//! lrm 9.5.3:1001
//! bias V(p) = 1.0, V(n) = 0.0
//! checks 2
`include "check.vh"
module b6_sformat_variable_format_mismatch_continues(p, n);
  inout p, n; electrical p, n;
  string fmt, t;
  integer k, count;
  analog begin
    if (V(p, n) > 0.5) fmt = "<%d>";
    else fmt = "<%d>%d";
    $sformat(t, fmt, 7, 9);
    count = $sscanf(t, "<%d>", k);
    `CHECKI("§9.5.3 the variable's one %d took the first argument, and execution continued", k, 7);
    `CHECKI("§9.5.4.2 the scan matched the <7> prefix", count, 1);
    I(p, n) <+ V(p, n);
  end
endmodule
