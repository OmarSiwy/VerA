// §9.15 uses runtime iteration and the unknown-name fallback.
// The first iterate seeds the limiter; each subsequent iterate advances 1 V.
// The `//! time` points stand for the iterates of ONE static solve, so the
// analysis is dc: `initialize_limiting` reads analysis("dc"), and a grid with
// no `//! analysis` line would run as a transient.
//
// UNTAGGED (VD-082: a pinned choice carries no clause tag): §9.15 names no
// `iteration` count and no `iniLim`; the iterate numbering and the seeded
// trajectory are VerA's (the unknown-name fallback half is 9.15's and is pinned
// with a tag elsewhere).
//! fd-exempt §9.17.3: the residual is evaluated at the limited iterate and the Jacobian is taken w.r.t. it (Newton linearization), so a difference across the clamp is not the Jacobian
//! analysis dc
//! time 0, 1, 2, 3
//! bias V(p) = 5
`include "check.vh"
module ch09_limit_initialize_limiting(p, n);
  inout p, n; electrical p, n;
  real vold, vlim, it, ini;

  analog function integer initialize_limiting;
    input dummy;
    real dummy;
    integer il;
    begin
      il = $simparam("iniLim", -1);
      if (il < 0)
        initialize_limiting = ($simparam("iteration", 10) == 1) &&
                              (analysis("dc") || analysis("static"));
      else
        initialize_limiting = il;
    end
  endfunction

  analog function real getold;
    input vnew, vold;
    real vnew, vold;
    begin
      getold = vold;
      // §9.17.3: "shall call $discontinuity(-1) when its return value is not
      // sufficiently close to the value of its first argument".
      if (abs(vold - vnew) > 1e-12) $discontinuity(-1);
    end
  endfunction

  analog function real setnew;
    input vnew, vold, value;
    real vnew, vold, value;
    begin
      setnew = value;
      if (abs(value - vnew) > 1e-12) $discontinuity(-1);
    end
  endfunction

  analog begin
    it  = $simparam("iteration", 10);
    ini = $simparam("iniLim", -1);
    vold = $limit(V(p,n), getold);
    vlim = vold + max(-1.0, min(1.0, V(p,n) - vold));
    // SPICE MODEINITJCT: on the first iterate the model, not the solver, says
    // where the junction starts.
    if (initialize_limiting(0.0)) vlim = 0.7;
    vlim = $limit(V(p,n), setnew, vlim);

    // Closed forms of the table above, subtracted so every want is a literal 0
    // (the suite refuses an expression in the WANT column).
    `CHECK("iteration counts each evaluated iterate",
           it - ($abstime + 1.0), 0.0, 1e-12);
    `CHECK("unknown vendor name returns its supplied fallback",
           ini + 1.0, 0.0, 1e-12);
    `CHECK("the SEEDED bias is what the next evaluation limits against",
           vold - (($abstime == 0.0) ? 0.0 : (0.7 + $abstime - 1.0)), 0.0, 1e-12);
    `CHECK("and the clamp walks 1 V per evaluation from 0.7, not from 0",
           vlim - (0.7 + $abstime), 0.0, 1e-12);
    I(p,n) <+ vlim;
  end
endmodule
