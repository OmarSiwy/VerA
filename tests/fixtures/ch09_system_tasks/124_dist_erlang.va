// §9.13: "Verilog-AMS HDL extends the probabilistic distribution functions so
// that they are supported in the analog context." Table 9-10 lists all 17 names
// and every row reads `Yes  Yes` — digital context AND analog context. So this
// file must COMPILE and run green; a compiler that refuses the call is the one
// that is wrong, which is why the expectation is a run and not a reject.
//
// The value is not free — §9.13.3 binds this family to the IEEE 1364 §17.9.3
// C listing (Table 9-26), and 171_random_ieee1364_digits.va pins that stream
// digit for digit. This fixture keeps the clause-local claim: §9.13.2's
// repeatability, "The system functions shall always return the same value
// given the same seed." Two seeds initialized to the same integer must agree,
// and that holds for any conforming implementation of the listing.
//
// The $dist_* family is the IEEE 1364 §17.9 integer form, carried into the
// analog context unchanged by §9.13; Table 9-10 marks it analog Yes.
//
// Arguments: k_stage = 2 and mean = 3, both of which §9.13.2 requires to be greater than zero.
//
// A SECOND rule, and the one that makes this fixture more than a stub test.
// §9.13.2 makes the seed an inout: "If it is an integer variable, then it is an
// inout argument; that is, a value is passed to the function and A DIFFERENT
// VALUE IS RETURNED. The variable is initialized by the user and only updated by
// the system function. This ensures the desired distribution is achieved upon
// successive calls." So after the call `sa` shall no longer read 7. Without that
// check the only assertion here is `a == b`, which a `return 0` stub satisfies
// perfectly; with it, a constant-returning implementation fails.
//
//! lrm 9.13.2
//! lrm 9.13.2:4
`include "check.vh"
module ch09_dist_erlang(p, n);
  inout p, n; electrical p, n;
  integer sa, sb;
  integer a, b;
  analog begin
    sa = 7; sb = 7;
    a = $dist_erlang(sa, 2, 3);
    b = $dist_erlang(sb, 2, 3);
    `CHECKI("§9.13.2 the same seed gives the same value", a == b, 1);
    `CHECKI("§9.13.2 the seed is inout: a DIFFERENT value is returned", sa != 7, 1);
    `CHECKI("and both seeds advanced the same way from the same start", sa == sb, 1);
    I(p,n) <+ V(p,n) + a + b + sa + sb;
  end
endmodule
