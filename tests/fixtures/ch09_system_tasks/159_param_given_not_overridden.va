// §9.19: "The return value shall be one (1) if the parameter was overridden,
// either by a defparam statement or by a module instance parameter value
// assignment, and ZERO (0) otherwise."
//
// 103_param_given.va and 29_binding_detection.va both test the 1 direction.
// This is the 0 direction, and it is one deleted directive away: there is NO
// `//! param` line here, so nothing instantiates this module with an override
// and `gain` keeps the value in its declaration.
//
// The second check pins that the declared default is the value actually in
// force, so an implementation that answers $param_given correctly while losing
// the default — or one that answers 0 because it lost the parameter entirely —
// still fails.
//
//! lrm 9.19
//! lrm 9.19:4
//! bias V(p) = 0.5
`include "check.vh"
module ch09_param_given_not_overridden(p, n);
  inout p, n; electrical p, n;
  parameter real gain = 1.0;
  analog begin
    `CHECKI("§9.19 $param_given is 0 for a parameter nothing overrode",
            $param_given(gain), 0);
    `CHECKX("and the declared default is the value in force", gain * V(p,n), 0.5);
    I(p,n) <+ gain * V(p,n);
  end
endmodule
