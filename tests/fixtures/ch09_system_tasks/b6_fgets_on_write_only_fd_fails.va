// §9.5.4: "Files opened using file descriptors can be read from only if they
// were opened with either the r or r+ type values."
//
// One file, one content, two modes. The descriptor `fdw` is opened "w" (Table
// 9-24: "truncate to zero length or create for writing"), given the line
// "abc\n" and flushed, so the bytes are there; a read through it is still not
// allowed. §9.5.4.1: "If an error occurs reading from the file, then code is
// set to zero", and §9.5.7: "Should any error be detected by one of the file
// I/O routines, an error code is returned" by $ferror, nonzero. The numeric
// errno is the host's, so it is asserted only as != 0 (053_ferror.va's
// reasoning).
//
// The same file reopened "r" reads the four-byte line, newline included
// (§9.5.4.1, 046_fgets.va), and $ferror reports zero: so the zero above is
// the mode, not the file.
//
//   via "w":  code 0,  errno != 0
//   via "r":  code 4,  errno 0
//
// "w+"/"a+" are left out: the doubt on whether Table 9-24's "update" modes
// read is open (ledger 9.5.4:1000).
//
//! lrm 9.5.4
//! lrm 9.5.4:1000
//! lrm 9.5.4.1
//! lrm 9.5.7
//! checks 4
`include "check.vh"
module b6_fgets_on_write_only_fd_fails(p, n);
  inout p, n; electrical p, n;
  integer fdw, fdr, code_w, err_w, code_r, err_r;
  string s, e_w, e_r;
  analog begin
    fdw = $fopen("b6_fgets_mode.dat", "w");
    $fwrite(fdw, "abc\n");
    $fflush(fdw);
    code_w = $fgets(s, fdw);
    err_w = $ferror(fdw, e_w);
    $fclose(fdw);
    fdr = $fopen("b6_fgets_mode.dat", "r");
    code_r = $fgets(s, fdr);
    err_r = $ferror(fdr, e_r);
    $fclose(fdr);
    `CHECKI("§9.5.4 a descriptor opened \"w\" cannot be read: $fgets returns 0", code_w, 0);
    `CHECKI("§9.5.7 and $ferror reports that error", err_w != 0, 1);
    `CHECKI("§9.5.4.1 the same file opened \"r\" reads its 4-byte line", code_r, 4);
    `CHECKI("§9.5.7 with no error", err_r, 0);
    I(p, n) <+ V(p, n);
  end
endmodule
