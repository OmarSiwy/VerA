// §3.4.7 permits `aliasparam m = $mfactor` as an alternate binding name,
// but requires equations to use the original name. The host supplies m=4;
// the original $mfactor must therefore read 4, and at V(p,n)=0.5 its product
// with that potential is 2. These observations require the alias binding.
// The old equation reads of m were forbidden. That withdrawn acceptance
// claim moves to ch03_data_types/aliasparam_system_read_rejected.va; the
// unoverridden Table 9-29 identity remains in 097_mfactor.va.
//! lrm 3.4.7
//! lrm 9.18
//! lrm 9.18:1000
//! lrm 9.18:1001
//! param m = 4
//! bias V(p) = 0.75, V(n) = 0.25
//! checks 2
`include "check.vh"
module ch09_aliasparam_mfactor(p, n);
  inout p, n; electrical p, n;
  aliasparam m = $mfactor;
  analog begin
    `CHECKX("alias binding reaches the original system name", $mfactor, 4.0);
    `CHECKX("the original name participates in an equation", $mfactor * V(p,n), 2.0);
    I(p,n) <+ V(p,n);
  end
endmodule
