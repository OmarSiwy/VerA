// §9.17.1: "A special form of the $discontinuity task, $discontinuity(-1), is
// used with the $limit() function so -1 is also a valid argument of
// $discontinuity." §9.17.3 says what it is for: "In order to prevent
// convergence when the output of the $limit() function is not sufficiently
// close to the value of the access function reference, the user-defined
// function shall call $discontinuity(-1)".
//
// So the task asks the simulator not to converge on the iterate the model was
// evaluated at. A host reads that request as the `converged` flag of the
// device's `limit` hook (contract.LimitResult), which evaluates the model at
// `old`: the previous iterate, the point the host last evaluated. `//! limit`
// calls that hook with the bias as `cur` and the listed entries of `old`.
//
// The model requests rejection when |V(p,n)| > 0.7. BIAS (cur): V(p) = 0.9,
// V(n) = 0. Nothing is clamped, so V(p) comes back as cur, 0.9, each time.
// [0] old V(p) = 0.3: |0.3| <= 0.7, no request, converged = 1, although cur
//     (0.9) would request one. The verdict is old's, not cur's.
// [1] old V(p) = 0.9 = cur: 0.9 > 0.7, converged = 0.
// [2] old V(p) = -0.8: |-0.8| = 0.8 > 0.7, converged = 0 (the `abs` arm).
// At the bias, "This task does not directly specify the behavior of the
// module" (§9.17.1): V(p,n) is 0.9 exactly. 3 x 2 limit verdicts + 1 CHECK.
//
// The invalid neighbour is 185_discontinuity_negative_degree_rejected.va
// (-2, E0820): -1 is the one negative degree the clause admits.
//! lrm 9.17.1
//! bias V(p) = 0.9, V(n) = 0
//! print none
//! checks 7
//! limit V(p) = 0.3 -> V(p) = 0.9, converged = 1
//! limit V(p) = 0.9 -> V(p) = 0.9, converged = 0
//! limit V(p) = -0.8 -> V(p) = 0.9, converged = 0
`include "check.vh"
module ch09_discontinuity_reject_is_limit_verdict(p, n);
  inout p, n; electrical p, n;
  analog begin
    if (abs(V(p,n)) > 0.7) $discontinuity(-1);
    I(p,n) <+ V(p,n);
    `CHECK("the request moves nothing it annotates", V(p,n), 0.9, 0.0);
  end
endmodule
