// §9.5 "Verilog-AMS HDL extends many of the file operation tasks so that they
// can be used in the analog context. ... The system tasks and functions for
// file-based operations are divided into the following categories:
//   - Functions and tasks that open and close files
//   - Tasks that output values into files
//   - Tasks that output values into variables
//   - Tasks and functions that read values from files and load into variables"
//
// The positive half of the clause's first sentence: one member of each
// category, called from an `analog` block. 153_file_io_digital_only_analog_
// rejected.va is its only other cite and pins a task that is NOT extended.
//
// DERIVATION.
//   open/close   $fopen(..., "w") truncates-or-creates, which cannot fail on a
//                writable working directory, so the descriptor is non-zero
//                (§9.5.1: zero is the failure value).
//   into file    $fwrite(fd, ...) writes to it; §9.5 asks only that the call
//                be legal here, and no value comes back to assert.
//   into var     $sformat(s, "%d:%d", 37, -5) builds the string "37:-5".
//   from var     $sscanf(s, "%d:%d", a, b) reads it back: a = 37, b = -5, and
//                returns 2, the number of items assigned (§9.5.4.2).
// All integers, so every check is exact.
//
// The write is not read back from the FILE on purpose: whether an analog-context
// $fwrite is visible before the iteration is accepted is §9.3's question, and a
// conforming implementation may defer it.
//
//! lrm 9.5
//! lrm 9.5.4.2
//! lrm 9.5.4.2:1
//! lrm 9.5.4.2:4
//! bias V(p) = 0.5
`include "check.vh"
module ch09_file_io_categories_in_analog_context(p, n);
  inout p, n; electrical p, n;
  integer fd, a, b, code;
  string s;
  analog begin
    fd = $fopen("ch09_198_categories.log", "w");
    `CHECKI("§9.5 open: $fopen in the analog context returns a descriptor", fd != 0, 1);
    $fwrite(fd, "%d\n", 37);
    $fclose(fd);
    $sformat(s, "%d:%d", 37, -5);
    code = $sscanf(s, "%d:%d", a, b);
    `CHECKI("§9.5 into a variable, then read back: first item", a, 37);
    `CHECKI("§9.5 into a variable, then read back: second item", b, -5);
    `CHECKI("§9.5 the read returns the count of items assigned", code, 2);
    I(p, n) <+ V(p, n);
  end
endmodule
