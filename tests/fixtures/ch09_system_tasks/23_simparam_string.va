// §9.15 Table 9-28 makes "analysis_type" one of the string parameters a
// simulator SHALL support, and defines it as "the type of the current analysis
// (e.g., dc, tran, ac)". §4.6.1 fixes the spelling of those types, and the
// testbench below declares the analysis, so the returned string is determined
// by the LRM plus one directive: it is "dc".
//
// (Table 9-28 lives in §9.15 "Analog Kernel Parameter System Functions",
// alongside $simparam and $simparam$str. §9.10 is the time functions and says
// nothing about it.)
//
// §3.3.1 makes the comparison of two strings an integer, so the verdict stays
// an operand and the check stays unconditional.
//
//! lrm 9.15
//! lrm 9.15:4
//! analysis dc
`include "check.vh"
module ch09_simparam_string(p, n);
  inout p, n; electrical p, n;
  string analysis_type;
  analog begin
    analysis_type = $simparam$str("analysis_type");
    `CHECKI("Table 9-28 analysis_type names the current analysis", analysis_type == "dc", 1);
    I(p,n) <+ 0.0*V(p,n);
  end
endmodule
