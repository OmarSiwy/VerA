// §9.16 Dynamic Simulation Probe Function. Table 9-13 marks $simprobe
// `No  Yes` — it exists ONLY in the analog context, so this file must compile
// and run green; a compiler that refuses the call is the one that is wrong,
// which is why the expectation is a run and not a reject.
//
//   dynamic_monitor_function ::= $simprobe ( inst_name , param_name
//                                            [, expression] )   (Syntax 9-11)
//
// §9.16 has exactly one clause with a value in it, and it is the third
// argument: "If either the inst_name or param_name cannot be resolved, and the
// optional expression is not supplied, then an error shall be generated. If the
// optional expression is supplied, its value will be returned in lieu of
// raising an error."
//
// This suite elaborates one device on its own, so it has no parent and
// therefore no sibling named "no_such_instance". The resolution MUST fail —
// that is a fact about the netlist, not about the tool — and the LRM then fixes
// the result exactly: the fallback, 2.5. Anything else, including 0.0 or a
// diagnostic, is non-conforming. The no-fallback ERROR branch is the separate
// negative and is not tested here.
//
//! lrm 9.16
//! xfail VerA refuses $simprobe with E0801 (no sibling-instance host to probe); Table 9-13 marks it analog-context Yes
`include "check.vh"
module ch09_simprobe(p, n);
  inout p, n; electrical p, n;
  real probe;
  analog begin
    probe = $simprobe("no_such_instance", "no_such_param", 2.5);
    `CHECKX("§9.16 an unresolvable probe returns the supplied expression",
            probe, 2.5);
    I(p,n) <+ V(p,n) + probe;
  end
endmodule
