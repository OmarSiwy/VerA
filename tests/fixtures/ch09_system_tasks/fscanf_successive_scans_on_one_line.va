// §9.5.4.2 fixes exactly how much input one $fscanf consumes, and it is a
// per-DIRECTIVE quantity, never a line:
//
//   "An input field is defined as a string of nonspace characters; it extends to
//    the next inappropriate character or until the maximum field width, if one
//    is specified, is exhausted."
//   "If conversion terminates on a conflicting input character, the offending
//    input character is left unread in the input stream. TRAILING WHITE SPACE
//    (INCLUDING NEWLINE CHARACTERS) IS LEFT UNREAD unless matched by a
//    directive."
//   "If the input ends before the first matching failure or conversion, EOF is
//    returned."
//
// §9.5.5 makes the consumption measurable: $ftell "returns in pos the offset
// from the beginning of the file of the current byte of the file fd, which shall
// be read or written by a SUBSEQUENT OPERATION on that file descriptor."
//
// THE FILE, byte by byte. "12 34\n56\n" — nine bytes:
//
//   offset  0   1   2   3   4   5    6   7   8
//   byte   '1' '2' ' ' '3' '4' '\n' '5' '6' '\n'
//
// HAND DERIVATION, one scan at a time. Every scan is the same directive, "%d",
// and "for all descriptors except the character c, white space leading an input
// field is ignored":
//
//   scan 1  no leading white space; the field is "12" (offsets 0-1) and stops on
//           the inappropriate ' ' at offset 2, which is left unread.
//           -> code 1, value 12, $ftell 2
//   scan 2  skips the ' ' at 2; the field is "34" (3-4) and stops on the '\n' at
//           offset 5, which is left unread.
//           -> code 1, value 34, $ftell 5
//   scan 3  skips the '\n' at 5 — leading white space is ignored, and a newline
//           is white space; the field is "56" (6-7) and stops on the '\n' at 8.
//           -> code 1, value 56, $ftell 8
//   scan 4  skips the '\n' at 8 and reaches end of file with nothing converted:
//           "the input ends before the first matching failure or conversion",
//           so the return is EOF.
//           -> code EOF, $ftell 9
//
// EOF's numeric value is left to IEEE 1364 by this clause, so it is asserted as
// "negative" rather than as -1; every other number above is fixed by the byte
// layout and is asserted exactly. §9.5.8's $feof — "returns a nonzero value when
// EOF has previously been detected reading fd" — is asserted as the companion,
// and asserted to be ZERO after the third scan, because that scan stopped on a
// newline and not on the end of the file.
//
// THE FAILURE THIS CATCHES. An implementation that consumes a whole LINE per
// scan reports $ftell = 6 after the first scan and then reads 56 as the second
// item, silently skipping the 34 that was still on the line. The second value
// and the three positions are what separate the two behaviours; the return
// codes alone do not.
//
//! lrm 9.5.4.2
//! lrm 9.5.5
//! lrm 9.5.8
//! lrm 9.5.8:1000
//! lrm 9.5.4.2:1003
//! print none
`include "check.vh"
module s01_fscanf_successive(p, n);
  inout p, n; electrical p, n;
  integer fd, c1, c2, c3, c4, t1, t2, t3, t4, a, b, c, d, eof3, eof4;
  analog begin
    fd = $fopen("s01_08_scan.dat", "w");
    $fwrite(fd, "12 34\n56\n");
    $fclose(fd);

    fd = $fopen("s01_08_scan.dat", "r");
    c1 = $fscanf(fd, "%d", a);
    t1 = $ftell(fd);
    c2 = $fscanf(fd, "%d", b);
    t2 = $ftell(fd);
    c3 = $fscanf(fd, "%d", c);
    t3 = $ftell(fd);
    eof3 = $feof(fd);
    c4 = $fscanf(fd, "%d", d);
    t4 = $ftell(fd);
    eof4 = $feof(fd);
    $fclose(fd);

    `CHECKI("§9.5.4.2 the first %d matches one item", c1, 1);
    `CHECKI("§9.5.4.2 and it is the first field on the line", a, 12);
    `CHECKI("§9.5.5 it consumed two bytes, not the line", t1, 2);

    `CHECKI("§9.5.4.2 the second %d matches one item", c2, 1);
    `CHECKI("§9.5.4.2 and it is the SECOND field of the same line", b, 34);
    `CHECKI("§9.5.5 trailing white space is left unread, so the position is 5", t2, 5);

    `CHECKI("§9.5.4.2 the third %d skips the newline and matches", c3, 1);
    `CHECKI("§9.5.4.2 and reads the field on the next line", c, 56);
    `CHECKI("§9.5.5 stopping on a newline leaves the position at 8", t3, 8);
    `CHECKI("§9.5.8 stopping on a newline is not end of file", eof3, 0);

    `CHECKI("§9.5.4.2 input ending before any conversion returns EOF", (c4 < 0), 1);
    `CHECKI("§9.5.5 and the trailing newline was consumed looking for a field", t4, 9);
    `CHECKI("§9.5.8 EOF has now been detected on this descriptor", (eof4 != 0), 1);

    I(p,n) <+ V(p,n) + a + b + c;
  end
endmodule
