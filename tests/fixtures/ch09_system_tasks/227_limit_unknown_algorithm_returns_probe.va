// §9.17.3: "In all cases, the simulator is responsible for determining if
// limiting should be applied and what the return value is on a given iteration.
// In particular, the simulator may simply choose to have $limit() return the
// value of its first argument". An unknown name is the same case: "If the
// string refers to an unknown or unsupported function, the simulator is
// responsible for determining the appropriate limiting algorithm, just as if no
// string had been supplied." VerA declines this site: it compiles, warns W0853
// (the name is not one VerA implements), and returns the probe unchanged. The
// warning is asserted by the unit test "a declined $limit is W0853 naming why"
// (lib/backend/codegen/test.zig) and by `//! warn` below; the checks assert
// what the clause fixes about the value.
//
// Two 100 ohm resistors divide V(p) = 1 V, so V(a) = 0.5 V, independent of any
// limiting; the returned value is used in the contribution, so a return other
// than the probe would move the root.
//
//! lrm 9.17.3
//! lrm 9.17.3:2
//! lrm 9.17.3:4
//! warn W0853
//! warn names no algorithm VerA implements
//! solve
//! bias V(p) = 1, V(n) = 0
`include "check.vh"
module ch09_limit_unknown_algorithm_returns_probe(p, n);
  inout p, n; electrical p, n, a;
  real v;
  analog begin
    v = $limit(V(a,n), "nosuchlim", 0.5);
    I(p,a) <+ V(p,a) / 100.0;
    I(a,n) <+ v / 100.0;
    `CHECKR("an unknown algorithm returns the probe", v, 0.5, 1e-4);
  end
endmodule
