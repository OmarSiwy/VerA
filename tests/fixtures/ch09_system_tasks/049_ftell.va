// §9.5.5: `pos = $ftell(fd)` "returns in pos the offset from the beginning of
// the file of the current byte of the file fd, which shall be read or written
// by a subsequent operation on that file descriptor."
//
// An offset in bytes from the beginning is an exact integer, so this fixture
// writes its own file and names both of them. "abc\n" is four bytes:
//
//   immediately after a successful open for reading   ->  0
//   after one $fgets has consumed the whole line      ->  4
//
// Neither number is negotiable and neither depends on the host. The previous
// version of this fixture opened a name it did not create and asserted
// `(position == 0) || (position == -1)` — a disjunction satisfied by an
// implementation that returns -1 unconditionally, and hedged that way only
// because a sibling fixture sharing the same filename might have created it.
// Every §9.5 fixture now owns its filename, so the hedge is gone.
//
// The EOF/-1 error return §9.5.5 also defines ("if an error occurs, EOF is
// returned") is NOT asserted here: this open succeeds, so the error branch does
// not arise, and pinning it would need a descriptor the LRM does not fix.
//
//! lrm 9.5.5
//! xfail VerA has no file-descriptor surface: codegen.zig `void_tasks` lowers the whole §9.5 family to the constant `S.con(0.0)`, so $fopen answers 0 and $ftell answers 0 whatever has been read
`include "check.vh"
module ch09_atomic_ftell(p, n);
  inout p, n; electrical p, n;
  integer fd, before, after, count; string text;
  analog begin
    fd = $fopen("ch09_049_ftell.dat", "w");
    $fwrite(fd, "abc\n");
    $fclose(fd);
    fd = $fopen("ch09_049_ftell.dat", "r");
    before = $ftell(fd);
    count = $fgets(text, fd);
    after = $ftell(fd);
    $fclose(fd);
    `CHECKI("§9.5.5 $ftell before any read is byte 0", before, 0);
    `CHECKI("§9.5.5 $ftell after reading the 4-byte line is byte 4", after, 4);
    I(p,n) <+ V(p,n) + before + after + count;
  end
endmodule
