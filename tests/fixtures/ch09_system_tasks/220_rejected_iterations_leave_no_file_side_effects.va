// §9.3: "A key difference is that the analog engine iteratively evaluates the
// analog blocks in an analog macro process until that process is converged
// 8.4. ... The goal of the defined behavior of a system task or function in the
// analog context is that a call to a such system task or function in an analog
// block during an iteration that is rejected should cause no side-effects on
// the next iteration."
//
// §9.5.9 is the relevant section it defers to for files: "If a file is being
// written to during an iterative solve, then the file write operations shall
// not be performed unless the iteration is accepted."
//
// THE SOLVE. `//! solve` frees p, and the conductance is the cubic
// I = v + v^3 - 10, whose root is v = 2 (2 + 8 = 10). From the zero start
// Newton needs several iterations to get there (the first step lands at
// v = 10, then walks back down), so the analog block below is EVALUATED
// several times per point, and every evaluation reaches the `$fwrite`.
//
// THE DIGITS, BY HAND. Only accepted iterations may write, and there is one
// accepted solution per time point. `//! time 0, 1e-3, 2e-3` is three points
// of one analysis, so after point k (k = 1, 2, 3) the file holds exactly k
// lines — however many iterations each point took. The line count is taken
// after the write at the same point, through a separate read descriptor, by
// §9.5.4.1 `$fgets` (0 at EOF; ten tries bound three lines). The point's
// 0-based index is $abstime / 1e-3 rounded — 0, 1, 2 from the `//! time` line
// the fixture states — so k = index + 1 and the check is `lines - index`,
// want 1 at every point.
//
// A tool that wrote on every evaluation would count one line per Newton
// iteration — more than k at the first point, where the solve starts cold.
// The final check is the solve itself, so the fixture cannot pass by never
// iterating.
//
//! lrm 9.3
//! lrm 9.5.9
//! lrm 9.5.9:1
//! lrm 9.5.4.1
//! lrm 9.3:1000
//! lrm 9.5.9:1001
//! solve
//! bias V(n) = 0
//! time 0, 1e-3, 2e-3
`include "check.vh"
module ch09_rejected_iterations_leave_no_file_side_effects(p, n);
  inout p, n; electrical p, n;
  integer fd, rfd, lines, code, k, index;
  string s;
  analog begin
    @(initial_step) fd = $fopen("ch09_220_iterations.log", "w");
    $fwrite(fd, "x\n");
    $fflush(fd);
    rfd = $fopen("ch09_220_iterations.log", "r");
    lines = 0;
    for (k = 0; k < 10; k = k + 1) begin
      code = $fgets(s, rfd);
      if (code > 0) lines = lines + 1;
    end
    $fclose(rfd);
    index = floor($abstime / 1.0e-3 + 0.5);
    I(p, n) <+ V(p, n) + V(p, n) * V(p, n) * V(p, n) - 10.0;
    `CHECKI("§9.3/§9.5.9 one line per ACCEPTED point, none per rejected iteration (lines - index)",
            lines - index, 1);
    `CHECKR("the solve converged to the cubic's root", V(p, n), 2.0, 1e-9);
  end
endmodule
