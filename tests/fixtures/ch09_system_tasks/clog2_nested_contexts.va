// AMS §9.14 imports IEEE §17.11.1. IEEE §5.4.2 requires interim results to
// take the largest operand's size; §5.5.2 propagates that size and signedness
// through context-dependent operands. Table 5-22 makes shift/power counts,
// logical operands and a ternary condition self-determined; comparisons
// share one operand context independent of their one-bit result.
//
// HAND DERIVATION. At signed width 4, 7+1=-8 and -8/2=-4; unsigned bits 12
// need ceiling log 4. An 8-bit divisor widens the sum first: 8/2=4 -> 2.
// An unsigned four-bit divisor makes the whole arithmetic unsigned: 8/2=4
// -> 2. A unary minus propagated into unsigned width 8 makes ff -> 8.
// The signed four-bit sum's logical right shift uses bits 8 >> 1=4 -> 2.
// Counts f+1 wrap at their own width 4: shifting 80 by 0 gives 80 -> 7, and
// 3**0 gives 1 -> 0. A logical f+1 is false, so 8+0=8 -> 3; a comparison of
// that wrapped sum with 0 is true, so 8+1=9 -> 4. The same false ternary
// condition selects 8 -> 3, while an eight-bit arm widens f+1 to 16 -> 4.
// A nested $clog2 has its own argument context: clog2(f)=4, then 8+4=12 -> 4.
// A mixed unsigned bitwise parent zero-extends signed four-bit f to 0f,
// so f|00 has unsigned value 15 -> 4, rather than sign-extending it to ff.
// In a constant default (outside analog), >>> takes the propagated unsigned
// type: 80000000 >>> 1=40000000 -> 30. A 63-bit complement of zero has all
// 63 bits set and therefore ceiling log 63.
// An unsigned 64-bit 2**63 compares greater than 0 despite the carrier's
// sign bit: 8+true=9 -> 4, both folded and in an analog expression.
//
// Ordinary integer assignment and the function's integer return supply
// width 32: (7+1)/2=4; its separate $clog2 is 2. These neighbours ensure the
// argument context does not leak into ordinary analog arithmetic or calls.
// Wide bitwise values and aliases keep their bits: 2**32+1 -> 33, and the
// 33-bit all-ones literal -> 33. Wider arithmetic limitations have named
// neighbours reject_clog2_wide_arithmetic{,_default}.va, not an XFAIL.
//! lrm 9.14
//! lrm 6.3.4
//! lrm 6.3.4:1000
//! param a = 7
//! checks 26
`include "check.vh"
module clog2_nested_contexts;
  parameter signed [3:0] a = 4'sh6;
  parameter high = 40'h100000000;
  localparam high_alias = high;
  localparam integer folded = $clog2((4'sh7 + 4'sh1) / 4'sh2);
  localparam integer dependent = $clog2((a + 4'sh1) / 4'sh2);
  localparam integer ordinary_folded = (4'sh7 + 4'sh1) / 4'sh2;
  localparam integer folded_unsigned_shift = $clog2((32'sh80000000 >>> 1) | 32'h0);
  localparam integer folded_unsigned_compare = $clog2(8'd8 + (64'h8000000000000000 > 64'h0));
  integer ordinary;
  analog function integer ordinary_function;
    input unused;
    integer unused;
    begin ordinary_function = (4'sh7 + 4'sh1) / 4'sh2; end
  endfunction
  analog begin
    `CHECKI("folded narrow intermediate", folded, 4);
    `CHECKI("dependent narrow intermediate", dependent, 4);
    `CHECKI("runtime narrow intermediate", $clog2((a + 4'sh1) / 4'sh2), 4);
    ordinary = (4'sh7 + 4'sh1) / 4'sh2;
    `CHECKI("ordinary integer assignment retains its context", ordinary, 4);
    `CHECKI("ordinary constant default retains its context", ordinary_folded, 4);
    `CHECKI("integer variable is a separate operand", $clog2(ordinary), 2);
    `CHECKI("larger divisor propagates into the sum", $clog2((4'sh7 + 4'sh1) / 8'sh2), 2);
    `CHECKI("unsigned divisor propagates into the sum", $clog2((a + 4'sh1) / 4'h2), 2);
    `CHECKI("parent width reaches unary minus", $clog2(-4'sh1 + 8'd0), 8);
    `CHECKI("logical shift clears narrow sign extension", $clog2((a + 4'sh1) >> 1), 2);
    `CHECKI("shift count has its own width", $clog2(8'h80 >> (4'hf + 4'h1)), 7);
    `CHECKI("power count has its own width", $clog2(8'd3 ** (4'hf + 4'h1)), 0);
    `CHECKI("logical operand has its own width", $clog2(8'd8 + ((4'hf + 4'h1) || 1'b0)), 3);
    `CHECKI("comparison operands share their own width", $clog2(8'd8 + ((4'hf + 4'h1) == 4'h0)), 4);
    `CHECKI("ternary condition has its own width", $clog2((4'hf + 4'h1) ? 8'hff : 8'h8), 3);
    `CHECKI("ternary arms share the wider width", $clog2(1'b1 ? (4'hf + 4'h1) : 8'h0), 4);
    `CHECKI("function return keeps ordinary assignment context", $clog2(ordinary_function(0)), 2);
    `CHECKI("nested system function has its own context", $clog2(4'd8 + $clog2(4'shf)), 4);
    `CHECKI("unsigned parent zero extends each source width", $clog2(4'shf | 8'h0), 4);
    `CHECKI("constant shift takes propagated unsigned type", folded_unsigned_shift, 30);
    `CHECKI("63-bit normalization remains legal", $clog2(~63'h0), 63);
    `CHECKI("folded comparison uses unsigned 64-bit ordering", folded_unsigned_compare, 4);
    `CHECKI("comparison uses unsigned 64-bit ordering", $clog2(8'd8 + (64'h8000000000000000 > 64'h0)), 4);
    `CHECKI("wide bitwise carrier remains legal", $clog2((64'h100000000 ^ 64'h1) & 64'h1ffffffff), 33);
    `CHECKI("wide alias and bitwise carrier remain legal", $clog2(high_alias | 40'h1), 33);
    `CHECKI("33-bit literal remains legal", $clog2(33'h1ffffffff), 33);
  end
endmodule
