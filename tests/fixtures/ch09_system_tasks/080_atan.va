// §9.2 Table 9-11 lists $atan as supported in the analog context; §4.3
// Table 4-15 defines it as C `atan(x)`, the arc-tangent, RETURNED IN RADIANS,
// for all x. §4.3 also says the IEEE 1364 `$` spelling and the traditional
// Verilog-AMS spelling name the same function.
//
// atan(1/2) = 0.4636476090008061 rad. (A degrees-returning implementation would
// give 26.565; tanh(0.5) = 0.46211715726, a table mix-up, is 1.5e-3 away.)
//
//! lrm 9.14
//! bias V(p) = 0.5
`include "check.vh"
module ch09_atomic_atan(p, n);
  inout p, n; electrical p, n;
  analog begin
    `CHECK("$atan(0.5) in radians", $atan(V(p,n)), 0.4636476090008061, 1e-15);
    `CHECK("traditional atan() is the same function", atan(V(p,n)), 0.4636476090008061, 1e-15);
    I(p,n) <+ V(p,n) + $atan(V(p,n));
  end
endmodule
