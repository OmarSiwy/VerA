// §9.5.6 lists every shape the task has:
//
//   $fflush( mcd );
//   $fflush( fd );
//   $fflush( );
//
// "Writes any buffered output to the file(s) specified by mcd, to the file
// specified by fd, or if $fflush is invoked with no arguments, to all open
// files."
//
// Zero or one argument, and the one argument may already name several files —
// that is what an mcd's OR'd bits are for (§9.5.1: "Output is directed to two
// or more files opened with multichannel descriptors by bitwise OR-ing
// together their multichannel descriptors"). Two FILE descriptors cannot be
// OR'd ("Unlike multichannel descriptors, file descriptors cannot be combined
// via bitwise OR"), and nor can they be listed: the task has no second slot.
// Flushing `a` and `b` is two statements; either one alone compiles (probed).
//
// VerA used to accept the call without a word. It now reports E0887 "wrong
// number of arguments to a system task or function".
//
//! lrm 9.5.6
//! reject-only E0887
//! reject `$fflush` takes at most 1 argument, got 2
`include "disciplines.vams"
module ch09_fflush_two_descriptors(p, n);
  inout p, n; electrical p, n;
  integer a, b;
  analog begin
    @(initial_step) begin
      a = $fopen("ch09_203_a.log", "w");
      b = $fopen("ch09_203_b.log", "w");
      $fflush(a, b);                     // illegal: at most one descriptor
    end
    I(p, n) <+ V(p, n);
  end
endmodule
