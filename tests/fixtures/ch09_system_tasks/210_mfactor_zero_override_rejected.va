// §9.18 Table 9-29, the $mfactor row:
//
//   System Parameter | Top-Level Value | Resolved Value for Instance       | Allowed Values
//   $mfactor         | 1.0             | $mfactor_specified * $mfactor_hier | $mfactor > 0
//
// and "$mfactor is the shunt multiplicity factor of the instance, that is, the
// number of identical devices that should be combined in parallel and
// modeled." Zero devices in parallel is not a device, and §6.3.6's automatic
// rules make the arithmetic say so: "The value returned by any branch flow
// probe in the analog block ... shall be divided by $mfactor".
//
// `rcell #(.$mfactor(0))` specifies 0 for the instance. The resolved value is
// 0 * $mfactor_hier = 0 whatever the hierarchy above holds, so the instance's
// $mfactor is outside the allowed values by the table's own product rule — no
// host value can rescue it. `.$mfactor(2)` in the same place compiles
// (probed; 097_mfactor.va and ch06_hierarchy/mfactor.va run nonzero ones).
//
// VerA used to accept the override without a word. It now reports E0890 "hierarchical system parameter outside
// its allowed values". Only a factor that folds without the model card is
// judged; one written over a parent parameter is the host's to supply.
//
//! lrm 9.18
//! lrm 6.3.6
//! lrm 9.18:1000
//! reject-only E0890
//! reject Table 9-29 allows only $mfactor > 0
//! neighbour 097_mfactor.va
//! neighbour ../ch06_hierarchy/mfactor.va
`include "disciplines.vams"
module ch09_mfactor_zero_top(p, n);
  inout p, n; electrical p, n;
  rcell #(.$mfactor(0)) c1(p, n);         // illegal: $mfactor > 0
endmodule

module rcell(a, b);
  inout a, b; electrical a, b;
  analog I(a, b) <+ V(a, b) / 1.0e3;
endmodule
