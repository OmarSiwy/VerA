// §9.11 / Table 9-8: `$realtobits` yields the IEEE-754 bit PATTERN of its real
// argument, verbatim, and §2.6.2 fixes reals as IEEE Std 754 doubles — so the
// pattern is a number this comment can derive by hand:
//
//   1.0 = +1.0 x 2^0   sign 0, biased exponent 1023 = 0x3FF, zero mantissa
//                      -> 0x3FF0000000000000 = 4607182418800017408
//   0.5 = +1.0 x 2^-1  biased exponent 1022 = 0x3FE
//                      -> 0x3FE0000000000000 = 4602678819172646912
//
// Both need the full 64 bits, which is why §2.5.1's "at least 32 bits" has to be
// read as 64 here: neither literal is reachable in a 32-bit integer.
//
//! bias V(p) = 1.0
`include "check.vh"
module ch09_atomic_realtobits(p, n);
  inout p, n; electrical p, n;
  analog begin
    `CHECKI("pattern of 1.0 is 0x3FF0000000000000", $realtobits(V(p,n)), 4607182418800017408);
    `CHECKI("pattern of 0.5 is 0x3FE0000000000000", $realtobits(0.5), 4602678819172646912);
    I(p,n) <+ $realtobits(V(p,n)) + V(p,n);
  end
endmodule
