// §9.11 / Table 9-8: `$realtobits` yields the IEEE-754 bit PATTERN of its real
// argument, verbatim, and §2.6.2 fixes reals as IEEE Std 754 doubles — so the
// pattern is a number this comment can derive by hand:
//
//   1.0 = +1.0 x 2^0   sign 0, biased exponent 1023 = 0x3FF, zero mantissa
//                      -> 0x3FF0000000000000 = 4607182418800017408
//   0.5 = +1.0 x 2^-1  biased exponent 1022 = 0x3FE
//                      -> 0x3FE0000000000000 = 4602678819172646912
//
// KNOWN LIMITATION OF THIS FIXTURE. Both wants need the full 64 bits, and both
// are written as unsized decimal literals because torture.zig requires a `want`
// to be a plain numeric literal — `64'h3FF0000000000000` is not one. §2.5.1 says
// only that "the number of bits that make up an unsized number ... shall be at
// least 32", so a conforming compiler that picks exactly 32 truncates both wants
// to zero and fails this file for a reason that has nothing to do with
// $realtobits. That is an over-specification here, written down rather than
// argued away: the fixture assumes an unsized literal at least 64 bits wide.
// 064_bitstoreal.va, where the pattern is an ARGUMENT rather than a want, uses
// the sized form and has no such assumption.
//
//! lrm 9.2
//! lrm 9.11
//! bias V(p) = 1.0
`include "check.vh"
module ch09_atomic_realtobits(p, n);
  inout p, n; electrical p, n;
  analog begin
    `CHECKI("pattern of 1.0 is 0x3FF0000000000000", $realtobits(V(p,n)), 4607182418800017408);
    `CHECKI("pattern of 0.5 is 0x3FE0000000000000", $realtobits(0.5), 4602678819172646912);
    I(p,n) <+ $realtobits(V(p,n)) + V(p,n);
  end
endmodule
