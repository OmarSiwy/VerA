// The legal neighbour of limit_omitted_algorithm_rejected.va: the same call
// with §9.17.3's "pnjlim" written in the second position.
//
// At the forced bias V(p,n) = 0.5 V, below vcrit = 0.6 V, SPICE's pnjlim
// returns its new value unchanged, and §9.17.3 lets the simulator return the
// first argument in any case ("the simulator may simply choose to have
// $limit() return the value of its first argument"). Either way vd = 0.5
// exactly.
//
//! lrm 9.17.3
//! bias V(p) = 0.5, V(n) = 0
//! checks 1
`include "check.vh"
module ch09_limit_omitted_algorithm_neighbour(p, n);
  inout p, n; electrical p, n;
  real vd;
  analog begin
    vd = $limit(V(p,n), "pnjlim", 0.025, 0.6);
    I(p,n) <+ 1e-14 * (exp(vd / 0.025) - 1.0);
    `CHECKX("pnjlim below vcrit returns its argument", vd, 0.5);
  end
endmodule
