// §9.4.5: "For each %s specification which appears in a string, a
// corresponding argument shall follow the string in the argument list."
//
// "<%s>" carries one %s and no argument follows it. The format is a literal
// and the argument list is empty, so the shortfall is statically known. The
// latitude §9.5.3 grants (warn and continue) is stated for $sformat's
// format_string only; $swrite takes "the same type of arguments" as $fwrite,
// whose strings are §9.4.5's.
//
// The neighbour b6_swrite_s_with_argument.va is this file with "x" supplied.
//
//! lrm 9.4.5
//! lrm 9.4.5:1
//! reject-only E0810
//! neighbour b6_swrite_s_with_argument.va
`include "check.vh"
module b6_swrite_s_without_argument_rejected(p, n);
  inout p, n; electrical p, n;
  string t;
  analog begin
    $swrite(t, "<%s>");                  // illegal: the %s has no argument
    `CHECKI("§9.4.5 the %s takes the argument after the string", t == "<x>", 1);
    I(p, n) <+ V(p, n);
  end
endmodule
