// §9.22, paragraph 3, verbatim: "The driver access functions described here
// only access drivers found in ordinary modules and not to those found in
// connect modules. Driver access functions can only be called from connect
// modules."
//
// The module below is an ordinary module, so the call is diagnosable on sight —
// no elaboration, no netlist, no driver needed. That is the whole test.
//
// NOTHING IS ASSERTED, deliberately. §9.23.3 defines driver_index as "an integer value between 0 and
// N-1, where N is the total number of drivers contributing to the signal
// value". A continuous node of a flat design has N = 0, so that range is
// EMPTY and there is no element 0 to return a value for. A fixture that
// asserted one would be pinning its own host's convenience.
//
//! lrm 9.22
//! lrm 9.23.3
//! reject connect module
//! xfail VerA has no `connectmodule` design element and no digital driver state — the two things §9.22/§9.23 are defined over — so it cannot tell a legal call site from an illegal one; it lowers the whole driver-access family to a constant (codegen.zig driver_queries) instead of refusing the call
module ch09_atomic_driver_next_strength_connectmodule_rejected(p, n);
  inout p, n; electrical p, n;
  real info;
  analog begin
    info = $driver_next_strength(p, 0);
    I(p,n) <+ V(p,n) + info;
  end
endmodule
