// §9.7.1 Syntax 9-5:
//
//   finish_task ::= $finish [ ( n ) ] ;
//
// One optional argument, and its meaning is fixed by Table 9-25: "If an
// expression is supplied to this task, its value determines which diagnostic
// messages are printed after the $finish call is executed" — 0 prints nothing,
// 1 time and location, 2 adds statistics. There is one diagnostic level per
// call, so a second expression has no row to select and no slot in the
// production. `$finish(0);` and `$finish;` both compile (probed; 055_finish.va
// and 12_finish_stop.va run them).
//
// VerA used to accept `$finish(1, 2)` without a word. It now reports E0887
// "wrong number of arguments to a system task or function".
//
//! lrm 9.7.1
//! reject-only E0887
//! reject `$finish` takes at most 1 argument, got 2
//! neighbour 055_finish.va
//! neighbour 12_finish_stop.va
`include "disciplines.vams"
module ch09_finish_two_arguments(p, n);
  inout p, n; electrical p, n;
  analog begin
    I(p, n) <+ V(p, n);
    @(final_step) $finish(1, 2);         // illegal: Syntax 9-5 has one slot
  end
endmodule
