// AMS §9.12 and IEEE 1364-2005 §17.10.2: search arguments in supplied
// order, use the first matching prefix, convert its remainder, and do not
// modify the destination on no match. +gain=7 precedes +gain=8, so gain=7.
// +empty= supplies an empty numeric remainder, which must convert to zero.
// Status is nonzero, not necessarily 1; normalize successful statuses.
//! lrm 9.12
//! plusargs +gain=7 +gain=8
//! plusargs +empty=
//! checks 6
//! xfail PLUSARGS-002: runtime codegen returns zero without converting argv
`include "check.vh"
module audit_plusargs_value_order(p, n);
  inout p, n; electrical p, n;
  integer found, value;
  analog begin
    value = -3;
    found = $value$plusargs("gain=%d", value);
    `CHECKI("gain found", found != 0, 1);
    `CHECKI("first matching argument", value, 7);
    value = 99;
    found = $value$plusargs("empty=%d", value);
    `CHECKI("empty remainder found", found != 0, 1);
    `CHECKI("empty numeric remainder is zero", value, 0);
    value = 42;
    found = $value$plusargs("missing=%d", value);
    `CHECKI("missing return", found, 0);
    `CHECKI("missing destination unchanged", value, 42);
    I(p,n) <+ V(p,n);
  end
endmodule
