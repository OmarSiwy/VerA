// Wide localparam storage and derivation retain every byte.
//! lrm 3.4.1
//! lrm 9.4.3
`include "check.vh"
module ch09_numeric_string_local_width(p,n);
  inout p,n; electrical p,n;
  localparam wide = 64'h4142434445464748;
  string text;
  analog begin
    $sformat(text, "%s", wide);
    `CHECKI("localparam preserves eight bytes", text == "ABCDEFGH", 1);
    I(p,n) <+ V(p,n);
  end
endmodule
