// §9.14 trigonometric and hyperbolic system functions — aliases of the §4.3.2
// analog operators (Table 4-14). Biased at V(p,n) = 0.5 rather than the default
// 0, where sin/tan are both 0 and cos is 1 and the first line would pass for a
// stub. Each running total is fixed by real analysis:
//
//   sin(0.5)   0.4794255386042030   cos(0.5) 0.8775825618903728
//   tan(0.5)   0.5463024898437905                  sum 1.9033105903383662
//
//   asin(0.5)  0.5235987755982989  = pi/6   } asin+acos = pi/2 for any argument
//   acos(0.5)  1.0471975511965979  = pi/3   } (§4.3.2 principal values), so the
//   atan(1.0)  0.7853981633974483  = pi/4     second line adds 3*pi/4 exactly
//                                             running total 4.259505080530712
//
//   sinh(1)    1.1752011936438014           cosh(1) 1.5430806348152437
//   tanh(1)    0.7615941559557649           running total 7.739381064945521
//
//   asinh(1)   0.8813735870195430  = ln(1+sqrt2)
//   acosh(2)   1.3169578969248166  = ln(2+sqrt3)
//   atanh(0.5) 0.5493061443340548  = 0.5*ln 3
//                                             running total 10.487018693223936
//
// Every argument is chosen where the inverse functions have a closed form, so
// each digit above is checkable by hand. The tolerance is 1e-12 absolute on
// totals of order 10 — about 1e-13 relative — which admits an implementation
// that builds asin/acosh out of atan/log identities but not one that is wrong.
//
//! lrm 9.14
//! bias V(p) = 0.5
`include "check.vh"
module ch09_math_trig(p, n);
  inout p, n; electrical p, n;
  real x;
  analog begin
    x = $sin(V(p,n)) + $cos(V(p,n)) + $tan(V(p,n));
    `CHECK("§9.14 sin+cos+tan at 0.5", x, 1.9033105903383662, 1e-12);
    x = x + $asin(0.5) + $acos(0.5) + $atan(1.0);
    `CHECK("§4.3.2 asin(.5)+acos(.5)+atan(1) adds 3*pi/4", x, 4.259505080530712, 1e-12);
    x = x + $sinh(1.0) + $cosh(1.0) + $tanh(1.0);
    `CHECK("sinh(1)+cosh(1)+tanh(1) adds e + tanh(1)", x, 7.739381064945521, 1e-12);
    x = x + $asinh(1.0) + $acosh(2.0) + $atanh(0.5);
    `CHECK("asinh(1)+acosh(2)+atanh(.5) adds ln((1+sqrt2)(2+sqrt3)*sqrt3)",
           x, 10.487018693223936, 1e-12);
    I(p,n) <+ x;
  end
endmodule
