// §9.2 Table 9-11 lists $sinh as supported in the analog context; §4.3
// Table 4-15 defines it as C `sinh(x)` = (e^x - e^-x)/2, for all x. §4.3 makes
// the `$` and traditional spellings the same function.
//
// sinh(0.5) = 0.5210953054937474, and sinh is ODD — the property that separates
// it from cosh(0.5) = 1.1276259652063807.
//
//! lrm 9.14
//! bias V(p) = 0.5
`include "check.vh"
module ch09_atomic_sinh(p, n);
  inout p, n; electrical p, n;
  analog begin
    `CHECK("$sinh(0.5)", $sinh(V(p,n)), 0.5210953054937474, 1e-15);
    `CHECK("sinh is odd", $sinh(-V(p,n)), -0.5210953054937474, 1e-15);
    `CHECK("traditional sinh() is the same function", sinh(V(p,n)), 0.5210953054937474, 1e-15);
    I(p,n) <+ V(p,n) + $sinh(V(p,n));
  end
endmodule
