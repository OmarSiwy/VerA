//! lrm 9.21.1
//! analysis tran
//! time 0, 1, 2
`include "check.vh"
module ch09_table_snapshot(p,n);
  inout p,n; electrical p,n,m;
  real xs[0:1], ys[0:1], early, delayed, repeated;
  integer k;
  analog begin
    if ($simparam("iteration") < 0) $discontinuity(-1);
    xs[0]=$abstime; xs[1]=1+$abstime;
    ys[0]=10*$abstime; ys[1]=2+10*$abstime;
    early=$table_model(0.5, xs, ys);
    `CHECKX("array coordinates and values captured", early, 1);
    delayed=0;
    if ($abstime >= 1) begin
      delayed=$table_model(1.5, xs, ys);
      `CHECKX("conditional first call at time one", delayed, 11);
    end
    for (k=0;k<2;k=k+1) begin
      xs[0]=0; xs[1]=1;
      ys[0]=100*k; ys[1]=2+100*k;
      repeated=$table_model(0.5,xs,ys);
      `CHECKX("same call site repeated in a loop", repeated, 1);
    end
    I(m,n) <+ $limit(V(m,n),"pnjlim",0.026+abs(V(p,n))*0.001,0.7);
    I(p,n) <+ V(p,n)+early+delayed+repeated;
  end
endmodule
