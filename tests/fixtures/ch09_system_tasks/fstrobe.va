// §9.5.2: $fstrobe is $strobe against a descriptor, so §9.4.1 still governs
// what it prints — the argument at the ACCEPTED solution. §1.3.1 pins that
// value: V(p,n) = 3.5 - 1.5 = 2.0 V, exact in binary floating point.
//
//! lrm 9.5.2
//! bias V(p) = 3.5, V(n) = 1.5
`include "check.vh"
module ch09_atomic_fstrobe(p, n);
  inout p, n; electrical p, n;
  integer fd;
  analog begin
    fd = $fopen("ch09_041_fstrobe.log", "a");
    `CHECK("the %g argument is the accepted branch potential", V(p,n), 2.0, 1e-15);
    $fstrobe(fd, "value=%g", V(p,n));
    I(p,n) <+ V(p,n);
  end
endmodule
