// §9.13: "Verilog-AMS HDL extends the probabilistic distribution functions so
// that they are supported in the analog context." Table 9-10 lists all 17 names
// and every row reads `Yes  Yes` — digital context AND analog context. So this
// file must COMPILE and run green; a compiler that refuses the call is the one
// that is wrong, which is why the expectation is a run and not a reject.
//
// The value itself is implementation-defined — §9.13.3 points at the IEEE 1364
// §17.9.3 C code, which no clause of this LRM requires a tool to reproduce — so
// no digits are written for it. What §9.13.2 DOES fix is repeatability: "The
// system functions shall always return the same value given the same seed."
// Two seeds initialized to the same integer must therefore agree, and that
// holds for any conforming RNG whatever its stream.
//
// §9.13.2 adds one more fixed fact for the real family: "All functions return
// a real value." Table 9-26 cross-lists each $rdist_* name to the IEEE 1364
// §17.9.3 C routine, so the stream is defined there and not here.
//
// $rdist_uniform is the one with a bound to write down: "In $rdist_uniform,
// the start and end arguments are real inputs which bound the values returned.
// The start value shall be smaller than the end value." start = 0.0, end = 10.0.
//
// A SECOND rule, and the one that makes this fixture more than a stub test.
// §9.13.2 makes the seed an inout: "If it is an integer variable, then it is an
// inout argument; that is, a value is passed to the function and A DIFFERENT
// VALUE IS RETURNED. The variable is initialized by the user and only updated by
// the system function. This ensures the desired distribution is achieved upon
// successive calls." So after the call `sa` shall no longer read 7. Without that
// check the only assertion here is `a == b`, which a `return 0` stub satisfies
// perfectly; with it, a constant-returning implementation fails.
//
//! lrm 9.13.2
//! xfail VerA refuses the whole §9.13 probabilistic family with E0801 rather than stubbing a seeded RNG stream; Table 9-10 marks every one of the 17 names analog-context Yes
`include "check.vh"
module ch09_real_distribution(p, n);
  inout p, n; electrical p, n;
  integer sa, sb;
  real a, b;
  analog begin
    sa = 7; sb = 7;
    a = $rdist_uniform(sa, 0.0, 10.0);
    b = $rdist_uniform(sb, 0.0, 10.0);
    `CHECKI("§9.13.2 $rdist_uniform repeats on the same seed", a == b, 1);
    `CHECKI("§9.13.2 the seed is inout: a DIFFERENT value is returned", sa != 7, 1);
    `CHECKI("and both seeds advanced the same way from the same start", sa == sb, 1);
    `CHECKI("start and end bound the values returned",
            (a >= 0.0) && (a <= 10.0), 1);
    I(p,n) <+ V(p,n) + a + b + sa + sb;
  end
endmodule
