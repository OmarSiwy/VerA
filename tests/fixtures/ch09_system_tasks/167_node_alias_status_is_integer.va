// §9.20: "The return value for both system functions shall be one (1) if the
// hierarchical_reference_string points to a valid continuous node and zero (0)
// otherwise." One or zero is an INTEGER, and §4.2 says what may be done with
// one: §4.2.11 shifts it, §4.2.9 masks it, §4.2.5 compares it. §4.2.9's own
// sentence — "shall operate on integer operands" — is the rule a compiler that
// types this call `real` then breaks, on code the LRM permits without
// qualification.
//
// `105_analog_node_alias.va` and `106_analog_port_alias.va` pin the VALUE (0
// here, for the same unresolvable `$root.top.*` reference: this compilation
// elaborates this module as the top level and instantiates nothing). This file
// pins the TYPE, which they cannot: they assign the result straight into an
// `integer` variable, and an implicit §4.2.1.1 conversion hides the difference.
// Put the call under a shift and there is nowhere for the conversion to hide.
//
//! lrm 9.20
//! lrm 9.20:10
//! lrm 4.2.9
//! lrm 4.2.11
`include "check.vh"

module ch09_node_alias_status_is_integer(p, n);
  inout p, n; electrical p, n;
  electrical node_a, node_b;
  integer shifted, masked;
  analog initial begin
    // 0 << 3 is 0, and the digit is not the point — the point is that §4.2.11
    // accepts the operand at all. A `real` here is E0322.
    shifted = $analog_node_alias(node_a, "$root.top.n") << 3;
    // §4.2.9 the same operand under a bitwise operator, and `~0` is -1 over
    // §3.2.1's 32-bit `integer`, so the mask distinguishes 0-because-integer
    // from 0-because-nothing-happened.
    masked = ~$analog_port_alias(node_b, "$root.top.dev.p") & 7;
  end
  analog begin
    `CHECKI("§4.2.11 a §9.20 status is a legal shift operand", shifted, 0);
    `CHECKI("§4.2.9 and a legal bitwise operand: ~0 & 7", masked, 7);
    I(p,n) <+ V(node_a) + V(node_b) + (shifted + masked) * 0.0;
  end
endmodule
