// §9.2 Table 9-11 lists $pow as supported in the analog context; §4.3
// Table 4-14 defines it as C `pow(x,y)` = x^y, legal for all y when x > 0 and
// for all INTEGER y when x < 0. §4.3 makes the `$` and traditional spellings the
// same function.
//
// At V(p,n) = 0.5: 0.5^2 = 0.25, exactly representable, so the equality is
// exact. The negative base with an integer exponent is the other half of the
// stated domain: (-0.5)^2 = 0.25 as well, and the sign must not leak through.
//
//! lrm 9.14
//! bias V(p) = 0.5
`include "check.vh"
module ch09_atomic_pow(p, n);
  inout p, n; electrical p, n;
  analog begin
    `CHECKX("$pow(0.5, 2.0)", $pow(V(p,n), 2.0), 0.25);
    `CHECKX("negative base with an integer exponent", $pow(-V(p,n), 2.0), 0.25);
    `CHECKX("traditional pow() is the same function", pow(V(p,n), 2.0), 0.25);
    `CHECKX("$pow(x, 0) is 1", $pow(V(p,n), 0.0), 1.0);
    I(p,n) <+ V(p,n) + $pow(V(p,n), 2.0);
  end
endmodule
