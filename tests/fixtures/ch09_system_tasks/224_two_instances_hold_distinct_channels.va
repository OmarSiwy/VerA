// §9.5.1: "The file descriptor fd is a 32-bit value. ... The remaining bits hold
// a small number indicating what file is opened", and "The $fopen function
// shall reuse channels that have been closed." A channel is reused only once
// it is closed — so two files open AT THE SAME TIME hold two different
// channels, whichever instance opened them.
//
// CLAUSE-AUDIT §5.4 records VerA's scope for this as a stated choice without a
// fixture: "Descriptor table scope — one per device image, shared by
// instances ... needs a two-instance fixture". `file_kernels.zf_slots` is one
// file-scope table, so two instances of `writer` open through the same table.
// This file is that fixture.
//
// THE DESIGN. Two instances of one module, each opening its OWN file "w"
// under @(initial_step) and KEEPING it open, then writing its own tag through
// the descriptor it holds, flushing (§9.5.6), and reading its file back
// through a second, read-only descriptor with §9.5.4.2's `$fscanf("%d")`. Both
// write descriptors are open simultaneously when the writes happen.
//
// THE DIGITS, BY HAND. a writes 11 into two_inst_a, b writes 22 into
// two_inst_b; each reads back exactly its own tag, one item:
//
//   a: items 1, got 11      b: items 1, got 22
//
// written as `got - tag`, want 0, because the two instances share one source
// text. A table that handed both instances the same channel — per-instance
// numbering over a shared file list, or a reused open slot — puts both writes
// into ONE file: the other reads nothing (items != 1) or the wrong tag.
//
//! lrm 9.5.1
//! lrm 9.5.1:3
//! lrm 9.5.6
//! lrm 9.5.4.2
`include "check.vh"
module ch09_two_instances_hold_distinct_channels(p, n);
  inout p, n; electrical p, n;
  ch09_224_writer #(.fname("ch09_224_a.log"), .tag(11)) a(p, n);
  ch09_224_writer #(.fname("ch09_224_b.log"), .tag(22)) b(p, n);
endmodule

module ch09_224_writer(p, n);
  inout p, n; electrical p, n;
  parameter string fname = "ch09_224_x.log";
  parameter integer tag = 0;
  integer fd, rfd, got, items;
  analog begin
    @(initial_step) begin
      fd = $fopen(fname, "w");
      $fwrite(fd, "%0d\n", tag);
      $fflush(fd);
    end
    rfd = $fopen(fname, "r");
    items = $fscanf(rfd, "%d", got);
    $fclose(rfd);
    `CHECKI("each instance reads back one item from its own channel", items, 1);
    `CHECKI("and it is its own tag (got - tag)", got - tag, 0);
    @(final_step) $fclose(fd);
    I(p, n) <+ V(p, n) / 1.0e3;
  end
endmodule
