// NONCONFORMING ACCEPTANCE SNAPSHOT: $driver_next_strength is valid only in the digital context of a connectmodule.
//
// §9.23.3 gives the one value-level rule that survives into this context:
// "The pending strength value is returned as an integer between 0 and 7."
// §9.22.4 explains why the ceiling is 7 and not 255 — a FULL strength word is
// two fields, bits 5-3 for strength0 and bits 2-0 for strength1 — so a single
// returned strength cannot exceed 3'b111.
//
// The range is the whole claim, and it is restricting in both directions: a -1
// sentinel (the shape §9.23.1 uses for "no pending value") and a two-field
// strength word both fail it.
`include "check.vh"
module ch09_atomic_driver_next_strength(p, n);
  inout p, n; electrical p, n;
  analog begin
    `CHECKI("§9.23.3: the pending strength is an integer in 0..7",
            ($driver_next_strength(p,0) >= 0) && ($driver_next_strength(p,0) <= 7), 1);
    I(p,n) <+ V(p,n) + $driver_next_strength(p,0);
  end
endmodule
