// §9.7.3: "The finish_number may be used in an implementation-specific
// manner." This file pins VerA's manner: the finish_number is the process
// exit status (cg_display.emitDisplayTask, "floored at 1 so a $fatal never
// reads as success to a shell"). $fatal(2, ...) therefore exits 2;
// 173_fatal_terminates.va has $fatal(1, ...) exiting 1 and
// b6_fatal_finish_number_0_exit_status.va has the floor.
//
// The sweep is 173's oracle: at point 0, V(p) = 1.0, the check prints ok=1
// (1.0 < 1.5), then $fatal ends the run with status 2. Point 1, V(p) = 2.0,
// never runs; had it run, the check would print 2.0 < 1.5 = 0, ok=0.
//
// Also the legal neighbour of b6_fatal_finish_number_3_rejected.va:
// Syntax 9-7 `finish_number ::= 0 | 1 | 2`, and 2 is in it.
//
//! lrm 9.7.3
//! lrm 9.7.3:9
//! lrm 9.7.3:1
//! lrm 9.7.3:2
//! exit 2
//! sweep V(p) = 1.0, 2.0
//! checks 1
`include "check.vh"
module b6_fatal_finish_number_2_exit_status(p, n);
  inout p, n; electrical p, n;
  analog begin
    `CHECKI("printed at the first point only: $fatal ends the run before the second", V(p) < 1.5, 1);
    $fatal(2, "giving up at v=%g", V(p));
    I(p, n) <+ V(p, n);
  end
endmodule
