// §9.17.3: "One additional argument to the $limit() function is required when
// the second argument to the limit function is the string "fetlim": the third
// argument to $limit() is generally the threshold voltage of the MOS
// transistor."
//
// THE POSITIVE HALF of 9.17.3:1003. limit_fetlim_missing_vth_rejected.va takes
// the negative side of the same sentence: naming "fetlim" and supplying no
// third argument is E0809. Here the required argument is supplied.
//
// WHAT IS PINNED. When the simulator has converged, §9.17.3's return value "is
// the value of the access function reference, within appropriate tolerances",
// so at the answer $limit() is transparent. The bias below imposes 0.3 V on
// both nets and the device is evaluated once; DEVfetlim(0.3, vold, 0.7) is 0.3
// for any cold-start vold below vth + 3.5, so the digit survives the limiter.
//
// WHY THE PROBE IS AN INTERNAL NET. A $limit on a module PORT is one a
// simulator may decline outright (annex_e_spice/limit_fet.va explains why), so
// `mid` is private to the device and the call is one the tool cannot refuse.
//
// 1e-6 is the Annex D `nature Voltage` abstol, the only tolerance the LRM
// supplies for a voltage-natured quantity.
//
//! lrm 9.17.3
//! lrm 9.17.3:1003
//! bias V(p) = 0.3, V(mid) = 0.3
`include "check.vh"
module ch09_limit_fetlim_with_vth(p);
  inout p; electrical p; electrical mid; real limited;
  analog begin
    limited = $limit(V(mid), "fetlim", 0.7);
    I(mid, p) <+ (limited - V(p)) / 1.0;
    `CHECK("fetlim with its required vth returns the access function", limited, 0.3, 1e-6);
  end
endmodule
