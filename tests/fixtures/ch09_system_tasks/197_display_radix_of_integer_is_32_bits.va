// §9.4.3 Table 9-22: %h "display in hexadecimal format", %o octal, %b
// binary — the operand's bit pattern, and IEEE 1364-2005 §17.1.1.2 (which
// §9.4 inherits) sizes that display to the operand's width. §3.2: "An
// integer declaration declares one or more variables of type integer. These
// variables can hold values ranging from -2^31 to 2^31-1" — a 32-bit two's
// complement variable. So, derived by hand:
//
//   integer k = -5;  32-bit pattern 0xFFFF_FFFB
//     %h -> "fffffffb"       (8 hex digits, not 16)
//     %o -> "37777777773"    (0xFFFFFFFB = 4294967291 = 37777777773 octal)
//     %b -> "11111111111111111111111111111011"  (32 digits)
//   integer j = 255;  IEEE 1364-2005 §17.1.1.3 sizes the field too: "In other
//   radices, leading zeros are always displayed" (its 12-bit example prints
//   10 as `00a`), and only `%0h` overrides that. 32 bits is 8 hex digits:
//     %h -> "000000ff"
//   (An earlier revision asserted "ff" here, which was VerA's minimal-width
//   deviation and not the clause; audit_integer_default_fields.va pins the
//   same rule on a 12-bit literal.)
//
// This fixture asserts the variable, which §3.2 fixes. An unsized literal is
// the same width (IEEE 1364-2005 Table 5-22, "Same as integer"; §2.6.1 says
// only "at least 32"): 171_display_c_format_flags pins `%h` of -42 as
// ffffffd6, and analog_radix_of_integer_expression_is_32_bits.va the
// operators over integers (#77).
//
//! print none
//! lrm 9.4.3
//! lrm 3.2
`include "check.vh"
module ch09_display_radix_integer_32(p, n);
  inout p, n; electrical p, n;
  integer k, j;
  string t;
  analog begin
    k = -5;
    j = 255;
    $sformat(t, "%h", k);
    `CHECKI("%h of integer -5 is its 32-bit pattern", t == "fffffffb", 1);
    $sformat(t, "%o", k);
    `CHECKI("%o of integer -5 is its 32-bit pattern", t == "37777777773", 1);
    $sformat(t, "%b", k);
    `CHECKI("%b of integer -5 is 32 binary digits", t == "11111111111111111111111111111011", 1);
    $sformat(t, "%h", j);
    `CHECKI("%h of integer 255 keeps its 32-bit leading zeros", t == "000000ff", 1);
    I(p,n) <+ V(p,n);
  end
endmodule
