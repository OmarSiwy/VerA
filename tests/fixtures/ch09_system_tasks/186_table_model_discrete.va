//! lrm 9.21.2
//! lrm 9.21.4
//! lrm 9.21.2:2
//! lrm 9.21
//! lrm 9.21:4
//! lrm 9.21:10
//! lrm 9.21.1:1002
//! lrm 9.21.4:1001
//! bias V(p) = 2.0
`include "check.vh"
module ch09_table_model_discrete(p, n);
  inout p, n; electrical p, n;
  real xs[0:3], fs[0:3], outer[0:3], inner[0:3], values[0:3];
  analog begin
    xs[0]=3; fs[0]=30;
    xs[1]=-1; fs[1]=10;
    xs[2]=-3; fs[2]=-30;
    xs[3]=1; fs[3]=20;
    `CHECKX("positive tie away from zero", $table_model(V(p,n), xs, fs, "D"), 30);
    `CHECKX("negative tie away from zero", $table_model(-V(p,n), xs, fs, "D"), -30);
    `CHECKX("nearest sample", $table_model(-1.25, xs, fs, "D"), 10);
    `CHECKX("low endpoint", $table_model(-10, xs, fs, "DCL"), -30);
    `CHECKX("high endpoint", $table_model(10, xs, fs, "DLC"), 30);
    outer[0]=-1; inner[0]=0; values[0]=10;
    outer[1]=-1; inner[1]=4; values[1]=18;
    outer[2]=3; inner[2]=1; values[2]=20;
    outer[3]=3; inner[3]=5; values[3]=32;
    `CHECKX("discrete outer and linear inner", $table_model(1, 3, outer, inner, values, "D,1"), 26);
    `CHECKX("linear outer and discrete inner", $table_model(0, 2, outer, inner, values, "1,D"), 18.5);
    I(p,n) <+ V(p,n);
  end
endmodule
