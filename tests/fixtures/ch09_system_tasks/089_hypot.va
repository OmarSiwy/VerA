// §9.2 Table 9-11 lists $hypot as supported in the analog context; §4.3
// Table 4-15 defines it as C `hypot(x,y)` = sqrt(x^2 + y^2), for all x and all
// y. §4.3 makes the `$` and traditional spellings the same function.
//
// At V(p,n) = 0.5: sqrt(0.25 + 1) = sqrt(1.25) = 1.118033988749895.
// hypot is even in each argument and never negative, so flipping the sign of the
// first argument must not change the result.
//
//! lrm 9.14
//! bias V(p) = 0.5
`include "check.vh"
module ch09_atomic_hypot(p, n);
  inout p, n; electrical p, n;
  analog begin
    `CHECK("$hypot(0.5, 1)", $hypot(V(p,n), 1.0), 1.118033988749895, 1e-15);
    `CHECK("hypot is even in its first argument", $hypot(-V(p,n), 1.0), 1.118033988749895, 1e-15);
    `CHECKX("$hypot(3, 4) is the exact Pythagorean 5", $hypot(3.0, 4.0), 5.0);
    `CHECK("traditional hypot() is the same function", hypot(V(p,n), 1.0), 1.118033988749895, 1e-15);
    I(p,n) <+ V(p,n) + $hypot(V(p,n), 1.0);
  end
endmodule
