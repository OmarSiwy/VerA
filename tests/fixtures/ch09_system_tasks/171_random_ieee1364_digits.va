// §9.13.3 "Algorithm for Probabilistic Distribution": "17.9.3 of IEEE Std 1364
// Verilog contains the C-code to describe the algorithm of probabilistic system
// functions based on the seed value passed to them. This code also describe the
// algorithm of the IEEE Std 1364 Verilog probabilistic functions extensions in
// Verilog-AMS HDL as indicated in Table 9-26." Table 9-26 maps $rdist_uniform
// onto that listing's `uniform`; §9.13.1's $random is the listing's own
// `rtl_dist_uniform(&seed, INT_MIN, INT_MAX)` caller, and $dist_uniform is
// `rtl_dist_uniform` itself. So unlike the rest of this family's fixtures,
// which pin §9.13.1/§9.13.2's repeatability and inout-seed sentences, this one
// pins DIGITS: the clause names one algorithm, and only that algorithm's
// stream passes.
//
// HOW THE DIGITS WERE PRODUCED — not by hand, and not from this compiler. The
// §17.9.3 listing was taken from two independent open-source reproductions,
// cross-checked constant-by-constant (LCG 69069·s+1 on a wrapping 32-bit word,
// zero-seed escape 259341593, mantissa fill (s>>9)|0x3f800000, d = 2⁻²³):
//
//   Icarus Verilog  vpi/sys_random.c   (rtl_dist_uniform / uniform)
//   Verilator       include/verilated_probdist.cpp (VL_DIST_UNIFORM /
//                                                   _vl_dbase_uniform)
//
// then compiled with `zig cc` and RUN, and the printed values pasted below
// verbatim (%.17g for the real; the full URLs are in the header of
// lib/backend/rng_kernels.zig, whose unit test pins the same run). Every
// operation on the $random and $rdist_uniform paths is IEEE-754 mul/add/div —
// no libm — so the want column is exact to the last bit and `CHECKX`/`CHECKI`
// are the right macros, not a tolerance.
//
// The SECOND draw from each seed is the sharper half of the fixture: it passes
// only if the inout write-back landed the seed exactly where the reference's
// `long *seed` did (483484 = 69069·7+1, then −965981971), i.e. the stream
// rejoins the listing call after call, not just on the first draw.
//
//! lrm 9.13.3
//! lrm 9.13.1
//! lrm 9.13.1:5
//! lrm 9.13.3:1000
//! lrm 9.13.1:1003
`include "check.vh"
module ch09_random_ieee1364_digits(p, n);
  inout p, n; electrical p, n;
  integer sa, sb, sc;
  integer a, a2, c, d;
  real r1, r2;
  analog begin
    // $random = rtl_dist_uniform(&seed, INT_MIN, INT_MAX), seed 7.
    sa = 7;
    a = $random(sa);
    `CHECKI("§9.13.3/17.9.3 $random(7) is the listing's draw", a, -2146999808);
    `CHECKI("and the seed lands where the listing's long *seed did (69069*7+1)",
            sa, 483484);
    a2 = $random(sa);
    `CHECKI("the SECOND draw rejoins the reference stream", a2, 1181502348);
    `CHECKI("and the second seed update is the listing's too", sa, -965981971);

    // Table 9-26: $rdist_uniform -> uniform(seed, start, end). Pure IEEE-754
    // arithmetic, so the want is exact.
    sb = 7;
    r1 = $rdist_uniform(sb, 0.0, 10.0);
    `CHECKX("Table 9-26 $rdist_uniform(7,0,10) is uniform()'s double, bit-exact",
            r1, 0.0011265279204053513);
    `CHECKI("and uniform() stepped the seed once", sb, 483484);
    r2 = $rdist_uniform(sb, 0.0, 10.0);
    `CHECKX("second uniform() draw, from the updated seed", r2, 7.7508995236036071);
    `CHECKI("second step", sb, -965981971);

    // $dist_uniform -> rtl_dist_uniform: an integer on the CLOSED range.
    sc = 7;
    c = $dist_uniform(sc, 1, 6);
    `CHECKI("17.9.3 rtl_dist_uniform(7,1,6)", c, 1);
    `CHECKI("one seed step", sc, 483484);

    // §9.13.1 "$arandom is upwardly compatible with $random ... and has the
    // same behavior" — same listing, same digit.
    sc = 7;
    d = $arandom(sc);
    `CHECKI("$arandom(7) draws the identical reference value", d, -2146999808);

    I(p,n) <+ V(p,n) + a + a2 + c + d + r1 + r2;
  end
endmodule
