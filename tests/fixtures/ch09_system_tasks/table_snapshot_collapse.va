//! lrm 9.21.1
//! analysis tran
//! time 0,1
`include "check.vh"
module ch09_table_snapshot_collapse(p,n);
  inout p,n; electrical p,n,ai;
  parameter real rs=0 from [0:inf);
  branch (p,ai) series;
  real xs[0:1],ys[0:1],value;
  analog begin
    xs[0]=0;xs[1]=1;ys[0]=2*$abstime;ys[1]=2*$abstime+2;
    value=$table_model(0.5,xs,ys);
    if (rs>0) I(series) <+ V(series)/rs;
    else V(series) <+ 0;
    I(ai,n) <+ value;
    `CHECKX("snapshot survives later array changes",value,1);
  end
endmodule
