// §9.17.3: "When the second argument is a string, it refers to a built-in
// function of the simulator. The two most common such functions are pnjlim and
// fetlim". This is the call VerA HONOURS: pnjlim across a junction with one
// internal net (`a`, behind a series resistance), unconditional, real
// arguments. The unit test "a declined $limit is W0853 naming why, an honoured
// one is silent" (lib/backend/codegen/test.zig) asserts this shape compiles to a
// `limit` clamp with no W0853; `//! nowarn` pins that here, and the checks
// assert what the clause fixes about the answer.
//
// "When the simulator has converged, the return value of the $limit() function
// is the value of the access function reference, within appropriate
// tolerances" — so limiting changes the path Newton takes, never the root.
// Solving from the cold start, the root is the KCL at `a`:
//
//   (0.7 - Va) / 100 = 1e-14 * (exp(Va / 0.025) - 1)
//
// The left side falls and the right rises in Va, so there is one root; bisection
// over [0, 0.7] puts it at Va = 0.625763159. vcrit = vte * ln(vte / (sqrt(2)*Is))
// = 0.025 * ln(0.025 / 1.41421e-14) = 0.705018 V, the clause's own formula. The
// band is the solver's convergence tolerance, relative 1e-4, as in 26_limit.
//
//! lrm 9.17.3
//! lrm 9.17.3:1002
//! nowarn
//! solve
//! bias V(p) = 0.7, V(n) = 0
`include "check.vh"
module ch09_limit_pnjlim_internal_node_honoured(p, n);
  inout p, n; electrical p, n, a;
  real vd;
  analog begin
    vd = $limit(V(a,n), "pnjlim", 0.025, 0.705018);
    I(p,a) <+ V(p,a) / 100.0;
    I(a,n) <+ 1e-14 * (exp(vd / 0.025) - 1.0);
    `CHECKR("the junction settles at the KCL root", V(a,n), 0.625763159, 1e-4);
    `CHECKR("and the converged $limit returns it", vd, 0.625763159, 1e-4);
  end
endmodule
