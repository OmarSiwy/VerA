// §9.12: "Verilog AMS HDL extends the command line input functions defined in
// IEEE Std 1364 Verilog so that they can be used in the analog context." The
// functions are EXTENDED, not redefined, so their shape is IEEE 1364-2005
// §17.10.2's:
//
//   $value$plusargs ( user_string, variable )
//
// (paraphrased: the 1364 text is not in docs/) a matching plusarg's remainder
// is converted by the user_string's format and stored in the variable. The
// variable is the whole point of the function — without it the converted value
// has nowhere to go and the call is a slower `$test$plusargs`. The
// two-argument shape is the one 066_value_plusargs.va and
// audit_plusargs_value_order.va run.
//
// Adding `, width` makes this file compile (probed).
//
// VerA used to accept the one-argument call without a word. It now reports
// E0887 "wrong number of arguments to a system task or function".
//
//! lrm 9.12
//! reject-only E0887
//! reject `$value$plusargs` takes 2 arguments, got 1
//! neighbour 066_value_plusargs.va
//! neighbour audit_plusargs_value_order.va
`include "disciplines.vams"
module ch09_value_plusargs_without_variable(p, n);
  inout p, n; electrical p, n;
  integer found, width;
  analog begin
    width = 1;
    found = $value$plusargs("WIDTH=%d");   // illegal: no variable to store into
    I(p, n) <+ V(p, n) * width;
  end
endmodule
