// §9.5.1.1: "If a file is opened in a write mode in the first analysis and
// reopened in that write mode in following analysis, then content written from
// the following analyses shall be appended to the content written during the
// previous analyses." To keep that promise VerA remembers each path opened for
// writing. It used to remember 64 and fail the 65th open; the rows now grow
// with the run (#29), so every distinct path opens.
//
// HAND DERIVATION. Paths 1..65 are opened for writing and closed at once:
// 65 nonzero descriptors, and $ferror after the 65th reports no error (§9.5.7:
// "If the most recent operation did not result in an error, then the value
// returned shall be zero"). Path 1 is remembered, so reopening it succeeds.
// That is the PATH-MEMORY half only; the append half of §9.5.1.1's sentence is
// asserted by write_mode_reopen_appends_across_analyses.va, which writes in
// each analysis and counts the surviving lines.
//
//! lrm 9.5.1
//! lrm 9.5.1.1
//! lrm 9.5.7
//! lrm 9.5.7:1
//! bias V(p) = 0
//! checks 4
`include "check.vh"
module write_mode_path_65_opens(p, n);
  inout p, n; electrical p, n;
  integer k, fd, opened, extra, again, code;
  string name, why;
  analog begin
    @(initial_step) begin
      opened = 0;
      for (k = 1; k <= 64; k = k + 1) begin
        $sformat(name, "wpath_%0d.dat", k);
        fd = $fopen(name, "w");
        if (fd != 0) opened = opened + 1;
        $fclose(fd);
      end
      extra = $fopen("wpath_65.dat", "w");
      code = $ferror(extra, why);
      $fclose(extra);
      again = $fopen("wpath_1.dat", "w");
      $fclose(again);
    end
    `CHECKI("64 distinct paths open for writing", opened, 64);
    `CHECKI("§9.5.1 and so does the 65th", extra != 0, 1);
    `CHECKI("§9.5.7 with no error", code, 0);
    `CHECKI("a remembered path still opens", again != 0, 1);
    I(p, n) <+ V(p, n);
  end
endmodule
