// DEBT — this rejection is NOT conformance.
// The LRM permits what VerA refuses here. The substrings below record
// CURRENT behavior so the suite stays green on it; they do not claim it
// is right. `zig build ledger` counts this rule against VerA.
//
// VAMS-9.13.2-06  (ch9-system.html)
// The type_string provides support for Monte-Carlo analysis and shall only be used in calls to a distribution function from within a paramset.
//
//! reject E0201
// EXPECT: error -- the type string is only valid in a paramset, which FastVAF rejects.
paramset ch09_rdist_type_string parameters;
  .gain = $rdist_normal(-7, 0.0, 1.0, "global");
endparamset
