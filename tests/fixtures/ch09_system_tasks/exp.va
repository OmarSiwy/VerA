// §9.2 Table 9-11 lists `$exp` as supported in the analog context; §4.3.1
// Table 4-14 defines it as C `exp(x)`, domain all x.
//
// exp(1) = e = 2.718281828459045235360287..., whose correctly rounded double is
// 2.718281828459045. exp(0) = 1 EXACTLY, for every conforming library — the one
// point of the exponential a check may pin to the last bit.
//
//! lrm 9.14
`include "check.vh"
module ch09_atomic_exp(p, n);
  inout p, n; electrical p, n;
  analog begin
    `CHECK("$exp(1.0) is e", $exp(1.0), 2.718281828459045, 1e-15);
    `CHECKX("$exp(0.0) is exactly one", $exp(0.0), 1.0);
    I(p,n) <+ V(p,n) + $exp(1.0);
  end
endmodule
