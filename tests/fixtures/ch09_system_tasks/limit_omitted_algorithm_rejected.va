// A.8.2 admits an empty slot in any system function call:
//
//   analog_system_function_call ::= analog_system_function_identifier
//     [ ( [ analog_expression ] { , [ analog_expression ] } ) ]
//
// but only the function's own clause can say what an empty slot means.
// §9.17.3 Syntax 9-12 gives `$limit` three forms; the two that take more than
// one argument put a string or an analog_function_identifier second, and
// neither leaves that position empty. So `$limit(V(p,n), , vte, vcrit)` names
// no algorithm and no function, and the empty slot has no value: E0894.
// Before 2026-10-08 VerA crashed here (index out of bounds on the empty node);
// found by the Annex A grammar oracle (specification/TESTING.md L5c).
//
// The neighbour is the same module with the algorithm written.
//
//! lrm 9.17.3
//! lrm A.8.2
//! reject-only E0894
//! neighbour limit_omitted_algorithm_neighbour.va
module ch09_limit_omitted_algorithm_rejected(p, n);
  inout p, n; electrical p, n;
  real vd;
  analog begin
    vd = $limit(V(p,n), , 0.025, 0.6);
    I(p,n) <+ 1e-14 * (exp(vd / 0.025) - 1.0);
  end
endmodule
