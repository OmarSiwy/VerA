// §9.21's rule on repeated sample points, quoted in full:
//
//   "Within the data set, each point shall be distinct in terms of its
//    independent variable values. If there are two or more data points with the
//    same independent AND dependent values, then the duplicates shall be
//    ignored and the tool may generate a warning. If there are two or more data
//    points with the same independent values but DIFFERENT dependent values
//    then an error is generated."
//
// WHAT THE CLAUSE DOES NOT SAY, AND WHAT THIS FILE THEREFORE DOES NOT ASSERT
// (corrected after review). "an error is generated" fixes no diagnosis point.
// An earlier revision of this file required the error to be DEFERRED to the
// second sweep point and built the conflicting table out of four literals, so
// an implementation that folded that constant array and refused the model at
// elaboration — equally conformant, and the cheaper thing to write — failed the
// fixture. That is the class of defect where the easy way to green is to make
// the compiler worse, so the timing requirement is gone.
//
// It is replaced by data that removes the choice instead of legislating it: the
// conflicting dependent below is `94.0 + V(p,n)`, a function of a solution
// variable. No implementation can know at elaboration whether the two points at
// x = 1 conflict, because their dependents are not known then; and it may not
// refuse on the independents alone, because on the independents alone the
// BENIGN table is identical and §9.21 says those duplicates "shall be ignored".
// So every conformant tool reaches the same place: the check happens when the
// data source is captured, §9.21.1's "first call to the table model function",
// and the run ends there. `//! exit 1` (VerA floors a fatal status at 1) is
// then the only expressible outcome, not a choice between two.
//
// BENIGN, both sweep points:
//
//     x = 0, 1, 1, 2     f = 0, 10, 10, 20
//
//   The repeated (1, 10) is a true duplicate and is dropped, leaving the three
//   distinct samples (0,0), (1,10), (2,20). Linear interpolation then gives
//
//       f(1.5) = 10 + 0.5*(20 - 10) = 15
//       f(1.0) = the surviving sample                = 10
//
//   A tool that kept both copies has two samples with the same abscissa; the
//   interval between them has zero width, and the lookup at 1.5 either divides
//   by that zero or brackets the wrong pair. These two assertions PASS AT HEAD
//   (see tests/fixtures/ch09_system_tasks/a05_SPEC.md at 8b1514d4) — they are the half of §9.21's duplicate rule VerA already
//   satisfies, and this file claims no pressure from them.
//
// CONFLICTING, reached at the second sweep point:
//
//     x = 0, 1, 1, 2     f = 0, 10, 94 + V(p,n), 20
//
//   The guard is false at V(p,n) = 1.0 and true at V(p,n) = 5.0, where the
//   fourth sample reads 99.0 against the second's 10.0 at the same abscissa.
//   The guard is here for §9.21.1's reason, not for the error's: an unexecuted
//   site makes no first call and so captures nothing (that rule is pinned on
//   its own in 08). Its side effect is a clean point-0 transcript — both `ok=1`
//   lines print at the first sweep point and again at the second, before the
//   guarded site runs — so a tool that silently accepted the conflict exits 0
//   and fails the status check with four passing assertions above it, which is
//   exactly what HEAD does today.
//
//! lrm 9.21
//! lrm 9.21:6
//! lrm 9.21:7
//! lrm 9.21:1001
//! lrm 9.21.1
//! exit 1
//! sweep V(p) = 1.0, 5.0
`include "check.vh"
module a05_duplicate_points(p, n);
  inout p, n; electrical p, n;
  real gx[0:3], gf[0:3], bx[0:3], bf[0:3], bad;
  analog begin
    gx[0] = 0.0; gf[0] =  0.0;
    gx[1] = 1.0; gf[1] = 10.0;
    gx[2] = 1.0; gf[2] = 10.0;
    gx[3] = 2.0; gf[3] = 20.0;
    `CHECKX("an identical duplicate point is ignored, not treated as a second sample",
            $table_model(1.5, gx, gf), 15.0);
    `CHECKX("the surviving sample is returned at its own abscissa",
            $table_model(1.0, gx, gf), 10.0);
    bx[0] = 0.0; bf[0] =  0.0;
    bx[1] = 1.0; bf[1] = 10.0;
    // Not foldable: the conflict is invisible until the solution is known, so
    // no conformant implementation can diagnose it before the site runs.
    bx[2] = 1.0; bf[2] = 94.0 + V(p, n);
    bx[3] = 2.0; bf[3] = 20.0;
    bad = 0.0;
    // False at the first sweep point: the conflicting table is not captured and
    // not diagnosed until this site actually executes (§9.21.1).
    if (V(p, n) > 3.0) bad = $table_model(1.5, bx, bf);
    I(p, n) <+ V(p, n) + bad;
  end
endmodule
