// §9.13: "Verilog-AMS HDL extends the probabilistic distribution functions so
// that they are supported in the analog context." Table 9-10 lists all 17 names
// and every row reads `Yes  Yes` — digital context AND analog context. So this
// file must COMPILE and run green; a compiler that refuses the call is the one
// that is wrong, which is why the expectation is a run and not a reject.
//
// The seed "may be omitted, in which case the simulator picks a seed", so
// repeatability is NOT claimable here and is not asserted. What survives is the
// printed example of §9.13.1: "Where b > 0, the expression ($random % b) gives
// a number in the following range: [(-b+1) : (b-1)]" — for b = 60, -59..59.
// That holds for whatever seed the simulator picked.
//
// WHAT THIS FIXTURE CAN AND CANNOT PROVE. With no seed variable there is no
// inout to observe, and §9.13.1 fixes NOTHING else about the returned value —
// "it may be omitted, in which case the simulator picks a seed", so neither a
// digit nor a repetition is claimable. The one sentence left with content is the
// width: "the random number returned is a 32-bit signed integer; it can be
// positive or negative." That is the check below, and it is the weakest in the
// chapter: it is falsifiable only on a host whose integer type is wider than 32
// bits (VerA carries integers in i64 — see the width note in
// 07_file_open_close.va), and satisfied for free where `integer` is exactly 32.
//
// It is deliberately NOT the chapter's old `($random % 60) is in [-59,59]`.
// §9.13.1 does print that example, but as an assertion it is EMPTY: a % 60 lies
// in [-59,59] for every integer a of every width, including 0, so it cannot fail
// under any implementation. Dressing an identity as a check is worse than
// admitting the clause pins nothing.
//
// The discriminating checks for this family are elsewhere and are cited here so
// the gap is not silent: 32_random.va / 33_arandom.va pin the inout seed rule
// ("a value is passed to the function and a different value is returned") and
// 117_arandom_parameter_seed.va pins the parameter form that must NOT be
// updated.
//
//! lrm 9.13.1
//! xfail VerA refuses the whole §9.13 probabilistic family with E0801 rather than stubbing a seeded RNG stream; Table 9-10 marks every one of the 17 names analog-context Yes
`include "check.vh"
module ch09_random_no_seed(p, n);
  inout p, n; electrical p, n;
  integer a;
  analog begin
    a = $random;
    `CHECKI("§9.13.1 the result is a 32-bit SIGNED integer",
            (a >= -2147483648) && (a <= 2147483647), 1);
    I(p,n) <+ V(p,n) + a;
  end
endmodule
