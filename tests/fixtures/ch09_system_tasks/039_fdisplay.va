// §9.5.2: $fdisplay is $display with one extra leading argument, "either a
// multichannel descriptor or a file descriptor". §9.5.1 says what $fopen hands
// back when a type argument is present: "The most significant bit (bit 31) of a
// fd is reserved and shall always be set", and a zero is returned ONLY if the
// file cannot be opened. Type "a" is "Append; open for writing at end of file,
// or create for writing" (Table 9-24), so this open cannot fail for want of an
// existing file: a conforming $fopen returns a descriptor whose bit 31 is 1.
//
// The second check pins the argument the task formats: §1.3.1 makes V(p,n) the
// node difference, 1.25 - 0.25 = 1.0 V, exact in binary floating point.
//
//! bias V(p) = 1.25, V(n) = 0.25
//! lrm 9.5.1
//! lrm 9.5.2
//! xfail VerA has no file-descriptor surface: codegen.zig `void_tasks` lowers the whole §9.5 family to the constant `S.con(0.0)`, so $fopen answers 0 (bit 31 clear) and $fdisplay writes nothing. lower.zig:2362 records the reason — the file family is kept out of `isDisplayTask` because "it needs a descriptor the compiled device has no way to own"
`include "check.vh"
module ch09_atomic_fdisplay(p, n);
  inout p, n; electrical p, n;
  integer fd;
  analog begin
    fd = $fopen("ch09_039_fdisplay.log", "a");
    // Masked, not shifted: `>>` fills with zeros on a 32-bit integer but VerA
    // carries integers in an i64, where a sign-extended fd would answer a shift
    // differently. `& 2147483648` is bit 31 whatever the width, so this pins
    // §9.5.1 and not the shift's word size.
    `CHECKI("bit 31 of an fd is always set", (fd & 2147483648) != 0, 1);
    `CHECK("the %g argument is the branch potential", V(p,n), 1.0, 1e-15);
    $fdisplay(fd, "value=%g", V(p,n));
    I(p,n) <+ V(p,n);
  end
endmodule
