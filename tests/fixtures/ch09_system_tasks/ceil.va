// LRM 9.14 / Table 4-14: $ceil is an alias of the 4.3.1 operator ceil, which
// rounds towards PLUS infinity. ceil(1.1) is 2; ceil(-1.1) is -1, which is the
// case that distinguishes it from rounding away from zero.
//
//! lrm 9.14
`include "check.vh"
module ch09_atomic_ceil(p, n);
  inout p, n; electrical p, n;
  analog begin
    `CHECKX("$ceil(1.1)", $ceil(1.1), 2.0);
    `CHECKX("$ceil rounds up, not away from zero", $ceil(-1.1), -1.0);
    I(p,n) <+ V(p,n) + $ceil(1.1);
  end
endmodule
