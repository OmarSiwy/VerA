// §9.21.4 QUADRATIC SPLINE, Table 9-30 character `2`.
//
//   "Quadratic splines are similar to cubic splines, offering more efficient
//    evaluation with generally less favorable interpolation results. Again one
//    should attempt to avoid end point discontinuities, though it is not always
//    possible in this case."
//
// WHAT "not always possible" IS. Over k intervals a C1 quadratic spline has 3k
// coefficients and 2k + (k-1) = 3k-1 interpolation/continuity constraints, so
// exactly ONE end condition can be imposed — unlike the cubic, which takes one
// at each end (§9.21.4: "the desired derivative of the interpolation function
// at BOTH end points must be specified"). The clause's "not always possible" is
// that arithmetic: one of the two ends keeps its first-derivative jump.
//
// WHY THIS FILE WRITES NO DIGITS FOR THE INTERIOR VALUES (corrected after
// review). §9.21.4 never says WHICH end gets the single condition, and both
// answers are defensible. On x = {0,1,2}, f = {0,1,4} with "2CL":
//
//   reading A — the condition goes to the LOW end, so `C` forces S'(0) = 0:
//       [0,1]  S = x^2            [1,2]  S = 1 + 2u + u^2 = x^2   (u = x-1)
//       S(0.5) = 0.25   S(1.5) = 2.25   S'(2) = 4   f(3) = 8
//
//   reading B — the condition goes to the HIGH end, so `L` forces S'' = 0 on
//   the last interval (the extrapolant and the last segment are one line):
//       [1,2]  S = 1 + 3u        [0,1]  S = -x + 2x^2
//       S(0.5) = 0.00   S(1.5) = 2.50   S'(2) = 3   f(3) = 7
//       and S'(0) = -1, so it is the LOW end that keeps the jump here.
//
// A plain local-quadratic scheme (fit the three samples with one parabola, no
// end condition at all) gives yet a third set. An earlier revision of this file
// wrote reading A's digits — 0.25, 2.25, 8, and 1.0 for the two-sample form —
// as if the clause settled it. It does not, so those five wants are withdrawn;
// tests/fixtures/ch09_system_tasks/a05_SPEC.md at 8b1514d4's "Deliberately NOT covered" says what would bring them back.
//
// WHAT IS LEFT IS NOT NOTHING. Everything below holds under A, under B, and
// under any scheme that is a C1 quadratic spline honouring Table 9-31, and it
// still separates `2` from every other character in Table 9-30:
//
//   (1) the samples are reproduced exactly at their own abscissae;
//   (2) the first derivative is continuous ACROSS THE INTERIOR KNOT — the
//       property that makes the constraint count above come out at 3k-1, and
//       the property a linear interpolation (slopes 1 then 3 at x = 1) does not
//       have;
//   (3) the scheme is QUADRATIC, not cubic, and not a discrete lookup: the
//       third divided difference inside one segment vanishes identically. A
//       cubic spline on this same data with the same end characters solves to
//       M0 = 12/7, M1 = 18/7, M2 = 0, so S''' = (M2-M1)/h = -18/7 on [1,2] and
//       the third difference below would read h^3*S''' = 0.008*(-18/7) =
//       -0.0206. Closest-point lookup on the same four abscissae reads
//       4 - 3*4 + 3*1 - 1 = -6. Both are many orders outside the band;
//   (4) `C` at the low end "returns the table endpoint value" (Table 9-31),
//       which IS a number the clause writes down: 0.0, at any distance;
//   (5) `L` at the high end "extends linearly ... using a slope consistent with
//       the selected interpolation method" (Table 9-31) — so the extrapolant's
//       second difference is zero (a quadratic continuation would read 2 there)
//       and its slope is the spline's own end slope, not the secant of the last
//       two samples (which is 3, and under reading A the end slope is 4). The
//       VALUE of that slope is reading-dependent, so it is asserted as the
//       identity S'(2+) = S'(2-) rather than as digits.
//
// The two identities in (2) and (5) are one-sided difference quotients with
// h = 1e-5. Their exact residual is h*(S''(left) + S''(right))/2, and |S''| is
// at most 4 under either reading, so the residual is at most 4e-5; the 1e-3
// band is 25x that and still 2000x below the 2.0 gap a linear interpolation
// leaves at the knot. `CHECKEQ` is used because the clause states these as
// identities with no value to write down.
//
// TWO SAMPLES. x = {0,2}, f = {0,4} with "2CL" is §9.21's minimum data
// requirement ("at least two points per dimension") under a quadratic control
// character: one interval, three coefficients, two interpolation conditions and
// one free condition. Reading A gives f(1) = 1, reading B degenerates the
// segment to a straight line and gives 2, so no interior digit is written. What
// is asserted is that the call is LEGAL and still reproduces its samples —
// today the whole file is refused at compile time by E0815 because `2` is not
// implemented, which is the pressure this fixture exists to apply.
//
//! lrm 9.21
//! lrm 9.21.2
//! lrm 9.21.4
//! lrm 9.21.2:2
`include "check.vh"
module a05_quadratic_spline(p, n);
  inout p, n; electrical p, n;
  real xs[0:2], fs[0:2], xt[0:1], ft[0:1];
  real h, lo, hi;
  analog begin
    xs[0] = 0.0; fs[0] = 0.0;
    xs[1] = 1.0; fs[1] = 1.0;
    xs[2] = 2.0; fs[2] = 4.0;
    h = 1e-5;

    // (1) Interpolation at the knots. Exact under every reading.
    `CHECKX("the low endpoint sample is returned exactly",
            $table_model(0.0, xs, fs, "2CL"), 0.0);
    `CHECKX("the interior knot sample is returned exactly",
            $table_model(1.0, xs, fs, "2CL"), 1.0);
    `CHECKX("the high endpoint sample is returned exactly",
            $table_model(2.0, xs, fs, "2CL"), 4.0);

    // (2) C1 across the interior knot. Linear interpolation gives 1 vs 3 here.
    lo = ($table_model(1.0, xs, fs, "2CL") - $table_model(1.0 - h, xs, fs, "2CL")) / h;
    hi = ($table_model(1.0 + h, xs, fs, "2CL") - $table_model(1.0, xs, fs, "2CL")) / h;
    `CHECKEQ("the slope is continuous across the interior knot", lo, hi, 1e-3);

    // (3) Quadratic, not cubic: third difference inside [1,2] with spacing 0.2.
    `CHECK("the third difference vanishes inside a segment: the pieces are quadratic",
           $table_model(1.7, xs, fs, "2CL") - 3.0 * $table_model(1.5, xs, fs, "2CL")
             + 3.0 * $table_model(1.3, xs, fs, "2CL") - $table_model(1.1, xs, fs, "2CL"),
           0.0, 1e-9);

    // (4) `C` low end: "the constant extrapolation method returns the table
    //     endpoint value" — a number Table 9-31 does supply.
    `CHECKX("low end is constant: the endpoint value, just outside",
            $table_model(-1.0, xs, fs, "2CL"), 0.0);
    `CHECKX("low end is constant: the same value far outside",
            $table_model(-1000.0, xs, fs, "2CL"), 0.0);

    // (5) `L` high end: linear, anchored on the spline's own end slope.
    `CHECK("the high-end extrapolant is LINEAR: its second difference is zero",
           $table_model(4.0, xs, fs, "2CL") - 2.0 * $table_model(3.0, xs, fs, "2CL")
             + $table_model(2.0, xs, fs, "2CL"),
           0.0, 1e-9);
    lo = ($table_model(2.0, xs, fs, "2CL") - $table_model(2.0 - h, xs, fs, "2CL")) / h;
    hi = ($table_model(2.0 + h, xs, fs, "2CL") - $table_model(2.0, xs, fs, "2CL")) / h;
    `CHECKEQ("the extrapolation slope is the spline's end slope, not the last secant",
             lo, hi, 1e-3);

    // TWO SAMPLES: legal, and its own samples are still exact.
    xt[0] = 0.0; ft[0] = 0.0;
    xt[1] = 2.0; ft[1] = 4.0;
    `CHECKX("a two-sample table is legal under a quadratic control character (low)",
            $table_model(0.0, xt, ft, "2CL"), 0.0);
    `CHECKX("a two-sample table is legal under a quadratic control character (high)",
            $table_model(2.0, xt, ft, "2CL"), 4.0);
    I(p, n) <+ V(p, n);
  end
endmodule
