// Digits and seeds from tests/rng_reference.c, compiled with -ffp-contract=off.
// Count 4097 must not be substituted by 4096. The Erlang product's infinity
// is the reference algorithm's underflow result, not a finite approximation.
//! lrm 9.13.3
//! lrm 9.13.3:1000
`include "check.vh"
module ch09_rng_reference_large_count(p, n);
  inout p, n; electrical p, n;
  integer seed;
  real r;
  analog begin
    seed = 7;
    r = $rdist_chi_square(seed, 4097);
    `CHECKR("chi-square above former cap", r, 4015.20344480726, 2e-14);
    `CHECKI("chi-square exact final seed", seed, -1470156349);
    seed = 7;
    r = $rdist_t(seed, 4097);
    `CHECKR("t above former cap", r, 0.71332480625867889, 2e-14);
    `CHECKI("t exact final seed", seed, 1194846217);
    seed = 7;
    r = $rdist_erlang(seed, 4097, 3);
    `CHECKI("reference Erlang product underflows", r > 1e300, 1);
    `CHECKI("Erlang exact final seed", seed, -767029092);
    I(p,n) <+ V(p,n);
  end
endmodule
