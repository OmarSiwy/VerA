// §9.13.1:4: "If the call to $random is within the digital context it may be a
// reg, integer, or time variable." The sentence is a permission about the
// SEED argument's type, so the fixture exercises all three and asserts that
// each is a real inout seed rather than a read-only snapshot.
//
// THE DIGITS ARE 171_random_ieee1364_digits.va's, from the IEEE 1364-2005
// §17.9.3 listing: seed 7 draws -2146999808 and is updated to 69069*7+1 =
// 483484. That fixture does the derivation in the analog context; this one
// crosses only the context boundary the row names, so the same listing values
// are the oracle for every seed kind.
//
// The written-back seed is the second check per kind: a tool that accepted a
// reg or time seed but only read it (no inout write-back) returns the right
// first draw and leaves the seed at 7, which is what the seed check rejects.
//
//! lrm 9.13.1
//! lrm 9.13.1:4
//! analysis tran
//! time 0, 10n
//! checks 6
`timescale 1ns/1ns
`include "disciplines.vams"
`include "check.vh"
module ch09_random_digital_context_seed_kinds(p, n);
  inout p, n; electrical p, n;
  reg [31:0] sr;
  integer si, a, b, c;
  time ts;
  initial begin
    sr = 7;
    a = $random(sr);
    si = 7;
    b = $random(si);
    ts = 7;
    c = $random(ts);
    #1;
    `CHECKI("a reg seed in the digital context draws the listing's value", a, -2146999808);
    `CHECKI("and the reg is written back with the listing's seed", sr, 483484);
    `CHECKI("an integer seed draws the same stream", b, -2146999808);
    `CHECKI("and its inout write-back lands", si, 483484);
    `CHECKI("a time seed carries the same stream", c, -2146999808);
    `CHECKI("and its inout write-back lands", ts, 483484);
  end
  analog I(p, n) <+ V(p, n);
endmodule
