// §9.20: "If a particular node is involved in multiple calls to either system
// function, then the last evaluated call shall take precedence."
//
// `30_node_alias_calls.va` writes two calls and says in its own header that it
// does NOT test this rule: both of its references fail to resolve, so both
// aliases are the same non-event and the two orders are indistinguishable. This
// file is the input that tells them apart — both references resolve, to two
// DIFFERENT nodes held at two different potentials, so the reading of `V(n1)`
// names which call won.
//
// The clause's own example writes exactly this shape and says so in a comment:
// "even though n1 was assigned a valid alias to top.gnd, this one to top.a will
// take precedence."
//
// 2.0 is `b`'s bias and 5.0 is `a`'s. A compiler that kept the FIRST alias
// reads 5.0; one that performed neither reads 0.
//
//! lrm 9.20
//! lrm 9.20:14
//! lrm 9.20:10
//! bias V(a) = 5.0, V(b) = 2.0, V(g) = 0.0
`include "check.vh"

module ch9_alias_last_top(a, b, g);
  inout a, b, g; electrical a, b, g;
  ch9_alias_last_checker ch1();
  analog begin
    I(a, g) <+ V(a, g) / 1000.0;
    I(b, g) <+ V(b, g) / 1000.0;
  end
endmodule

module ch9_alias_last_checker;
  electrical n1;
  integer first, second;
  analog initial begin
    first  = $analog_node_alias(n1, "ch9_alias_last_top.a");
    second = $analog_node_alias(n1, "ch9_alias_last_top.b");
  end
  analog begin
    `CHECKI("both references resolve, so both calls return 1", first + second, 2);
    `CHECKX("and the LAST of the two is the alias the node keeps", V(n1), 2.0);
  end
endmodule
