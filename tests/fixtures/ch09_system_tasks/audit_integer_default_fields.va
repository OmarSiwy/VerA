// IEEE 1364-2005 17.1.1.3: "When displaying decimal values, leading zeros
// are suppressed and replaced by spaces." Automatic sizing uses the largest
// value representable by the expression; AMS 9.4.3 gives bare operands the
// default decimal format, and 9.5.3 supplies the string-output observation.
// Explicitly sized unsigned 12-bit literals avoid assuming an implementation's
// width for integer declarations or unsized constants. Maximum 4095 needs four
// decimal columns; 7 therefore needs three spaces and 42 needs two. The hex
// width is three digits: 12'd10 -> 00a. %0d overrides automatic sizing -> 10.
// The leading/trailing bare-operand cases retain claims withdrawn from 170;
// argument-run separation there now uses explicit minimal-width conversions.
//! lrm 9.4.3
//! lrm 9.5.3
//! print none
//! checks 5
//! xfail FMT-WIDTH-001: analog integer formatting omits inherited automatic fields
`include "check.vh"
module audit_integer_default_fields(p, n);
  inout p, n; electrical p, n;
  string text;
  analog begin
    $sformat(text, "[%d]", 12'd7);
    `CHECKI("decimal field is sized for all 12-bit values", text == "[   7]", 1);
    $sformat(text, 12'd7, " then %0d", 3);
    `CHECKI("leading bare operand uses default decimal field", text == "   7 then 3", 1);
    $sformat(text, "v:", 12'd42);
    `CHECKI("unconsumed operand retains default field", text == "v:  42", 1);
    $sformat(text, "%h", 12'd10);
    `CHECKI("hexadecimal field retains leading zero digits", text == "00a", 1);
    $sformat(text, "%0d", 12'd10);
    `CHECKI("explicit minimum-width conversion removes padding", text == "10", 1);
    I(p,n) <+ V(p,n);
  end
endmodule
