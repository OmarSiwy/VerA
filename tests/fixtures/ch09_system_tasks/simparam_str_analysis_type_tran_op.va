// §9.15 Table 9-28: "analysis_type" is "the type of the current analysis
// (e.g., dc, tran, ac)". Which type the operating point that opens a
// transient has is not stated; VerA answers the §4.6.1 Table 4-21 name of
// the analysis the point evaluates as (specification/Vague_Decisions.md
// VD-118, #67). Table 4-21: "ic" is "the initial-condition analysis which
// precedes a transient analysis", and every host evaluates a transient's
// t = 0 point as "ic" (#53, tran_op_is_ic_and_static.va). So by hand:
//
//     t = 0   "ic"    (the TRAN OP)
//     t = 1n  "tran"  (a Tran point)
//
// Each check's want is the time test, an integer (§4.2.5); §3.3.1 makes the
// string comparison an integer too. The wrong implementation this catches:
// "tran" at every point, which fails both checks at t = 0.
//
// Checks: 2 per point x 2 points = 4.
//
//! lrm 9.15
//! analysis tran
//! time 0, 1n
//! checks 4
`include "check.vh"
module ch09_simparam_str_analysis_type_tran_op(p, n);
  inout p, n; electrical p, n;
  string at;
  analog begin
    at = $simparam$str("analysis_type");
    `CHECKI("analysis_type is \"ic\" at the TRAN OP (VD-118)", at == "ic", $abstime == 0);
    `CHECKI("analysis_type is \"tran\" at a Tran point", at == "tran", $abstime != 0);
    I(p, n) <+ V(p, n);
  end
endmodule
