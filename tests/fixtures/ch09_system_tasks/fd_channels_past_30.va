// §9.5.1 limits only the multichannel descriptor: "The most significant bit
// (bit 31) of a multichannel descriptor is reserved and shall always be
// cleared, limiting an implementation to at most 31 files opened for output
// via multichannel descriptors." A file descriptor is another shape: "The
// file descriptor fd is a 32-bit value. The most significant bit (bit 31) of
// a fd is reserved and shall always be set; this allows implementations of the
// file input and output functions to determine how the file was opened. The
// remaining bits hold a small number indicating what file is opened." VerA
// used to share one 30-channel table between the two; file descriptors now
// have their own, as many as memory holds (#29), while the mcd keeps its 30
// (222_mcd_channels_exhausted_at_bit_31.va).
//
// HAND DERIVATION. 40 files are opened as file descriptors and held open:
// each open succeeds (nonzero) and they are 40 different values. With all 40
// open, 30 more are opened as mcds: each is a single bit above bit 0, the 30
// bits 1..30 (their OR is 32'h7FFF_FFFE = 2147483646), and the 31st mcd open
// still returns 0: the file descriptors neither take nor add mcd channels.
// Then descriptor k (k = 1..40) writes k and is read back: the sum of what is
// read is 1 + ... + 40 = 820.
//
//! lrm 9.5.1
//! lrm 9.5.1:1
//! lrm 9.5.1:2
//! bias V(p) = 0
//! checks 6
`include "check.vh"
module fd_channels_past_30(p, n);
  inout p, n; electrical p, n;
  integer k, j, fd[1:40], m, all, singles, extra, fds_set, distinct, sum, v, r;
  string name;
  analog begin
    @(initial_step) begin
      fds_set = 0;
      distinct = 0;
      for (k = 1; k <= 40; k = k + 1) begin
        $sformat(name, "fd_past_30_%0d.dat", k);
        fd[k] = $fopen(name, "w");
        if (fd[k] != 0) fds_set = fds_set + 1;
      end
      for (k = 1; k <= 40; k = k + 1) begin
        v = 1;
        for (j = 1; j < k; j = j + 1)
          if (fd[j] == fd[k]) v = 0;
        distinct = distinct + v;
      end
      all = 0;
      singles = 0;
      for (k = 1; k <= 30; k = k + 1) begin
        $sformat(name, "fd_past_30_mcd_%0d.log", k);
        m = $fopen(name);
        if (m > 1 && (m & (m - 1)) == 0) singles = singles + 1;
        all = all | m;
      end
      extra = $fopen("fd_past_30_mcd_31.log");
      $fclose(all);
      for (k = 1; k <= 40; k = k + 1) begin
        $fwrite(fd[k], "%0d\n", k);
        $fclose(fd[k]);
      end
      sum = 0;
      for (k = 1; k <= 40; k = k + 1) begin
        $sformat(name, "fd_past_30_%0d.dat", k);
        r = $fopen(name, "r");
        j = $fscanf(r, "%d", v);
        sum = sum + v;
        $fclose(r);
      end
    end
    `CHECKI("40 file descriptors open at once", fds_set, 40);
    `CHECKI("and 40 different ones", distinct, 40);
    `CHECKI("30 mcds open beside them, bits 1..30", all, 2147483646);
    `CHECKI("each a single bit", singles, 30);
    `CHECKI("the 31st mcd still fails", extra, 0);
    `CHECKI("every descriptor reads back what it wrote", sum, 820);
    I(p, n) <+ V(p, n);
  end
endmodule
