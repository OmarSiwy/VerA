// §9.15: "If param_name is known, its value is returned." The list is open:
// "There is no fixed list of simulation parameters. ... Simulators can also
// accept other strings to access the same parameters."
//
// VerA knows "reltol", "abstol" and "vntol" (specification/Vague_Decisions.md, §9.15):
// SPICE's `.options` Newton tolerances, whose value is the host's. A host
// writes each as a Model field (tools/contract.zig `host_model_fields`) before
// `derive`. `//! param` writes Model fields at exactly that point, so here it
// stands in for the host, with values no default has: 2.5e-4, 3e-11, 4e-5.
//
// Known, so the host's value is returned. The fallback expression is returned
// only "if param_name is not known", so $simparam("reltol", 0.5) is 2.5e-4 as
// well, not 0.5. A §3.4 parameter default reads the same value, since `derive`
// computes `rt` after the host's write. Each value is the f64 the host wrote,
// passed through untouched, hence CHECKX: 5 checks.
//
// The invalid neighbour is simparam_spice_option_not_known_rejected.va: a SPICE
// option VerA does not publish ("chgtol") is still E0811.
//! lrm 9.15
//! param reltol__ = 2.5e-4, abstol__ = 3e-11, vntol__ = 4e-5
//! print none
//! checks 5
`include "check.vh"
module ch09_simparam_newton_tolerances_host_written(p, n);
  inout p, n; electrical p, n;
  parameter real rt = $simparam("reltol");
  analog begin
    `CHECKX("reltol is the host's", $simparam("reltol"), 2.5e-4);
    `CHECKX("abstol is the host's", $simparam("abstol"), 3e-11);
    `CHECKX("vntol is the host's", $simparam("vntol"), 4e-5);
    `CHECKX("a known name ignores its fallback", $simparam("reltol", 0.5), 2.5e-4);
    `CHECKX("a parameter default reads the host's value", rt, 2.5e-4);
    I(p,n) <+ V(p,n);
  end
endmodule
