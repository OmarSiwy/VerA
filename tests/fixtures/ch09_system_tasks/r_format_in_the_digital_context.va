// §9.4.7, in full: "For $strobe, $display, $write, and $monitor: the %r (or
// %R) format specifier may be used on real expressions in the digital
// context." §9.5.2 extends every display permission to the file twins —
// "$fdisplay, $fwrite, $fmonitor, $fstrobe ... accept the same type of
// arguments as the tasks upon which they are based" — so `$fwrite(fd, "%r",
// x)` in an `initial` block is the clause's case with a file as the sink.
//
// WHAT %r PRINTS. §9.4.3 Table 9-23: "%r or %R  Display 'real' in engineering
// notation, using the scale factors defined in 2.6.2". §2.6.2 Table 2-1 gives
// K = 10^3 (and k, the same factor), so 1500.0 in engineering notation is the
// mantissa 1.5 and the scale factor for 10^3:
//
//   1500.0 = 1.5 * 10^3  ->  "1.5K"  (or "1.5k"; the clause picks no case)
//
// Both spellings are accepted, because §2.6.2 lists both letters for the same
// factor and §9.4.3 does not choose. What is NOT accepted is "1500" or
// "1.500000e+03": those are %f/%e, and a tool that ignored %r in this context
// (or refused it, as VerA's digital kernel did before this file — a run-time
// E1100 naming the conversions it had) fails the first check.
//
// HOW IT IS READ BACK. The `initial` block is the digital context (§7.2.2);
// it writes the file, and the analog block reads it in two independent ways:
//   - §9.5.4.1 `$fgets` returns the characters themselves; "1.5K" is 4
//     characters and no newline was written, so the count is 4;
//   - §9.5.4.2 `$fscanf` with %r — "Matches a 'real' number in engineering
//     notation, using the scale factors defined in 2.6.2" — turns the text
//     back into the real it came from, 1500.0 exactly (1.5 and 1000 are exact
//     binary values and their product is exact).
// The descriptor-sharing mechanics are 194_file_descriptor_shared_across_-
// contexts.va's, which asserts them on their own.
//
//! lrm 9.4.7
//! lrm 9.4.7:1
//! lrm 9.4.3
//! lrm 9.5.4.2
`include "check.vh"
module ch09_r_format_in_the_digital_context(p, n);
  inout p, n; electrical p, n;
  integer fd, rfd, count, items;
  string text;
  real back;
  initial begin
    fd = $fopen("ch09_217_r_format.log", "w");
    $fwrite(fd, "%r", 1500.0);
    $fclose(fd);
  end
  analog begin
    rfd = $fopen("ch09_217_r_format.log", "r");
    count = $fgets(text, rfd);
    $fclose(rfd);
    rfd = $fopen("ch09_217_r_format.log", "r");
    items = $fscanf(rfd, "%r", back);
    $fclose(rfd);
    `CHECKI("§9.4.7 %r in the digital context writes 1500.0 as 1.5 and the 10^3 scale factor",
            (text == "1.5K") || (text == "1.5k"), 1);
    `CHECKI("four characters, no newline", count, 4);
    `CHECKI("§9.5.4.2 %r matches the one item", items, 1);
    `CHECKX("and reads back the real that was written", back, 1500.0);
    I(p, n) <+ V(p, n);
  end
endmodule
