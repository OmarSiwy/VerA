// §9.20's positive half, the one `30`, `105` and `106` deliberately cannot
// reach: "If the hierarchical_reference_string references a valid continuous
// node, then the analog_net_reference will be aliased to that hierarchical node
// and shall refer to the same circuit matrix position."
//
// Those three files pass because their strings name an instance hierarchy that
// a single-module compilation does not have, so §9.20's "zero (0) otherwise"
// and a compiler that always answered zero are indistinguishable. Here the
// hierarchy EXISTS: `ch9_alias_top` instantiates `ch9_alias_checker`, and
// elaboration flattens the pair, so `ch9_alias_top.a` is a node of the design
// the alias is resolved against and the answer 1 is the only correct one.
//
// The two CHECKs are the clause's two halves and neither implies the other:
//
//   status == 1        "the return value ... shall be one (1) if the
//                       hierarchical_reference_string points to a valid
//                       continuous node";
//   V(n1) == V(a)      "shall refer to the same circuit matrix position" — the
//                       part that is topology and not a flag. `n1` is a local
//                       net of the child that nothing in the child drives, so
//                       without the alias it is an isolated node reading 0, and
//                       the 5 V here can only come from being the SAME unknown
//                       as `a`.
//
// The bias pins `a` rather than solving, for the reason `30` pins its own net:
// what is asserted is an identity between two names, and forcing one of them is
// the cleanest way to see the other move with it. `n1` is deliberately NOT
// biased — it no longer has a matrix position of its own to bias.
//
//! lrm 9.20
//! lrm 9.20:11
//! lrm 9.20:10
//! bias V(a) = 5.0, V(g) = 0.0
`include "check.vh"

module ch9_alias_top(a, g);
  inout a, g; electrical a, g;
  ch9_alias_checker ch1();
  analog begin
    I(a, g) <+ V(a, g) / 1000.0;
  end
endmodule

module ch9_alias_checker;
  electrical n1;
  integer status;
  analog initial begin
    status = $analog_node_alias(n1, "ch9_alias_top.a");
  end
  analog begin
    `CHECKI("a hierarchical reference that resolves returns 1", status, 1);
    `CHECKX("and the aliased net IS that node's matrix position", V(n1), 5.0);
  end
endmodule
