// §9.5.2: $fmonitor is $monitor against a descriptor. §9.4.1 says a $monitor
// reports "as if reported by the $strobe task" when an argument changes across
// an accepted step, so the value it would report is the argument at the
// operating point. §1.3.1 pins it: V(p,n) = 0.5 - 0.25 = 0.25 V, exact in
// binary floating point.
//
//! lrm 9.5.2
//! bias V(p) = 0.5, V(n) = 0.25
`include "check.vh"
module ch09_atomic_fmonitor(p, n);
  inout p, n; electrical p, n;
  integer fd;
  analog begin
    fd = $fopen("ch09_042_fmonitor.log", "a");
    `CHECK("the monitored value is the branch potential", V(p,n), 0.25, 1e-15);
    $fmonitor(fd, "value=%g", V(p,n));
    I(p,n) <+ V(p,n);
  end
endmodule
