//! lrm 9.21.1
//! analysis tran
//! time 0,1
// One snapshot per source table expression across function invocations is
// inferred from §§4.7 and 9.21.1; the LRM gives no explicit inlining example.
`include "check.vh"
module ch09_table_snapshot_function(p,n);
  inout p,n; electrical p,n,a;
  real xs[0:1], ys[0:1], first, second, skipped, early_row, late_row;
  analog function real lookup;
    input v;
    input [0:1]x,y;
    real v, x[0:1], y[0:1];
    begin
      lookup=$table_model(v,x,y);
    end
  endfunction
  analog function real guarded;
    input v;
    input [0:1]x,y;
    real v, x[0:1], y[0:1];
    begin
      guarded=$table_model(v,x,y);
    end
  endfunction
  analog function real row_order;
    input v;
    input [0:1]x,y;
    real v, x[0:1], y[0:1];
    begin
      row_order=$table_model(v,x,y);
    end
  endfunction
  analog function real future;
    input v;
    input [0:1]x,y;
    real v, x[0:1], y[0:1];
    begin
      future=$table_model(v,x,y);
    end
  endfunction
  analog begin
    xs[0]=0; xs[1]=1; ys[0]=0; ys[1]=2;
    first=lookup(0.5,xs,ys);
    ys[0]=100; ys[1]=102;
    second=lookup(0.5,xs,ys);
    `CHECKX("same table site inside function",second,1);
    xs[0]=0; xs[1]=1; ys[0]=0; ys[1]=2;
    if ($abstime>0) skipped=guarded(0.5,xs,ys);
    ys[0]=100;ys[1]=102;
    skipped=guarded(0.5,xs,ys);
    `CHECKX("skipped first call does not capture",skipped,101);
    ys[0]=0;ys[1]=2;
    late_row=row_order(0.5,xs,ys);
    ys[0]=100;ys[1]=102;
    early_row=row_order(0.5,xs,ys);
    `CHECKX("source order before contribution row order",early_row,1);
    ys[0]=10*$abstime;ys[1]=10*$abstime+2;
    if ($abstime==0) first=future(0.5,xs,ys);
    if ($abstime>0) begin
      second=future(0.5,xs,ys);
      `CHECKX("unused first call at earlier time",second,1);
    end
    I(p,n) <+ V(p,n)+second+early_row;
    I(a,n) <+ late_row;

  end
endmodule
