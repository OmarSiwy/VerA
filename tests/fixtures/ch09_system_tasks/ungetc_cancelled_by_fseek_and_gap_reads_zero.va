// §9.5.5 has two sentences about state that a position change owns:
//
//   "Any repositioning shall cancel any $ungetc operations."
//
//   "If the file is positioned beyond the end of the file and data are later
//    written at this point, subsequent reads of data in the gap shall return
//    zero until data are actually written into the gap."
//
// The first is asserted by making $ungetc work first and then moving: read
// 'A' (65), push back 'B' (ungetc returns 0), read the pushed-back 66 to prove
// it is live, push 66 back again, and then $fseek(fd, 0, 0). The next $fgetc
// must be 65 ('A'), not 66 ('B'): the reposition, not a no-op $ungetc, is what
// makes the difference. Without the middle read, a tool whose $ungetc does
// nothing would pass the cancellation check trivially.
//
// The second is asserted with a two-byte file "AB", a seek to offset 5 and a
// one-byte write "Z". Positions 2, 3 and 4 are in the gap and read as zero (not
// EOF: $fgetc returns -1 only past the end), and position 5 then returns 90.
// A tool that pads the gap with a fill byte, or that reads it as EOF, fails;
// the check is the SUM of the three gap bytes, which is zero exactly when all
// three are zero.
//
// WHY THIS IS A DIGITAL `initial`. Table 9-2 lists $fgetc and $ungetc as
// digital-context only ("Yes  No"), and 153_file_io_digital_only_analog_
// rejected.va pins that refusal. $fopen/$fwrite/$fseek/$fgetc/$ungetc all run
// on the executable's one descriptor table (§17.2, §9.5.1.2), so the same
// kernel bytes are read back here that the writes put down.
//
// WHY THE ANALOG BLOCK OPENS THE FILE. In a mixed model the one descriptor
// table is the DEVICE's, and the mixed runner hands it to the digital half only
// when the analog lowered form uses a §9.5 task. A model whose only file calls
// are in `initial` builds no table and every digital $fopen answers 0, so the
// @(initial_step) open/close below is what makes the table exist. Its result is
// ignored: the open may run before the digital block creates the file, and only
// the table's existence matters. 194_file_descriptor_shared_across_contexts.va
// asserts the sharing itself.
//
// A $strobe prints at the end of its time step, so the checks sit one tick
// after the file operations and `//! time` carries the run past that tick.
//
//! lrm 9.5.5
//! lrm 9.5.5:2
//! lrm 9.5.5:4
//! analysis tran
//! time 0, 10n
//! checks 10
`timescale 1ns/1ns
`include "disciplines.vams"
`include "check.vh"
module ch09_ungetc_cancelled_by_fseek_and_gap_reads_zero(p, n);
  inout p, n; electrical p, n;
  integer fd, afd, seek_eof, a, ungetc1, b, ungetc2, reposition, c;
  integer seek_gap, gap2, gap3, gap4, z;
  initial begin
    fd = $fopen("ch09_ungetc_gap.dat", "w");
    $fwrite(fd, "AB");
    seek_eof = $fseek(fd, 5, 0);
    $fwrite(fd, "Z");
    $fclose(fd);

    fd = $fopen("ch09_ungetc_gap.dat", "r");
    a = $fgetc(fd);
    ungetc1 = $ungetc(66, fd);
    b = $fgetc(fd);
    ungetc2 = $ungetc(66, fd);
    reposition = $fseek(fd, 0, 0);
    c = $fgetc(fd);
    seek_gap = $fseek(fd, 2, 0);
    gap2 = $fgetc(fd);
    gap3 = $fgetc(fd);
    gap4 = $fgetc(fd);
    z = $fgetc(fd);
    $fclose(fd);

    #1;
    `CHECKI("the seek past the end succeeds", seek_eof, 0);
    `CHECKI("the first byte is 'A'", a, 65);
    `CHECKI("$ungetc accepts the byte it pushes back", ungetc1, 0);
    `CHECKI("and the next read returns the pushed-back 'B'", b, 66);
    `CHECKI("$ungetc accepts the second pushback", ungetc2, 0);
    `CHECKI("the reposition succeeds", reposition, 0);
    `CHECKI("§9.5.5.2 the reposition cancelled the pushed-back 'B'", c, 65);
    `CHECKI("the seek into the gap succeeds", seek_gap, 0);
    `CHECKI("§9.5.5.4 the three gap bytes read as zero", gap2 + gap3 + gap4, 0);
    `CHECKI("and the byte written past the gap is 'Z'", z, 90);
  end
  analog begin
    @(initial_step) begin
      afd = $fopen("ch09_ungetc_gap.dat", "r");
      if (afd != 0) $fclose(afd);
    end
    I(p, n) <+ V(p, n);
  end
endmodule
