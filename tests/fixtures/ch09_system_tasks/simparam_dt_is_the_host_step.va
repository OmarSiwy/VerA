// §9.15: "There is no fixed list of simulation parameters. However,
// simulators shall accept the strings in Table 9-27". VerA also knows "dt"
// (specification/Vague_Decisions.md, §9.15): the host's `SimState.dt`, the step since
// the last accepted point, 0 in a static solve. It is the host's f64 itself,
// so a model can rebuild the host's previous time as `$abstime - dt` bit for
// bit (a host keying history on trunc((t - dt) * 1e12) needs exactly that).
//
// THE DERIVATION. The grid is non-uniform and dyadic, so every difference is
// exact in f64 and CHECKX can hold it:
//
//     t      0     0.5   1.5   1.75
//     dt     0     0.5   1.0   0.25     (t = 0 is the DC point: dt = 0)
//     t-dt   0     0     0.5   1.5      (the previous point)
//
// `dt` is the same at every Newton iteration of one timepoint, so a
// `(* vera_timepoint *)` statement may read it (no E0531): the cached copy is
// checked too. Three checks at four points: 12.
//
// No refusal: every analog context may read the step (an `analog initial`
// one sees the DC point's 0), so there is no invalid form to pin.
//! lrm 9.15
//! analysis tran
//! time 0, 0.5, 1.5, 1.75
//! checks 12
`include "check.vh"
module ch09_simparam_dt(p, n);
  inout p, n; electrical p, n;
  real cached;
  analog begin
    (* vera_timepoint *) cached = $simparam("dt");
    `CHECKX("dt is the host's step", $simparam("dt"),
            ($abstime == 0.5) ? 0.5 : ($abstime == 1.5) ? 1.0 : ($abstime == 1.75) ? 0.25 : 0.0);
    `CHECKX("a vera_timepoint statement reads it", cached,
            ($abstime == 0.5) ? 0.5 : ($abstime == 1.5) ? 1.0 : ($abstime == 1.75) ? 0.25 : 0.0);
    `CHECKX("t - dt is the previous point", $abstime - $simparam("dt"),
            ($abstime == 1.5) ? 0.5 : ($abstime == 1.75) ? 1.5 : 0.0);
    I(p, n) <+ V(p, n);
  end
endmodule
