// §9.19: "$param_given() function can be used to determine whether a parameter
// value was obtained from the DEFAULT VALUE IN ITS DECLARATION STATEMENT or if
// that value was OVERRIDDEN. ... The return value shall be one (1) if the
// parameter was overridden, either by a defparam statement or by a module
// instance parameter value assignment, and zero (0) otherwise."
//
// The rule is about the BINDING, not about the value. §9.19 says so at length
// in the paragraph that follows: "It is important to be able to distinguish the
// case where tdevice has its default value (say, 27) from the declaration
// statement from the case where the value 27 was in fact specified as an
// override" — the LRM's own example is an override that equals the default.
//
// So this fixture overrides `gain` with 1.0 against a declared default of 1.0
// and demands 1. An implementation that answers $param_given by comparing the
// resolved value against the default returns 0 here and passes every other
// $param_given fixture in the chapter: 103 overrides 2.0 against 1.0, 159
// overrides nothing. This is the input that separates a comparison from a flag.
//
//! lrm 9.19
//! lrm 9.19:4
//! param gain = 1.0
//! bias V(p) = 0.5
`include "check.vh"
module ch09_param_given_override_equals_default(p, n);
  inout p, n; electrical p, n;
  parameter real gain = 1.0;
  analog begin
    `CHECKI("§9.19 an override that equals the default is still an override",
            $param_given(gain), 1);
    `CHECKX("and the value in force is that same 1.0", gain * V(p,n), 0.5);
    I(p,n) <+ gain * V(p,n);
  end
endmodule
