// §9.5.4.1:
//
//   integer code;
//   code = $fgets( str, fd );
//
// "reads characters from the file specified by fd into the STRING VARIABLE,
// str until a newline character is read and transferred to str, or an EOF
// condition is encountered."
//
// The destination is named by its type: a string variable. A real cannot hold
// "characters ... until a newline", so `$fgets(r, fd)` asks for a transfer the
// clause does not define. The sibling rule is §9.5.3's "The first argument to
// $swrite shall be a string variable", which reject_9_5_3_swrite_into_real.va
// pins with the same code; with `r` declared `string` this file compiles
// (probed).
//
// VerA reports E0813 "`$fgets` writes into a `string` variable, and this one
// is real".
//
//! lrm 9.5.4.1
//! lrm 9.5.4.1:1000
//! reject-only E0813
//! neighbour 046_fgets.va
//! reject `$fgets` writes into a `string` variable, and this one is real
`include "disciplines.vams"
module ch09_fgets_into_real(p, n);
  inout p, n; electrical p, n;
  integer fd, code;
  real r;
  analog begin
    @(initial_step) begin
      fd = $fopen("ch09_201.dat", "r");
      code = $fgets(r, fd);              // illegal: str shall be a string variable
    end
    I(p, n) <+ V(p, n);
  end
endmodule
