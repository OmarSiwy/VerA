// §9.4.1: "$strobe provides the ability to display simulation data when the
// simulator has converged on a solution for all nodes." Its arguments are the
// converged state, so a branch flow it reads is the flow the block has
// contributed by the END of the cycle (§5.6.1.2 retention), wherever in the
// block the $strobe sits.
//
// Below, both strobes sit BEFORE the only contribution, `I(br) <+ 2.0`, so the
// converged flow of `br` is exactly 2.0 and both checks want 2.0, exact.
//
//   - The first reads `I(br)` directly: the control.
//   - The second reads it as an element of an A.8.1 assignment pattern, the
//     array actual of §4.7.2.3's `input` array argument, and `first` returns
//     element 0 unchanged. Same flow, same converged value: 2.0.
//
// A tool that evaluates the second operand where the statement stands (before
// the contribution) reads 0.0 — nothing is retained yet — and fails only the
// second check. VerA did: its "does this operand read a flow" scan did not look
// inside an assignment pattern.
//
//! lrm 9.4.1
//! lrm 5.6.1.2
//! lrm 4.7.2.3
//! lrm 5.6.1.2:1000
`include "check.vh"
module ch09_strobe_flow_read_in_pattern(p, n);
  inout p, n; electrical p, n;
  branch (p, n) br;
  analog function real first;
    input [0:1] a;
    real a[0:1];
    begin
      first = a[0];
    end
  endfunction
  analog begin
    `CHECKX("strobe reads the converged flow", I(br), 2.0);
    `CHECKX("also through an assignment-pattern actual", first('{I(br), 0.0}), 2.0);
    I(br) <+ 2.0;
  end
endmodule
