// AMS §9.5.4.2 assigns only successfully converted, nonsuppressed items.
// Destinations beyond the matched count retain prior int/real/string values.
// Count includes assignments, not suppressed fields or literal matches.
// Repeating a destination must preserve the most recent successful assignment
// when a later conversion fails: scanning "12 nope" writes shared=12 once.
//! lrm 9.5.4.2
//! lrm 9.5.4.2:4
//! lrm 9.5.4.2:5
//! checks 15
`include "check.vh"
module audit_scan_destination_preservation(p, n);
  inout p, n; electrical p, n;
  integer count, iv, shared;
  real rv;
  string sv;
  analog begin
    iv = 73; rv = 2.5; sv = "kept";
    count = $sscanf("bad", "tag=%d %f %s", iv, rv, sv);
    `CHECKI("literal mismatch count", count, 0);
    `CHECKI("integer retained", iv, 73);
    `CHECKX("real retained", rv, 2.5);
    `CHECKI("string retained", sv == "kept", 1);
    count = $sscanf("12 34 nope", "%*d %d %f %s", iv, rv, sv);
    `CHECKI("suppressed item does not count", count, 1);
    `CHECKI("first assigned item is 34", iv, 34);
    `CHECKX("failed real conversion retains destination", rv, 2.5);
    `CHECKI("unreached string retained", sv == "kept", 1);
    shared = 73;
    count = $sscanf("12 nope", "%d %d", shared, shared);
    `CHECKI("repeated destination retains successful first write", shared, 12);
    sv = "12 34";
    count = $sscanf(sv, "%s %d", sv, iv);
    `CHECKI("source alias scan count uses original input", count, 2);
    `CHECKI("source alias first destination", sv == "12", 1);
    `CHECKI("source alias second conversion uses original input", iv, 34);
    sv = "%s %d";
    count = $sscanf("word 56", sv, sv, iv);
    `CHECKI("format alias count uses original format", count, 2);
    `CHECKI("format alias first destination", sv == "word", 1);
    `CHECKI("format alias second conversion uses original format", iv, 56);
    I(p,n) <+ V(p,n);
  end
endmodule
