// §9.4.1 "$write provides the same capabilities as $strobe, but with no
// newline"; §9.4.3 Table 9-23 gives %r as engineering notation for a real.
// Neither changes the argument VALUE, which §1.3.1 pins:
// V(p,n) = 2.25 - 0.25 = 2.0 V, exact in binary floating point.
//
//! lrm 9.4.1
//! lrm 9.4.7
//! bias V(p) = 2.25, V(n) = 0.25
`include "check.vh"
module ch09_display_write(p, n);
  inout p, n; electrical p, n;
  analog begin
    `CHECK("the %r argument is the branch potential", V(p,n), 2.0, 1e-15);
    $write("no newline: %r", V(p,n));
    I(p,n) <+ V(p,n);
  end
endmodule
