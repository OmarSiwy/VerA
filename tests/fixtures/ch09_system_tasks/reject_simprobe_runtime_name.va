// §9.16: "The arguments inst_name and param_name are string values, either a
// string literal, string parameter, or a string variable." and "If either the
// inst_name or param_name cannot be resolved, and the optional expression is
// not supplied, then an error shall be generated. If the optional expression
// is supplied, its value will be returned in lieu of raising an error."
//
// Here inst_name is a string variable whose value the solution picks, so the
// name exists only when the analog block runs. "Cannot be resolved" is about
// whether the name exists, not when the tool learns it, and this name ("u_a")
// does exist; returning the fallback would be a wrong value with no
// diagnostic. VerA resolves names at compile time only, so it refuses the
// call with E0823, a named implementation limit (specification/Vague_Decisions.md
// VD-030, specification/Vague_Decisions.md §7), even though a fallback is supplied.
// Legal neighbour: simprobe_string_parameter_name_resolves.va, the same probe
// with the names in string parameters.
//
//! lrm 9.16
//! lrm 9.16:1
//! reject-only E0823
//! neighbour simprobe_string_parameter_name_resolves.va
`include "disciplines.vams"
module reject_simprobe_runtime_name(p, n);
  inout p, n;
  electrical p, n;
  reject_spr_dev #(.gain(3.0)) u_a(p, n);
  reject_spr_mon u_m(p, n);
endmodule

module reject_spr_dev(c, d);
  inout c, d;
  electrical c, d;
  parameter real gain = 1.0;
  analog I(c, d) <+ gain * V(c, d);
endmodule

module reject_spr_mon(c, d);
  inout c, d;
  electrical c, d;
  string inst;
  real got;
  analog begin
    inst = (V(c, d) > 0.0) ? "u_a" : "u_b";
    got = $simprobe(inst, "gain", -1.0);
    I(c, d) <+ got * V(c, d);
  end
endmodule
