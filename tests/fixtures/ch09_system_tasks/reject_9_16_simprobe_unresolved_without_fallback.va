// §9.16: "If either the inst_name or param_name cannot be resolved, and the
// optional expression is not supplied, then an error shall be generated. If
// the optional expression is supplied, its value will be returned in lieu of
// raising an error."
//
// The design has no instance called "nosuch", and no third argument is given,
// so the probe cannot resolve and there is nothing to return in lieu. The same
// call with a fallback, `$simprobe("nosuch", "gm", 1.0)`, compiles (probed),
// which is what makes the missing fallback the error and not the name.
//
// VerA reports E0817 "$simprobe resolves to nothing and has no fallback".
//
//! lrm 9.16
//! lrm 9.16:1
//! reject-only E0817
//! neighbour simprobe_string_parameter_name_resolves.va
`include "disciplines.vams"
module ch9_simprobe_unresolved(p, n);
  inout p, n;
  electrical p, n;
  real x;

  analog begin
    x = $simprobe("nosuch", "gm");    // illegal: unresolvable, no fallback
    I(p, n) <+ x * V(p, n);
  end
endmodule
