// AMS 9.4.3 gives real formats "the full formatting capabilities available
// in the C language"; 9.5.3 applies the display formatter to string output.
// See docs/conformance-display.md at 8b1514d4 for the C-source cross-check and the separate
// unresolved wording around %g. These cases use exactly representable 0.5
// and -0.5, so no decimal rounding-boundary choice affects the expected text.
// With four fractional digits, %e gives 5.0000e-01 (ten characters);
// width 12 adds two leading spaces. Width 2 cannot truncate the ten characters.
// With two fractional digits, %f gives 0.50 (four characters); width 7 adds
// three leading spaces. -0.50 has five characters, leaving two leading spaces.
// Direct string equality, not sscanf, detects missing padding/digits/exponent.
//! lrm 9.4.3
//! lrm 9.5.3
//! print none
//! checks 4
`include "check.vh"
module audit_real_format_fields(p, n);
  inout p, n; electrical p, n;
  string text;
  analog begin
    $sformat(text, "%12.4e", 0.5);
    `CHECKI("exponential field includes two leading spaces", text == "  5.0000e-01", 1);
    $sformat(text, "%2.4e", 0.5);
    `CHECKI("minimum width does not truncate exponent digits", text == "5.0000e-01", 1);
    $sformat(text, "%7.2f", 0.5);
    `CHECKI("fixed field includes three leading spaces", text == "   0.50", 1);
    $sformat(text, "%7.2f", -0.5);
    `CHECKI("negative sign occupies one field position", text == "  -0.50", 1);
    I(p,n) <+ V(p,n);
  end
endmodule
