// §9.21 Table Based Interpolation and Lookup. Table 9-18 marks $table_model
// `Yes  Yes`, so it is legal in the analog context and this file must compile
// and run green; a compiler that refuses the call is the one that is wrong,
// which is why the expectation is a run and not a reject.
//
//   table_model_function ::= $table_model ( table_inputs , table_data_source
//                                           [, table_control_string] )
//
// The data source is the LRM's OWN worked example, transcribed verbatim into
// ch09_table_model_2d.tbl: the §9.21.1 sample of f(x,y) = 0.5x + y on three
// isolines of y (0.0, 0.5, 1.0), laid out outermost-first as `y x f(x,y)` with
// the isoline ordinate repeated on every row.
//
// The lookup point is the LRM's own too. Figure 9-2 walks the recursive scheme
// for (x1, y1) = (3.5, 0.25) and states the answer: the y=0.0 and y=0.5
// isolines bracket 0.25, each is interpolated at x=3.5 to give 1.75 and 2.25,
// and interpolating those two in y at 0.25 yields f = 2.0. The underlying
// function agrees exactly — 0.5*3.5 + 0.25 = 2.0 — because it is linear and the
// scheme requested is linear, so the digits are exact and CHECKX applies.
//
// Control string "1LL,1LL;1" is Table 9-32's third row: 2-D, linear
// interpolation with linear extrapolation at both ends of both dimensions,
// dependent variable 1. The outer sub-string governs y, the inner governs x,
// matching the column order in the file.
//
//! lrm 9.21
//! lrm 9.21.1
//! bias V(p) = 3.5
//! xfail VerA refuses $table_model with E0801 (no file-backed isoline interpolator); Table 9-18 marks it analog-context Yes
`include "check.vh"
module ch09_table_model(p, n);
  inout p, n; electrical p, n;
  real f;
  analog begin
    f = $table_model(0.25, V(p,n), "ch09_table_model_2d.tbl", "1LL,1LL;1");
    `CHECKX("§9.21 Figure 9-2: f(x=3.5, y=0.25) on the LRM's own sample table",
            f, 2.0);
    I(p,n) <+ V(p,n) + f;
  end
endmodule
