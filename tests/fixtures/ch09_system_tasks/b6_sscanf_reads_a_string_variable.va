// §9.5.4.2: "$sscanf reads from the string str (which shall be a string
// variable, string parameter, or string literal)."
//
// The legal half of b6_sscanf_from_real_rejected.va: `src` is a string
// variable holding "42", and "%d" "matches an optionally signed decimal
// number", so k = 42 and the count of assigned items is 1.
//
//! lrm 9.5.4.2
//! lrm 9.5.4.2:1
//! checks 2
`include "check.vh"
module b6_sscanf_reads_a_string_variable(p, n);
  inout p, n; electrical p, n;
  string src;
  integer k, code;
  analog begin
    src = "42";
    code = $sscanf(src, "%d", k);
    `CHECKI("§9.5.4.2 %d read the decimal number from the string variable", k, 42);
    `CHECKI("§9.5.4.2 one item was assigned", code, 1);
    I(p, n) <+ V(p, n);
  end
endmodule
