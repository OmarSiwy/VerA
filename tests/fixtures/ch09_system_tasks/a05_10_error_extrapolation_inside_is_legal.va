// §9.21.2 Table 9-31 character `E` — "Error on an extrapolation request":
//
//   "The user may also disable extrapolation by choosing the error
//    extrapolation method. With this method, an extrapolation error is reported
//    if the $table_model function is requested to evaluate a point BEYOND the
//    interpolation region."
//
// `E` is therefore a RUNTIME condition on the evaluated point, not a property
// of the call: a control string containing `E` is perfectly legal and a lookup
// that stays inside the interpolation region must return the ordinary
// interpolated value. Refusing the call at compile time turns a legal model
// into a diagnostic, and the LRM prints `E` in the same table as `C` and `L`
// with no restriction on where it may appear.
//
// 12_error_extrapolation_is_fatal.va asserts the other half — that a point
// beyond the region does terminate the run.
//
// PART 1, 1-D:   x = 1, 3     f = 2, 6      (the line f = 2x)
//
//   "1EE" at x = 2:   inside; linear between the two samples,
//                     2 + (2-1)/(3-1) * (6-2) = 4
//   "1EE" at x = 1:   the LOW ENDPOINT itself. An endpoint is the boundary of
//                     the interpolation region, not a point beyond it, so this
//                     is a lookup and not an error: 2
//   "1EE" at x = 3:   the high endpoint: 6
//
// PART 2, 2-D, f(y,x) = 2y + x on the 2x2 corner set, showing that `E` binds
// per dimension AND per end:
//
//   "1LL,1EE" at (y, x) = (2, 0.5): y is extrapolated (allowed — the outer
//       sub-string is `L`) while x stays inside the region the `E` guards.
//       f is affine so the linear scheme is exact: 2*2 + 0.5 = 4.5
//   "1EL,1LL" at the same point: the outer dimension's `E` guards only the LOW
//       end ("the first character specifies the extrapolation method used for
//       the end with the lower coordinate value"); y = 2 is past the HIGH end,
//       whose character is `L`, so this too is legal: 4.5
//
//! lrm 9.21.2
//! lrm 9.21.2:1
//! lrm 9.21.2:2
`include "check.vh"
module a05_error_extrapolation_inside_is_legal(p, n);
  inout p, n; electrical p, n;
  real xs[0:1], fs[0:1];
  real ys2[0:3], xs2[0:3], fs2[0:3];
  analog begin
    xs[0] = 1.0; fs[0] = 2.0;
    xs[1] = 3.0; fs[1] = 6.0;
    `CHECKX("`E` control, point inside the region: ordinary linear interpolation",
            $table_model(2.0, xs, fs, "1EE"), 4.0);
    `CHECKX("the low endpoint is on the boundary, not beyond it",
            $table_model(1.0, xs, fs, "1EE"), 2.0);
    `CHECKX("the high endpoint is on the boundary, not beyond it",
            $table_model(3.0, xs, fs, "1EE"), 6.0);
    ys2[0]=0.0; xs2[0]=0.0; fs2[0]=0.0;
    ys2[1]=0.0; xs2[1]=1.0; fs2[1]=1.0;
    ys2[2]=1.0; xs2[2]=0.0; fs2[2]=2.0;
    ys2[3]=1.0; xs2[3]=1.0; fs2[3]=3.0;
    `CHECKX("`E` in the inner dimension does not forbid extrapolating the outer one",
            $table_model(2.0, 0.5, ys2, xs2, fs2, "1LL,1EE"), 4.5);
    `CHECKX("`E` as the FIRST character guards only the low end",
            $table_model(2.0, 0.5, ys2, xs2, fs2, "1EL,1LL"), 4.5);
    I(p, n) <+ V(p, n);
  end
endmodule
