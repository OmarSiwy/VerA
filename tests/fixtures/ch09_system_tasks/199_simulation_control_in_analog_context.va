// §9.7 "Verilog AMS HDL extends the two simulation control tasks, $finish and
// $stop so that they can be run in the analog context. ... Verilog AMS HDL also
// supports three new simulation control tasks in the analog context only;
// $fatal, $error, $warning."
//
// The positive half: control tasks CALLED from an `analog` block, where the
// clause puts them. 193_severity_task_digital_context_rejected.va is its only
// other cite, and pins the "analog context only" refusal.
//
// Two tasks from the clause's two lists, each with an observable consequence:
//
//   $warning   a run-time warning (§9.7.3) — the run CONTINUES, so the check
//              after it is reached at the first point.
//   $finish    "the simulator shall exit after the current solution is
//              complete" (§9.7.1) — the second sweep point is never solved.
//
// DERIVATION. The sweep is V(p) = 1.0, then 2.0. At the first point the check
// `V(p) < 1.5` prints 1 and $finish ends the run after that solution. Were
// $finish dropped, the second point would print `V(p) < 1.5` = 0 against want 1,
// a hard ok=0 — the same shape 174_stop_terminates.va uses for $stop.
//
// $finish's argument 0 selects the least diagnostic output (Table 9-25) and the
// process exits with status 0, which is the harness default.
//
//! lrm 9.7
//! lrm 9.7.1
//! lrm 9.7.1:2
//! lrm 9.7:1000
//! sweep V(p) = 1.0, 2.0
`include "check.vh"
module ch09_simulation_control_in_analog_context(p, n);
  inout p, n; electrical p, n;
  analog begin
    $warning("§9.7 a warning from the analog context");
    `CHECKI("§9.7 the run continues past $warning, and $finish ends it after the first point", V(p) < 1.5, 1);
    $finish(0);
    I(p, n) <+ V(p, n);
  end
endmodule
