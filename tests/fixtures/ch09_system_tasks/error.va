// §9.7.3 $error: "shall be a run-time error", one of the three non-fatal
// severity tasks, and §9.7.3 adds that a non-fatal severity task "called during
// a rejected iteration shall have no effect". It returns nothing and its message
// goes to the simulator's log, so the rule pins no value on that side.
//
// The guard does carry one. §4.2.5 makes a relational an integer, 1 or 0, and
// `>` is STRICT, so the bias is put exactly on the threshold: V(p,n) = 1.0 - 0 =
// 1.0, both operands exact in binary, and 1.0 > 1.0 is false. This is the
// accepted-iteration operating point at which the severity task is NOT raised,
// which is what makes the fixture observable at all.
//
// A `>` lowered as `>=` raises the error at this bias and turns the 0 into a 1.
//
// WHAT THIS FIXTURE DOES NOT PROVE. $error is never executed here, so this file
// carries no exact-id citation for §9.7.3:3, "$error shall be a run-time
// error", and the assertion below is about the OPERATING POINT — that the bias
// sits below the guard, i.e. that `>` is strict — and not about §9.7. It
// documents why the call is not reached. The running half is asserted by
// tests/fixtures/exhaustive/severity_tasks.va, which calls $error
// unconditionally, checks that the block continues past it, and carries the
// 9.7.3:3 citation. error_in_analog_initial_stops_after_initialization.va
// additionally pins the termination side for an initialization-time $error.
//
//! lrm 9.7.3
//! bias V(p) = 1.0
`include "check.vh"
module ch09_atomic_error(p, n);
  inout p, n; electrical p, n;
  analog begin
    if (V(p,n) > 1.0) $error("voltage=%g", V(p,n));
    `CHECKI("strict > is false exactly at the threshold, so $error is not raised", V(p, n) > 1.0, 0);
    I(p,n) <+ V(p,n);
  end
endmodule
