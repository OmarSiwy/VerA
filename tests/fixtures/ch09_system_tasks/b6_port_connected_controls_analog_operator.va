// §9.19: "Note that the return values of these functions shall be constant
// during a simulation; the value is fixed during elaboration. As such, these
// functions can be used in genvar expressions controlling conditional or
// looping behavior of the analog operators of 4.5."
//
// §4.5 is why that matters: "Analog operators shall not be used inside
// conditional (if, case, or ?:) statements unless the conditional expression
// controlling the statement consists of terms which can not change their
// value during the course of a simulation." So a `transition` under
// `if ($port_connected(q))` is legal exactly because of this sentence; the
// clause's own myclk example does it.
//
// THE HIERARCHY. b6_pcop_clk is instantiated with only `q` connected; `qb` is
// left off the instance line, so $port_connected(qb) = 0 (§9.19 "zero (0)
// otherwise", audit_binding_unused_parent_port.va) and $port_connected(q) = 1.
//
// THE DIGITS. A single dc point. §4.5.8: "In DC analysis, transition() passes
// the value of the expr directly to its output", so the q arm gives x = 2.0
// exactly; the qb arm is the else, -1.0.
//
//! lrm 9.19
//! lrm 9.19:2
//! lrm 9.19:6
//! lrm 4.5.8
//! bias V(p) = 0.5, V(n) = 0.0
//! checks 2
`include "check.vh"

module b6_pcop_top(p, n);
  inout p, n; electrical p, n;
  b6_pcop_clk c1(.q(p));
  analog begin
    I(p, n) <+ V(p, n);
  end
endmodule

module b6_pcop_clk(q, qb);
  inout q, qb; electrical q, qb;
  real x, y, yb;
  analog begin
    x = 2.0;
    if ($port_connected(q)) y = transition(x, 0, 1n);
    else y = -1.0;
    if ($port_connected(qb)) yb = transition(x, 0, 1n);
    else yb = -1.0;
    I(q) <+ 1e-3 * V(q);
    I(qb) <+ 1e-3 * V(qb);
    `CHECKX("q is connected: its arm runs transition(), which passes 2.0 at dc", y, 2.0);
    `CHECKX("qb is left open: its arm is the constant -1.0", yb, -1.0);
  end
endmodule
