// §9.5.3 $swrite/$sformat are the display tasks writing into a string variable
// instead of the transcript — "the first argument to $swrite shall be a string
// variable to which the resulting string shall be written, instead of a variable
// specifying the file to which to write" — so §9.4.3 governs the text they
// produce: Table 9-23 gives %e "Display 'real' in an exponential format" with
// "the full formatting capabilities available in the C language", and its own
// example reads "the format specification %10.3g sets a minimum field width of
// 10 with three (3) fractional digits".
//
// String equality checks the requested format directly; §9.5.4.2 $sscanf
// separately checks that it can be read back. The bias makes
// V(p,n) = 0.5, so "%10.4e" of it is "5.0000e-01" — exactly ten characters, so
// the width-10 MINIMUM is already met and no padding is added — and scanning
// that back with %e must recover 0.5 exactly, since 5.0000e-01 is 1/2 with no
// digits lost. $sscanf also "returns the number of items read", one here.
//
// A formatter that dropped the field width, the four fractional digits or the
// exponent would still round-trip. The exact string checks reject those
// errors, and width 12 needs two padding spaces beyond the ten-character
// exponential rendering. Observe $swrite before $sformat replaces its result.
//
//! bias V(p) = 0.5
//! print none
//! lrm 9.4.3
//! lrm 9.5.3
//! lrm 9.5.4.2
//! lrm 9.4.1
//! lrm 9.4.1:1
//! lrm 9.5.4.2:1
//! lrm 9.5.4.2:4
//! checks 5
`include "check.vh"
module ch09_string_formatting(p, n);
  inout p, n; electrical p, n;
  string text;
  real back;
  integer nread;
  analog begin
    $swrite(text, "value=%g", V(p,n));
    `CHECKI("$swrite writes the requested text to its string destination", text == "value=0.5", 1);
    $sformat(text, "value=%10.4e", V(p,n));
    `CHECKI("explicit exponential precision and exponent are preserved", text == "value=5.0000e-01", 1);
    nread = $sscanf(text, "value=%e", back);
    `CHECKI("$sscanf read one item back out of the formatted string", nread, 1);
    `CHECKX("%10.4e of 0.5 round-trips to 0.5", back, 0.5);
    $sformat(text, "value=%12.4e", V(p,n));
    `CHECKI("a larger minimum field width pads the real with two spaces", text == "value=  5.0000e-01", 1);
    I(p,n) <+ V(p,n);
  end
endmodule
