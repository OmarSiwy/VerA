// §9.18: "$angle indicates that the instance has been rotated some number of
// degrees in the counter-clockwise direction", and "$angle is specified and
// returned in degrees, but trigonometric functions (see 4.3.2) operate in
// radians." Table 9-29: top-level value 0 degrees, resolved value
// $angle_specified + $angle_hier modulo 360, allowed 0 <= $angle < 360.
//
// This module is elaborated on its own, so it IS the top of the hierarchy: no
// enclosing instance contributes a rotation and the resolved value is 0
// degrees.
//
// The second check is the allowed-values column, written as the integer
// conjunction §4.2.5 makes it. At the top level it is IMPLIED by the first —
// 0.0 satisfies 0 <= x < 360 — and it is here to carry the column, not to add
// discrimination: it is the check that survives if a future fixture instantiates
// this device under a rotated parent, where the resolved value is
// $angle_specified + $angle_hier modulo 360 and the modulo is the whole point.
// (The old note that "-0.0 passes the first check but fails this one" was
// wrong twice over: -0.0 == 0.0 and -0.0 >= 0.0 are both TRUE in IEEE-754, so
// -0.0 passes both.)
//
//! lrm 9.18
//! lrm 9.18:1000
`include "check.vh"
module ch09_atomic_angle(p, n);
  inout p, n; electrical p, n;
  analog begin
    `CHECKX("Table 9-29 top-level $angle, in degrees", $angle, 0.0);
    `CHECKI("Table 9-29 allows only 0 <= $angle < 360", ($angle >= 0.0) && ($angle < 360.0), 1);
    I(p,n) <+ V(p,n) + $angle;
  end
endmodule
