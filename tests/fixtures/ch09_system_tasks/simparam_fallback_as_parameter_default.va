// §9.15 `$simparam(param_name [, expression])`: "If param_name is known, its
// value is returned. [...] If the optional expression is supplied, its value
// is returned if param_name is not known and no error is generated." A §3.4
// parameter default is no exception: the analog block and the default must
// answer the same call the same way.
//
// `"vera_no_such_simparam"` is not in Table 9-27 and is no plausible vendor
// name, so the LRM requires the second argument back: `lo` is 1e-3, and `hi`,
// a §6.3.4 default over `lo`, is 2 * 1e-3 = 2e-3.
//
// `"scale"` IS known: VerA answers 1.0, because geometry scaling is applied
// when the card is built (specification/Vague_Decisions.md, the §9.15 row:
// "`scale` and `shrink` are 1"). The fallback 2.0 is therefore NOT returned,
// and `w` = 1.0 * 3.0 = 3.0. A fallback-taking implementation would give 6.0,
// the pre-fix one 0 (W1050).
//
// All three are exact in binary64 (one multiply by a power of two or by 1),
// hence CHECKX. `//! nowarn`: every default now has a value, so W1050 (and
// anything else) must not fire. 3 checks.
//
// The invalid neighbour is 147_simparam_unknown_no_fallback_rejected.va: an
// unknown name with no fallback is E0811.
//! lrm 9.15
//! nowarn
//! bias V(p) = 1.0, V(n) = 0.0
//! checks 3
`include "check.vh"
module ch09_simparam_fallback_default(p, n);
  inout p, n; electrical p, n;
  parameter real lo = $simparam("vera_no_such_simparam", 1e-3);
  parameter real hi = 2.0 * lo;
  parameter real w = $simparam("scale", 2.0) * 3.0;
  analog begin
    `CHECKX("unknown name in a parameter default returns its fallback", lo, 1e-3);
    `CHECKX("a default over it sees the fallback too", hi, 2e-3);
    `CHECKX("a known name in a default is VerA's answer, not the fallback", w, 3.0);
    I(p, n) <+ V(p, n) / 1k;
  end
endmodule
