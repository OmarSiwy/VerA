// LRM 9.14 / Table 4-14: $sqrt is an alias of the 4.3.1 analog operator sqrt.
// 4 is a perfect square, so sqrt(4) is 2 with no rounding at all — the one
// class of argument for which an exact comparison is legitimate.
//
//! lrm 9.14
`include "check.vh"
module ch09_atomic_sqrt(p, n);
  inout p, n; electrical p, n;
  analog begin
    `CHECKX("$sqrt(4.0) is exactly 2", $sqrt(4.0), 2.0);
    I(p,n) <+ V(p,n) + $sqrt(4.0);
  end
endmodule
