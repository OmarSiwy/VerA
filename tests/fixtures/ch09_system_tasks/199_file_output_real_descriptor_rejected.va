// §9.5.2: the file output tasks "accept the same type of arguments as the
// tasks upon which they are based, with one exception: The first argument
// shall be either a multichannel descriptor or a file descriptor, which
// indicates where to direct the file output. ... A multichannel descriptor is
// either a variable or the result of an expression that takes the form of a
// 32-bit unsigned integer value."
//
// §9.5.1 fixes both shapes as integers: "The multichannel descriptor mcd is a
// 32-bit integer in which a single bit is set", "The file descriptor fd is a
// 32-bit value" whose bit 31 "shall always be set".
//
// `where` below is a REAL holding the descriptor's value. A real has no bit 31
// and no single set bit — it is not a 32-bit integer at all — so the first
// argument is neither shape and the "shall" is broken. Declaring `where` as
// `integer` instead makes the file compile (probed).
//
// VerA used to accept this silently. It now reports E0888 "descriptor argument
// is not an integer".
//
//! lrm 9.5.2
//! lrm 9.5.1
//! lrm 9.5.2:1
//! reject-only E0888
//! neighbour 08_file_output.va
//! reject `$fwrite`'s descriptor argument is a real
`include "disciplines.vams"
module ch09_file_output_real_descriptor(p, n);
  inout p, n; electrical p, n;
  integer fd;
  real where;
  analog begin
    @(initial_step) begin
      fd = $fopen("ch09_199.log", "w");
      where = fd;
      $fwrite(where, "%g\n", V(p, n));   // illegal: a real is not a descriptor
      $fclose(fd);
    end
    I(p, n) <+ V(p, n);
  end
endmodule
