// §9.2 Table 9-11 lists $atanh as supported in the analog context; §4.3
// Table 4-15 defines it as C `atanh(x)`, the arc-hyperbolic tangent, on the OPEN
// domain -1 < x < 1 — which is why the fixture scales tanh(V) by 0.5 to stay
// strictly inside it. §4.3 makes the `$` and traditional spellings the same
// function.
//
// At V(p,n) = 0.5 the argument is 0.5 * tanh(0.5) = 0.23105857863000487, and
// atanh(u) = 0.5 * ln((1 + u)/(1 - u)) = 0.2353074598670406.
//
//! lrm 9.14
//! bias V(p) = 0.5
`include "check.vh"
module ch09_atomic_atanh(p, n);
  inout p, n; electrical p, n;
  analog begin
    `CHECK("the argument stays inside (-1, 1)", 0.5 * tanh(V(p,n)), 0.23105857863000487, 1e-15);
    `CHECK("$atanh(0.5*tanh(0.5))", $atanh(0.5 * tanh(V(p,n))), 0.2353074598670406, 1e-15);
    `CHECK("atanh is 0.5*ln((1+u)/(1-u))", 0.5 * ln((1.0 + 0.5 * tanh(V(p,n))) / (1.0 - 0.5 * tanh(V(p,n)))), 0.2353074598670406, 1e-15);
    I(p,n) <+ V(p,n) + $atanh(0.5 * tanh(V(p,n)));
  end
endmodule
