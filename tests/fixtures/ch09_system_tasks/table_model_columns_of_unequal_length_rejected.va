// §9.21.1: "A table of M dependent variables of dimension N are laid out in N+M
// columns in the file", one sample point per line, and "When the data source is
// a sequence of 1-D arrays the isolines are laid out in conceptually the same
// way with each array being just as a column in the file format described
// above."
//
// So the arrays of an array data source are the COLUMNS of one table, and row k
// is (xs[k], fs[k]). Below, `xs` has four entries and `fs` three: the fourth
// sample has an abscissa and no value, which no line of the file format can
// express. The legal array source, equal lengths, is 131_table_model_array_control.va.
//
//! lrm 9.21
//! lrm 9.21.1
//! reject-only E0815
//! neighbour 131_table_model_array_control.va
`include "disciplines.vams"
module ch09_table_model_columns_of_unequal_length(p, n);
  inout p, n; electrical p, n;
  real xs[0:3], fs[0:2];
  analog begin
    xs[0] = 0.0; xs[1] = 1.0; xs[2] = 2.0; xs[3] = 3.0;
    fs[0] = 0.0; fs[1] = 1.0; fs[2] = 4.0;
    I(p, n) <+ $table_model(V(p, n), xs, fs);
  end
endmodule
