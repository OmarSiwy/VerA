// §9.13.3: "17.9.3 of IEEE Std 1364 Verilog contains the C-code to describe the
// algorithm of probabilistic system functions based on the seed value passed to
// them. This code also describe the algorithm of the IEEE Std 1364 Verilog
// probabilistic functions extensions in Verilog-AMS HDL as indicated in Table
// 9-26." Table 9-26 maps $rdist_normal/_exponential/_poisson onto the listing's
// normal/exponential/poisson; IEEE 1364 Table 17-17 maps $dist_normal/_exponential/
// _poisson/_erlang onto rtl_dist_normal/_exponential/_poisson/_erlang.
//
// 124_dist_erlang.va, 125_rdist_normal.va and their siblings assert only §9.13.2's
// repeatability and that the seed moves, which a `return 0; seed += 1` stub
// passes. 171_random_ieee1364_digits.va and 189_rng_reference_large_count.va pin
// digits for uniform, chi-square, t and $rdist_erlang. This file pins digits for
// the rest of the family, so only the listing's stream passes.
//
// HOW THE DIGITS WERE PRODUCED — not from this compiler. The §17.9.3 listing
// (IEEE 1364-2005 pp. 313-320) was transcribed into C, `long *seed` as a wrapping
// 32-bit word (a Verilog integer), compiled with `zig cc -O0 -ffp-contract=off`
// and run from seed 12345 (seed 7's first draw is 0.00011, which makes Poisson
// return 0 — a value a stub reaches):
//
//   normal(12345, 5, 2)       = 4.9027475136280634   seed -438629137
//   exponential(12345, 10)    = 16.168415660540937   seed  852656806
//   poisson(12345, 4)         = 3                    seed 1580485141
//   erlangian(12345, 3, 10)   = 10.529462301506166   seed 1023442532
//
// The rtl_dist_* wrappers round half away from zero ((long)(r+0.5), negated for
// r < 0): 4.90 -> 5, 16.17 -> 16, 10.53 -> 11; rtl_dist_poisson returns
// poisson()'s long unchanged. No raw value sits within 0.02 of a .5 boundary.
//
// Integer-valued means are used for the $rdist_ calls on purpose: the listing's
// normal/exponential/poisson take `long mean`, and an integer-valued real reads
// the same whether an implementation truncates it or passes it as a double.
//
// normal/exponential/erlangian call libm's log/sqrt, so the real wants use CHECKR
// at 1e-14; every seed is integer arithmetic and is exact.
//
//! lrm 9.13.3
//! lrm 9.13.3:1000
`include "check.vh"
module ch09_dist_ieee1364_reference_digits(p, n);
  inout p, n; electrical p, n;
  integer seed, i;
  real r;
  analog begin
    seed = 12345; i = $dist_normal(seed, 5, 2);
    `CHECKI("rtl_dist_normal(12345,5,2)", i, 5);
    `CHECKI("rtl_dist_normal seed", seed, -438629137);
    seed = 12345; i = $dist_exponential(seed, 10);
    `CHECKI("rtl_dist_exponential(12345,10)", i, 16);
    `CHECKI("rtl_dist_exponential seed", seed, 852656806);
    seed = 12345; i = $dist_poisson(seed, 4);
    `CHECKI("rtl_dist_poisson(12345,4)", i, 3);
    `CHECKI("rtl_dist_poisson seed", seed, 1580485141);
    seed = 12345; i = $dist_erlang(seed, 3, 10);
    `CHECKI("rtl_dist_erlang(12345,3,10)", i, 11);
    `CHECKI("rtl_dist_erlang seed", seed, 1023442532);

    seed = 12345; r = $rdist_normal(seed, 5.0, 2.0);
    `CHECKR("normal(12345,5,2)", r, 4.9027475136280634, 1e-14);
    `CHECKI("normal seed", seed, -438629137);
    seed = 12345; r = $rdist_exponential(seed, 10.0);
    `CHECKR("exponential(12345,10)", r, 16.168415660540937, 1e-14);
    `CHECKI("exponential seed", seed, 852656806);
    seed = 12345; r = $rdist_poisson(seed, 4.0);
    `CHECKX("poisson(12345,4)", r, 3.0);
    `CHECKI("poisson seed", seed, 1580485141);
    I(p, n) <+ V(p, n);
  end
endmodule
