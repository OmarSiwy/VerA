// §9.9 "Verilog AMS HDL does not extend the stochastic analysis tasks defined
// in IEEE Std 1364 Verilog."
//
// So the tasks keep their IEEE 1364 §17.6 meaning in the DIGITAL context, and
// that is the positive half this file pins. 154_timescale_pla_queue_analog_
// rejected.va is the clause's only other cite and pins the other half — not
// extended means not callable from the analog block.
//
// IEEE 1364-2005 §17.6 (inventoried in docs/conformance-ieee-queue-review.md at 8b1514d4,
// QUEUE-001..008): $q_initialize(q_id, q_type, max_length, status) with type 1
// = FIFO; $q_add(q_id, job_id, inform_id, status); $q_full(q_id, status)
// returns 1 when full; $q_exam(q_id, q_stat_code, q_stat_value, status) with
// code 1 = current queue length; $q_remove(q_id, job_id, inform_id, status);
// status 0 = OK (Table 17-16).
//
// DERIVATION. A FIFO of capacity 2 receives (13, 130) then (27, 270):
//
//   $q_full            -> 1           (two entries in a capacity-2 queue)
//   $q_exam code 1     -> length 2
//   $q_remove          -> job 13, info 130   (FIFO: the first added comes out)
//   every status       -> 0
//
// The queue calls run at t = 1 (one tick after time zero); the analog block
// reads the integers through §7.3.1 Table 7-1 at t = 10n, well after. `bad` counts nonzero statuses so one check covers all
// six calls. All integers, so every comparison is exact.
//
//! lrm 9.9
//! lrm 9.9:1000
//! analysis tran
//! time 0, 10n
//! print none
`timescale 1ns/1ns
`include "check.vh"
module ch09_stochastic_queue_in_digital_context(out);
  inout out;
  electrical out;
  integer st, bad, full, len, job, info;

  // Defined values for the analog block's time-zero read (§7.3.2 makes an x
  // read from the continuous context an error, and a digital integer starts
  // at x, IEEE 1364 §4.2.2); the queue calls below then run one tick later.
  initial begin
    bad = 0; full = 0; len = 0; job = 0; info = 0;
  end

  initial begin
    #1;
    $q_initialize(1, 1, 2, st);  bad = bad + (st != 0);
    $q_add(1, 13, 130, st);      bad = bad + (st != 0);
    $q_add(1, 27, 270, st);      bad = bad + (st != 0);
    full = $q_full(1, st);       bad = bad + (st != 0);
    $q_exam(1, 1, len, st);      bad = bad + (st != 0);
    $q_remove(1, job, info, st); bad = bad + (st != 0);
  end

  analog begin
    if ($abstime > 5n) begin
      `CHECKI("§9.9 every queue call reported status 0", bad, 0);
      `CHECKI("§9.9 $q_full: a capacity-2 queue holding 2 is full", full, 1);
      `CHECKI("§9.9 $q_exam code 1: current length 2", len, 2);
      `CHECKI("§9.9 $q_remove from a FIFO returns the first job", job, 13);
      `CHECKI("§9.9 with the information it was added with", info, 130);
    end
    V(out) <+ 0.0;
  end
endmodule
