// §9.5.4.2 spells out what a conversion specification is, and the suite only
// ever reached the plainest one. The full form is
//
//   "the character %, an optional assignment suppression character *, a decimal
//    digit string that specifies an optional numerical maximum field width, and
//    a conversion code"
//
// and three separate claims hang off the two optional parts:
//
//   %*d  "the result is placed in the variable specified in the corresponding
//        argument UNLESS assignment suppression was indicated by the character
//        *. In this case, NO ARGUMENT SHALL BE SUPPLIED." Plus the return rule:
//        "the number of successfully MATCHED AND ASSIGNED input items is
//        returned in code" — a suppressed field is matched and not assigned, so
//        it is consumed, it takes no argument, and it is not counted.
//
//   %2d  "An input field is defined as a string of nonspace characters; it
//        extends to the next inappropriate character or until the MAXIMUM FIELD
//        WIDTH, if one is specified, is exhausted." So "%2d" against "12345"
//        stops after two characters: 12, not 12345.
//
//   %d on "hello"  "this number can be 0 in the event of an EARLY MATCHING
//        FAILURE between an input character and the control string." The first
//        directive fails on 'h', nothing is assigned, and the return is 0 —
//        not EOF, which the same paragraph reserves for input that ends before
//        any conversion.
//
// The last pair covers the two codes 048_sscanf.va does not reach: "%s Matches
// a string, which is a sequence of nonwhite space characters" and "%f, %e, or
// %g Matches a floating point number". 5.5 is exact in binary, so CHECKX.
//
// $sscanf reads a string literal, so none of this touches the filesystem and
// none of it depends on run order.
//
//! lrm 9.5.4.2
//! xfail VerA has no string-scanning surface: codegen.zig `void_tasks` lowers $sscanf to the constant `S.con(0.0)`, so every call returns 0 and no output argument is ever written
`include "check.vh"
module ch09_sscanf_conversion_rules(p, n);
  inout p, n; electrical p, n;
  integer n1, n2, n3, n4;
  integer second, clipped, junk;
  real fval;
  string word;
  analog begin
    n1 = $sscanf("12 34", "%*d %d", second);
    `CHECKI("§9.5.4.2 a suppressed field is consumed but not counted", n1, 1);
    `CHECKI("§9.5.4.2 and the one argument received the SECOND field", second, 34);

    n2 = $sscanf("12345", "%2d", clipped);
    `CHECKI("§9.5.4.2 a digit string is a maximum field width", clipped, 12);
    `CHECKI("one item matched and assigned", n2, 1);

    n3 = $sscanf("hello", "%d", junk);
    `CHECKI("§9.5.4.2 an early matching failure returns 0", n3, 0);

    n4 = $sscanf("abc 5.5", "%s %f", word, fval);
    `CHECKI("§9.5.4.2 %s then %f assigns two items", n4, 2);
    `CHECKX("and %f converted the floating point field", fval, 5.5);

    I(p,n) <+ V(p,n) + n1 + n2 + n3 + n4 + second + clipped + fval;
  end
endmodule
