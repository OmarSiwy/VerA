// §9.4.3: Table 9-23's conversions "have the full formatting capabilities
// available in the C language", so the ROUNDING of a %f is C's rounding.
// C11 7.21.6.1p13: "the value is correctly rounded to the given precision" —
// correctly rounded in the current rounding direction, which is IEEE 754's
// default roundTiesToEven on every host this compiler targets. §2.6.2 makes a
// real constant an IEEE 754 double, so the operand is exactly the bit pattern
// the rule is applied to and nothing here depends on decimal parsing.
//
// This is also the whole of what "locale independence" can mean for a fixture:
// the digits and the radix character are fixed by the standard and by IEEE 754,
// not by an environment. A `%f` that answers a different digit under a
// different rounding mode — or that rounds half AWAY from zero, which is the
// naive `@round` — fails here.
//
// EVERY OPERAND BELOW IS EXACTLY A TIE, and every one is exact in binary, so
// the answer is a rule and not an approximation:
//
//   %.0f of 2.5   candidates 2 and 3; 2 is even  -> "2"
//   %.0f of 3.5   candidates 3 and 4; 4 is even  -> "4"
//   %.0f of 0.5   candidates 0 and 1; 0 is even  -> "0"
//   %.1f of 0.25  candidates 0.2 and 0.3; 2 is even -> "0.2"
//   %.0f of 1.5   candidates 1 and 2; 2 is even  -> "2"
//
// 2.5 / 3.5 are written as a PAIR on purpose: round-half-away gives "3" and "4",
// round-half-even gives "2" and "4". An implementation that gets 3.5 right by
// accident still fails 2.5, so the pair separates the rule from the coincidence.
//
// No trailing-zero or width machinery is involved: every result below is the
// bare digit string, so a failure is a rounding failure and nothing else.
//
//! lrm 9.4.3
//! lrm 9.5.3
//! print none
`include "check.vh"
module s01_real_round_half_even(p, n);
  inout p, n; electrical p, n;
  string two_five, three_five, half, quarter, one_five;
  analog begin
    $sformat(two_five,   "%.0f", 2.5);
    $sformat(three_five, "%.0f", 3.5);
    $sformat(half,       "%.0f", 0.5);
    $sformat(quarter,    "%.1f", 0.25);
    $sformat(one_five,   "%.0f", 1.5);

    `CHECKI("§9.4.3 %.0f of 2.5 is a tie and 2 is the even candidate", (two_five == "2"), 1);
    `CHECKI("§9.4.3 %.0f of 3.5 is a tie and 4 is the even candidate", (three_five == "4"), 1);
    `CHECKI("§9.4.3 %.0f of 0.5 is a tie and 0 is the even candidate", (half == "0"), 1);
    `CHECKI("§9.4.3 %.1f of 0.25 is a tie and 0.2 is the even candidate", (quarter == "0.2"), 1);
    `CHECKI("§9.4.3 %.0f of 1.5 is a tie and 2 is the even candidate", (one_five == "2"), 1);

    I(p,n) <+ V(p,n);
  end
endmodule
