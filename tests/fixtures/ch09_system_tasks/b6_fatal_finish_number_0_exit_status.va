// §9.7.3: "The finish_number may be used in an implementation-specific
// manner", and $fatal "terminates the simulation with an errorcode". VerA
// uses the finish_number as the exit status, floored at 1 so that a fatal
// error never exits 0 (cg_display.emitDisplayTask). $fatal(0, ...) is legal
// (Syntax 9-7 `finish_number ::= 0 | 1 | 2`) and exits 1, not 0.
//
// The sweep is 173_fatal_terminates.va's oracle: point 0, V(p) = 1.0, prints
// ok=1, then the run ends with status 1; point 1, V(p) = 2.0, would print
// ok=0 if it ran.
//
//! lrm 9.7.3
//! lrm 9.7.3:9
//! lrm 9.7.3:1
//! exit 1
//! sweep V(p) = 1.0, 2.0
//! checks 1
`include "check.vh"
module b6_fatal_finish_number_0_exit_status(p, n);
  inout p, n; electrical p, n;
  analog begin
    `CHECKI("printed at the first point only: $fatal ends the run before the second", V(p) < 1.5, 1);
    $fatal(0, "giving up at v=%g", V(p));
    I(p, n) <+ V(p, n);
  end
endmodule
