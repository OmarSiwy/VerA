// §9.2 Table 9-11 lists $max among the math system functions, and §9.14 says
// every one of them except $clog2 is an ALIAS of the analog math operator of
// §4.3.1. Table 4-14 gives $max(x,y) the C function fmax, and §4.3.1 pins the
// value at the discontinuity exactly: "max(x,y) is equivalent to (x > y) ? x : y".
//
// The bias makes V(p,n) = 0.5 - 0.0 = 0.5, exact in binary. So max(0.5, 0.0)
// must select the first operand and max(-0.5, 0.0) must select the second —
// both sides of the same selection rule at one operating point. Both are exact:
// max returns one of its operands unmodified, never a blend of them.
//
//! lrm 9.2
//! lrm 9.14
//! bias V(p) = 0.5
`include "check.vh"
module ch09_atomic_max(p, n);
  inout p, n; electrical p, n;
  analog begin
    `CHECKX("max selects the larger operand", $max(V(p,n), 0.0), 0.5);
    `CHECKX("max selects the other side of the same rule", $max(-V(p,n), 0.0), 0.0);
    I(p,n) <+ V(p,n) + $max(V(p,n), 0.0);
  end
endmodule
