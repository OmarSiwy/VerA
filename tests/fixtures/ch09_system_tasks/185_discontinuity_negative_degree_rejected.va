//! lrm 9.17.1
//! reject E0820
module ch09_discontinuity_negative_degree_rejected(p, n);
  inout p, n; electrical p, n;
  analog begin
    $discontinuity(-2);
    I(p,n) <+ V(p,n);
  end
endmodule
