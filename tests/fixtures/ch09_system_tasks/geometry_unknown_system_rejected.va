// §6.3.6 implicitly declares exactly the system parameters listed there.
// $temperature is a simulation-query function (§9.15), not an instance
// parameter; defparam cannot assign it. geometry_defparam_alias.va is the
// legal neighbour using all six declared hierarchical system parameters.
//! lrm 6.3.6
//! reject-only E0907
//! neighbour geometry_defparam_alias.va
module geometry_unknown_system_top;
  geometry_unknown_system_child child();
  defparam child.$temperature = 300;
endmodule
module geometry_unknown_system_child;
  analog $display("temperature=%g", $temperature);
endmodule
