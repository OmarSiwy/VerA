//! reject E0801
//! reject $dist_t
// EXPECT: error
module ch09_dist_t_unsupported(p, n);
  inout p, n; electrical p, n;
  integer seed;
  analog I(p,n) <+ $dist_t(seed, 4);
endmodule
