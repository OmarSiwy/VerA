// §9.13: "Verilog-AMS HDL extends the probabilistic distribution functions so
// that they are supported in the analog context." Table 9-10 lists all 17 names
// and every row reads `Yes  Yes` — digital context AND analog context. So this
// file must COMPILE and run green; a compiler that refuses the call is the one
// that is wrong, which is why the expectation is a run and not a reject.
//
// The value is not free — §9.13.3 binds this family to the IEEE 1364 §17.9.3
// C listing (Table 9-26), and 171_random_ieee1364_digits.va pins that stream
// digit for digit. This fixture keeps the clause-local claim: §9.13.2's
// repeatability, "The system functions shall always return the same value
// given the same seed." Two seeds initialized to the same integer must agree,
// and that holds for any conforming implementation of the listing.
//
// $arandom is the analog spelling: "$arandom is upwardly compatible with
// $random — $arandom can take the same arguments as $random and has the same
// behavior." So the repeatability clause carries over unchanged.
//
// A SECOND rule, and the one that makes this fixture more than a stub test.
// §9.13.1 makes the seed an inout: "If the random_seed argument is specified it
// is an inout argument; that is, a value is passed to the function and A
// DIFFERENT VALUE IS RETURNED. The variable should be initialized by the user
// prior to calling $random and only updated by the system function." So after
// the call `sa` shall no longer read 7. Without that check the only assertion
// here is `a == b`, which a `return 0` stub satisfies perfectly; with it, a
// constant-returning implementation fails.
//
//! lrm 9.13.1
`include "check.vh"
module ch09_arandom(p, n);
  inout p, n; electrical p, n;
  integer sa, sb;
  integer a, b;
  analog begin
    sa = 7; sb = 7;
    a = $arandom(sa);
    b = $arandom(sb);
    `CHECKI("§9.13.1 $arandom on the same seed gives the same stream", a == b, 1);
    `CHECKI("§9.13.1 the seed is inout: a DIFFERENT value is returned", sa != 7, 1);
    `CHECKI("and both seeds advanced the same way from the same start", sa == sb, 1);
    I(p,n) <+ V(p,n) + a + b + sa + sb;
  end
endmodule
