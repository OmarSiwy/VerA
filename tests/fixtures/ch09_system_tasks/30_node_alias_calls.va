// §9.20: "The return value for both system functions shall be one (1) if the
// hierarchical_reference_string points to a valid continuous node and zero (0)
// otherwise", and "If the return value is zero (0), then the node referenced by
// the analog_net_reference shall be treated as a normal continuous node
// declared in the module containing the system function call."
//
// Neither `$root.top.n` nor `$root.top.dev.p` resolves here: this module is
// elaborated on its own, so there is no `top` and no `top.dev` for §6.7 to walk
// to. Both calls therefore return 0, so `status` is 0 whichever of them wrote
// it last.
//
// That "whichever" is ordinary sequential assignment, NOT §9.20's rule that "if
// a particular node is involved in multiple calls to either system function,
// then the last evaluated call shall take precedence". That clause is about
// which alias BINDS the node in the matrix; `status` is an integer variable and
// the second assignment overwrites the first for the same reason any two
// assignments in a block do. Nothing here tests the precedence rule — both
// return values are 0, so the two are indistinguishable — and the file should
// not be read as claiming otherwise.
//
// The second check is what makes the first one more than a restatement of the
// integer's default: because the alias failed, `local_node` stayed an ordinary
// local continuous node of this module, so the testbench can bias it by name
// and read 0.4 V back through V(). Had the alias succeeded, the net would have
// been folded onto the hierarchical node instead.
//
//! lrm 9.20
//! lrm 9.20:10
//! lrm 9.20:12
//! lrm 9.20:14
//! bias V(local_node) = 0.4
`include "check.vh"
module ch09_node_alias_calls(p, n);
  inout p, n; electrical p, n;
  electrical local_node;
  integer status;
  analog initial begin
    status = $analog_node_alias(local_node, "$root.top.n");
    status = $analog_port_alias(local_node, "$root.top.dev.p");
  end
  analog begin
    `CHECKI("an unresolvable hierarchical reference makes the alias return 0", status, 0);
    `CHECK("so the net stays an ordinary local node the testbench can bias",
           V(local_node), 0.4, 1e-15);
    I(p,n) <+ V(local_node);
  end
endmodule
