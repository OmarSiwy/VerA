// §9.5 / Table 9-2. The file family is mostly analog-context "Yes" — $fopen,
// $fclose, $fdisplay, $fwrite, $fstrobe, $fmonitor, $fgets, $fscanf, $swrite,
// $sformat, $sscanf, $rewind, $fseek, $ftell, $fflush, $ferror and $feof all
// carry over, and this directory has a fixture for each. Twelve spellings do
// not:
//
//     $fdisplayb , $fdisplayh , $fdisplayo   Yes  No
//     $fwriteb , $fwriteh , $fwriteo         Yes  No
//     $fstrobeb , $fstrobeh , $fstrobeo      Yes  No
//     $fmonitorb , $fmonitorh , $fmonitoro   Yes  No
//     $swriteb , $swriteh , $swriteo         Yes  No
//     $fgetc , $ungetc                       Yes  No
//     $fread                                 Yes  No
//     $readmemb , $readmemh                  Yes  No
//     $sdf_annotate                          Yes  No
//
// Three reasons, one per group. The b/h/o suffixes are the Table 9-1 radix
// story written against a descriptor instead of the transcript (see 152).
// $fgetc/$ungetc/$fread are byte- and vector-level reads whose results are bit
// patterns, and $ungetc additionally maintains a pushback state §9.5.5 only
// ever mentions in order to say that $fseek and $rewind cancel it.
// $readmemb/$readmemh load a memory array and $sdf_annotate loads timing onto a
// digital netlist; neither object exists in the analog context.
//
// One file for the whole column. The first diagnostic ends the compile, so the
// remaining calls are there to say which names the rule covers.
//
// A reject, so there is nothing to run and no `want` to write.
//
//! lrm 9.5
//! reject analog context
//! xfail VerA implements no Table 9-2 analog-context restriction; grep across src/ finds no analog-context check for any ch9 system task
module ch09_file_io_digital_only_analog_rejected(p, n);
  inout p, n; electrical p, n;
  integer fd, code;
  string text;
  analog begin
    fd = $fopen("ch09_153.log", "w");
    $fdisplayb(fd, 5);
    $fwriteh(fd, 5);
    $fstrobeo(fd, 5);
    $fmonitorb(fd, 5);
    $swriteh(text, 5);
    code = $fgetc(fd);
    code = $ungetc(65, fd);
    code = $fread(text, fd);
    $readmemb("ch09_153.mem", text);
    $sdf_annotate("ch09_153.sdf");
    $fclose(fd);
    I(p,n) <+ V(p,n) + code;
  end
endmodule
