// A device with a §9.21.1 first-call table, a §9.7.3 status site, a noise
// source and an AC stimulus: mutable_eval for two reasons, and the core
// itself writes the table. tests/fixtures/ch09_system_tasks/table_status_host.zig calls the contract's
// *const Instance entries (noisePsd, acStim) on it; they must run the core
// on a copy (`probeInstance`) and leave the caller's Instance untouched.
`include "disciplines.vams"
module table_status(a, k);
  inout a, k; electrical a, k;
  parameter real r = 1k;
  real xs[0:2], fs[0:2], g;
  analog begin
    xs[0] = 0.0; fs[0] = 0.0;
    xs[1] = 0.5; fs[1] = 0.25;
    xs[2] = 1.0; fs[2] = 1.0;
    if (r <= 0) $error("bad r %g", r);
    g = $table_model(V(a, k), xs, fs, "1L");
    I(a, k) <+ 1e-14 * (limexp($limit(V(a, k), "pnjlim", 0.025, 0.6) / 0.025) - 1) + g / r
             + white_noise(4e-21, "th") + ac_stim("ac", 1.0);
  end
endmodule
