// The positive half of §9.4.1's $monitor mechanism:
//
//   "...for each accepted step, if the variable or an expression in the argument
//    list changes value compared with the last accepted step ... the entire
//    argument list is displayed AT THE END OF THE TIME STEP as if reported by
//    the $strobe task."
//
// "for each accepted step" is a per-step obligation, so a list that changes at
// every step is reported at every step — and §9.5.2 makes $fmonitor the same
// task with a descriptor in front.
//
// WHY THIS FILE WAS RESHAPED. As first written it called $fmonitor and then
// $ftell inside the SAME analog-block evaluation, re-opened the file and
// $fscanf'd it in that same evaluation, and $fclose'd before the step ended.
// "at the end of the time step" puts the record after all of that, so on a
// conforming implementation every measurement read zero and the file collapsed
// entirely; it passed only because VerA's `$fmonitor` is literally `$fdisplay`.
// It now uses the same cross-step measurement as
// 05_monitor_suppresses_an_unchanged_step.va — see that file's header for why
// the descriptor is opened once under §5.10.2's `@(initial_step)` and why
// re-invoking $monitor every step would hand the implementation latitude the
// clause does not intend. The $fscanf read-back is gone with it: it coupled
// this file's verdict to the scanner defects that fixtures 08-11 own, and the
// byte arithmetic below pins the record's CONTENT without it.
//
// HAND DERIVATION. `//! wave V(p) = 0.25, 2.5, 25.0, 250.0` gives one value per
// declared time and V(n) is tied to the reference, so the monitored expression
// V(p,n)*4 takes the values
//
//   t = 0 -> 1     t = 1 -> 10     t = 2 -> 100     t = 3 -> 1000
//
// each exact in binary (a quarter is dyadic and 4*0.25 = 1 exactly; 2.5, 25 and
// 250 are exact and so are their products with 4), each an exact integer under
// §4.2.1.1's round-to-nearest conversion for %d, and each DIFFERENT from its
// predecessor. Their decimal renderings are 1, 2, 3 and 4 characters long, and
// §9.4.1 gives $monitor $strobe's trailing newline, so the four records are
//
//   "1\n" = 2 bytes   "10\n" = 3   "100\n" = 4   "1000\n" = 5
//
// THE LENGTHS ARE THE POINT. They are deliberately all different, so the running
// byte total is not merely a count of records — it is a function of the VALUES
// the monitor was asked to display. A printer that emits one record per step of
// some fixed content fails this file even though it reports on exactly the right
// steps.
//
// $ftell at the TOP of step k is the total written at the ends of steps 0..k-1:
//
//   t = 0 -> 0     t = 1 -> 2     t = 2 -> 2+3 = 5     t = 3 -> 2+3+4 = 9
//
// Those four numbers are (t² + 3t)/2 — check: (0+0)/2 = 0, (1+3)/2 = 2,
// (4+6)/2 = 5, (9+9)/2 = 9 — so the four rows collapse to the single literal
// the harness wants as `2*bytes - ($abstime² + 3*$abstime) == 0`.
//
// WHAT FAILS IT.
//   Never reports:                bytes 0,0,0,0 -> 0, -4, -10, -18.
//   Reports once and then stops:  bytes 0,2,2,2 -> 0,  0,  -6, -14.
//   Reports every step, but with
//   a record that does not carry
//   the value (fixed 2 bytes):    bytes 0,2,4,6 -> 0,  0,  -2,  -6.
//   Reports per solver iteration: bytes far larger, positive at every t > 0.
//
// Together with fixture 05 — which fails an over-reporter and an under-reporter
// on a CONSTANT list — the pair pins both directions of the clause's "if ...
// changes value" condition.
//
// FAILS TODAY for the same two reasons fixture 05 does, and they are listed in
// full there: no change detection in `Lower.isDisplayTask`, and a `$fopen`
// result that reads back as 0 outside the display unit, so `$ftell(fd)` is −1. This file no
// longer passes at HEAD; the earlier version did, and only because $fmonitor
// was $fdisplay and the measurement was taken inline.
//
//! lrm 9.4.1
//! lrm 9.5.2
//! lrm 9.5.5
//! lrm 5.10.2
//! time 0, 1, 2, 3
//! wave V(p) = 0.25, 2.5, 25.0, 250.0
//! print none
`include "check.vh"
module s01_monitor_change(p, n);
  inout p, n; electrical p, n;
  integer fd, bytes;
  analog begin
    @(initial_step) begin
      fd = $fopen("s01_06_monitor_change.dat", "w");
      $fmonitor(fd, "%d", V(p,n) * 4.0);
    end

    bytes = $ftell(fd);

    `CHECKI("§9.4.1 a changed list is reported every step, and the record carries the value",
            2 * bytes - ($abstime * $abstime + 3 * $abstime), 0);

    I(p,n) <+ V(p,n) + bytes;
  end
endmodule
