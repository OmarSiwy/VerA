// §9.20: "The hierarchical_reference_string shall be a CONSTANT string value
// (string literal or string parameter) containing a hierarchical reference to a
// continuous node."
//
// The parenthesis is the whole rule: two spellings are admitted and nothing
// else. A string VARIABLE holding the same characters is not one of them, and
// the reason is the same one behind the analog-initial restriction — the alias
// is a topology edit, so the target has to be known before any solve and not
// read out of storage during one. 105 and 106 use the literal spelling; the
// LRM's own §9.20 example uses the other, `parameter string n1_str =
// "(not_given)"` passed down as a module parameter.
//
// `ref_str` below is an ordinary string variable assigned one statement earlier
// in the same analog initial block — the characters are right, the constancy is
// not, and nothing else differs from the legal 105.
//
// A reject, so there is nothing to run and no `want` to write.
//
//! lrm 9.20
//! reject hierarchical_reference_string
//! xfail VerA lowers $analog_node_alias/$analog_port_alias to a constant 0 (codegen.zig) without checking that the second argument is a constant string
module ch09_node_alias_nonconstant_string_rejected(p, n);
  inout p, n; electrical p, n;
  electrical local_node; integer status; string ref_str;
  analog initial begin
    ref_str = "$root.top.a";
    status = $analog_node_alias(local_node, ref_str);
  end
  analog begin
    I(p,n) <+ V(p,n) + status;
  end
endmodule
