// §9.14 binary math system functions — aliases of the §4.3.1/§4.3.2 analog
// operators. Biased at V(p,n) = 2.0, where every one of the five has a value
// real analysis fixes and where the two selectors are not ties:
//
//   $pow(2,2)     = 4                    exact
//   $atan2(2,1)   = 1.1071487177940904   = atan(2), first quadrant. NOTE the
//                                          ARGUMENT ORDER is (y, x): atan2(1,2)
//                                          would be 0.4636…, so the order is
//                                          pinned by the digits.
//   $hypot(2,1)   = 2.2360679774997896   = sqrt(5)
//                   -------------------
//                   7.34321669529388
//
//   $min(2,0)     = 0    } §4.3.1 min/max over the two arguments, so the second
//   $max(2,0)     = 2    } line adds exactly 2. Swapping min and max would add
//                          2 as well — hence the FIRST total is what carries the
//                          weight, and the second confirms only the sum.
//
//! lrm 9.14
//! bias V(p) = 2.0
`include "check.vh"
module ch09_math_binary(p, n);
  inout p, n; electrical p, n;
  real x;
  analog begin
    `CHECKX("§4.3.1 $pow(2,2) = 4 exactly", $pow(V(p,n), 2.0), 4.0);
    `CHECK("§4.3.2 $atan2(y=2, x=1) = atan(2), not atan(0.5)",
           $atan2(V(p,n), 1.0), 1.1071487177940904, 1e-14);
    `CHECK("§4.3.1 $hypot(2,1) = sqrt(5)", $hypot(V(p,n), 1.0), 2.2360679774997896, 1e-14);
    x = $pow(V(p,n), 2.0) + $atan2(V(p,n), 1.0) + $hypot(V(p,n), 1.0);
    `CHECK("pow + atan2 + hypot", x, 7.34321669529388, 1e-12);
    `CHECKX("§4.3.1 $min(2,0) = 0", $min(V(p,n), 0.0), 0.0);
    `CHECKX("§4.3.1 $max(2,0) = 2", $max(V(p,n), 0.0), 2.0);
    x = x + $min(V(p,n), 0.0) + $max(V(p,n), 0.0);
    `CHECK("min + max add 0 + 2", x, 9.34321669529388, 1e-12);
    I(p,n) <+ x;
  end
endmodule
