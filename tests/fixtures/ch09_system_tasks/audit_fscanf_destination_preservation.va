// AMS §9.5.4.2 shares sscanf's assignment rules, but a file scan also consumes
// exactly the matching bytes once. File "12 34 nope" with "%*d %d %f"
// consumes six bytes (including the space before offending n), assigns34
// once, and preserves real2.5 and excess string"kept". A second scan reads
// "nope" from that SAME offending character. EOF leaves later outputs intact.
//! lrm 9.5.4.2
//! lrm 9.5.5
//! lrm 9.5.4.2:5
//! lrm 9.5.5:1
//! checks 8
`include "check.vh"
module audit_fscanf_destination_preservation(p, n);
  inout p, n; electrical p, n;
  integer fd, count, iv, position;
  real rv;
  string sv;
  analog begin
    fd = $fopen("audit_scan_preservation.dat", "w");
    $fwrite(fd, "12 34 nope");
    $fclose(fd);
    fd = $fopen("audit_scan_preservation.dat", "r");
    iv = 73; rv = 2.5; sv = "kept";
    count = $fscanf(fd, "%*d %d %f", iv, rv, sv);
    `CHECKI("one assignment after suppression", count, 1);
    `CHECKI("assigned integer", iv, 34);
    `CHECKX("failed real remains", rv, 2.5);
    `CHECKI("excess string remains", sv == "kept", 1);
    position = $ftell(fd);
    `CHECKI("input consumed once before offending n", position, 6);
    count = $fscanf(fd, "%s", sv);
    `CHECKI("retry reads conflicting word", sv == "nope", 1);
    count = $fscanf(fd, "%d", iv);
    `CHECKI("EOF count", count, -1);
    `CHECKI("EOF preserves last integer", iv, 34);
    $fclose(fd);
    I(p,n) <+ V(p,n);
  end
endmodule
