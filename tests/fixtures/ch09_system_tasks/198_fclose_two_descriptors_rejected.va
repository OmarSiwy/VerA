// §9.5.1 Syntax 9-2:
//
//   file_close_task ::= $fclose ( multi_channel_descriptor ) ;
//                     | $fclose ( fd ) ;
//
// Both productions take exactly ONE argument. To close two files at once the
// clause gives the mcd shape its own mechanism — "The $fclose system task ...
// closes the file(s) specified by the multichannel descriptor mcd", i.e. the
// bits are OR'd into one argument — so a second argument is not an alternative
// spelling of that, it is outside the grammar.
//
// Until this fixture VerA accepted the call without a word (and `$fclose()`
// with none). The one-argument statement `$fclose(a | b)`, the form the
// clause does define, compiles (probed).
//
// VerA reports E0887 "wrong number of arguments to a system task or function".
//
//! lrm 9.5.1
//! reject-only E0887
//! reject `$fclose` takes 1 argument, got 2
`include "disciplines.vams"
module ch09_fclose_two_descriptors(p, n);
  inout p, n; electrical p, n;
  integer a, b;
  analog begin
    @(initial_step) begin
      a = $fopen("ch09_198_a.log");
      b = $fopen("ch09_198_b.log");
      $fclose(a, b);                     // illegal: Syntax 9-2 has one slot
    end
    I(p, n) <+ V(p, n);
  end
endmodule
