// DEBT — this rejection is NOT conformance.
// The LRM permits what VerA refuses here. The substrings below record
// CURRENT behavior so the suite stays green on it; they do not claim it
// is right. `zig build ledger` counts this rule against VerA.
//
// VAMS-9.13.2-01  (ch9-system.html)
// For the $rdist_exponential, $rdist_poisson, $rdist_chi_square, $rdist_t, and $rdist_erlang functions, the arguments mean, degree_of_freedom, and k_sta
//
//! reject E0801
//! reject $rdist_exponential
// EXPECT: error
// LRM 9.13.2: $rdist_exponential draws a pseudo-random variate from a seed the call itself updates, so it differs on every Newton re-evaluation of one operating point -- a non-deterministic residual that never converges (determinism invariant); the whole 9.13 family is rejected.
module ch09_rdist_exponential_unsupported(p, n);
  inout p, n; electrical p, n;
  integer seed;
  analog I(p,n) <+ $rdist_exponential(seed, 3.0);
endmodule
