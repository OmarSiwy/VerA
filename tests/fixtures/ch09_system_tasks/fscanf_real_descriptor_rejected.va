// §9.5.4: "Files opened using FILE DESCRIPTORS can be read from only if they
// were opened with either the r or r+ type values." Reading is defined for a
// file descriptor and for nothing else, and §9.5.4.2 prints the call as
//
//   code = $fscanf( fd, format, args );
//
// with "$fscanf reads from the file specified by fd". §9.5.1 makes fd "a 32-bit
// value" whose "most significant bit (bit 31) ... shall always be set; this
// allows implementations of the file input and output functions to determine
// how the file was opened."
//
// `src` below is a REAL copy of a descriptor that was opened "r". A real has
// no bit 31, so it cannot tell the reader how the file was opened — it is not
// a file descriptor, and §9.5.4 gives reading through anything else no
// meaning. With `src` declared `integer` the file compiles (probed); only the
// descriptor's type is wrong here.
//
// The file is never read: the fixture is refused at compile time.
//
// VerA reports E0888 "descriptor argument is not an integer".
//
//! lrm 9.5.4
//! lrm 9.5.4.2
//! reject-only E0888
//! reject `$fscanf`'s descriptor argument is a real
`include "disciplines.vams"
module ch09_fscanf_real_descriptor(p, n);
  inout p, n; electrical p, n;
  integer fd, code, item;
  real src;
  analog begin
    @(initial_step) begin
      fd = $fopen("ch09_200.dat", "r");
      src = fd;
      code = $fscanf(src, "%d", item);   // illegal: a real is not a file descriptor
    end
    I(p, n) <+ V(p, n);
  end
endmodule
