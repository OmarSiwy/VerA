// §9.5.2 lists $fdebug among the file counterparts of the display tasks;
// §9.4.1 gives $debug its distinguishing behaviour — it "displays its arguments
// for each iteration of the analog solver" rather than once per accepted step.
// Either way the argument is the branch potential of the point being evaluated,
// and this fixture holds BOTH nodes, so every iterate is the same point.
// §1.3.1 pins it: V(p,n) = 1.75 - 0.75 = 1.0 V, exact in binary floating point.
//
//! lrm 9.5.2
//! bias V(p) = 1.75, V(n) = 0.75
`include "check.vh"
module ch09_atomic_fdebug(p, n);
  inout p, n; electrical p, n;
  integer fd;
  analog begin
    fd = $fopen("ch09_043_fdebug.log", "a");
    `CHECK("the debugged value is the branch potential", V(p,n), 1.0, 1e-15);
    $fdebug(fd, "value=%g", V(p,n));
    I(p,n) <+ V(p,n);
  end
endmodule
