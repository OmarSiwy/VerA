// §9.5.1 defines TWO return shapes for $fopen and the suite only tested one.
// Syntax 9-2:
//
//     mcd = $fopen ( filename ) ;
//     fd  = $fopen ( filename , type ) ;
//
// "If type is omitted, the file is opened for writing, and a multichannel
// descriptor mcd is returned." 07_file_open_close.va and 052_fflush.va both use
// the two-argument form; this is the one-argument form, and the LRM pins its
// bit pattern exactly:
//
//   "The multichannel descriptor mcd is a 32-bit integer in which a SINGLE BIT
//    is set indicating which file is opened. The least significant bit (bit 0)
//    of an mcd always refers to the standard output. ... The most significant
//    bit (bit 31) of a multichannel descriptor is reserved and shall always be
//    CLEARED, limiting an implementation to at most 31 files opened for output
//    via multichannel descriptors."
//
// Three checks follow with no reference to any host:
//
//   bit 31 clear          — this is an mcd, not the fd whose bit 31 "shall
//                           always be set". That bit is the whole discrimination
//                           §9.5.1 builds so $fclose and $fdisplay can tell the
//                           two overloads apart, and it is why "file descriptors
//                           cannot be combined via bitwise OR" while mcds can.
//   exactly one bit set   — `mcd & (mcd-1)` is zero for a power of two and for
//                           nothing else; a nonzero mcd with two bits set is two
//                           channels, which one $fopen may not return.
//   not bit 0             — bit 0 is standard output, which is pre-opened and
//                           is not this file. An implementation that answered
//                           $fopen with 1 would quietly route every later
//                           $fdisplay to the transcript.
//
// The mcd is nonzero because the open cannot fail: the one-argument form opens
// "for writing", which creates.
//
// Masked, not shifted: `>>` fills with zeros on a 32-bit integer, but VerA
// carries integers in an i64 where a sign-extended descriptor would answer a
// shift differently. `& 2147483648` is bit 31 whatever the width.
//
//! lrm 9.5.1
//! xfail VerA has no file-descriptor surface: codegen.zig `void_tasks` lowers the whole §9.5 family to the constant `S.con(0.0)`, so the one-argument $fopen answers 0 — bit 31 is clear by accident but no bit is set at all
`include "check.vh"
module ch09_fopen_multichannel_descriptor(p, n);
  inout p, n; electrical p, n;
  integer mcd;
  analog begin
    mcd = $fopen("ch09_158_mcd.log");
    `CHECKI("§9.5.1 an mcd has bit 31 clear", (mcd & 2147483648) == 0, 1);
    `CHECKI("§9.5.1 an mcd has exactly one bit set", (mcd != 0) && ((mcd & (mcd - 1)) == 0), 1);
    `CHECKI("§9.5.1 bit 0 is standard output, so a fresh channel is not 1", mcd != 1, 1);
    $fclose(mcd);
    I(p,n) <+ V(p,n) + mcd;
  end
endmodule
