// §9.2 Table 9-11 lists $atan2 as supported in the analog context; §4.3
// Table 4-15 defines it as C `atan2(y,x)` — the arc-tangent of y/x IN RADIANS,
// for all x and all y, with atan2(0,0) = 0. Note the argument order: the
// NUMERATOR comes first. §4.3 makes the `$` and traditional spellings the same
// function.
//
// With y = V(p,n) = 0.5 and x = 1: atan2(0.5, 1) = atan(0.5) = 0.4636476090008061.
// The point of atan2 over atan is the quadrant, which only a second argument can
// carry: atan2(0.5, -1) = pi - atan(0.5) = 2.677945044588987, whereas
// atan(0.5 / -1) would collapse to -0.4636476090008061.
//
//! lrm 9.14
//! bias V(p) = 0.5
`include "check.vh"
module ch09_atomic_atan2(p, n);
  inout p, n; electrical p, n;
  analog begin
    `CHECK("$atan2(0.5, 1) in radians", $atan2(V(p,n), 1.0), 0.4636476090008061, 1e-15);
    `CHECK("$atan2 carries the quadrant", $atan2(V(p,n), -1.0), 2.677945044588987, 1e-15);
    `CHECK("atan2(0, 0) is 0", $atan2(0.0, 0.0), 0.0, 1e-15);
    `CHECK("traditional atan2() is the same function", atan2(V(p,n), 1.0), 0.4636476090008061, 1e-15);
    I(p,n) <+ V(p,n) + $atan2(V(p,n), 1.0);
  end
endmodule
