// §9.7.3: "Non-fatal system severity tasks ($error, $warning, $info) called
// during a rejected iteration shall have no effect."
//
// THE REJECTED ITERATION is b6_finish_in_rejected_iteration_has_no_effect.va's
// (from 184_limit_veto_after_correction.va): iteration 1 lands on v = 1e-10,
// already inside abstol, and vetoes itself with $discontinuity(-1), which
// `limit` reads at old = the updated vector, so iteration 1 is rejected and
// iteration 2 is accepted at the same voltage. The guard must not read V:
// `limit` sees old = 1e-10, but the display pass sees the pre-update x = 0,
// where V > 0 is false.
//
// THE OBSERVABLE. The display pass of iteration 1 reaches the three guarded
// tasks; only the pass gate keeps them from running. Their only effect is the
// message, and each message starts with "FAIL", which the harness treats as
// the testbench reporting a failure wherever it appears in the transcript. So
// any one of the three printing fails this file; none printing, with both
// checks present, passes it.
//
//   iteration at acceptance = 2,  V(p,n) = 1e-10,  no "FAIL" text
//
//! lrm 9.7.3
//! lrm 9.7.3:6
//! lrm 9.17.1
//! solve
//! bias V(n) = 0
//! checks 2
`include "check.vh"
module b6_severity_in_rejected_iteration_has_no_effect(p, n);
  inout p, n; electrical p, n;
  analog begin
    if ($simparam("iteration") == 1) begin
      $discontinuity(-1);
      $error("FAIL: $error in a rejected iteration was reported");
      $warning("FAIL: $warning in a rejected iteration was reported");
      $info("FAIL: $info in a rejected iteration was reported");
    end
    I(p, n) <+ V(p, n) - 1e-10;
    `CHECK("the accepted vector is the iterate after the vetoed one", $simparam("iteration"), 2.0, 0.0);
    `CHECK("the run reached the accepted solution", V(p, n), 1e-10, 1e-18);
  end
endmodule
