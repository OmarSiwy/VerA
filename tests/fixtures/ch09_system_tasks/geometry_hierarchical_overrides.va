// §9.18: "The rules for combining the values are given in Table 9-29."
// Positions add without rotation or reflection; flips multiply; angles add
// modulo 360 degrees. From the table's top-level identities, the outer values
// are (x,y,angle,hflip,vflip,mfactor) = (2,-4,300,-1,-1,2). Its inner values are
// (-1,2,40,+1,-1,6), because (300+100) modulo 360 = 40. The next instance has
// empty named associations, which supply no new value (§6.3.3), and inherits
// those six values. A sibling has the top-level identities: no instance's
// override may leak into another instance of the same module.
// The five geometric controls have no automatic simulation effect (§6.3.6).
// Invalid flip/angle values have isolated E0890 neighbours in this directory;
// positions allow any value, so there is no invented position rejection.
//! lrm 6.3.3
//! lrm 6.3.6
//! lrm 9.18
//! lrm 6.3.3:2
//! lrm 6.3.6:1
//! lrm 6.3.6:2
//! lrm 9.18:1000
//! checks 18
`include "check.vh"
module geometry_hierarchy_top;
  geometry_outer #(.$xposition(2), .$yposition(-4), .$angle(300),
                   .$hflip(-1), .$vflip(-1), .$mfactor(2)) outer();
  geometry_leaf sibling();
endmodule
module geometry_outer;
  geometry_inner #(.$xposition(-3), .$yposition(6), .$angle(100),
                   .$hflip(-1), .$mfactor(3)) inner();
  analog begin
    `CHECKX("outer x", $xposition, 2.0);
    `CHECKX("outer y", $yposition, -4.0);
    `CHECKX("outer angle", $angle, 300.0);
    `CHECKX("outer hflip", $hflip, -1.0);
    `CHECKX("outer vflip", $vflip, -1.0);
    `CHECKX("outer mfactor", $mfactor, 2.0);
  end
endmodule
module geometry_inner;
  geometry_leaf #(.$xposition(), .$yposition(), .$angle(), .$hflip(),
                  .$vflip(), .$mfactor(), .x(-1), .y(2), .a(40),
                  .h(1), .v(-1), .m(6)) inherited();
endmodule
module geometry_leaf;
  parameter real x=0, y=0, a=0, h=1, v=1, m=1;
  analog begin
    `CHECKEQ("leaf x", $xposition, x, 0);
    `CHECKEQ("leaf y", $yposition, y, 0);
    `CHECKEQ("leaf angle", $angle, a, 0);
    `CHECKEQ("leaf hflip", $hflip, h, 0);
    `CHECKEQ("leaf vflip", $vflip, v, 0);
    `CHECKEQ("leaf mfactor", $mfactor, m, 0);
  end
endmodule
