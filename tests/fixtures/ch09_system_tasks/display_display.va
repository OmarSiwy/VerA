// §9.4.1 "The $display task provides the same capabilities as $strobe", and
// §9.4.3 Table 9-23 makes %e an exponential rendering of a real. Neither
// changes the argument VALUE, which §1.3.1 pins: V(p,n) = 1.5 - 0.5 = 1.0 V,
// exact in binary floating point.
//
//! lrm 9.4.1
//! bias V(p) = 1.5, V(n) = 0.5
`include "check.vh"
module ch09_display_display(p, n);
  inout p, n; electrical p, n;
  analog begin
    `CHECK("the %e argument is the branch potential", V(p,n), 1.0, 1e-15);
    $display("accepted value %e", V(p,n));
    I(p,n) <+ V(p,n);
  end
endmodule
