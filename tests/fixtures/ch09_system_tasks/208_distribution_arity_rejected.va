// §9.13: "Verilog-AMS HDL extends the probabilistic distribution functions so
// that they are supported in the analog context. Also, real versions of the
// probabilistic distribution functions are introduced". The real versions'
// argument lists are §9.13.2's Syntax 9-9, and for the uniform one that is
//
//   $rdist_uniform ( seed , start_expression , end_expression [, type_string] )
//
// Only the type_string is optional. The interval needs both ends — §9.13.2:
// "In $rdist_uniform, the start and end arguments are real inputs which bound
// the values returned. The start value shall be smaller than the end value." —
// and with the end missing, "shall be smaller than the end value" has nothing
// to compare against. This file passes seed and start and stops. Adding the
// end, `$rdist_uniform(seed, 0.0, 10.0)`, compiles (probed).
//
// VerA reports E0816, the §9.13 argument-rule code, naming the arity.
//
//! lrm 9.13
//! lrm 9.13.2
//! lrm 9.13.2:5
//! reject-only E0816
//! reject `$rdist_uniform` takes
`include "disciplines.vams"
module ch09_distribution_arity(p, n);
  inout p, n; electrical p, n;
  integer seed;
  real draw;
  analog begin
    @(initial_step) seed = 7;
    draw = $rdist_uniform(seed, 0.0);    // illegal: no end of the interval
    I(p, n) <+ V(p, n) + 0.0 * draw;
  end
endmodule
