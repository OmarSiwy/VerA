// §9.13.2: "For the $rdist_exponential, $rdist_poisson, $rdist_chi_square,
// $rdist_t, and $rdist_erlang functions, the arguments mean,
// degree_of_freedom, and k_stage shall be greater than zero (0). Otherwise an
// error shall be reported."
//
// The legal neighbour of b6_rdist_zero_mean_at_run_time_is_an_error.va: the
// same module, whose mean is the probe V(p,n), at points where it stays
// greater than zero. Only the second point differs:
//
//   point 0, V(p) = 1.0:  mean 1.0 > 0, legal; the check prints 1.0 > 0.5 = 1.
//   point 1, V(p) = 0.75: mean 0.75 > 0, legal; no error is reported, and
//     the check prints 0.75 > 0.5 = 1.
//
// So the run ends normally (status 0) with two passing checks, where the
// neighbour's mean 0 ends it with E0816 after one.
//
//! lrm 9.13.2
//! lrm 9.13.2:2
//! sweep V(p) = 1.0, 0.75
//! checks 2
`include "check.vh"
module b6_rdist_positive_mean_at_run_time(p, n);
  inout p, n; electrical p, n;
  integer seed;
  real r;
  analog begin
    seed = 5;
    `CHECKI("printed at both points: each mean is greater than zero", V(p, n) > 0.5, 1);
    r = $rdist_exponential(seed, V(p, n));
    I(p, n) <+ V(p, n) + 1e-9 * r;
  end
endmodule
