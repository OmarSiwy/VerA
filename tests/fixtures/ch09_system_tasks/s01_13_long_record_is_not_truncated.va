// The scratch-buffer ceiling, from both sides, in one file.
//
// §9.4.3 makes the C field width part of the real conversions ("the full
// formatting capabilities available in the C language. For example, the format
// specification %10.3g sets a MINIMUM FIELD WIDTH of 10"), and C11 7.21.6.1p5
// fixes what a width does: "if the converted value has fewer characters than the
// field width, it is padded with spaces ... to the field width". §9.5.2 gives
// $fdisplay $display's argument list with a descriptor in front, and §9.5.5's
// $ftell then reports "the offset from the beginning of the file of the current
// byte", which after one write is the number of bytes written.
//
// §9.5.4.1 fixes the other direction: "$fgets reads characters from the file
// specified by fd into the string variable, str until a newline character is read
// and transferred to str, or an EOF condition is encountered. ... the number of
// characters read is returned in code." Neither sentence has a length limit in
// it, and §3.3's `string` is not a fixed-width type.
//
// HAND DERIVATION, the write:
//
//   $fdisplay(fd, "%600.2f", 3.5)
//     "3.50" is four characters (precision 2 on an exact dyadic operand).
//     Field width 600, right-justified -> 596 spaces then "3.50" = 600 bytes.
//     $fdisplay is the $display family member, so §9.4.1's newline is appended.
//     -> 601 bytes.
//
// HAND DERIVATION, the read back:
//
//   $fgets reads to and including the newline -> 601 characters, and §9.5.5's
//   position afterwards is 601. The file holds nothing else, so a second $fgets
//   would hit EOF; that is not asserted here, 08_fscanf_successive_scans pins the
//   EOF rule already.
//
// The second half of the file repeats the read against a line assembled from
// SEVEN separate $fwrite calls (six fields plus the newline), so that the read
// limit is exercised independently of whether the write limit was honoured:
// 5 x 100 + 99 = 599 characters plus one newline = 600 bytes. If the writer is
// fixed and the reader is not, the first pair passes and this one still fails.
//
// WHAT THIS CATCHES TODAY. Both ceilings are 512 bytes of per-call-site scratch
// (lib/backend/str_kernels.zig zSBuf, lib/backend/file_kernels.zig ZFSlot.line)
// and both are documented as deliberate shortcuts rather than as limits any
// clause states. The write ceiling does not truncate — it drops the record
// entirely and the file ends up 0 bytes long — and the read ceiling returns 512
// and leaves the rest of the line for a subsequent read that no application
// asked for. A 601-column report line is unusual; a 601-byte line of comma-
// separated table data is not, and it is the input case that silently splits a
// row in two.
//
//! lrm 9.4.3
//! lrm 9.5.2
//! lrm 9.5.4.1
//! lrm 9.5.5
//! print none
`include "check.vh"
module s01_long_record(p, n);
  inout p, n; electrical p, n;
  integer fd, written, read_back, after, built, got, pos;
  string line, other;
  analog begin
    fd = $fopen("s01_13_wide.dat", "w");
    $fdisplay(fd, "%600.2f", 3.5);
    written = $ftell(fd);
    $fclose(fd);

    fd = $fopen("s01_13_wide.dat", "r");
    read_back = $fgets(line, fd);
    after = $ftell(fd);
    $fclose(fd);

    fd = $fopen("s01_13_built.dat", "w");
    $fwrite(fd, "%100.2f", 3.5);
    $fwrite(fd, "%100.2f", 3.5);
    $fwrite(fd, "%100.2f", 3.5);
    $fwrite(fd, "%100.2f", 3.5);
    $fwrite(fd, "%100.2f", 3.5);
    $fwrite(fd, "%99.2f", 3.5);
    $fwrite(fd, "\n");
    built = $ftell(fd);
    $fclose(fd);

    fd = $fopen("s01_13_built.dat", "r");
    got = $fgets(other, fd);
    pos = $ftell(fd);
    $fclose(fd);

    `CHECKI("§9.4.3 a 600-column field plus §9.4.1's newline is 601 bytes", written, 601);
    `CHECKI("§9.5.4.1 $fgets returns every character up to and including the newline", read_back, 601);
    `CHECKI("§9.5.5 and the position afterwards is the whole line", after, 601);

    `CHECKI("§9.5.2 six $fwrite fields plus a newline are 600 bytes", built, 600);
    `CHECKI("§9.5.4.1 a 600-byte line read in one call returns 600", got, 600);
    `CHECKI("§9.5.5 and leaves the position at the end of the line", pos, 600);

    I(p,n) <+ V(p,n) + written + read_back + built + got;
  end
endmodule
