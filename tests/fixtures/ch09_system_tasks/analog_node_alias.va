// §9.20: "The return value for both system functions shall be one (1) if the
// hierarchical_reference_string points to a valid continuous node and zero (0)
// otherwise." The string here names `$root.top.n` — an instance `top` beneath
// the root of the instance hierarchy (§6.7). This compilation elaborates this
// module AS the top level and instantiates nothing, so no such instance exists,
// the reference resolves to nothing, and the status is 0. §9.20 then says
// `local_node` stays an ordinary continuous node of this module.
//
//! lrm 9.20
//! lrm 9.20:10
`include "check.vh"

module ch09_atomic_analog_node_alias(p, n);
  inout p, n; electrical p, n;
  electrical local_node; integer status;
  analog initial begin
    status = $analog_node_alias(local_node, "$root.top.n");
  end
  analog begin
    `CHECKI("$analog_node_alias on an unresolvable hierarchical reference", status, 0);
    I(p,n) <+ V(local_node) + status * 0.0;
  end
endmodule
