// §9.4.3: the real conversions of Table 9-23 "have the full formatting
// capabilities available in the C language", and C11 7.21.6.1p6's '#' flag
// gives f its alternative form: "the result of converting a floating-point
// number always contains a decimal-point character, even if no digits follow
// it". Without '#', p8: "If the precision is zero and the # flag is not
// specified, no decimal-point character appears." Before #41 the '#' was read
// as the conversion letter and `%#.0f` printed the value and then "f".
//
// HAND DERIVATION (%f: the integer digits, then `.precision` fractional
// digits; each value below is an integer or an exact binary fraction, so no
// rounding is involved):
//
//   %.0f    of 2.0   no fractional digit, no '#':         -> "2"
//                    (the neighbour: the same field without the flag)
//   %#.0f   of 2.0   '#' adds the point:                  -> "2."
//   %#.0f   of -3.0  the sign, then "3.":                 -> "-3."
//   %#08.0f of 7.0   "7." is two characters; '0' pads the width of 8 with
//                    six zeros in front (no sign to keep before them):
//                                                         -> "0000007."
//   %#-6.0f| of 4.0  '-' left-justifies "4." in six columns, four spaces
//                    on the right:                        -> "4.    |"
//   %#.2f   of 1.5   two fractional digits already print a point, so '#'
//                    changes nothing:                     -> "1.50"
//
//! lrm 9.4.3
//! lrm 9.5.3
//! print none
`include "check.vh"
module s01_real_hash_flag_f(p, n);
  inout p, n; electrical p, n;
  string plain, alt, neg, zero, left, prec;
  analog begin
    $sformat(plain, "%.0f",     2.0);
    $sformat(alt,   "%#.0f",    2.0);
    $sformat(neg,   "%#.0f",    -3.0);
    $sformat(zero,  "%#08.0f",  7.0);
    $sformat(left,  "%#-6.0f|", 4.0);
    $sformat(prec,  "%#.2f",    1.5);

    `CHECKI("§9.4.3/C11 %.0f prints no point without '#' (neighbour)", (plain == "2"), 1);
    `CHECKI("§9.4.3/C11 '#' on %.0f always prints the point", (alt == "2."), 1);
    `CHECKI("§9.4.3/C11 '#' on %.0f of a negative value", (neg == "-3."), 1);
    `CHECKI("§9.4.3/C11 '#' with '0' and a width: zeros, then the digits and the point", (zero == "0000007."), 1);
    `CHECKI("§9.4.3/C11 '#' with '-': the point, then the right-hand pad", (left == "4.    |"), 1);
    `CHECKI("§9.4.3/C11 '#' on %f with a nonzero precision changes nothing", (prec == "1.50"), 1);

    I(p,n) <+ V(p,n);
  end
endmodule
