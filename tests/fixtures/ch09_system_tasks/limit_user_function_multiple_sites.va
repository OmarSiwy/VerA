// §9.17.3 with more than one `$limit` in a module, and one of them under an
// `if`. Both are cases a real device model writes — a BJT limits vbe and vbc, a
// MOSFET vgs/vds/vbs/vbd — and both are cases the STRING form of `$limit`
// handles in the host, where the clamp list has no control flow and a guarded
// site is declined outright (cg_limit.zig). The user-function form runs INSIDE
// `eval`, so it has the body's control flow and needs neither exception.
//
// WHAT EACH SITE PINS.
//
//   V(a,c)  two sites, reader and writer, on the SAME access function: one
//           piece of state, so the reader sees what the writer left. This is
//           the ngspice `BJTvbe`/`MOS1vgs` idiom.
//   V(b,c)  one site, on a DIFFERENT access function: its own state, unrelated
//           to the first. Two access functions are two slots, so a clamp on one
//           branch cannot leak into the other.
//   V(b,c)  again, under `if (V(b,c) > 1.5)` — the guarded site. When the guard
//           is false the slot keeps what it held; when it is true the guarded
//           site is the LAST writer and its return is what the next evaluation
//           reads. That "keeps what it held" is not a special case in the
//           backend: the slot is an ordinary SSA place seeded with the previous
//           return, so a branch that does not run leaves the seed in it.
//
// THE NUMBERS. `step` is a +/-1 V per-evaluation clamp. The harness walks
// V(a) over 0, 4, 8 and V(b) over 0, 4, 4 with c at the reference:
//
//   pt  V(a)  a_old  a_lim | V(b)  b_old  guard   b_lim
//    0    0     0      0   |   0     0    false     0
//    1    4     0      1   |   4     0    true      1   (guarded site runs)
//    2    8     1      2   |   4     1    true      2
//
// b's guard is false at point 0 only, and the b slot still advances from point 1
// on — the unguarded site above the `if` is a writer too.
//
//
// UNTAGGED (VD-082: a pinned choice carries no clause tag): §9.17.3 fixes no
// state model for several sites on one access function; the per-access-function
// slot and the guarded-site rule are VerA's.
// The callbacks call $discontinuity(-1) when they return other than their
// first argument, as §9.17.3 requires of a user-defined limiter.
//! fd-exempt §9.17.3: the residual is evaluated at the limited iterate and the Jacobian is taken w.r.t. it (Newton linearization), so a difference across the clamp is not the Jacobian
//! time 0, 1, 2
//! wave V(a) = 0, 4, 8
//! wave V(b) = 0, 4, 4
`include "check.vh"
module ch09_limit_multiple_sites(a, b, c);
  inout a, b, c; electrical a, b, c;
  real a_old, a_lim, b_old, b_lim;

  analog function real getold;
    input vnew, vold;
    real vnew, vold;
    begin
      getold = vold;
      // §9.17.3: "shall call $discontinuity(-1) when its return value is not
      // sufficiently close to the value of its first argument".
      if (abs(vold - vnew) > 1e-12) $discontinuity(-1);
    end
  endfunction

  // A limiter that limits: at most 1 V of movement per evaluation, measured
  // from the value this call site returned last time.
  analog function real step1;
    input vnew, vold;
    real vnew, vold;
    begin
      step1 = vold + max(-1.0, min(1.0, vnew - vold));
      if (abs(step1 - vnew) > 1e-12) $discontinuity(-1);
    end
  endfunction

  analog begin
    // Reader and writer on V(a,c) — two sites, ONE piece of state.
    a_old = $limit(V(a,c), getold);
    a_lim = $limit(V(a,c), step1);

    // A second access function, so a second slot.
    b_old = $limit(V(b,c), getold);
    b_lim = $limit(V(b,c), step1);
    // …and a THIRD site on it, guarded. Its return is what the next evaluation
    // reads whenever it runs; when it does not, the slot keeps b_lim.
    if (V(b,c) > 1.5) b_lim = $limit(V(b,c), step1);

    // Closed forms of the table above, subtracted so every want is a literal 0
    // (the suite refuses an expression in the WANT column).
    `CHECK("V(a,c): reader sees the writer's previous return, a_old - (t-1) is 0",
           a_old - max(0.0, $abstime - 1.0), 0.0, 1e-12);
    `CHECK("V(a,c): clamped 1 V per evaluation, so a_lim - t is 0",
           a_lim - $abstime, 0.0, 1e-12);
    `CHECK("V(b,c): its own slot, not V(a,c)'s, so b_old - (t-1) is 0",
           b_old - max(0.0, $abstime - 1.0), 0.0, 1e-12);
    `CHECK("V(b,c): the guarded site is the last writer, so b_lim - t is 0",
           b_lim - $abstime, 0.0, 1e-12);

    I(a,c) <+ a_lim;
    I(b,c) <+ b_lim;
  end
endmodule
