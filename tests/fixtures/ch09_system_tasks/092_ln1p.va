// §9.14 Table 9-11 lists $ln1p and makes it an alias of the §4.3.1 operator.
// Table 4-14: "$ln1p(x) ... C log1p ... Natural logarithm of 1 plus x", domain
// x > -1. §4.3.1 adds "For small magnitude values of x, ln1p(x) can be more
// accurate than ln(1+x)".
//
// Two claims, both derived from ln(1+x) alone:
//
//   ln(1 + 0.5) = ln(3/2) = 0.40546510810816438 to double precision.
//
//   the small-x case is the only thing that distinguishes ln1p from ln(1+x).
//   For x = 5e-16, ln(1+x) = x - x^2/2 + ... = 4.9999999999999994e-16 once
//   rounded to a double. Forming (1 + x) FIRST cannot produce that: doubles
//   near 1 are spaced 2^-52 = 2.22e-16, so 1+5e-16 rounds to 1 + 2*2^-52 and
//   ln of that is 4.4408920985006252e-16 — 11% low. The rtol below is far
//   tighter than that gap, so only an implementation that never forms 1+x
//   passes.
//
//! bias V(p) = 0.5
//! lrm 9.14
//! lrm 4.3.1
//! xfail VerA forms 1+x: codegen.zig `zLn1p` is `a.addC(1.0).log()`, so $ln1p(5e-16) returns 4.440892098500625e-16 — 11% low, precisely the ln(1+x) value Table 4-14's C log1p exists to replace
`include "check.vh"
module ch09_atomic_ln1p(p, n);
  inout p, n; electrical p, n;
  analog begin
    `CHECK("ln1p(0.5) is ln(3/2)", $ln1p(V(p,n)), 0.40546510810816438, 1e-15);
    `CHECKR("ln1p(5e-16) never forms 1+x", $ln1p(V(p,n)*1e-15), 4.9999999999999994e-16, 1e-9);
    I(p,n) <+ V(p,n) + $ln1p(V(p,n));
  end
endmodule
