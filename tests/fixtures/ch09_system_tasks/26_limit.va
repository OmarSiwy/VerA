// §9.17.3 `$limit(access_function_reference)`: "It returns a real value that is
// derived from its first argument ... On any iteration where the output value
// is not the same as the value of the access function (within appropriate
// tolerances), the simulator is prevented from terminating the iteration."
//
// That sentence is what makes this checkable. A printed operating point is an
// ACCEPTED solution — the iteration terminated — so at the point the transcript
// shows, $limit() must already have returned the branch potential itself. The
// LRM adds that "the simulator may simply choose to have $limit() return the
// value of its first argument"; either way the converged answer is V(p,n).
//
// The contribution is then exp(0.25) - 1 = 0.2840254166877414 (§4.3.1 exp),
// which pins the same value once more through the constitutive relation rather
// than through the local variable.
//
//! bias V(p) = 0.25
`include "check.vh"
module ch09_limit(p, n);
  inout p, n; electrical p, n;
  real limited;
  analog begin
    limited = $limit(V(p,n));
    `CHECK("at an accepted solution $limit returns the access function itself",
           limited, 0.25, 1e-15);
    `CHECK("so the diode-like current is exp(0.25) - 1",
           exp(limited) - 1.0, 0.2840254166877414, 1e-15);
    I(p,n) <+ exp(limited) - 1.0;
  end
endmodule
