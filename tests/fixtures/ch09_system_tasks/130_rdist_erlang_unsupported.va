//! reject E0801
//! reject $rdist_erlang
// EXPECT: error
// LRM 9.13.2: $rdist_erlang draws a pseudo-random variate from a seed the call itself updates, so it differs on every Newton re-evaluation of one operating point -- a non-deterministic residual that never converges (determinism invariant); the whole 9.13 family is rejected.
module ch09_rdist_erlang_unsupported(p, n);
  inout p, n; electrical p, n;
  integer seed;
  analog I(p,n) <+ $rdist_erlang(seed, 2.0, 3.0);
endmodule
