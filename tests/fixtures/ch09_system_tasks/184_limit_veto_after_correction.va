// A correction below voltage tolerance can cross a rejection boundary.
//! lrm 9.17.1
//! lrm 9.15
//! solve
//! bias V(n) = 0
`include "check.vh"
module ch09_limit_veto_after_correction(p, n);
  inout p, n; electrical p, n;
  analog begin
    if ($simparam("iteration") == 1 && V(p,n) > 0.0)
      $discontinuity(-1);
    I(p,n) <+ V(p,n) - 1e-10;
    `CHECK("veto applies to the accepted vector", $simparam("iteration"), 2.0, 0.0);
    `CHECK("the solved voltage is retained", V(p,n), 1e-10, 1e-18);
  end
endmodule
