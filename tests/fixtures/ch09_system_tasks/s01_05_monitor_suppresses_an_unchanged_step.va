// §9.4.1, the sentence that separates $monitor from $strobe and is the whole
// reason the task exists (specification/ch9-system.html, quoted in full):
//
//   "When a $monitor task is invoked with one or more arguments, the simulator
//    sets up a mechanism whereby for each accepted step, IF THE VARIABLE OR AN
//    EXPRESSION IN THE ARGUMENT LIST CHANGES VALUE compared with the last
//    accepted step — with the exception of the $abstime or $realtime system
//    functions — the entire argument list is displayed AT THE END OF THE TIME
//    STEP as if reported by the $strobe task. If two or more arguments change
//    value at the same time, only one display is produced that shows the new
//    values."
//
// §9.5.2 carries that to the file form verbatim: "The $fstrobe and $fmonitor
// system tasks work just like their counterparts, $strobe and $monitor, except
// that they write to files using the file descriptor."
//
// WHY THIS FILE WAS RESHAPED. The earlier version invoked $fmonitor and then
// read $ftell on the same descriptor inside the SAME analog-block evaluation,
// and closed the file before the step ended. That measurement is unsound
// against the clause it cites: "at the end of the time step" puts the record
// AFTER the block that registered it, so a conforming implementation writes
// nothing the reading $ftell could see and the old file read -2 on its first
// row. §9.5.9 points the same way for the file form — a write during an
// iterative solve "shall not be performed unless the iteration is accepted",
// i.e. not at the moment the statement is executed. The fixture was satisfiable
// only by an implementation that prints inline, which is exactly the
// implementation §9.4.1 excludes. It now measures ACROSS steps instead.
//
// THE MEASUREMENT. §5.10.2 makes an unqualified initial_step active during
// the solution of the first point, or initial DC analysis. This fixture's
// fixed-grid runner evaluates each declared point once, so its descriptor is
// opened and its monitor registered once under `@(initial_step)`.
// Nothing closes or truncates it mid-run, so §9.5.5's $ftell ("returns in pos
// the offset from the beginning of the file of the current byte") read at the
// TOP of step k is the total number of bytes the monitor has produced at the
// ends of steps 0 .. k-1. That is a quantity the clause fixes and that no
// statement in this step has touched.
//
// Registering once also removes the other latitude: a $monitor re-invoked every
// step is arguably a fresh "sets up a mechanism", under which an implementation
// may legitimately report at every step. There is exactly one invocation here,
// so the only question left is the one the clause answers.
//
// HAND DERIVATION.
//   `//! wave V(p) = 0.5` holds the potential at every declared time and V(n)
//   is tied to the reference, so V(p,n) = 0.5 at all four steps and the
//   monitored expression V(p,n)*4 is 2 at all four steps. §4.2.1.1 converts it
//   for %0d by rounding to nearest, giving the single character '2' (the zero
//   width drops IEEE 1364 §17.1.1.3's automatic field); §9.4.1 gives
//   $monitor $strobe's trailing newline. One record is therefore 2 bytes.
//
//   end of step t=0  first accepted step, nothing to compare against, reported
//   end of step t=1  the list is unchanged             -> nothing written
//   end of step t=2  the list is unchanged             -> nothing written
//   end of step t=3  the list is unchanged             -> nothing written
//
//   so $ftell at the top of each step reads
//
//     t = 0 -> 0     t = 1 -> 2     t = 2 -> 2     t = 3 -> 2
//
//   The four rows collapse to one literal because `2 * ($abstime > 0)` is 0 on
//   the first step and 2 afterwards, so `bytes - 2*($abstime > 0)` is 0 at every
//   step. ($abstime is used to SELECT the row, not as a monitored argument; it
//   is not in the $fmonitor argument list, so the clause's $abstime exception
//   does not come into it.)
//
// WHAT FAILS IT, IN BOTH DIRECTIONS.
//   An implementation with no change detection — one that reports on every
//   accepted step — leaves 0, 2, 4, 6 and answers 0, 0, 2, 4.
//   An implementation that never reports at all leaves 0, 0, 0, 0 and answers
//   0, -2, -2, -2.
//   So this file alone discriminates over-reporting from under-reporting;
//   06_monitor_reports_every_change.va is not needed to close that hole and
//   pins the complementary positive obligation instead.
//
// The first step is counted as "reported" rather than "suppressed" because
// there is no "last accepted step" to compare against at t = 0; the mechanism
// has to start somewhere and the argument list is what it is asked to display.
//
// WHAT IT TOOK — two defects, closed together on 2026-09-23. (1) VerA's §9.4.1
// was a print-if-changed AT THE STATEMENT, so a monitor registered once under
// the guard never reported again. The statement now arms site k where it
// stands and the report runs at the end of every accepted step from then on
// (`lower_event.armMonitor`). (2) The guarded `$fopen`'s RESULT could not leave
// the display unit: `emitFileCallDropped` rendered it as the literal 0 in the
// core, so `updateState` held fd = 0 and `$ftell(fd)` was `$ftell(0)` = -1. The
// display unit now latches it (`file_kernels.zFRes`) and the core reads that.
//
//! lrm 9.4.1
//! lrm 9.5.2
//! lrm 9.5.5
//! lrm 5.10.2
//! time 0, 1, 2, 3
//! wave V(p) = 0.5
//! print none
`include "check.vh"
module s01_monitor_hold(p, n);
  inout p, n; electrical p, n;
  integer fd, bytes;
  analog begin
    @(initial_step) begin
      fd = $fopen("s01_05_monitor_hold.dat", "w");
      $fmonitor(fd, "%0d", V(p,n) * 4.0);
    end

    bytes = $ftell(fd);

    `CHECKI("§9.4.1 an unchanged argument list produces no further report", bytes - 2 * ($abstime > 0), 0);

    I(p,n) <+ V(p,n) + bytes;
  end
endmodule
