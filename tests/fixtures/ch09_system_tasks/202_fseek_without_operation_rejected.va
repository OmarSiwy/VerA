// §9.5.5 Example 2:
//
//   code = $fseek( fd, offset, operation );
//
// "sets the position of the next input or output operation on the file
// specified by fd. The new position is at the signed distance offset bytes
// from the beginning, from the current position, or from the end of the file,
// according to an operation value of 0, 1, and 2".
//
// The operation is what gives `offset` a meaning: 16 bytes from WHERE is not
// answerable without it, and the clause names no default — C's fseek has none
// either, and `$rewind(fd)` is the clause's own spelling of the one case that
// needs no origin. So a two-argument `$fseek` is not a shorter form, it is a
// call the clause does not define. Adding `, 0` makes this file compile
// (probed).
//
// VerA used to accept it without a word. It now reports E0887 "wrong number of
// arguments to a system task or function".
//
//! lrm 9.5.5
//! reject-only E0887
//! reject `$fseek` takes 3 arguments, got 2
`include "disciplines.vams"
module ch09_fseek_without_operation(p, n);
  inout p, n; electrical p, n;
  integer fd, code;
  analog begin
    @(initial_step) begin
      fd = $fopen("ch09_202.dat", "w+");
      code = $fseek(fd, 16);             // illegal: no origin for the offset
    end
    I(p, n) <+ V(p, n);
  end
endmodule
