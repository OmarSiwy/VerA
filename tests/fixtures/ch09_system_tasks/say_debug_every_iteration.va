// §9.4.1: "The $debug task provides the capability to display simulation data
// while the analog simulator is solving the equations; it displays its
// arguments for each iteration of the analog solver." §9.4.6: "All the display
// tasks, except $debug, shall not display output unless an iteration has been
// accepted." A VerA device built for a simulator records its display tasks
// for its host (`contract.Say`, #10); `//! display record` builds this
// testbench over that device. The testbench runs the device's `say` after
// every Newton iteration with `pass = .iteration` ($debug alone, at that
// iterate) and at the accepted point with `pass = .accepted` (everything but
// $debug), as contract.SayPass asks a host to.
//
// THE ITERATIONS. `//! solve` hands V(p, n) to the testbench's Newton loop,
// which starts at 0. The branch is linear, f(V) = V/1000 - 0.001:
//   iteration 1, V = 0: f = -0.001, f' = 0.001, so dV = 1 (not settled).
//   iteration 2, V = 1: f = 1/1000 - 0.001 = 0 exactly (1/1000 rounds to the
//     double the literal 1m is), so dV = 0: converged at V = 1.
// $debug therefore shows the iterates 0 and 1, and the accepted point shows
// the $strobe of V = 1 and not $debug a third time. Three verdicts: one per
// $debug line (each asserts its iterate is one of the two derived above) and
// the accepted CHECK. A device that showed $debug only at the accepted point
// prints two; one that showed it per iteration and again when accepted, four.
// There is no invalid input: $debug takes any display argument list.
//! lrm 9.4.1
//! lrm 9.4.6
//! lrm 9.4.6:1
//! lrm 9.4.1:1003
//! display record
//! solve
//! print none
//! checks 3
`include "check.vh"
module say_debug_every_iteration(p, n);
  inout p, n; electrical p, n;
  analog begin
    I(p, n) <+ V(p, n) / 1k - 1m;
    $debug("debug at iterate V(p,n) = %g ok=%d", V(p, n), V(p, n) == `VERA_PW(0.0) || V(p, n) == `VERA_PW(1.0));
    `CHECK("the accepted solution", V(p, n), 1.0, 1e-12);
  end
endmodule
