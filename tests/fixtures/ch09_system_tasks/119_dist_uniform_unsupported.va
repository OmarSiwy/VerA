// DEBT — this rejection is NOT conformance.
// The LRM permits what VerA refuses here. The substrings below record
// CURRENT behavior so the suite stays green on it; they do not claim it
// is right. `zig build ledger` counts this rule against VerA.
//
// VAMS-9.13.2-05  (ch9-system.html)
// The start value shall be smaller than the end value.
//
//! reject E0801
//! reject $dist_uniform
// EXPECT: error
module ch09_dist_uniform_unsupported(p, n);
  inout p, n; electrical p, n;
  integer seed;
  analog I(p,n) <+ $dist_uniform(seed, 0, 10);
endmodule
