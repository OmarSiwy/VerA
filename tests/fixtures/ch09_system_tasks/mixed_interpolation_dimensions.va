// §9.21 MIXED schemes across dimensions — the property the whole recursive
// formulation exists to support:
//
//   "As a consequence of this algorithm, the interpolation and extrapolation
//    schemes always operate in a single dimension analogous to how the data was
//    originally generated, so the interpolation and extrapolation schemes used
//    may be specified on a per dimension basis."
//
// Table 9-32's "D,1,3" row is the same statement as an example: "Closest point
// lookup in the outer dimension, linear interpolation on dimension two and
// cubic spline interpolation on the inner dimension."
//
// DATA — 2-D, three isolines in y, two samples of x on each:
//
//     f(y,x) = g(y) + x      with g(0)=0, g(1)=1, g(2)=0
//
//     y x f          y x f          y x f
//     0 0 0          1 0 1          2 0 0
//     0 1 1          1 1 2          2 1 1
//
// The dependence on x is exactly +x, and the dependence on y is the non-linear
// hump g, so the two dimensions are separable and each scheme can be checked
// alone.
//
// "3LL,1LL" — cubic in y, linear in x. §9.21's recursion interpolates each
// isoline in x first, then the resulting isoline in y:
//
//     at x = 0.5 the three isolines give 0.5, 1.5, 0.5, i.e. g + 0.5
//     the natural cubic through (0,0.5),(1,1.5),(2,0.5) is the spline of
//     01_cubic_spline_natural_ends.va shifted by a constant (a spline is linear
//     in its data), so at y = 0.5 it is 0.6875 + 0.5 = 1.1875
//     and at y = 0.25 it is 0.3671875 + 0.5 = 0.8671875
//
// "1LL,1LL" — linear in y instead, SAME point: (0.5 + 1.5)/2 = 1.0. The 0.1875
// gap between 1.1875 and 1.0 is the assertion that the outer character alone
// changed the scheme.
//
// "3LL,D" — cubic in y, CLOSEST POINT in x. §9.21.4: "The closest point lookup
// algorithm returns the closest point in the specified dimension." At x = 0.4
// the closest sample is x = 0, so the three isolines give 0, 1, 0 and the
// natural cubic at y = 0.5 is 0.6875 exactly as in the 1-D fixture.
//
// "D,1LL" — closest point in y, linear in x: at y = 1.4 the closest isoline is
// y = 1, whose value at x = 0.25 is 1 + 0.25 = 1.25. Combined with the previous
// want this pins that `D` can sit in EITHER position.
//
//! lrm 9.21
//! lrm 9.21:4
//! lrm 9.21.2
//! lrm 9.21.4
//! lrm 9.21:5
//! lrm 9.21.3:1000
`include "check.vh"
module a05_mixed_interpolation_dimensions(p, n);
  inout p, n; electrical p, n;
  real ys[0:5], xs[0:5], fs[0:5];
  analog begin
    ys[0]=0.0; xs[0]=0.0; fs[0]=0.0;
    ys[1]=0.0; xs[1]=1.0; fs[1]=1.0;
    ys[2]=1.0; xs[2]=0.0; fs[2]=1.0;
    ys[3]=1.0; xs[3]=1.0; fs[3]=2.0;
    ys[4]=2.0; xs[4]=0.0; fs[4]=0.0;
    ys[5]=2.0; xs[5]=1.0; fs[5]=1.0;
    `CHECK("cubic outer, linear inner at (0.5,0.5): 0.6875 + 0.5",
           $table_model(0.5, 0.5, ys, xs, fs, "3LL,1LL"), 1.1875, 1e-12);
    `CHECK("same site, cubic outer at y=0.25: 0.3671875 + 0.5",
           $table_model(0.25, 0.5, ys, xs, fs, "3LL,1LL"), 0.8671875, 1e-12);
    `CHECKX("linear outer at the same point is 1.0 — only the outer character changed",
            $table_model(0.5, 0.5, ys, xs, fs, "1LL,1LL"), 1.0);
    `CHECK("cubic outer, closest-point inner: x=0.4 snaps to the x=0 samples",
           $table_model(0.5, 0.4, ys, xs, fs, "3LL,D"), 0.6875, 1e-12);
    `CHECKX("closest-point outer, linear inner: y=1.4 snaps to the y=1 isoline",
            $table_model(1.4, 0.25, ys, xs, fs, "D,1LL"), 1.25);
    I(p, n) <+ V(p, n);
  end
endmodule
