// §9.13.2 states the seed's type twice.
//
// In prose: "For each system function, the seed argument SHALL BE AN INTEGER.
// If it is an integer variable, then it is an inout argument ... If the seed
// argument is a parameter or constant, then the system function does not update
// the parameter value."
//
// And in Syntax 9-9, which admits exactly three spellings and no others:
//
//     seed ::= integer_variable_identifier
//            | integer_parameter_identifier
//            | [ sign ] decimal_number
//
// A real literal is none of the three. `0.5` is a real_number by §2.5.2, not a
// decimal_number, so it is outside the production as well as outside the prose
// rule — and neither reading leaves room for a coercion: the inout half of the
// rule needs a location the function can write an updated integer seed back to.
//
// This was previously the third call inside 150_rdist_domain_rejected.va, whose
// `//! reject greater than zero` pins the mean/degree_of_freedom/k_stage domain
// sentence and cannot pin this one. Two rules, two files.
//
// A reject, so there is nothing to run and no `want` to write.
//
//! lrm 9.13.2
//! reject seed argument shall be an integer
//! xfail VerA refuses the whole §9.13 family with E0801 at the function name, so no argument is ever examined and the seed's type is never checked
module ch09_rdist_real_seed_rejected(p, n);
  inout p, n; electrical p, n;
  real c;
  analog begin
    c = $rdist_exponential(0.5, 1.0);
    I(p,n) <+ V(p,n) + c;
  end
endmodule
