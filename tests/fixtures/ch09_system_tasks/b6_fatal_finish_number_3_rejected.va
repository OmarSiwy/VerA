// §9.7.3 Syntax 9-7:
//
//   fatal_message_task ::= $fatal [ ( finish_number [ , message_argument ... ] ) ] ;
//   finish_number ::= 0 | 1 | 2
//
// and the prose: "The first argument passed to $fatal shall be consistent
// with the corresponding argument to the Verilog $finish system task", whose
// levels are Table 9-25's 0, 1 and 2 (§9.7.2: "an optional expression
// argument (0, 1, or 2)"). 3 is not a finish_number.
//
// The neighbour b6_fatal_finish_number_2_exit_status.va is this file with 2.
// The refusal is named by the production, `finish_number`.
//
//! lrm 9.7.3
//! lrm 9.7.3:2
//! reject-only finish_number
//! neighbour b6_fatal_finish_number_2_exit_status.va
`include "check.vh"
module b6_fatal_finish_number_3_rejected(p, n);
  inout p, n; electrical p, n;
  analog begin
    `CHECKI("printed at the first point only: $fatal ends the run before the second", V(p) < 1.5, 1);
    $fatal(3, "giving up at v=%g", V(p));   // illegal: 3 is not a finish_number
    I(p, n) <+ V(p, n);
  end
endmodule
