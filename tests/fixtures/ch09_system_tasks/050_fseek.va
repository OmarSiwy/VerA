// §9.5.5: `code = $fseek( fd, offset, operation )` — "2 sets position to EOF
// plus offset" — and the return is pinned to exactly two values: "If an error
// occurs repositioning the file, then code is set to -1. Otherwise, code is set
// to 0."
//
// So a seek to the end of a file this fixture wrote itself has two exact
// answers, not one. "abc\n" is four bytes:
//
//   $fseek(fd, 0, 2)   ->  0   (a STATUS, not a position)
//   the $ftell after it ->  4   (EOF plus an offset of zero)
//
// The pair is the point. Asserting only the status would pass an implementation
// that returns 0 and seeks nowhere; asserting only the position would pass one
// that returns the new position from $fseek. Together they pin both halves of
// the sentence.
//
// The previous version opened a name it did not create and asserted
// `(code == 0) || (code == -1)` — satisfied by an implementation that returns
// -1 unconditionally. Every §9.5 fixture now owns its filename.
//
//! lrm 9.5.5
//! xfail VerA has no file-descriptor surface: codegen.zig `void_tasks` lowers the whole §9.5 family to the constant `S.con(0.0)`, so $fseek is a no-op returning 0 and the $ftell after it also answers 0
`include "check.vh"
module ch09_atomic_fseek(p, n);
  inout p, n; electrical p, n;
  integer fd, code, pos;
  analog begin
    fd = $fopen("ch09_050_fseek.dat", "w");
    $fwrite(fd, "abc\n");
    $fclose(fd);
    fd = $fopen("ch09_050_fseek.dat", "r");
    code = $fseek(fd, 0, 2);
    pos = $ftell(fd);
    $fclose(fd);
    `CHECKI("§9.5.5 $fseek returns a status, and success is 0", code, 0);
    `CHECKI("§9.5.5 operation 2 sets the position to EOF, which is byte 4", pos, 4);
    I(p,n) <+ V(p,n) + code + pos;
  end
endmodule
