// §9.5.3: $swrite is $fwrite with a string variable in place of the descriptor
// — "the same type of arguments as the tasks upon which it is based", so the
// value formatted by %g is still an ordinary expression evaluated at the
// operating point. §1.3.1 pins it: V(p,n) = 4.5 - 0.5 = 4.0 V, exact in binary
// floating point.
//
// The resulting string itself is not assertable here: `text` can only be
// compared with the §3.8 string operators, which these macros do not cover.
//
//! lrm 9.5.3
//! lrm 9.5.3:1
//! bias V(p) = 4.5, V(n) = 0.5
`include "check.vh"
module ch09_atomic_swrite(p, n);
  inout p, n; electrical p, n;
  string text;
  analog begin
    `CHECK("the %g argument is the branch potential", V(p,n), 4.0, 1e-15);
    $swrite(text, "value=%g", V(p,n));
    I(p,n) <+ V(p,n);
  end
endmodule
