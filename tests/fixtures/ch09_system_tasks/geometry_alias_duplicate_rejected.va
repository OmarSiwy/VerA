// §3.4.7 forbids overriding a parameter through its original name and an
// alias, even when the values are equal and different mechanisms are used.
// geometry_defparam_alias.va is the legal neighbour: its named assignment
// and defparam both use the same alias spelling, so ordinary §6.3 precedence
// applies. Here the defparam uses the original system spelling instead.
//! lrm 3.4.7
//! lrm 3.4.7:4
//! reject-only E0908
//! neighbour geometry_defparam_alias.va
module geometry_duplicate_top;
  geometry_duplicate_child #(.placement_x(2)) child();
  defparam child.$xposition = 2;
endmodule
module geometry_duplicate_child;
  aliasparam placement_x = $xposition;
  analog $display("x=%g", $xposition);
endmodule
