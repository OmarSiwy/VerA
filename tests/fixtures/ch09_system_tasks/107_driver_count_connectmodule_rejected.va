// §9.22, paragraph 3, verbatim: "The driver access functions described here
// only access drivers found in ordinary modules and not to those found in
// connect modules. Driver access functions can only be called from connect
// modules."
//
// The module below is an ordinary module, so the call is diagnosable on sight —
// no elaboration, no netlist, no driver needed. That is the whole test.
//
// NOTHING IS ASSERTED, deliberately. An illegal call site has no result, and §9.22.1's
// "integer representing the number of drivers associated with the signal"
// is a property of an elaborated connectmodule netlist, not of this source.
//
//! lrm 9.22
//! lrm 9.22.1
//! reject connect module
//! xfail VerA has no `connectmodule` design element and no digital driver state — the two things §9.22/§9.23 are defined over — so it cannot tell a legal call site from an illegal one; it lowers the whole driver-access family to a constant (codegen.zig driver_queries) instead of refusing the call
module ch09_atomic_driver_count_connectmodule_rejected(p, n);
  inout p, n; electrical p, n;
  real info;
  analog begin
    info = $driver_count(p);
    I(p,n) <+ V(p,n) + info;
  end
endmodule
