// AMS §9.13.2 gives constant/parameter distribution seeds the same hidden
// initialization and per-call update rule as §9.13.1. CHECKEQ asserts the
// required identity with an explicit seed, once per accepted point. Uniform
// consumes one LCG step; normal consumes pairs and may reject a pair, so its
// write-back must be the distribution's own final seed, not one generic step.
//
// The first uniform(7,0,10) anchor is independently derived by §9.13.3 /
// IEEE §17.9.3: seed'=483484; the binary32 mantissa and c+c*2^-23 mapping
// give 0.0011265279204053513. All arithmetic on this path is exact binary
// scaling or binary64 arithmetic, so the exact CHECKX is intentional.
// The seed-type refusal neighbour is 166_rdist_real_seed_rejected.va; no
// rejection is invented for the stream-identity rule itself.
//! lrm 9.13.2
//! lrm 9.13.3
//! lrm 9.13.2:4
//! lrm 9.13.3:1000
//! lrm 9.13.2:1001
//! lrm 9.13.2:1002
//! time 0, 1, 2
//! checks 7
`include "check.vh"
module rng_constant_distribution_stream;
  integer uniform_seed, normal_seed;
  real hidden_uniform, variable_uniform, hidden_normal, variable_normal;
  analog initial begin uniform_seed = 7; normal_seed = 7; end
  analog begin
    hidden_uniform = $rdist_uniform(7, 0.0, 10.0);
    variable_uniform = $rdist_uniform(uniform_seed, 0.0, 10.0);
    hidden_normal = $rdist_normal(7, 0.0, 1.0);
    variable_normal = $rdist_normal(normal_seed, 0.0, 1.0);
    `CHECKEQ("uniform hidden seed follows explicit seed", hidden_uniform, variable_uniform, 0);
    `CHECKEQ("normal uses its own final seed", hidden_normal, variable_normal, 0);
    if ($abstime == 0)
      `CHECKX("uniform reference first draw", hidden_uniform, 0.0011265279204053513);
  end
endmodule
