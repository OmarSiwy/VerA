// §9.5 file positioning and error status. Two rules here have an answer the LRM
// writes down, and both hold because "ch09_11_missing.dat" is a name no
// fixture in this directory ever creates, so it does not exist next to the
// testbench binary:
//
//   §9.5.1  "If a file cannot be opened (either the file does not exist and the
//            type specified is "r", "rb", "r+", "r+b", or "rb+", or the
//            permissions do not allow the file to be opened at that path), a
//            zero is returned for the mcd or fd."
//           The type here is "r+" and the file is absent, so fd is 0 — not a
//           descriptor, and not the -1 the C fopen convention would hand back.
//
//   §9.5.8  "$feof ... Returns a nonzero value when EOF has previously been
//            detected reading fd; returns zero otherwise."
//           Nothing is ever read from fd here, so no EOF has been detected and
//           the answer is zero. An implementation that reported EOF merely
//           because the descriptor is unusable fails this.
//
// Neither of those digits is 0 by accident on a real tool — but BOTH of them are
// 0 on an implementation that answers 0 to every §9.5 call, so on their own they
// cannot tell the two apart. That is what the second half of this fixture is
// for: it opens a descriptor that DOES work, on a four-byte file it writes
// itself, and walks the same positioning family across it, where §9.5.5 fixes
// every answer:
//
//   §9.5.5  "pos = $ftell(fd) returns in pos the offset from the beginning of
//            the file of the current byte" — 0 before any read, 4 after the
//            $fgets consumes "abc\n"
//   §9.5.5  "$rewind is equivalent to $fseek (fd,0,0)" and "code is set to 0"
//            on success — so 0 back, and $ftell 0 again
//
// Those are the same rules 049/050/051 pin one at a time; here they are the
// discriminator that stops the two zeros above from passing for free.
//
// The calls on the FAILED descriptor stay deliberately unasserted: §9.5.5/§9.5.7
// say only "if an error occurs, EOF is returned", and the LRM never fixes EOF's
// numeric value, so there is no digit to write for them.
//
// WHEN THE FILE IS WRITTEN, AND WHEN IT IS READ. §9.5.9: "If a file is being
// written to during an iterative solve, then the file write operations shall
// not be performed unless the iteration is accepted." So "abc\n" is written by
// `@(initial_step)` inside the t = 0 solve and reaches the file only when that
// point is accepted; the positioning walk runs at t = 1e-3, the next point,
// where the file holds exactly those four bytes. The exact rejected-iteration
// suppression is asserted by rejected_iterations_leave_no_file_side_effects.va;
// this file only relies on the accepted write being the one that lands. The
// failed-descriptor half is asserted at both points (2 + 2), the walk at
// t = 1e-3 only (4): eight checks.
// (Reconciler, 2026-10-08: an earlier revision wrote, closed, reopened and read
// in ONE evaluation, where §9.5.9 has not yet performed the write.)
//
// The filename is unique to this fixture on purpose. Nine §9.5 fixtures used to
// share the single name "fixture.dat", and fflush.va opened it for append —
// Table 9-24 type "a" is "create for writing" — so from the second run onward
// the file existed, this open succeeded, and the missing-file rule above went
// untested. Every §9.5 fixture now owns its filename.
//
//! lrm 9.5.1
//! lrm 9.5.5
//! lrm 9.5.8
//! lrm 9.5.5:1
//! lrm 9.5.5:3
//! lrm 9.5.8:1000
//! lrm 9.5.9
//! time 0, 1e-3
//! checks 8
`include "check.vh"
module ch09_file_position_status(p, n);
  inout p, n; electrical p, n;
  integer fd, code, pos;
  integer live, count, at_open, after_read, rewound, at_rewind;
  string message, text;
  analog begin
    fd = $fopen("ch09_11_missing.dat", "r+");
    `CHECKI("§9.5.1: opening a missing file with type r+ yields fd = 0", fd, 0);
    pos = $ftell(fd);
    code = $fseek(fd, 0, 0);
    code = $rewind(fd);
    $fflush(fd);
    code = $ferror(fd, message);
    code = $feof(fd);
    `CHECKI("§9.5.8: nothing was read from fd, so no EOF was detected", code, 0);

    @(initial_step) begin
      live = $fopen("ch09_11_position.dat", "w");
      $fwrite(live, "abc\n");
      $fclose(live);
    end
    if ($abstime > 0.0) begin
      live = $fopen("ch09_11_position.dat", "r");
      at_open = $ftell(live);
      count = $fgets(text, live);
      after_read = $ftell(live);
      rewound = $rewind(live);
      at_rewind = $ftell(live);
      $fclose(live);
      `CHECKI("§9.5.5: $ftell on a fresh read descriptor is byte 0", at_open, 0);
      `CHECKI("§9.5.5: and byte 4 once the 4-byte line has been read", after_read, 4);
      `CHECKI("§9.5.5: $rewind succeeds, and success is 0", rewound, 0);
      `CHECKI("§9.5.5: after which the position really is back at byte 0", at_rewind, 0);
    end
    I(p,n) <+ pos + code + count + at_open + after_read + rewound + at_rewind + 0.0*V(p,n);
  end
endmodule
