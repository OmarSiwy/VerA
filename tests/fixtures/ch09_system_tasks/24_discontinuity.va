// §9.17.1: "$discontinuity ... is used to give hints to the simulator about the
// behavior of the module ... This task does not directly specify the behavior
// of the module." It returns nothing and it must move nothing, so the only
// thing there is to pin is exactly that: the branch it annotates still carries
// the value the bias gives it, and the statements after the hint still run.
//
// §4.2.5 makes `V(p,n) >= 0.0` an integer, and at a 0.7 V bias it is 1 — which
// also records WHICH arm of the hint was taken here: the $discontinuity(0)
// (a step in the equation itself), not the $discontinuity(-1) that §9.17.3
// reserves for a $limit() helper that has not yet converged.
//
//! lrm 9.17.1
//! bias V(p) = 0.7
`include "check.vh"
module ch09_discontinuity(p, n);
  inout p, n; electrical p, n;
  analog begin
    if (V(p,n) >= 0.0) $discontinuity(0);
    else $discontinuity(-1);
    I(p,n) <+ V(p,n);
    `CHECKI("the guard selecting $discontinuity(0) is the integer 1 at a 0.7 V bias",
            V(p,n) >= 0.0, 1);
    `CHECK("a discontinuity hint does not move the value it annotates", V(p,n), 0.7, 1e-15);
  end
endmodule
