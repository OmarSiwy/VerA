// §9.7.1 $finish and §9.7.2 $stop, the two IEEE 1364 simulation-control tasks
// Verilog-AMS extends into the analog context (Table 9-4, "Yes" in both). Both
// are void — one suspends the solve at a converged point, the other exits after
// the current solution completes — so neither has a returned value to pin. The
// GUARD is the value, and the operating point is chosen so that neither fires.
//
// §5.4.1 gives V(p,n) = V(p) - V(n) = 2.0 - 0 = 2.0 V, and 2.0 is exact in
// binary, so it lands precisely on the $stop threshold. §4.2.5 makes a
// relational an integer, and `>` is STRICT: 2.0 > 2.0 is false. 2.0 > 3.0 is
// false by a whole volt. So this is the operating point at which the solve is
// neither suspended nor terminated.
//
// That the transcript below exists AT ALL is the second half of the assertion.
// A `>` lowered as `>=` fires $stop(1) here and turns the first 0 into a 1; a
// $finish reached out of turn would end the run before these lines are printed.
//
// WHAT THIS FIXTURE DOES NOT PROVE. $stop / $finish is never executed, and cannot be: doing
// so is what ends the run, and this suite reads its verdict off a transcript the
// run has to survive to print. So the assertion below is about the OPERATING
// POINT — that the bias sits below the guard, i.e. that `>` is strict — and not
// about §9.7. It documents why the call is not reached. 060_info.va and
// 059_warning.va are the two tasks of this family that CAN be called
// unconditionally, and they are, with the assertion placed after the call.
//
//! lrm 9.7.1
//! lrm 9.7.2
//! bias V(p) = 2.0
`include "check.vh"
module ch09_finish_stop(p, n);
  inout p, n; electrical p, n;
  analog begin
    `CHECKX("§5.4.1: the branch potential is V(p) - V(n), in that order", V(p, n), 2.0);
    `CHECKI("strict > is false exactly at the threshold, so $stop(1) is not reached", V(p, n) > 2.0, 0);
    `CHECKI("2.0 V is a volt below the $finish guard, so the run is not terminated", V(p, n) > 3.0, 0);
    if (V(p,n) > 2.0) $stop(1);
    if (V(p,n) > 3.0) $finish(2);
    I(p,n) <+ V(p,n);
  end
endmodule
