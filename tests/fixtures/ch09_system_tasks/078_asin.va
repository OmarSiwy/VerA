// LRM 9.14 / Table 4-14: $asin is an alias of the 4.3.1 operator asin, which
// returns RADIANS in [-pi/2, pi/2]. sin(30 deg) = 1/2, so asin(0.5) is exactly
// pi/6 = 3.14159265358979323846.../6 = 0.5235987755982989. A degree-returning
// implementation would give 30.
//
//! lrm 9.14
`include "check.vh"
module ch09_atomic_asin(p, n);
  inout p, n; electrical p, n;
  analog begin
    `CHECK("$asin(0.5) is pi/6 radians", $asin(0.5), 0.5235987755982989, 1e-15);
    I(p,n) <+ V(p,n) + $asin(0.5);
  end
endmodule
