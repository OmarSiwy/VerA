// A limiter return used only as next-iteration state must survive dead-code
// elimination, including a return that folds to a constant.
//
// UNTAGGED (VD-082: a pinned choice carries no clause tag): the persistence of
// a return used only as next-iteration state is VerA's state model, not a
// §9.17.3 sentence.
// The callbacks call $discontinuity(-1) when they return other than their
// first argument, as §9.17.3 requires of a user-defined limiter.
//! time 0, 1, 2
//! bias V(p) = 3
`include "check.vh"
module ch09_limit_constant_history(p, n);
  inout p, n; electrical p, n;
  real old, unused;
  analog function real previous;
    input vnew, vold;
    real vnew, vold;
    begin
      previous = vold;
      if (abs(vold - vnew) > 1e-12) $discontinuity(-1);
    end
  endfunction
  analog function real constant_limit;
    input vnew, vold;
    real vnew, vold;
    begin
      constant_limit = 3.0;
      if (abs(3.0 - vnew) > 1e-12) $discontinuity(-1);
    end
  endfunction
  analog begin
    old = $limit(V(p,n), previous);
    unused = $limit(V(p,n), constant_limit);
    `CHECK("constant return persists without a contribution",
           old - (($abstime >= 1.0) ? 3.0 : 0.0), 0.0, 1e-12);
  end
endmodule
