// §9.13.1/§9.13.2, the LEGAL side of the scope rule 132/133 pin the illegal
// side of. Syntax 9-8 and Syntax 9-9 both admit an optional trailing string —
//
//   analog_random_function ::= $arandom [ ( analog_random_seed [, type_string] ) ]
//   $rdist_normal ( seed , mean_expression ,
//                   standard_deviation_expression [, type_string] )
//   type_string            ::= "global" | "instance"
//
// — and §9.13.2 fences it to exactly one scope: "The type_string provides
// support for Monte-Carlo analysis and shall only be used in calls to a
// distribution function from within a paramset." The calls below ARE within a
// paramset, so a compiler that rejects them is the one that is wrong; this
// file must compile and run green.
//
// What is asserted is what the clause fixes WITHOUT a Monte-Carlo loop. The
// trials are the host's: "If the type_string is "global" (or not specified in
// a call within a paramset), then one value is generated for each Monte-Carlo
// trial", and "instance" gives one per referencing instance PER TRIAL — so a
// compilation is one trial with one instance, in which the three spellings
// select the same single draw, and §9.13.2's "The system functions shall
// always return the same value given the same seed" makes that draw one value.
// Hence ka == kb == kc (and ra == rb == rc): the type_string is accepted and
// changes nothing about the value. No drawn digit is pinned — §9.13.3 leaves
// the stream to IEEE 1364 §17.9.3 and no clause requires reproducing it — but
// $rdist_uniform's "the start and end arguments are real inputs which bound
// the values returned" gives one real draw a range to be checked against, so a
// stub that folds every draw to 0.0 fails here.
//
// Both families appear because 132/133 pinned them separately, for the same
// reason: a compiler could plausibly police one and not the other.
//
// A.1.9: a paramset needs >= 1 paramset_item_declaration (corrected 2026-10-08)
//! lrm 9.13.1
//! lrm 9.13.2
//! lrm 9.13.2:4
//! lrm 9.13.1:1004
//! lrm 6.4.1
//! lrm 6.4.1:4
`include "check.vh"
module ch09_ts_user(p, n);
  inout p, n; electrical p, n;
  ch09_ts_bin u(p, n);
endmodule

paramset ch09_ts_bin ch09_ts_base;
  parameter real unused_item = 0;
  .ka = $arandom(7, "global");
  .kb = $arandom(7, "instance");
  .kc = $arandom(7);
  .ra = $rdist_normal(7, 0.0, 1.0, "global");
  .rb = $rdist_normal(7, 0.0, 1.0, "instance");
  .rc = $rdist_normal(7, 0.0, 1.0);
  .ru = $rdist_uniform(7, 1.0, 2.0, "instance");
endparamset

module ch09_ts_base(a, b);
  inout a, b; electrical a, b;
  parameter integer ka = 0;
  parameter integer kb = 1;
  parameter integer kc = 2;
  parameter real ra = 0.0;
  parameter real rb = 1.0;
  parameter real rc = 2.0;
  parameter real ru = 0.0;
  analog begin
    `CHECKI("§9.13.1 \"global\" draws the value the bare call draws", ka == kc, 1);
    `CHECKI("§9.13.1 \"instance\" too: one trial, one value per seed", kb == kc, 1);
    `CHECKI("§9.13.2 \"global\" on $rdist_normal changes nothing", ra == rc, 1);
    `CHECKI("§9.13.2 \"instance\" on $rdist_normal changes nothing", rb == rc, 1);
    `CHECKI("§9.13.2 start and end bound the values returned", (ru >= 1.0) && (ru <= 2.0), 1);
    I(a, b) <+ V(a, b) + 0 * (ka + kb + kc) + 0.0 * (ra + rb + rc + ru);
  end
endmodule
