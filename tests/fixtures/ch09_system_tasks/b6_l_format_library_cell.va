// §9.4.3: "The formatting specification %l (or %L) is defined for displaying
// the library information of the specific module. This information shall be
// displayed as "library.cell" corresponding to the library name from which the
// current module instance was extracted and the cell name of the current module
// instance. See Clause 13 of IEEE Std 1364 Verilog."
//
// THE LIBRARY. This file is compiled with no library map. IEEE 1364-2005
// §13.2.1: "Any file encountered by the compiler that does not match any
// library's file_path_spec shall by default be compiled into a library named
// work." So the library is `work`.
//
// THE CELL. The module is the top-level instance, so its cell is the module
// name, b6_l_format_library_cell.
//
//   %l -> "work.b6_l_format_library_cell"
//   %L is the same specifier (Table 9-22 "%l or %L"), so "[%L]" gives
//   "[work.b6_l_format_library_cell]".
//
// VerA's own digital runner prints exactly this shape for unmapped source
// (ieee1364/13_configuration/b_13_1_1_config_named_like_module.v expects
// "top work.top"). 168_display_library_binding.va pins only that %l consumes
// no argument; this file pins the text.
//
//! lrm 9.4.3
//! lrm 9.4.3:2
//! checks 2
`include "check.vh"
module b6_l_format_library_cell(p, n);
  inout p, n; electrical p, n;
  string lower, upper;
  analog begin
    $sformat(lower, "%l");
    $sformat(upper, "[%L]");
    `CHECKI("§9.4.3 %l is library.cell, and unmapped source is in library work",
            lower == "work.b6_l_format_library_cell", 1);
    `CHECKI("§9.4.3 %L is the same specifier",
            upper == "[work.b6_l_format_library_cell]", 1);
    I(p, n) <+ V(p, n);
  end
endmodule
