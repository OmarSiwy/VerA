// §9.7.3 $fatal, EXECUTED: it "shall generate a run-time fatal assertion
// error, which terminates the simulation with an errorcode", with "an implicit
// call to $finish" — and unlike its guarded sibling 057_fatal.va, this one
// actually runs. The same sweep trick as 172_finish_terminates.va makes the
// termination itself the assertion:
//
//   point 0, V(p) = 1.0:  `ok=1` prints (1.0 < 1.5), then the message —
//                         §9.7.3 gives the family $display formatting, so the
//                         transcript carries `FATAL: giving up at v=1` — and
//                         the run exits with status 1 (the finish_number,
//                         which §9.7.3 leaves implementation-specific and VerA
//                         uses as the errorcode, floored at 1 so a $fatal can
//                         never exit 0; `vera --run` forwards it to the
//                         shell). The harness checks `//! exit 1` as well as
//                         the assertion columns.
//   point 1, V(p) = 2.0:  never reached. Without the termination — the
//                         pre-fix behaviour printed FATAL and carried on with
//                         exit 0 — this point prints 2.0 < 1.5 = 0 against
//                         want 1, a hard `ok=0`.
//
//! lrm 9.7.3
//! lrm 9.7.3:1
//! lrm 9.7.3:1002
//! exit 1
//! sweep V(p) = 1.0, 2.0
`include "check.vh"
module ch09_fatal_terminates(p, n);
  inout p, n; electrical p, n;
  analog begin
    `CHECKI("printed at the first point only: $fatal ends the run before the second", V(p) < 1.5, 1);
    $fatal(1, "giving up at v=%g", V(p));
    I(p,n) <+ V(p,n);
  end
endmodule
