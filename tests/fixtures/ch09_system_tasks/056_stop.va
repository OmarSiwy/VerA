// §9.7.2 $stop: "a call to $stop during an accepted iteration causes simulation
// to be suspended at a converged time point", with the optional argument (0, 1
// or 2) selecting the diagnostic of Table 9-25. Suspension is the simulator's
// behaviour and $stop yields nothing, so there is no returned value to pin.
//
// The guard is the value. §4.2.5 makes a relational an integer, 1 or 0, and `>`
// is STRICT, so the bias sits exactly on the threshold — V(p,n) = 1.0 - 0 = 1.0,
// both operands exact in binary — and 1.0 > 1.0 is false. That is the operating
// point this fixture describes: the one where $stop is not reached, so the solve
// is never suspended.
//
// A `>` lowered as `>=` fires $stop at this bias and turns the 0 into a 1.
//
// WHAT THIS FIXTURE DOES NOT PROVE. $stop is never executed, and cannot be: doing
// so is what ends the run, and this suite reads its verdict off a transcript the
// run has to survive to print. So the assertion below is about the OPERATING
// POINT — that the bias sits below the guard, i.e. that `>` is strict — and not
// about §9.7. It documents why the call is not reached. 060_info.va and
// 059_warning.va are the two tasks of this family that CAN be called
// unconditionally, and they are, with the assertion placed after the call.
//
//! lrm 9.7.2
//! bias V(p) = 1.0
`include "check.vh"
module ch09_atomic_stop(p, n);
  inout p, n; electrical p, n;
  analog begin
    if (V(p,n) > 1.0) $stop(1);
    `CHECKI("strict > is false exactly at the threshold, so $stop is not reached", V(p, n) > 1.0, 0);
    I(p,n) <+ V(p,n);
  end
endmodule
