// §9.2 Table 9-11 lists $tanh as supported in the analog context; §4.3
// Table 4-15 defines it as C `tanh(x)` = sinh(x)/cosh(x), for all x. §4.3 makes
// the `$` and traditional spellings the same function.
//
// tanh(0.5) = 0.46211715726000974, which is also
// 0.5210953054937474 / 1.1276259652063807 = sinh(0.5)/cosh(0.5).
//
//! lrm 9.14
//! bias V(p) = 0.5
`include "check.vh"
module ch09_atomic_tanh(p, n);
  inout p, n; electrical p, n;
  analog begin
    `CHECK("$tanh(0.5)", $tanh(V(p,n)), 0.46211715726000974, 1e-15);
    `CHECK("tanh is sinh over cosh", $sinh(V(p,n)) / $cosh(V(p,n)), 0.46211715726000974, 1e-15);
    `CHECK("traditional tanh() is the same function", tanh(V(p,n)), 0.46211715726000974, 1e-15);
    I(p,n) <+ V(p,n) + $tanh(V(p,n));
  end
endmodule
