// AMS §9.13.1 updates the internal seed "every time the call to $arandom
// is made". A skipped source call consumes nothing. Calls at t=1 and t=3
// therefore produce the first two seed-7 results derived in
// arandom_constant_seed_stream.va: -2146999808 then 1181502348. At t=0 the
// explicit seed is still 7; after the skipped t=2 it is still 483484.
//
// Two executions of the loop's SAME source site consume two draws, so its
// explicit seed is -965981971 after the first point. CHECKEQ checks the
// required stream identity on each loop iteration, not random uniqueness.
// The execution-count rule has no invalid form. Syntax/scope refusals are
// covered separately by the existing §9.13.1 rejection fixtures.
//! lrm 9.13.1
//! lrm 9.13.3
//! time 0, 1, 2, 3
//! checks 15
`include "check.vh"
module arandom_execution_paths;
  integer seed, loop_seed, i, hidden_draw, variable_draw;
  integer loop_hidden, loop_variable;
  analog initial begin seed = 7; loop_seed = 7; end
  analog begin
    if (($abstime == 1) || ($abstime == 3)) begin
      hidden_draw = $arandom(7);
      variable_draw = $random(seed);
      `CHECKEQ("skipped calls preserve the stream", hidden_draw, variable_draw, 0);
      if ($abstime == 1)
        `CHECKI("delayed first call keeps initial seed", hidden_draw, -2146999808);
      else
        `CHECKI("second executed call takes the second draw", hidden_draw, 1181502348);
    end else if ($abstime == 0)
      `CHECKI("no call has run", seed, 7);
    else
      `CHECKI("intervening skipped call consumes no draw", seed, 483484);

    for (i = 0; i < 2; i = i + 1) begin
      loop_hidden = $arandom(7);
      loop_variable = $random(loop_seed);
      `CHECKEQ("repeated execution advances one source site", loop_hidden, loop_variable, 0);
    end
    if ($abstime == 0)
      `CHECKI("the loop consumed two draws", loop_seed, -965981971);
  end
endmodule
