// §9.19: $param_given(p) shall return one (1) if the parameter was overridden,
// either by a defparam or by a module instance parameter value assignment, and
// zero (0) otherwise. The testbench overrides `gain`, so the answer is 1 — and
// the value the model sees must be the override (2.0), not the declared default
// (1.0), which the second check pins at V(p,n) = 0.5: 2.0 * 0.5 = 1.0.
`include "check.vh"

//! lrm 9.19
//! lrm 9.19:4
//! param gain = 2.0
//! bias V(p) = 0.5

module ch09_atomic_param_given(p, n);
  inout p, n; electrical p, n;
  parameter real gain = 1.0;
  analog begin
    `CHECKI("$param_given on an overridden parameter", $param_given(gain), 1);
    `CHECKX("the override is the value in force", ($param_given(gain) ? gain : 0.0) * V(p,n), 1.0);
    I(p,n) <+ ($param_given(gain) ? gain : 0.0) * V(p,n);
  end
endmodule
