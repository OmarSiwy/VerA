// §9.4.3 Table 9-22 (%h/%o/%b/%d/%c/%s) and Table 9-23 (%e/%f/%g/%r), plus the
// §9.4.2 escapes. What a display task produces is text on the transcript, and
// text is not a value these macros can hold to a literal — so the two $display
// lines below stay as they are, a rendering a reader checks by eye.
//
// Two of the rows CAN be pinned with digits, by sending the text back the way it
// came. §9.5.3 $sformat is the same formatter writing into a string variable
// instead of the transcript, and §9.5.4.2 $sscanf reads a string back with "%d
// Matches an optionally signed decimal number". So format an integer in a base,
// then read the resulting DIGITS back as base ten: the round trip is only the
// identity if the formatter did not use base ten in the first place.
//
//   4096 = 16^3       -> "%h" is the four characters 1000, read back as 1000
//   4096 = 8^4        -> "%o" is the five characters 10000, read back as 10000
//
// Both derived by hand: 4096 = 0x1000 = 0o10000. 4096 was chosen so the digits
// contain no letters (a hex a-f would not scan as decimal at all, which would
// make the check pass or fail for the wrong reason) and so the two bases give
// different answers from each other and from the input.
//
// The round trip is immune to field width: leading zeros or leading spaces are
// both consumed by %d, since "for all descriptors except the character c, white
// space leading an input field is ignored" and 00001000 converts to 1000. What
// it is NOT immune to is a formatter that ignores the base and prints 4096, or
// one that prefixes an 0x, or one that emits nothing at all — which is the whole
// content of the two Table 9-22 rows.
//
// The third $display line carries the two §9.4.1 rules that are not format
// specifiers at all: "Any null argument produces a single space character in
// the display. (A null argument is characterized by two adjacent commas (,,) in
// the argument list.)" and, from §9.4.3, "any expression argument with NO
// corresponding format specification is displayed using the default decimal
// format". Both are transcript-only — there is no return value to hold to a
// literal — so they sit beside the other renderings a reader checks by eye.
//
//! print none
//! lrm 9.4.1
//! lrm 9.4.2
//! lrm 9.4.3
//! lrm 9.5.3
//! lrm 9.5.4.2
//! xfail two gaps, and the first stops the build before the assertions run. (1) `%c` does not compile: cg_display.zig appendConv maps it to Zig verb `c` with want=.int, and renderPrintArg then hands std.fmt an i64 where `{c}` takes a u8 — "expected type 'u8', found 'i64'" out of std/Io/Writer.zig printAsciiChar, so ANY $display carrying a Table 9-22 %c kills the generated testbench. (2) codegen.zig `void_tasks` lowers $sformat/$sscanf to the constant `S.con(0.0)`, so `text` is never written and `back` never assigned
`include "check.vh"
module ch09_display_formats(p, n);
  inout p, n; electrical p, n;
  string text;
  integer back, nread;
  analog begin
    $display("bin=%b oct=%o dec=%d hex=%h char=%c str=%s", 5, 5, 5, 5, 65, "A");
    $display("real=%10.3g exp=%e fixed=%f eng=%r percent=%% name=%m octal=\\11 tab=\\t quote=\\\"");
    $display("null=[", , "] bare=", 7);
    $sformat(text, "%h", 4096);
    nread = $sscanf(text, "%d", back);
    `CHECKI("Table 9-22 %h of 4096 is the hex digits 1000", back, 1000);
    $sformat(text, "%o", 4096);
    nread = $sscanf(text, "%d", back);
    `CHECKI("Table 9-22 %o of 4096 is the octal digits 10000", back, 10000);
    `CHECKI("each round trip read exactly one item", nread, 1);
    I(p,n) <+ V(p,n);
  end
endmodule
