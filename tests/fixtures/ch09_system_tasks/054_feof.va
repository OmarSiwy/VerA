// §9.5.8: `code = $feof( fd )` "returns a NONZERO value when EOF has PREVIOUSLY
// BEEN DETECTED reading fd; returns zero otherwise."
//
// Two states, and a fixture that owns its file can put the descriptor in each
// of them in turn. "abc\n" is one four-byte line:
//
//   straight after the open, nothing read yet      ->  0
//   after the read that runs off the end of it     ->  nonzero
//
// The second read is the one that matters. The first $fgets consumes the line
// up to and including its newline and need not have touched the end, so only
// the read after it is guaranteed to hit EOF — which is why there are two.
//
// The nonzero side is asserted as `!= 0` and not as a digit on purpose: §9.5.8
// says "a nonzero value" and fixes no particular one, so writing 1 would
// over-specify and fail a conforming implementation returning the C EOF.
//
// The previous version of this fixture asserted only the zero side, on a
// descriptor from a failed open that nothing had read from — satisfied by an
// implementation returning 0 unconditionally, which is exactly the one this
// rule exists to catch.
//
//! lrm 9.5.8
//! xfail VerA has no file-descriptor surface: codegen.zig `void_tasks` lowers the whole §9.5 family to the constant `S.con(0.0)`, so $feof answers 0 whether or not a read has hit the end
`include "check.vh"
module ch09_atomic_feof(p, n);
  inout p, n; electrical p, n;
  integer fd, before, after, count; string text;
  analog begin
    fd = $fopen("ch09_054_feof.dat", "w");
    $fwrite(fd, "abc\n");
    $fclose(fd);
    fd = $fopen("ch09_054_feof.dat", "r");
    before = $feof(fd);
    count = $fgets(text, fd);
    count = $fgets(text, fd);
    after = $feof(fd);
    $fclose(fd);
    `CHECKI("§9.5.8 $feof is zero until a read detects EOF", before, 0);
    `CHECKI("§9.5.8 and nonzero after the read that runs off the end", after != 0, 1);
    I(p,n) <+ V(p,n) + before + after + count;
  end
endmodule
