// §9.17.2: "$bound_step ( expression ) ; where expression is a required
// argument and represents the maximum timestep the simulator can advance. The
// expression argument shall be non-negative." And: "the simulator shall
// ensure that the next time step taken is no larger than the smallest
// $bound_step() argument currently active."
//
// An infinite argument is non-negative, so the clause gives no ground to
// refuse it (136_bound_step_negative_rejected.va is the one invalid form, E0803).
// Read literally it is a maximum step of +inf: no bound, and as an operand of
// "the smallest ... argument currently active" it never wins against a finite
// one. So this device publishes:
//
//   V(c) = 0   only $bound_step(1.0/0.0) runs    -> bound_step = +inf
//   V(c) = 1   it and $bound_step(2n) both run   -> bound_step = 2e-9
//
// A tool that turned the infinite argument into 0 (or NaN) would publish 0
// (or NaN) in both rows. The published value is read by the host test
// tests/fixtures/ch09_system_tasks/bound_step_infinite_host.zig (Instance
// field `bound_step`, written by updateState); the fixed-grid testbench does
// not print it, so the transcript below asserts only that the argument this
// file hands the task is +inf (IEEE 754 division, §4.2.1), with the run
// proceeding through both points.
//
//! lrm 9.17.2
//! analysis tran
//! time 1n, 2n
`include "check.vh"
module bound_step_infinite_is_no_bound(p, c);
  inout p, c; electrical p, c;
  real big;
  analog begin
    big = 1.0/0.0;
    $bound_step(big);
    if (V(c) > 0.5) $bound_step(2n);
    `CHECKI("the argument handed to $bound_step is +inf", big > 1.7e308, 1);
    I(p) <+ V(p);
    I(c) <+ V(c);
  end
endmodule
