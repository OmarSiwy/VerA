// AMS §9.11 and inherited IEEE1364-2005 §17.8 printed310 explicitly permit
// conversion system functions in constant expressions. Truncating ±1.75 gives
// ±1, and integer -2147483647 converts exactly to binary64. These defaults
// must be evaluated, not replaced by zero; no host override supplies a value.
//! lrm 9.11
//! checks 3
//! xfail Constant evaluation does not fold $rtoi/$itor parameter defaults; W1050 replaces all three legal defaults with zero.
`include "check.vh"
module audit_conversion_constant_expressions;
  parameter integer cp = $rtoi(1.75), cn = $rtoi(-1.75);
  parameter real ci = $itor(-2147483647);
  analog begin
    `CHECKI("constant positive truncation", cp, 1);
    `CHECKI("constant negative truncation", cn, -1);
    `CHECKX("constant signed integer-to-real", ci, -2147483647.0);
  end
endmodule
