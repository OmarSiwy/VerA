// AMS §9.5.4.2: ordinary format characters match input literally; %% matches
// one percent without assignment. Exhausting the format ignores extra output
// arguments. For "tag=12%" / "tag=%d%%", exactly one assignment writes 12;
// the unused second destination retains its initialized sentinel 73.
// A conflicting first literal has no matched/assigned items and returns zero.
//! lrm 9.5.4.2
//! lrm 9.5.4.2:4
//! lrm 9.5.4.2:1001
// SCAN-EXCESS-001 implemented: lowering guards each destination by count.
//! checks 4
`include "check.vh"
module audit_sscanf_literal_and_excess_arguments(p, n);
  inout p, n; electrical p, n;
  integer count, value, unused;
  analog begin
    value = -9;
    unused = 73;
    count = $sscanf("tag=12%", "tag=%d%%", value, unused);
    `CHECKI("only decimal conversion counts", count, 1);
    `CHECKI("literal prefix permits decimal assignment", value, 12);
    `CHECKI("excess destination ignored", unused, 73);
    count = $sscanf("bag=12%", "tag=%d%%", value);
    `CHECKI("literal mismatch before assignment returns zero", count, 0);
    I(p,n) <+ V(p,n);
  end
endmodule
