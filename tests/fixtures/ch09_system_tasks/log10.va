// §9.2 Table 9-11 lists `$log10` as supported in the analog context; §4.3.1
// Table 4-14 defines it as the DECIMAL logarithm (C `log10`), domain x > 0.
//
// log10(10) = 1 exactly (natural log would give 2.302585...), and
// log10(100) = 2 exactly. The second check is on the traditional Verilog-AMS
// spelling, which Table 4-14 gives as `log()` — NOT the natural logarithm, a
// trap for anyone carrying C or Verilog habits over. Both are exact integers in
// IEEE-754, so the tolerance only absorbs a last-ulp library difference.
//
//! lrm 9.14
`include "check.vh"
module ch09_atomic_log10(p, n);
  inout p, n; electrical p, n;
  analog begin
    `CHECK("$log10(10.0) is base ten", $log10(10.0), 1.0, 1e-15);
    `CHECK("Table 4-14: traditional log() is base ten too", log(100.0), 2.0, 1e-15);
    I(p,n) <+ V(p,n) + $log10(10.0);
  end
endmodule
