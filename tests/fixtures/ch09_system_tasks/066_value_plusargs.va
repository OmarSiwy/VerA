// §9.12 / Table 9-9 makes IEEE 1364's `$value$plusargs` legal in the analog
// context. IEEE 1364 §17.10 states both halves of its contract for a plusarg
// that is NOT present: the function returns 0, AND "the variable ... is not
// modified" — so the model's own initial value survives the call.
//
// The testbench is run with no command-line arguments, so there is no
// `+gain=...`; `value` must still read 7 afterwards. The second check is the one
// that catches the common bug of zeroing the destination before the search.
//
//! lrm 9.2
//! lrm 9.12
//! lrm 9.2:1000
//! lrm 9.12:1000
`include "check.vh"
module ch09_atomic_value_plusargs(p, n);
  inout p, n; electrical p, n;
  integer found, value;
  analog begin
    value = 7;
    found = $value$plusargs("gain=%d", value);
    `CHECKI("an absent plusarg returns 0", found, 0);
    `CHECKI("an absent plusarg leaves the variable alone", value, 7);
    I(p,n) <+ V(p,n) + found + value;
  end
endmodule
