// DEBT — this rejection is NOT conformance.
// The LRM permits what VerA refuses here. The substrings below record
// CURRENT behavior so the suite stays green on it; they do not claim it
// is right. `zig build ledger` counts this rule against VerA.
//
// VAMS-9.13.2-01  (ch9-system.html)
// For the $rdist_exponential, $rdist_poisson, $rdist_chi_square, $rdist_t, and $rdist_erlang functions, the arguments mean, degree_of_freedom, and k_sta
//
//! reject E0801
//! reject $dist_poisson
// EXPECT: error
module ch09_dist_poisson_unsupported(p, n);
  inout p, n; electrical p, n;
  integer seed;
  analog I(p,n) <+ $dist_poisson(seed, 3);
endmodule
