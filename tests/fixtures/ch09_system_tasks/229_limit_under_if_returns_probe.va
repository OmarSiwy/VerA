// §9.17.3: "In all cases, the simulator is responsible for determining if
// limiting should be applied and what the return value is on a given iteration.
// In particular, the simulator may simply choose to have $limit() return the
// value of its first argument". A site under an `if` is one VerA declines: the
// host applies its clamps as a flat list, with no control flow to re-evaluate
// the guard in. The model-side fix is the trailing sign argument,
// `$limit(V(a,n), "pnjlim", vte, vcrit, type)`, not `if (type > 0)`. VerA
// declines this site: it compiles, warns W0853 (the call is under an `if`), and
// returns the probe unchanged. The warning is asserted by the unit test "a
// declined $limit is W0853 naming why" (lib/backend/codegen/test.zig) and by
// `//! warn` below; the checks assert what the clause fixes about the value.
//
// Two 100 ohm resistors divide V(p) = 1 V, so V(a) = 0.5 V, independent of any
// limiting; the returned value is used in the contribution, so a return other
// than the probe would move the root.
//
//! lrm 9.17.3
//! lrm 9.17.3:2
//! warn W0853
//! warn it is under an `if`
//! solve
//! bias V(p) = 1, V(n) = 0
`include "check.vh"
module ch09_limit_under_if_returns_probe(p, n);
  inout p, n; electrical p, n, a;
  parameter integer type = 1;
  real v;
  analog begin
    v = V(a,n);
    if (type > 0) v = $limit(V(a,n), "pnjlim", 0.025, 0.7);
    I(p,a) <+ V(p,a) / 100.0;
    I(a,n) <+ v / 100.0;
    `CHECKR("a limit under an if returns the probe", v, 0.5, 1e-4);
  end
endmodule
