// §9.17.3, the sentence the user-defined-limiter form exists for:
//
//   "The first argument of the user-defined function shall be the value of the
//    access function reference for the current iteration. The second argument
//    shall be the appropriate internal state; generally, this is the value that
//    was returned by the $limit() function on the previous iteration."
//
// 156_limit_user_function.va pins the ARGUMENT ORDER with an identity limiter,
// where the second argument cannot be observed. This one observes it: `getold`
// returns `vold` and nothing else, so whatever the transcript prints IS the
// value $limit returned last time.
//
// The pair of calls is the idiom every machine-converted SPICE model writes —
// ngspice keeps `MOS1vgs`/`BJTvbe` as instance state, reads it at the top of
// the load routine, limits against it, and writes the limited value back:
//
//     MOS1vgs  = MOS1type * $limit(V(g,s), DEVlimitOldGet);
//     ... the model's own fetlim/limvds/pnjlim ladder ...
//     load_vgs = MOS1type * $limit(V(g,s), DEVlimitNewSet, ..., limited);
//
// so the READER and the WRITER are two call sites on one access function. That
// is why VerA keys the state on the access function and not on the call site:
// per-site state would have `getold` storing back the value it just read, and
// the reader would be pinned at 0 forever.
//
// THE NUMBERS. The limiter is a +/-0.5 V per-step clamp, and the harness walks
// V(p) over 0, 2, 4, 6:
//
//   point 0   vold = 0    (no previous evaluation)   vnew = 0   -> 0
//   point 1   vold = 0                               vnew = 2   -> 0.5
//   point 2   vold = 0.5                             vnew = 4   -> 1.0
//   point 3   vold = 1.0                             vnew = 6   -> 1.5
//
// Each `vold` column is the previous row's return, which is the clause. The
// contributed current uses the LIMITED voltage, so the residual is the one a
// SPICE load routine would stamp.
//
//
// UNTAGGED (VD-082: a pinned choice carries no clause tag): §9.17.3 says the
// second argument is "generally" the previous return; which evaluation counts
// as "previous" (here, the harness's last evaluated point) and the per-access-
// function keying are VerA's.
// The callbacks call $discontinuity(-1) when they return other than their
// first argument, as §9.17.3 requires of a user-defined limiter.
//! time 0, 1, 2, 3
//! wave V(p) = 0, 2, 4, 6
`include "check.vh"
module ch09_limit_previous_iterate(p, n);
  inout p, n; electrical p, n;
  real vold, vlim;

  // §9.17.3 "The arguments of the user-defined function shall all be declared
  // input." Two formals is the minimum: the simulator supplies both.
  analog function real getold;
    input vnew, vold;
    real vnew, vold;
    begin
      getold = vold;
      // §9.17.3: "shall call $discontinuity(-1) when its return value is not
      // sufficiently close to the value of its first argument".
      if (abs(vold - vnew) > 1e-12) $discontinuity(-1);
    end
  endfunction

  // The writer. Its return is the value the NEXT iteration reads back, which is
  // what makes the two sites one piece of state.
  analog function real setnew;
    input vnew, vold, value;
    real vnew, vold, value;
    begin
      setnew = value;
      // §9.17.3: "the user-defined function shall call $discontinuity(-1) when
      // its return value is not sufficiently close to the value of its first
      // argument", so the simulator is prevented from converging on a clamped
      // iterate.
      if (abs(value - vnew) > 1e-12) $discontinuity(-1);
    end
  endfunction

  analog begin
    vold = $limit(V(p,n), getold);
    vlim = vold + max(-0.5, min(0.5, V(p,n) - vold));
    vlim = $limit(V(p,n), setnew, vlim);
    // The two columns above as closed forms of the timepoint, subtracted so the
    // want is a literal 0 at every point (the suite's rule: an expression in the
    // WANT column would let the compiler state its own expectation). The clamp
    // advances by exactly 0.5 V per evaluation, and `vold` is one row behind.
    `CHECK("vold is the previous evaluation's return, so vold - 0.5*(t-1) is 0",
           vold - max(0.0, 0.5 * ($abstime - 1.0)), 0.0, 1e-12);
    `CHECK("this evaluation returns the clamp, so vlim - 0.5*t is 0",
           vlim - 0.5 * $abstime, 0.0, 1e-12);
    I(p,n) <+ vlim;
  end
endmodule
