// Host-only input for AMS 9.23.4:1001; no standalone fixture credit.
// Bind one real host driver whose type is unavailable to opaque. A missing
// driver or an out-of-range index is not the conditional DRIVER_UNKNOWN case.
// known has one reg driver, independently checking DRIVER_BEHAVIORAL = 16.
`timescale 1ns/1ns
`include "disciplines.vams"
connectmodule driver_type_observer(d, a);
  input d;
  output a;
  ddiscrete d;
  electrical a;
  initial begin
    #25 $display("%m count=%0d type=%0d", $driver_count(d), $driver_type(d, 0));
  end
  analog V(a) <+ 0.0;
endmodule

module driver_type_known(o);
  output o;
  ddiscrete o;
  reg o;
  initial o = 1'b0;
endmodule

module driver_type_unavailable;
  ddiscrete opaque, known;
  electrical opaque_value, known_value;
  driver_type_known source(known);
  driver_type_observer unknown_observer(opaque, opaque_value);
  driver_type_observer known_observer(known, known_value);
endmodule
