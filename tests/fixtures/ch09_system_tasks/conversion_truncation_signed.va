// AMS §9.11 physical250 permits conversion functions in analog context.
// IEEE1364-2005 §17.8 printed310–311 defines $rtoi as truncation and $itor
// as integer-to-real conversion, and permits conversion constant expressions.
// For ±1.75, truncation gives ±1, distinct from implicit nearest-integer ±2.
// V(p) exercises runtime analog input; the separate constant-conversion fixture
// records the independently failing parameter-default path.
//! lrm 9.11
//! lrm 9.11:1000
//! bias V(p) = 1.75
//! checks 5
`include "check.vh"
module audit_conversion_truncation_signed(p);
  inout p; electrical p;
  integer rounded_positive, rounded_negative;
  analog begin
    rounded_positive = V(p);
    rounded_negative = -V(p);
    `CHECKI("runtime positive truncation", $rtoi(V(p)), 1);
    `CHECKI("runtime negative truncation", $rtoi(-V(p)), -1);
    `CHECKI("ordinary assignment rounds positive instead", rounded_positive, 2);
    `CHECKI("ordinary assignment rounds negative instead", rounded_negative, -2);
    `CHECKX("runtime signed integer-to-real", $itor(-rounded_positive), -2.0);
    I(p) <+ 0;
  end
endmodule
