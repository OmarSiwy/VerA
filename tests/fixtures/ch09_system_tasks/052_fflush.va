// §9.5.6: `$fflush( fd )` "writes any buffered output to the file specified by
// fd". It is a task — it returns nothing — and it writes to a file this fixture
// never reads back, so the assertable value here is the descriptor it is handed.
//
// §9.5.1 pins that descriptor twice over. Table 9-24 gives type "a" as "Append;
// open for writing at end of file, or create for writing", so this open cannot
// fail for want of an existing file — it creates one — and the "if a file cannot
// be opened ... a zero is returned for the mcd or fd" case does not arise. And:
// "the most significant bit (bit 31) of a fd is reserved and shall always be
// set; this allows implementations of the file input and output functions to
// determine how the file was opened". That bit is exactly the discrimination
// $fflush has to make between its two overloads, since a multichannel
// descriptor's bit 31 "shall always be cleared".
//
//! lrm 9.5.1
//! lrm 9.5.6
//! xfail VerA has no file-descriptor surface: codegen.zig `void_tasks` lowers the whole §9.5 family to the constant `S.con(0.0)`, so $fopen answers 0 (bit 31 clear) and $fflush is a no-op. lower.zig:2362 records the reason — the file family "needs a descriptor the compiled device has no way to own"
`include "check.vh"
module ch09_atomic_fflush(p, n);
  inout p, n; electrical p, n;
  integer fd;
  analog begin
    fd = $fopen("ch09_052_fflush.dat", "a");
    // Masked, not shifted: `>>` fills with zeros on a 32-bit integer, but VerA
    // carries integers in an i64 where a sign-extended fd would answer a shift
    // differently. `& 2147483648` is bit 31 whatever the width.
    `CHECKI("append cannot fail, so bit 31 of the fd handed to $fflush is set", (fd & 2147483648) != 0, 1);
    $fflush(fd);
    I(p,n) <+ V(p,n);
  end
endmodule
