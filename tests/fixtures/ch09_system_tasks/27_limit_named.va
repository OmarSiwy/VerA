// §9.17.3 Syntax 9-12's second form, `$limit(access, "pnjlim", vte, vcrit)`.
// What this fixture pins is that the STRING FORM is accepted and that it does
// not change the converged answer. Nothing about pnjlim's algorithm is pinned,
// and deliberately so:
//
//   "Simulators may support other built-in functions and NEED NOT SUPPORT
//    pnjlim or fetlim. If the string refers to an unknown or unsupported
//    function, the simulator is responsible for determining the appropriate
//    limiting algorithm, just as if no string had been supplied."
//
// The `spicepnjlim` analog function the LRM prints alongside is an EXAMPLE of
// how a simulator might implement the name — not a definition of it — so an
// answer derived from its `if ((vnew > vcrit) && ...)` guard would be derived
// from non-normative text. A reader who tightened or loosened this fixture from
// that guard would be reasoning about SPICE, not about the LRM.
//
// The answer comes from the same sentence 26_limit.va rests on, which the clause
// above makes cover this form too — an unsupported string degrades to the
// no-string case: "When the simulator has converged, the return value of the
// $limit() function is the value of the access function reference, within
// appropriate tolerances." A printed operating point is an accepted solution, so
// the return is the 0.3 V bias, to the solver's convergence tolerance. Hence
// CHECKR at 1e-3 (the SPICE default reltol) and not an absolute band: §9.17.3
// says "in all cases, the simulator is responsible for determining ... what the
// return value is on a given iteration", which is not a last-bit guarantee.
//
// The third and fourth arguments are required whenever the second is "pnjlim"
// ("the third argument to $limit() indicates a step size vte and the fourth
// argument is a critical voltage vcrit"), which is why they are present.
//
//! lrm 9.17.3
//! lrm 9.17.3:3
//! lrm 9.17.3:4
//! bias V(p) = 0.3
`include "check.vh"
module ch09_limit_named(p, n);
  inout p, n; electrical p, n;
  real limited;
  analog begin
    limited = $limit(V(p,n), "pnjlim", $vt, 0.7);
    `CHECKR("a converged $limit returns the access function, string form included",
            limited, 0.3, 1e-3);
    I(p,n) <+ limited;
  end
endmodule
