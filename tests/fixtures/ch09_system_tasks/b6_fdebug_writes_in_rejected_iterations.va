// §9.5.9: "If a file is being written to during an iterative solve, then the
// file write operations shall not be performed unless the iteration is
// accepted. The exception to this is the $fdebug. If $fdebug is evaluated
// during an iteration, the write operation shall occur even if the evaluation
// occurred during an iteration that was rejected."
//
// 220_rejected_iterations_leave_no_file_side_effects.va pins the rule; this
// file pins the exception, with the same solve.
//
// THE SOLVE. `//! solve` frees p and the branch is I = v + v^3 - 10, root
// v = 2. Newton from the zero start cannot stop at its first evaluation
// (f(0) = -10), so the block is evaluated at least twice in this one dc solve,
// and every evaluation but the accepted last one belongs to an iteration that
// is not accepted.
//
// THE COUNT. The file is opened once, in `analog initial` (run once, before
// the solve, so no iteration reopens and truncates it). Each evaluation writes
// one "x" line with $fdebug, flushes, and counts the lines read back that hold
// the "x" (code > 1: "x\n" is two characters). Counting only those lines keeps
// the result the same whether $fdebug, like $display, adds its own newline
// (an extra "\n" line, code 1, not counted) or not. 400 tries bound it.
//
// At the accepted evaluation the file holds one "x" per evaluation so far,
// at least 2. A tool that wrote only at the accepted iteration has exactly 1.
//
//   lines > 1   (want 1)
//
//! lrm 9.5.9
//! lrm 9.5.9:2
//! lrm 9.5.4.1
//! solve
//! bias V(n) = 0
//! checks 2
//! xfail every §9.5 call runs in the display unit, once per accepted solution, so $fdebug never writes in a rejected iteration; a per-iteration write needs §9.5 calls in the core, with an analog-initial $fopen descriptor available during the first point's iterations (the core reads the previous point's latched result, file_kernels.zFRes)
`include "check.vh"
module b6_fdebug_writes_in_rejected_iterations(p, n);
  inout p, n; electrical p, n;
  integer fd, rfd, code, k, lines;
  string s;
  analog initial begin
    fd = $fopen("b6_fdebug_iterations.log", "w");
  end
  analog begin
    $fdebug(fd, "x\n");
    $fflush(fd);
    rfd = $fopen("b6_fdebug_iterations.log", "r");
    lines = 0;
    for (k = 0; k < 400; k = k + 1) begin
      code = $fgets(s, rfd);
      if (code > 1) lines = lines + 1;
    end
    $fclose(rfd);
    I(p, n) <+ V(p, n) + V(p, n) * V(p, n) * V(p, n) - 10.0;
    `CHECKI("§9.5.9 $fdebug wrote at the rejected iterations too: more x lines than the one accepted solution",
            lines > 1, 1);
    `CHECKR("the solve converged to the cubic's root", V(p, n), 2.0, 1e-9);
  end
endmodule
