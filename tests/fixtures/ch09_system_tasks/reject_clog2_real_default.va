// AMS §9.14 / IEEE 1364-2005 §17.11.1 also restricts a constant $clog2
// argument to integer/vector. An integral numeric VALUE such as 8.0 still
// has real TYPE; folding must not round it and bypass the operand check.
// Legal constant defaults are in clog2_unsigned_width.va.
//! lrm 9.14
//! reject-only E0892
//! neighbour clog2_unsigned_width.va
module reject_clog2_real_default;
  parameter integer bad = $clog2(8.0);
  analog begin
  end
endmodule
