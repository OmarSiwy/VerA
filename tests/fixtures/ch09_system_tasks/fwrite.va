// §9.5.2: $fwrite is $write against a descriptor — "the same type of arguments
// as the tasks upon which they are based", with the descriptor prepended. The
// destination and the rendering are not observable from inside the model; the
// VALUE handed to %g is, and §1.3.1 pins it: V(p,n) = 0.875 - 0.375 = 0.5 V,
// exact in binary floating point.
//
//! lrm 9.5.2
//! bias V(p) = 0.875, V(n) = 0.375
`include "check.vh"
module ch09_atomic_fwrite(p, n);
  inout p, n; electrical p, n;
  integer fd;
  analog begin
    fd = $fopen("ch09_040_fwrite.log", "a");
    `CHECK("the %g argument is the branch potential", V(p,n), 0.5, 1e-15);
    $fwrite(fd, "value=%g", V(p,n));
    I(p,n) <+ V(p,n);
  end
endmodule
