// LRM 9.14: $clog2 is the ONE math system function that is not an alias of a
// 4.3.1 operator — "the ceiling of the log base 2 of the argument". log2(9) is
// 3.1699…, so the ceiling is 4. 8 is the boundary the ceiling must not push
// past: log2(8) is exactly 3, so $clog2(8) is 3 and not 4.
//
//! lrm 9.14
//! lrm 9.14:1
`include "check.vh"
module ch09_atomic_clog2(p, n);
  inout p, n; electrical p, n;
  analog begin
    `CHECKI("$clog2(9) = ceil(3.1699...)", $clog2(9), 4);
    `CHECKI("$clog2 of an exact power of two does not round up", $clog2(8), 3);
    I(p,n) <+ V(p,n) + $clog2(9);
  end
endmodule
