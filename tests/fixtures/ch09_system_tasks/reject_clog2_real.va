// AMS §9.14 imports IEEE 1364-2005 §17.11.1, which permits an integer or
// vector argument. 8.5 is real and has neither integral bit pattern nor
// integral width. The legal neighbour clog2_unsigned_width.va explicitly
// converts a real with $rtoi and also exercises integer-valued arguments.
//! lrm 9.14
//! reject-only E0892
//! neighbour clog2_unsigned_width.va
module reject_clog2_real;
  integer result;
  analog result = $clog2(8.5);
endmodule
