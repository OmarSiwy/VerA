// §9.2 Table 9-11 lists $min as supported in the analog context; §4.3
// Table 4-14 defines it as C `fmin(x,y)` and §4.3.1 pins the discontinuous case
// exactly: "min(x,y) is equivalent to (x < y) ? x : y". §4.3 makes the `$` and
// traditional spellings the same function.
//
// The bias is NEGATIVE so both branches of that conditional are exercised
// against the fixed 0.0: min(-0.5, 0) = -0.5 picks the first operand, and
// min(-0.5 + 1, 0) = min(0.5, 0) = 0 picks the second. A $max mix-up flips both.
// All values are exactly representable, so the comparison is exact.
//
//! lrm 9.14
//! bias V(p) = -0.5
`include "check.vh"
module ch09_atomic_min(p, n);
  inout p, n; electrical p, n;
  analog begin
    `CHECKX("$min takes the first operand when it is smaller", $min(V(p,n), 0.0), -0.5);
    `CHECKX("$min takes the second operand when it is smaller", $min(V(p,n) + 1.0, 0.0), 0.0);
    `CHECKX("$min of equal operands is that operand", $min(V(p,n), -0.5), -0.5);
    `CHECKX("traditional min() is the same function", min(V(p,n), 0.0), -0.5);
    I(p,n) <+ V(p,n) + $min(V(p,n), 0.0);
  end
endmodule
