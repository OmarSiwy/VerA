// Elaboration must issue the same unsupported diagnostic before calling the
// emitted kernel during constant folding; it must not panic the compiler.
//! lrm 9.13.2
//! reject E0816
//! reject fractional or out-of-range
module ch09_rng_paramset_fractional_rejected(p, n);
  inout p, n; electrical p, n;
  sampled u(p, n);
endmodule
paramset sampled base;
  .r = $rdist_erlang(7, 1.5, 3.0, "global");
endparamset
module base(p, n);
  inout p, n; electrical p, n;
  parameter real r = 0;
  analog I(p,n) <+ V(p,n) + r;
endmodule
