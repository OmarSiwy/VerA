// DEBT — this rejection is NOT conformance.
// The LRM permits what VerA refuses here. The substrings below record
// CURRENT behavior so the suite stays green on it; they do not claim it
// is right. `zig build ledger` counts this rule against VerA.
//
// VAMS-9.16-01  (ch9-system.html)
// If either the inst_name or param_name cannot be resolved, and the optional expression is not supplied, then an error shall be generated.
//
//! reject E0801
//! reject $simprobe
// EXPECT: error
module ch09_simprobe_unsupported(p, n);
  inout p, n; electrical p, n;
  analog I(p,n) <+ $simprobe("sibling", "quantity", 0.0);
endmodule
