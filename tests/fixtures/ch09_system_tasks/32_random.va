// §9.13: "Verilog-AMS HDL extends the probabilistic distribution functions so
// that they are supported in the analog context." Table 9-10 lists all 17 names
// and every row reads `Yes  Yes` — digital context AND analog context. So this
// file must COMPILE and run green; a compiler that refuses the call is the one
// that is wrong, which is why the expectation is a run and not a reject.
//
// The value itself is implementation-defined — §9.13.3 points at the IEEE 1364
// §17.9.3 C code, which no clause of this LRM requires a tool to reproduce — so
// no digits are written for it. What §9.13.2 DOES fix is repeatability: "The
// system functions shall always return the same value given the same seed."
// Two seeds initialized to the same integer must therefore agree, and that
// holds for any conforming RNG whatever its stream.
//
// §9.13.1 also prints a worked example, and that one HAS a range to write down:
// "Where b > 0, the expression ($random % b) gives a number in the following
// range: [(-b+1) : (b-1)]", followed by `rand = $random % 60;` for -59..59.
// A 32-bit signed result is the only way that identity can hold.
//
//! lrm 9.13.1
//! xfail VerA refuses the whole §9.13 probabilistic family with E0801 rather than stubbing a seeded RNG stream; Table 9-10 marks every one of the 17 names analog-context Yes
`include "check.vh"
module ch09_random(p, n);
  inout p, n; electrical p, n;
  integer sa, sb;
  integer a, b;
  analog begin
    sa = 7; sb = 7;
    a = $random(sa);
    b = $random(sb);
    `CHECKI("§9.13.1 the same initial random_seed gives the same stream", a == b, 1);
    `CHECKI("§9.13.1 example: $random % 60 lands in [-59:59]",
            (a % 60 >= -59) && (a % 60 <= 59), 1);
    I(p,n) <+ V(p,n) + a;
  end
endmodule
