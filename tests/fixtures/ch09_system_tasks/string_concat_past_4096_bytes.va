// §3.3 Table 3-3 concatenation "Str1, ..., Strn" gives a string of every
// operand's characters, and §9.5.3 gives $sformat no truncation rule. VerA
// used to compose every run-time string in a 4096-byte row and end the run
// past it (E1011); a concatenation's row is now sized from its operands
// (#29), so the 8000 bytes below are composed whole.
//
// HAND DERIVATION. Two swept points.
//   s is "%4000d" of 1: 3999 spaces then '1', 4000 bytes.
//   point 0, V(p) = 0.5: t = s, 4000 bytes.
//   point 1, V(p) = 2.0: t = {s, s}, 8000 bytes: the 4000 twice.
// Each is compared with the same text folded from replications when the
// model compiles, a path that shares nothing with the run-time row.
//
//! lrm 3.3
//! lrm 9.5.3
//! sweep V(p) = 0.5, 2.0
//! checks 2
`include "check.vh"
module string_concat_past_4096_bytes(p, n);
  inout p, n; electrical p, n;
  string s, t, want;
  analog begin
    $sformat(s, "%4000d", 1);
    if (V(p, n) > 1.0) begin
      t = {s, s};
      want = {{3999{" "}}, "1", {3999{" "}}, "1"};
    end else begin
      t = s;
      want = {{3999{" "}}, "1"};
    end
    `CHECKI("the concatenation is every operand's bytes", t == want, 1);
    I(p,n) <+ V(p,n);
  end
endmodule
