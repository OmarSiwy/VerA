// §9.5.3: "The $swrite family of tasks is based on the $fwrite family of tasks
// and accepts the same type of arguments as the tasks upon which it is based,
// with one exception: The first argument to $swrite shall be a string variable
// to which the resulting string shall be written".
//
// `r` is a real variable, not a string variable. The same call with a
// `string s` as its first argument compiles (probed).
//
// VerA reports E0813 "`$swrite` writes into a `string` variable, and this one
// is real".
//
//! lrm 9.5.3
//! lrm 9.5.3:1
//! reject-only E0813
//! neighbour 044_swrite.va
`include "disciplines.vams"
module ch9_swrite_into_real(p, n);
  inout p, n;
  electrical p, n;
  real r;

  analog begin
    r = 0.0;
    $swrite(r, "x");           // illegal: the target is not a string variable
    I(p, n) <+ V(p, n);
  end
endmodule
