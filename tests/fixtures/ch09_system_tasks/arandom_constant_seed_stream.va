// AMS §9.13.1: "an internal seed is created which is assigned the initial
// value of the parameter or constant" and is updated on each call. The same
// clause makes $arandom upwardly compatible with $random. The repeated site
// must therefore follow the same stream as an explicitly initialized seed;
// CHECKEQ asserts that identity without assuming every pair of draws differs.
//
// Independent numeric anchor: AMS §9.13.3 imports IEEE §17.9.3, Table 17-17's
// full-range rtl_dist_uniform wrapper. At seed 7, wrapping 32-bit 69069*s+1
// gives 483484, -965981971, -1386778934. The listing forms the binary32
// mantissa (s>>9)|3f800000, applies c+c*2^-23, and maps it through the
// full signed range. Its three integer results are -2146999808, 1181502348,
// 760705370. These digits were recomputed from the local listing, including
// its extra-parenthesis correction, independently of the compiler kernel.
//
// The model-card seed override distinguishes initialization from a compiled
// default. A stream update has no invalid-input form; the argument/scope
// refusal neighbour is 132_arandom_type_string_outside_paramset_rejected.va.
//! lrm 9.13.1
//! lrm 9.13.3
//! lrm 9.13.3:1000
//! lrm 9.13.1:1002
//! param initial_seed = 7
//! time 0, 1, 2
//! checks 12
`include "check.vh"
module arandom_constant_seed_stream;
  parameter integer initial_seed = 11;
  integer seed, hidden_draw, parameter_draw, variable_draw;
  analog initial seed = initial_seed;
  analog begin
    hidden_draw = $arandom(7);
    parameter_draw = $arandom(initial_seed);
    variable_draw = $random(seed);
    `CHECKEQ("constant and explicit seed streams stay aligned", hidden_draw, variable_draw, 0);
    `CHECKEQ("parameter and explicit seed streams stay aligned", parameter_draw, variable_draw, 0);
    `CHECKI("parameter seed remains unchanged", initial_seed, 7);
    if ($abstime == 0)
      `CHECKI("reference first draw", hidden_draw, -2146999808);
    else if ($abstime == 1)
      `CHECKI("reference second draw", hidden_draw, 1181502348);
    else
      `CHECKI("reference third draw", hidden_draw, 760705370);
  end
endmodule
