// §9.5.2: the five file output tasks are the display tasks of §9.4 with one
// extra leading argument, "either a multichannel descriptor or a file
// descriptor". Every one of them here is handed the same fd, so §9.5.1 pins it:
// Table 9-24 gives type "a" as "Append; open for writing at end of file, or
// create for writing", which cannot fail for want of an existing file, and "the
// most significant bit (bit 31) of a fd is reserved and shall always be set".
// That bit is what each of these tasks has to test to tell an fd from a mcd,
// whose bit 31 "shall always be cleared".
//
// The second check pins the argument all five of them format. §1.3.1 makes
// V(p,n) the potential difference across the branch, 1.25 - 0.25 = 1.0 V, exact
// in binary floating point — so a %g that prints anything but 1 is printing
// something other than what it was passed. Note this is the ONLY value in the
// file that is not host state: what lands in ch09_08_file_output.log is not
// readable from here, and §9.5.9 makes even the timing of the write conditional ("if a file is
// being written to during an iterative solve, then the file write operations
// shall not be performed unless the iteration is accepted. The exception to this
// is the $fdebug").
//
//! bias V(p) = 1.25, V(n) = 0.25
//! lrm 9.5.1
//! lrm 9.5.2
//! xfail VerA has no file-descriptor surface: codegen.zig `void_tasks` lowers the whole §9.5 family to the constant `S.con(0.0)`, so $fopen answers 0 (bit 31 clear) and all five output tasks are no-ops — lower.zig:2365 `isDisplayTask` deliberately excludes them, so unlike $display they never even reach cg_display.zig
`include "check.vh"
module ch09_file_output(p, n);
  inout p, n; electrical p, n;
  integer fd;
  analog begin
    fd = $fopen("ch09_08_file_output.log", "a");
    // Masked, not shifted: `>>` fills with zeros on a 32-bit integer, but VerA
    // carries integers in an i64 where a sign-extended fd would answer a shift
    // differently. `& 2147483648` is bit 31 whatever the width.
    `CHECKI("append cannot fail, so bit 31 of the fd is set", (fd & 2147483648) != 0, 1);
    `CHECK("the %g argument of all five tasks is the branch potential", V(p,n), 1.0, 1e-15);
    $fdisplay(fd, "display %g", V(p,n));
    $fwrite(fd, "write %g", V(p,n));
    $fstrobe(fd, "strobe %g", V(p,n));
    $fmonitor(fd, "monitor %g", V(p,n));
    $fdebug(fd, "debug %g", V(p,n));
    I(p,n) <+ V(p,n);
  end
endmodule
