// §9.7.1 $finish: "if $finish is called during an accepted iteration, then the
// simulator shall exit after the current solution is complete", and the argument
// (2 here) selects how much diagnostic Table 9-25 prints. Neither of those is a
// VALUE the model can read back — $finish returns nothing, and its effect is the
// simulator's, not the device's.
//
// What IS a value, and what decides whether §9.7.1 applies at all, is the guard.
// §4.2.5 makes a relational expression an integer, 1 or 0, and `>` is STRICT, so
// the bias is put exactly ON the threshold: V(p,n) = 1.0 - 0 = 1.0, both exact
// in binary, and 1.0 > 1.0 is false. The operating point is therefore the one
// where $finish is not reached and the sweep runs to completion.
//
// Restricting on the thing that matters here: a `>` lowered as `>=`, or a guard
// that compared the node p against something other than n, fires $finish at this
// bias and turns the 0 into a 1.
//
// WHAT THIS FIXTURE DOES NOT PROVE. $finish is never executed, and cannot be: doing
// so is what ends the run, and this suite reads its verdict off a transcript the
// run has to survive to print. So the assertion below is about the OPERATING
// POINT — that the bias sits below the guard, i.e. that `>` is strict — and not
// about §9.7. It documents why the call is not reached. 060_info.va and
// 059_warning.va are the two tasks of this family that CAN be called
// unconditionally, and they are, with the assertion placed after the call.
//
//! lrm 9.7.1
//! lrm 9.7.1:2
//! bias V(p) = 1.0
`include "check.vh"
module ch09_atomic_finish(p, n);
  inout p, n; electrical p, n;
  analog begin
    if (V(p,n) > 1.0) $finish(2);
    `CHECKI("strict > is false exactly at the threshold, so $finish is not reached", V(p, n) > 1.0, 0);
    I(p,n) <+ V(p,n);
  end
endmodule
