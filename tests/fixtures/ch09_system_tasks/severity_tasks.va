// §9.7.3 $fatal, $error, $warning, $info — the four assertion severity tasks,
// analog-context-only in Table 9-4. None returns a value; what separates them is
// what they do to the RUN:
//
//   $info     "carries no specific severity"           — run continues
//   $warning  "a run-time warning"                     — run continues
//   $error    "a run-time error"                       — run does not proceed
//   $fatal    "terminates the simulation with an errorcode ... an implicit call
//              to $finish"                             — run ends here
//
// So the file splits them. $info and $warning are called UNCONDITIONALLY, and an
// assertion sits after them: the `ok=` line only appears if execution reached
// it, so a tool that stopped on either would print nothing and the fixture would
// fail. That is the only observable §9.7.3 gives a task with no return value,
// and it is the whole content of the "run continues" column above.
//
// $error and $fatal stay under a guard the operating point makes FALSE, because
// executing them is precisely what ends the run. §5.4.1 gives V(p,n) =
// 3.0 - 0.5 = 2.5 V, exact in binary, so both guards are 0. What that pair of
// checks proves is only that the bias is where the header says it is — it is
// arithmetic, not §9.7 — and it is here to document why those two calls are not
// reached, not to test them. Testing $error/$fatal positively would need a
// harness that can observe a terminated run, which this suite does not have.
//
//! lrm 9.7.3
//! lrm 9.7.3:4
//! lrm 9.7.3:1004
//! bias V(p) = 3.0, V(n) = 0.5
`include "check.vh"
module ch09_severity_tasks(p, n);
  inout p, n; electrical p, n;
  analog begin
    `CHECKI("§4.2.5: at V(p,n) = 2.5 V neither terminating guard is true",
            (V(p, n) > 3.0) || (V(p, n) > 4.0), 0);
    $info("info %g", V(p,n));
    $warning("warning %g", V(p,n));
    `CHECKX("§9.7.3: the run continues past $info and $warning, so this is reached",
            V(p,n)*2.0, 5.0);
    if (V(p,n) > 3.0) $error("error %g", V(p,n));
    if (V(p,n) > 4.0) $fatal(1, "fatal %g", V(p,n));
    I(p,n) <+ V(p,n);
  end
endmodule
