// §6.3.6 allows a paramset to specify all six hierarchical parameters;
// §9.18 applies the same Table 9-29 combination to module and paramset
// instances. The paramset instance inherits (2,-4,300,-1,-1,2); its body
// specifies (3,6,100,-1,-1,3), producing (5,2,40,+1,+1,6) in the associated
// module. Its own reads still see (2,-4,300,-1,-1,2), not the result it is
// assigning. The angle defparam takes precedence over its named value
// (§6.3). §3.4.7 permits the x alias on the paramset and y alias on the
// associated module. No variable participates in these constant assignments.
//! lrm 3.4.7
//! lrm 6.3
//! lrm 6.3.6
//! lrm 6.4.1
//! lrm 9.18
//! lrm 6.3.6:1
//! lrm 6.3.6:2
//! lrm 9.18:1000
//! checks 8
`include "check.vh"
module geometry_paramset_top;
  geometry_ps #(.placement_x(2), .$yposition(-4), .$angle(90),
               .$hflip(-1), .$vflip(-1), .$mfactor(2)) leaf();
  defparam leaf.$angle = 300;
endmodule
paramset geometry_ps geometry_paramset_leaf;
  parameter real dx = 3;
  aliasparam placement_x = $xposition;
  .$xposition = dx;
  .placement_y = 6;
  .$angle = 100;
  .$hflip = -1;
  .$vflip = -1;
  .$mfactor = 3;
  .seen_x = $xposition;
  .seen_angle = $angle;
endparamset
module geometry_paramset_leaf;
  parameter real seen_x=0, seen_angle=0;
  aliasparam placement_y = $yposition;
  analog begin
    `CHECKX("paramset x", $xposition, 5.0);
    `CHECKX("paramset y module alias", $yposition, 2.0);
    `CHECKX("paramset angle", $angle, 40.0);
    `CHECKX("paramset hflip", $hflip, 1.0);
    `CHECKX("paramset vflip", $vflip, 1.0);
    `CHECKX("paramset mfactor", $mfactor, 6.0);
    `CHECKX("paramset reads its own x", seen_x, 2.0);
    `CHECKX("paramset reads its own angle", seen_angle, 300.0);
  end
endmodule
