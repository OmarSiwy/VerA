// §9.5.7: `errno = $ferror( fd, str )` — "Should any error be detected by one
// of the file I/O routines, an error code is returned ... A string description
// of type of error encountered by the most recent file I/O operation is written
// into str ... The integral value of the error code is returned in errno. If
// the most recent operation did not result in an error, then the value returned
// shall be ZERO, and the string variable str shall be EMPTY."
//
// That is two states, and the fixture puts $ferror in both. It writes its own
// file first, so the successful case is reachable; the failing case is a second
// name that nothing in this directory ever creates, which §9.5.1 makes a
// definite error — "if a file cannot be opened ... a zero is returned for the
// mcd or fd. Applications can call $ferror to determine the cause of the most
// recent error."
//
//   after a successful open   ->  errno 0, str empty
//   after a failed open       ->  errno nonzero
//
// Both directions are needed. The no-error half alone is satisfied by an
// implementation that returns 0 and never writes str — a description of doing
// nothing, not of succeeding. The error half is asserted as `!= 0` and not as a
// digit: §9.5.7 says only "an error code is returned" and the numeric value is
// the host's errno, so writing one would over-specify and fail a conforming
// tool.
//
// The previous version of this fixture had a CHECKEQ between `(fd == 0)` and
// `(code != 0)` on a filename it shared with eight siblings, one of which
// created it — so which branch it took depended on run order, and an all-zeros
// implementation satisfied it in the one direction §9.5.7 forbids.
//
//! lrm 9.5.1
//! lrm 9.5.7
//! xfail VerA has no file-descriptor surface: codegen.zig `void_tasks` lowers the whole §9.5 family to the constant `S.con(0.0)`, so $fopen reports failure (fd 0) while $ferror still reports no error — a file that could not be opened raising none
`include "check.vh"
module ch09_atomic_ferror(p, n);
  inout p, n; electrical p, n;
  integer fd, ok_code, bad_fd, bad_code; string text; string bad_text;
  analog begin
    fd = $fopen("ch09_053_ferror.dat", "w");
    $fwrite(fd, "abc\n");
    $fclose(fd);
    fd = $fopen("ch09_053_ferror.dat", "r");
    ok_code = $ferror(fd, text);
    $fclose(fd);
    bad_fd = $fopen("ch09_053_missing.dat", "r");
    bad_code = $ferror(bad_fd, bad_text);
    `CHECKI("§9.5.7 a successful operation leaves errno zero", ok_code, 0);
    `CHECKI("§9.5.7 and leaves the description string empty", text == "", 1);
    `CHECKI("§9.5.1 a missing file cannot be opened for reading", bad_fd, 0);
    `CHECKI("§9.5.7 so $ferror reports that error with a nonzero errno", bad_code != 0, 1);
    I(p,n) <+ V(p,n) + ok_code + bad_code;
  end
endmodule
