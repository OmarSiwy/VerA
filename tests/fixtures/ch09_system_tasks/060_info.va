// §9.7 / Table 9-4: `$info` is a simulation-control message task, supported in
// the analog context and in no other. It returns nothing, so what a check can
// pin here is the operating point that decides whether it fires.
//
// §5.4.1 gives V(p,n) = 0.75 - 0.25 = 0.5 V exactly, which the first check pins;
// the operand order of the probe is what it catches.
//
// WHAT AN UNCONDITIONAL CALL PROVES, AND WHY IT IS UNCONDITIONAL. §9.7.3 gives
// these two tasks no return value, so there is no digit for them and the only
// observable the LRM fixes is that the RUN CONTINUES past them. The way to test
// that is to call them unconditionally and put an assertion AFTER the call: the
// `ok=` line only appears if execution got there, so a tool that terminated on
// $info would print nothing and the fixture would fail.
//
// The previous shape put the call under `if (V(p,n) > 1.0)` and then asserted
// the guard. That asserts that `>` is strict — arithmetic, not §9.7 — and under
// the drop that then applied to a display task under an `if` (W0851, since
// lifted) the task did not run at all. $error and $fatal still have to be guarded, because
// executing them is what they are FOR; these two do not.
//
//! lrm 9.2
//! lrm 9.7.3
//! lrm 9.2:1000
//! bias V(p) = 0.75, V(n) = 0.25
`include "check.vh"
module ch09_atomic_info(p, n);
  inout p, n; electrical p, n;
  analog begin
    `CHECKX("branch potential is V(p) - V(n), in that order", V(p,n), 0.5);
    $info("voltage=%g", V(p,n));
    `CHECKX("§9.7.3: the run continues past $info, so this line is reached",
            V(p,n)*3.0, 1.5);
    I(p,n) <+ V(p,n);
  end
endmodule
