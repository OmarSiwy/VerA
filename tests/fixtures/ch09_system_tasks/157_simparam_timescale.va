// §9.15 Table 9-27 names fourteen simulation parameters and fixes the value of
// exactly two, because those two are read out of the SOURCE and not out of a
// simulator's preference file:
//
//     "timeUnit"       s   Time unit as specified in `timescale, in seconds
//     "timePrecision"  s   Time precision as specified in `timescale, in seconds
//
// 22_simparam.va correctly declines to assert "gmin", "scale" and the rest —
// the LRM gives them units and a description and no number, so any digits would
// be a recording of one engine's defaults. These two are different: the
// `timescale directive one line below fixes them, so the answers are derivable
// from this file's own text.
//
// Under `timescale 1ns/1ps, in SECONDS (the units column is "s", not ticks):
//
//     timeUnit       = 1 ns  = 1e-9
//     timePrecision  = 1 ps  = 1e-12
//
// Both are exact in double, so CHECKX. §9.15 adds "$simparam() shall always
// return a real value; simulation parameters that have integer values shall be
// coerced to real", which is why the destinations are reals and not the tick
// counts a $timeformat-minded implementation would hand back.
//
//! lrm 9.15
//! xfail VerA does not thread `timescale into $simparam: codegen.zig answers every unknown name with its fallback, and "timeUnit"/"timePrecision" have none here, so both come back 0.0
`timescale 1ns/1ps
`include "check.vh"
module ch09_simparam_timescale(p, n);
  inout p, n; electrical p, n;
  real unit, precision;
  analog begin
    unit = $simparam("timeUnit");
    precision = $simparam("timePrecision");
    `CHECKX("Table 9-27 timeUnit is the `timescale unit in seconds", unit, 1e-9);
    `CHECKX("Table 9-27 timePrecision is the `timescale precision in seconds", precision, 1e-12);
    I(p,n) <+ V(p,n) + unit + precision;
  end
endmodule
