// §9.14: "All of these functions, except $clog2, are aliases of the analog
// math operators described in 4.3.1 and Table 4-14 shows which analog math
// operators are aliases of which math system functions."
//
// An alias is the same function under a second name, so it takes the same
// arguments. Table 4-14's row reads `$pow(x,y)` | `pow(x, y)` | C `pow(x,y)` |
// "Power (x^y)": two operands, the base and the exponent. `$pow(2.0)` is the
// §4.3.1 call `pow(2.0)`, which VerA refuses with E0506; the `$` spelling has
// to fail the same way or it is not an alias.
//
// It did not: the undecorated name went through §4.3's arity check and the
// system name went through Clause 9's generic call path, which checked none,
// so `$pow(2.0)` (and `$hypot(3.0)`, `$ln(1.0, 2.0)`) compiled. Adding the
// exponent, `$pow(2.0, 3.0)`, compiles (probed; 087_pow.va runs it).
//
// VerA reports E0506, the code the undecorated `pow(2.0)` gets.
//
//! lrm 9.14
//! lrm 4.3.1
//! reject-only E0506
//! reject `$pow()` takes 2
//! neighbour 087_pow.va
`include "disciplines.vams"
module ch09_math_system_function_arity(p, n);
  inout p, n; electrical p, n;
  real y;
  analog begin
    y = $pow(2.0);                       // illegal: Table 4-14 pow is binary
    I(p, n) <+ V(p, n) * y;
  end
endmodule
