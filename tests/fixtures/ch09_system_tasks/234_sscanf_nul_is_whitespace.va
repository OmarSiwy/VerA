// §9.5.4.2, the last sentence of item a): "For $sscanf, null characters
// shall also be considered white space." C's `scanf` does not treat NUL as
// white space, so the LRM calls the extension out separately, and scopes it
// to `$sscanf` — `$fscanf` keeps C's set.
//
// A literal cannot carry the NUL to the call: §3.3 converts a literal to the
// string type and "all the \0 characters are ignored", so `"1\0002"` reaches
// any analog string operation as `"12"`. A string READ FROM A FILE is the
// legal path: §9.5.4.1's `$fgets` transfers the characters a file holds, and
// `$fwrite`'s writer keeps a format literal's bytes (188_numeric_string.va
// pins that with `%c%c%c`).
//
// The file holds two lines, "7\n" and "1\0002". Two `$fgets` read them into
// two strings, the descriptor is CLOSED, and only then are both scanned. That
// ordering is load-bearing: §9.5.4.1 transfers the characters "to str" at the
// `$fgets`, so a string read before a `$fclose` (or before the next `$fgets`
// on the same descriptor) keeps what that read transferred. The first line
// pins this on its own; the second is the clause: the only character between
// its fields is the NUL, so "%d %d" assigns two items only if the NUL is
// white space. A scanner that keeps C's set stops at it and returns 1.
//
//! lrm 9.5.4.2
//! lrm 9.5.4.2:3
//! lrm 9.5.4.1
//! checks 6
`include "check.vh"
module ch09_sscanf_nul_is_whitespace(p, n);
  inout p, n; electrical p, n;
  integer fd, got1, got2, code1, code2, k, a, b;
  string line1, line2;
  analog begin
    @(initial_step) begin
      fd = $fopen("ch09_234_sscanf_nul.dat", "w");
      $fwrite(fd, "7\n1\0002");
      $fclose(fd);
      fd = $fopen("ch09_234_sscanf_nul.dat", "r");
      got1 = $fgets(line1, fd);
      got2 = $fgets(line2, fd);
      $fclose(fd);
    end
    code1 = $sscanf(line1, "%d", k);
    code2 = $sscanf(line2, "%d %d", a, b);
    `CHECKI("§9.5.4.1 the first line is the file's first two bytes", got1, 2);
    `CHECKI("§9.5.4.1 the first $fgets's string survives the next read and the close", k, 7);
    `CHECKI("§9.5.4.1 the second line carries the file's three remaining bytes", got2, 3);
    `CHECKI("§9.5.4.2 a NUL between fields is white space for $sscanf", code2, 2);
    `CHECKI("§9.5.4.2 the first field converted", a, 1);
    `CHECKI("§9.5.4.2 the scan crossed the NUL to the second field", b, 2);
    I(p, n) <+ V(p, n);
  end
endmodule
