// §9.4.1's argument-list model, pinned with values. "$strobe displays its
// arguments in the same order they appear in the argument list. Each argument
// can be a quoted string, an expression which returns a value, or a null
// argument", string contents "are output literally" except for format
// specifiers, and each specifier "establishes the display format for a
// subsequent expression argument" — so EVERY string argument is a format run
// whose conversions consume the arguments after it, a later string starts the
// NEXT run, and an expression no run consumed prints in §9.4.3's "default
// decimal format". Nothing in the clause inserts separators: §9.4.1's own way
// to write a space between fields is a null argument.
//
// Display text is not a value, so the rule is pinned the way 09_string_-
// formatting.va pins %10.4e: §9.5.3 makes $sformat the SAME formatter writing
// into a string variable ("the same as their counterparts ... except that ...
// the resulting string shall be written"), and a string comparison is an
// integer (§4.2.14/§4.2.5) — so each expected transcript is a literal the ok=
// column can hold. Derived by hand:
//
//   ("a=%d", 1, "b=%d", 2) -> "a=1" ++ "b=2"      = "a=1b=2"
//     the second string is a FORMAT, not the first run's operand — the old
//     first-string-is-THE-format model printed "a=1 b=%d 2"
//   (7, " then %d", 3)     -> "7" ++ " then 3"    = "7 then 3"
//     an expression BEFORE the first string prints (the old model dropped it)
//   ("v:", 42)             -> "v:" ++ "42"        = "v:42"
//     no inserted space before an unconsumed operand
//   ("%s;", "x", "end=%d", 9) -> "x;" ++ "end=9"  = "x;end=9"
//     a string consumed BY a conversion is an operand, not a format
//
// The integer default is minimal-width decimal — a documented deviation from
// 1364-2005 §17.1.1.2's auto-sized field (20 columns for VerA's 64-bit
// integers); see src/backend/cg_display.zig `buildArgs`.
//
//! print none
//! lrm 9.4.1
//! lrm 9.4.3
//! lrm 9.5.3
`include "check.vh"
module ch09_display_argument_runs(p, n);
  inout p, n; electrical p, n;
  string t;
  analog begin
    $sformat(t, "a=%d", 1, "b=%d", 2);
    `CHECKI("every string argument is its own format run, concatenated", t == "a=1b=2", 1);
    $sformat(t, 7, " then %d", 3);
    `CHECKI("an expression before the first string still displays, in order", t == "7 then 3", 1);
    $sformat(t, "v:", 42);
    `CHECKI("no separator is inserted before an unconsumed operand", t == "v:42", 1);
    $sformat(t, "%s;", "x", "end=%d", 9);
    `CHECKI("a string eaten by %s is an operand; the next string is a new run", t == "x;end=9", 1);
    I(p,n) <+ V(p,n);
  end
endmodule
