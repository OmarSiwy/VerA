// §9.19: "Note that the return values of these functions shall be constant
// during a simulation; the value is fixed during elaboration. As such, these
// functions can be used in genvar expressions controlling conditional or
// looping behavior of the analog operators of 4.5."
//
// b6_port_connected_controls_analog_operator.va covers a child instance,
// whose call folds at elaboration. Here the module is the top level, so
// `$port_connected(t)` reads the host's connection mask at run time and the
// `if` stays a runtime conditional: the analog operator under it is legal by
// the sentence above, not by folding (#33). `$param_given` is the same
// function class (Syntax 9-14 genvar_system_function).
//
// THE DIGITS. A single dc point with every port connected, so
// $port_connected(t) = 1, and `c` is never overridden, so $param_given(c) = 0.
// §4.5.5 ddt is 0 at dc, so i_t = 0.0 + 1.0 and i_c = 0.0 - 1.0 exactly.
//
//! lrm 9.19
//! lrm 9.19:6
//! lrm 9.19:2
//! bias V(p) = 0.5, V(n) = 0.0, V(t) = 0.0
//! checks 2
`include "check.vh"
module b6_top_pc_ddt(p, n, t);
  inout p, n, t; electrical p, n, t;
  parameter real c = 1e-12;
  real i_t, i_c;
  analog begin
    if ($port_connected(t)) i_t = ddt(c * V(p, n)) + 1.0;
    else i_t = -1.0;
    if ($param_given(c)) i_c = ddt(c * V(p, n)) + 1.0;
    else i_c = ddt(c * V(p, n)) - 1.0;
    I(p, n) <+ V(p, n);
    I(t) <+ V(t);
    `CHECKX("t is connected: its arm runs ddt(), 0 at dc, plus 1.0", i_t, 1.0);
    `CHECKX("c keeps its default: the else arm, ddt() at dc is 0, minus 1.0", i_c, -1.0);
  end
endmodule
