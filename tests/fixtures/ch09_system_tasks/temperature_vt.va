// §9.15 Analog Kernel Parameter System Functions. `$temperature` is the
// ambient temperature in KELVIN — that one IS fixed by the LRM and is checked
// exactly. `$vt` "returns the thermal voltage (kT/q) at the given temperature",
// and §9.15 mandates NO value for k or q, so the digits depend on which
// constant set the tool picked.
//
// Annex D.2 offers FIVE sets, selected by `PHYSICAL_CONSTANTS_NIST2018 /
// _NIST2010 / _SPICE / _OLD in that `ifdef order, with NIST1998 as the `else
// fallback taken when no macro is defined (annex-d-stddefs.html:363,371 define
// P_Q_NIST2018 = 1.602176634e-19 and P_K_NIST2018 = 1.380649e-23; :390 makes
// NIST2018 the FIRST branch of the chain). At 300 K:
//
//   SPICE     1.38062e-23   / 1.60219e-19      = 0.025851241113725592 V
//   OLD       1.3806226e-23 / 1.6021918e-19    = 0.025851260754174377 V
//   NIST1998  1.3806503e-23 / 1.602176462e-19  = 0.025852026903638286 V  <- default
//   NIST2010  1.3806488e-23 / 1.602176565e-19  = 0.025851997154882865 V
//   NIST2018  1.380649e-23  / 1.602176634e-19  = 0.025851999786435535 V
//
// The five spread by 3.04e-5 relative (SPICE low, NIST1998 high), so the
// literals below are the NIST1998 default at full precision and the tolerance is
// rtol 1e-4: every conforming choice of constants sits at most 3.04e-5 from the
// literal and passes, four significant figures are still pinned, and a wrong
// formula or a Celsius/Kelvin slip (300.15 vs 27.0 -> 40% off) still fails.
// rtol 1e-6 would be 30x tighter than that spread and would reject the four
// non-default sets, none of which the LRM forbids.
//
//   $vt(300.0)  = 0.025852026903638286 V
//   $vt         = $vt($temperature) at 300.15 K = 0.025864952917090102 V
//
// The 300.15/300 ratio between the two is the whole content of "$vt without
// the optional input temperature argument returns the thermal voltage using
// $temperature".
//
//! lrm 9.15
//! temp 300.15
`include "check.vh"
module ch09_temperature_vt(p, n);
  inout p, n; electrical p, n;
  analog begin
    `CHECK("$temperature is the ambient in kelvin", $temperature, 300.15, 1e-12);
    `CHECKR("$vt(300.0) is k*300/q", $vt(300.0), 0.025852026903638286, 1e-4);
    `CHECKR("bare $vt uses $temperature = 300.15 K", $vt, 0.025864952917090102, 1e-4);
    I(p,n) <+ $temperature + $vt + $vt(300.0) + 0.0*V(p,n);
  end
endmodule
