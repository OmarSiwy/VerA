// §9.13.2 states one flat domain rule for five of the seven real distributions:
//
//   "For the $rdist_exponential, $rdist_poisson, $rdist_chi_square, $rdist_t,
//    and $rdist_erlang functions, the arguments mean, degree_of_freedom, and
//    k_stage SHALL BE GREATER THAN ZERO (0). Otherwise an ERROR SHALL BE
//    REPORTED."
//
// "Shall ... otherwise an error shall be reported" is as unambiguous as the
// chapter gets, and it leaves no implementation latitude: not a warning, not a
// clamp, not a NaN. Three of the chapter's DEBT headers quote this sentence and
// then pass legal arguments, so it was cited and never exercised.
//
// Two of the three named arguments are violated here — k_stage == 0, which the
// rule excludes because it is not strictly greater than zero, and a negative
// degree_of_freedom. Both are in one file because they are one rule; the first
// diagnostic ends the compile.
//
// §9.13.2's OTHER rule — "for each system function, the seed argument shall be
// an integer" — used to be bundled in here as a third call with a real seed.
// It is a different sentence, and Syntax 9-9 states it as grammar
// (`seed ::= integer_variable_identifier | integer_parameter_identifier |
// [sign] decimal_number`), so `//! reject greater than zero` could never have
// pinned it. It now has its own file, 166_rdist_real_seed_rejected.va.
//
// A reject, so there is nothing to run and no `want` to write.
//
//! lrm 9.13.2
//! reject greater than zero
//! xfail VerA refuses the whole §9.13 family with E0801 at the function name, so no argument is ever examined and the domain rule is not reached
module ch09_rdist_domain_rejected(p, n);
  inout p, n; electrical p, n;
  integer seed;
  real a, b;
  analog begin
    seed = 1;
    a = $rdist_erlang(seed, 0, 1.0);
    b = $rdist_chi_square(seed, -2.0);
    I(p,n) <+ V(p,n) + a + b;
  end
endmodule
