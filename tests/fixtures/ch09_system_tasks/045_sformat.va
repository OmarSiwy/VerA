// §9.5.3: $sformat "always interprets its second argument, and only its second
// argument, as a format string", and supports every specifier of §9.4.3 — here
// %10.4e, a width-10 exponential with four fractional digits (Table 9-23 plus
// the C-style width.precision of §9.4.3). The remaining argument is an ordinary
// expression evaluated at the operating point, which §1.3.1 pins:
// V(p,n) = 0.125 - 0.0625 = 0.0625 V, exact in binary floating point. %10.4e of
// 0.0625 is "6.2500e-02" — exactly ten characters, so the width-10 minimum adds
// no padding. ("1.2500e-01" would be V(p) alone, which is the very mistake the
// branch-potential check below exists to catch.)
//
//! lrm 9.5.3
//! bias V(p) = 0.125, V(n) = 0.0625
`include "check.vh"
module ch09_atomic_sformat(p, n);
  inout p, n; electrical p, n;
  string text;
  analog begin
    `CHECK("the %10.4e argument is the branch potential", V(p,n), 0.0625, 1e-15);
    $sformat(text, "value=%10.4e", V(p,n));
    I(p,n) <+ V(p,n);
  end
endmodule
