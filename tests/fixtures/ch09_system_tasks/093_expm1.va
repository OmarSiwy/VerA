// §9.14 Table 9-11 lists $expm1 and makes it an alias of the §4.3.1 operator.
// Table 4-14: "$expm1(x) ... C expm1 ... Exponential minus 1", all x. §4.3.1
// adds "For small magnitude values of x, expm1(x) can be more accurate than
// exp(x)-1".
//
// Two claims, both derived from e^x - 1 alone:
//
//   e^0.5 - 1 = 1.6487212707001282 - 1 = 0.64872127070012819 to double
//   precision (sqrt(e) = 1.64872127070012814685...).
//
//   the small-x case is the only thing that distinguishes expm1 from exp-1.
//   For x = 5e-16, e^x - 1 = x + x^2/2 + ... = 5.0000000000000014e-16 as a
//   double. Computing exp(x) FIRST cannot produce that: doubles near 1 are
//   spaced 2^-52 = 2.22e-16, so exp(5e-16) rounds to 1 + 2*2^-52 and the
//   subtraction yields 4.4408920985006262e-16 — 11% low. The rtol below is far
//   tighter than that gap.
//
//! bias V(p) = 0.5
//! lrm 9.14
//! lrm 4.3.1
//! xfail VerA rounds through 1: codegen.zig `zExpm1` is `a.exp().addC(-1.0)`, so $expm1(5e-16) returns 4.440892098500626e-16 — 11% low, precisely the exp(x)-1 value Table 4-14's C expm1 exists to replace
`include "check.vh"
module ch09_atomic_expm1(p, n);
  inout p, n; electrical p, n;
  analog begin
    `CHECK("expm1(0.5) is sqrt(e) - 1", $expm1(V(p,n)), 0.64872127070012819, 1e-15);
    `CHECKR("expm1(5e-16) never rounds through 1", $expm1(V(p,n)*1e-15), 5.0000000000000014e-16, 1e-9);
    I(p,n) <+ V(p,n) + $expm1(V(p,n));
  end
endmodule
