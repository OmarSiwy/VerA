// NONCONFORMING ACCEPTANCE SNAPSHOT: $driver_next_state is valid only in the digital context of a connectmodule.
//
// §9.23.2 enumerates the answer exhaustively: "The pending state value is
// returned as 1'b0, 1'b1, 1'bx, or 1'bz." One bit, four codes.
//
// Two of those four cannot survive into this expression at all: §4.2.1.2 makes
// individual bits that are x or z an ERROR when the value is used in a real
// expression, and `+ $driver_next_state(p,0)` on the contribution below is
// exactly that. So the only values this fixture can legally observe are the two
// numeric ones, 0 and 1.
//
// That is restricting on both of the ways a driver query goes wrong: a -1
// "nothing pending" sentinel (§9.23.1's shape) fails it, and so does anything
// wider than one bit — a state accidentally carrying a strength word, say.
`include "check.vh"

//! bias V(p) = 0.5

module ch09_atomic_driver_next_state(p, n);
  inout p, n; electrical p, n;
  analog begin
    `CHECKI("§9.23.2 + §4.2.1.2: a one-bit state, and x/z cannot reach a real expression, so 0 or 1",
            ($driver_next_state(p,0) == 0) || ($driver_next_state(p,0) == 1), 1);
    I(p,n) <+ V(p,n) + $driver_next_state(p,0);
  end
endmodule
