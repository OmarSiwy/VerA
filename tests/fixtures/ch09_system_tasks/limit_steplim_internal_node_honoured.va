// §9.17.3: "When the second argument is a string, it refers to a built-in
// function of the simulator." Which built-ins exist is the tool's choice.
// VerA's set is pnjlim, pnjlimds, fetlim, fetlimds, limvds and steplim
// (specification/Vague_Decisions.md); steplim(step) clamps each Newton iterate to within
// `step` of the previous one. This is steplim HONOURED: `//! nowarn` pins that
// VerA takes the call silently (a declined $limit warns W0853), and the checks
// assert what the clause fixes about the answer: "When the simulator has
// converged, the return value of the $limit() function is the value of the
// access function reference, within appropriate tolerances."
//
// The circuit is 226_limit_pnjlim_internal_node_honoured.va's, so the root is
// its: the KCL at `a`, (0.7 - Va) / 100 = 1e-14 * (exp(Va / 0.025) - 1), one
// root, Va = 0.625763159 by bisection over [0, 0.7]. A 0.1 V step bound only
// changes the path Newton takes to it. The band is the solver's convergence
// tolerance, relative 1e-3, as in 226.
//
//! lrm 9.17.3
//! nowarn
//! solve
//! bias V(p) = 0.7, V(n) = 0
`include "check.vh"
module limit_steplim_internal_node_honoured(p, n);
  inout p, n; electrical p, n, a;
  real vd;
  analog begin
    vd = $limit(V(a,n), "steplim", 0.1);
    I(p,a) <+ V(p,a) / 100.0;
    I(a,n) <+ 1e-14 * (exp(vd / 0.025) - 1.0);
    `CHECKR("the junction settles at the KCL root", V(a,n), 0.625763159, 1e-3);
    `CHECKR("and the converged $limit returns it", vd, 0.625763159, 1e-3);
  end
endmodule
