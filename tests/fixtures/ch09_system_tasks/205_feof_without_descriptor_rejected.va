// §9.5.8:
//
//   integer code;
//   code = $feof( fd );
//
// "Returns a nonzero value when EOF has previously been detected reading the
// input file fd. It returns zero otherwise."
//
// Both answers are about ONE file, the one fd names. `$feof()` names none, so
// "EOF has previously been detected reading the input file fd" has no fd to be
// true or false of. Unlike §9.5.6's `$fflush( )`, which the clause prints with
// empty parentheses and gives a meaning ("to all open files"), §9.5.8 prints no
// empty form. `$feof(fd)` compiles (probed; 054_feof.va runs it).
//
// VerA used to accept the empty call and answer it. It now reports E0887
// "wrong number of arguments to a system task or function".
//
//! lrm 9.5.8
//! reject-only E0887
//! reject `$feof` takes 1 argument, got 0
//! neighbour 054_feof.va
`include "disciplines.vams"
module ch09_feof_without_descriptor(p, n);
  inout p, n; electrical p, n;
  integer fd, code;
  analog begin
    @(initial_step) begin
      fd = $fopen("ch09_205.log", "w");
      code = $feof();                    // illegal: which file?
    end
    I(p, n) <+ V(p, n);
  end
endmodule
