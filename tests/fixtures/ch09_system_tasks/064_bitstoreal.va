// §9.11 / Table 9-8: `$bitstoreal` reads a 64-bit pattern back as the IEEE-754
// double it stands for — the inverse of `$realtobits`.
//
//   0x3FF0000000000000 = 4607182418800017408 is sign 0, biased exponent
//   1023 = 0x3FF, zero mantissa, i.e. +1.0 x 2^0 = 1.0 exactly.
//
// The second check is the round trip on a value with a nonzero mantissa
// (0.75 = 1.1b x 2^-1), which the LRM pins to the last bit because both halves
// are reinterpretations and neither is a conversion.
`include "check.vh"
module ch09_atomic_bitstoreal(p, n);
  inout p, n; electrical p, n;
  analog begin
    `CHECKX("0x3FF0000000000000 is the double 1.0", $bitstoreal(4607182418800017408), 1.0);
    `CHECKX("pattern round trip is exact", $bitstoreal($realtobits(0.75)), 0.75);
    I(p,n) <+ $bitstoreal(1) + V(p,n);
  end
endmodule
