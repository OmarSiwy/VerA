// §9.11 / Table 9-8: `$bitstoreal` reads a 64-bit pattern back as the IEEE-754
// double it stands for — the inverse of `$realtobits`.
//
//   0x3FF0000000000000 is sign 0, biased exponent 1023 = 0x3FF, zero mantissa,
//   i.e. +1.0 x 2^0 = 1.0 exactly.
//
// The pattern is written as the SIZED literal `64'h3FF0000000000000` and not as
// its decimal value 4607182418800017408. §2.5.1 says only that "the number of
// bits that make up an unsized number ... shall be at least 32", so a conforming
// compiler that picks exactly 32 truncates the unsized decimal form to its low
// 32 bits — zero — and the check would fail for a reason that has nothing to do
// with $bitstoreal. The sized literal names its own width and removes the
// question. 063_realtobits.va now likewise uses sized pattern comparisons,
// asserting their Boolean result rather than an unsized 64-bit decimal want.
//
// The second check is the round trip on a value with a nonzero mantissa
// (0.75 = 1.1b x 2^-1), which the LRM pins to the last bit because both halves
// are reinterpretations and neither is a conversion.
//
//! lrm 9.2
//! lrm 9.11
//! lrm 9.2:1000
//! lrm 9.11:1000
`include "check.vh"
module ch09_atomic_bitstoreal(p, n);
  inout p, n; electrical p, n;
  analog begin
    `CHECKX("0x3FF0000000000000 is the double 1.0", $bitstoreal(64'h3FF0000000000000), 1.0);
    `CHECKX("pattern round trip is exact", $bitstoreal($realtobits(0.75)), 0.75);
    I(p,n) <+ $bitstoreal(1) + V(p,n);
  end
endmodule
