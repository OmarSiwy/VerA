// §9.15: "If param_name is known, its value is returned." Table 9-27 lists
// `gmin`, "Minimum conductance placed in parallel with nonlinear branches",
// and `sourceScaleFactor`, "Multiplicative factor for independent sources for
// source stepping homotopy". Both are the host solver's settings, which it
// changes during a run (gmin stepping, source stepping), so VerA publishes
// them as host-written Model fields, `gmin__` and `source_scale__`
// (specification/Vague_Decisions.md VD-072, tools/contract.zig `host_model_fields`),
// defaulting to 1e-12 and 1. `//! param` writes Model fields before `derive`,
// standing in for the host, with values no default has: 2e-9 and 0.25.
//
// Each read returns the f64 the host wrote, untouched, hence CHECKX. A §3.4
// parameter default reads the same value (derive runs after the write), and
// so does a value the card alone determines (computed once in `setup`):
// 0.25 * 4 = 1 exactly. The fallback is returned only "if param_name is not
// known", so $simparam("gmin", 0.5) is 2e-9. 5 checks.
//
// The invalid neighbour is simparam_spice_option_not_known_rejected.va: a
// SPICE option VerA does not publish ("chgtol") is E0811.
//! lrm 9.15
//! lrm 9.15:3
//! param gmin__ = 2e-9, source_scale__ = 0.25
//! print none
//! checks 5
`include "check.vh"
module simparam_gmin_source_scale_host_written(p, n);
  inout p, n; electrical p, n;
  parameter real g = $simparam("gmin");
  parameter real four = 4.0;
  analog begin
    `CHECKX("gmin is the host's", $simparam("gmin"), 2e-9);
    `CHECKX("sourceScaleFactor is the host's", $simparam("sourceScaleFactor"), 0.25);
    `CHECKX("a known name ignores its fallback", $simparam("gmin", 0.5), 2e-9);
    `CHECKX("a parameter default reads the host's value", g, 2e-9);
    `CHECKX("a card-only product reads it too", $simparam("sourceScaleFactor") * four, 1.0);
    I(p,n) <+ V(p,n) * (1.0 + g);
  end
endmodule
