// §9.14: "All of these functions, except $clog2, are aliases of the analog math
// operators described in 4.3.1" — so $ln/$log10/$exp/$sqrt/$floor/$ceil/$abs are
// exactly the Table 4-13 operators, and each line below is a sum whose value is
// fixed by real analysis alone.
//
//   $ln(2)      = 0.69314718055994530942…  (ln 2)
//   $log10(10)  = 1                        (base TEN, not the natural log — this
//                                           is the one §4.3.1 warns about, since
//                                           `log()` in C is base e)
//   $exp(1)     = 2.71828182845904523536…  (e)
//   $sqrt(4)    = 2                        (exact: IEEE-754 sqrt is correctly
//                                           rounded and 2 is representable)
//                 ------------------------
//                 6.41142900901899
//
//   $floor(1.9) = 1   (§4.3.1 floor rounds toward -inf, so NOT 2)
//   $ceil(1.1)  = 2   (ceil rounds toward +inf, so NOT 1)
//   $abs(-2.0)  = 2
//   $clog2(9)   = 4   §9.14: "the ceiling of the log base 2 of the argument".
//                     log2(9) = 3.1699…, so the ceiling is 4; a floor or a
//                     truncating cast would give 3, and clog2 of the next power
//                     of two (8) would give 3 as well — 9 is picked to separate
//                     the two readings.
//                 ------------------------
//                 the second line adds exactly 9
//
// The two sums together pin all eight functions: any one of them off by a real
// amount moves the first total, and any of the four integer-valued ones off by
// one moves the difference away from 9.
//
//! lrm 9.14
//! lrm 9.14:1
`include "check.vh"
module ch09_math_unary(p, n);
  inout p, n; electrical p, n;
  real x;
  analog begin
    x = $ln(2.0) + $log10(10.0) + $exp(1.0) + $sqrt(4.0);
    `CHECK("§9.14: ln2 + log10(10) + e + sqrt4", x, 6.41142900901899, 1e-12);
    `CHECKI("§9.14 $clog2(9) = ceil(log2 9) = 4", $clog2(9), 4);
    x = x + $floor(1.9) + $ceil(1.1) + $abs(-2.0) + $clog2(9);
    `CHECK("floor(1.9) + ceil(1.1) + abs(-2) + clog2(9) adds 1+2+2+4",
           x, 15.41142900901899, 1e-12);
    I(p,n) <+ x + 0.0*V(p,n);
  end
endmodule
