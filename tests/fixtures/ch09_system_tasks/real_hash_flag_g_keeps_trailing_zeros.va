// §9.4.3: the real conversions of Table 9-23 "have the full formatting
// capabilities available in the C language", and C11 7.21.6.1p6's '#' flag
// gives g its alternative form: the result "always contains a decimal-point
// character, even if no digits follow it", and "for g and G conversions,
// trailing zeros are not removed from the result". Before #41 the '#' was
// read as the conversion letter: `%#g` printed the value and then "g".
//
// Only %g WITHOUT a precision is asserted. With one, the clause's own example
// ("%10.3g sets a minimum field width of 10 with three (3) fractional
// digits") contradicts C's significant digits, and VerA follows the example
// (s01_01, `str_kernels.zCReal`); '#' does not touch that choice.
//
// HAND DERIVATION (C11 p8, %g: P = 6 significant digits; X is the exponent
// %e would print; if P > X >= -4, style f with precision P - 1 - X, else
// style e with precision P - 1; then, without '#', trailing zeros and a bare
// point go):
//
//   %g   of 1.5      X = 0: style f, precision 5, "1.50000", stripped:
//                                                        -> "1.5"
//                    (the neighbour: the same value without the flag)
//   %#g  of 1.5      the same "1.50000", kept:            -> "1.50000"
//   %#g  of 100000.0 X = 5 < P: style f, precision 0, "100000"; '#' adds
//                    the point:                           -> "100000."
//   %#g  of 1.0e-5   X = -5 < -4: style e, precision 5:   -> "1.00000e-05"
//   %#G  of 2.5e6    X = 6 >= P: style E, precision 5:    -> "2.50000E+06"
//   %#g  of 0.0      X = 0 for zero: style f, precision 5: -> "0.00000"
//
//! lrm 9.4.3
//! lrm 9.5.3
//! print none
`include "check.vh"
module s01_real_hash_flag_g(p, n);
  inout p, n; electrical p, n;
  string plain, alt, point, tiny, big, zero;
  analog begin
    $sformat(plain, "%g",  1.5);
    $sformat(alt,   "%#g", 1.5);
    $sformat(point, "%#g", 100000.0);
    $sformat(tiny, "%#g", 1.0e-5);
    $sformat(big,   "%#G", 2.5e6);
    $sformat(zero,  "%#g", 0.0);

    `CHECKI("§9.4.3/C11 %g strips trailing zeros without '#' (neighbour)", (plain == "1.5"), 1);
    `CHECKI("§9.4.3/C11 '#' on %g keeps the trailing zeros", (alt == "1.50000"), 1);
    `CHECKI("§9.4.3/C11 '#' on %g always prints the point", (point == "100000."), 1);
    `CHECKI("§9.4.3/C11 '#' on %g in style e keeps the mantissa's zeros", (tiny == "1.00000e-05"), 1);
    `CHECKI("§9.4.3/C11 '#' on %G in style E", (big == "2.50000E+06"), 1);
    `CHECKI("§9.4.3/C11 '#' on %g of zero", (zero == "0.00000"), 1);

    I(p,n) <+ V(p,n);
  end
endmodule
