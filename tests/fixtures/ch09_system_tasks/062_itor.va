// §9.11 / Table 9-8: `$itor` is the IEEE 1364 integer-to-real conversion, made
// legal in the analog context. Its value is unsurprising; its TYPE is the whole
// point, and §4.2.1.3 is what makes that observable:
//
//   3 / 2          is integer division and gives 1
//   $itor(3) / 2   has one real operand, so the 2 is converted and the quotient
//                  is real division: exactly 1.5, representable in IEEE-754.
//
// So the second check fails for any implementation that hands back an integer.
`include "check.vh"
module ch09_atomic_itor(p, n);
  inout p, n; electrical p, n;
  analog begin
    `CHECKX("$itor(2) is the real 2.0", $itor(2), 2.0);
    `CHECKX("$itor makes the quotient real (4.2.1.3)", $itor(3) / 2, 1.5);
    `CHECKI("without it the same division is integer", 3 / 2, 1);
    I(p,n) <+ $itor(2) + V(p,n);
  end
endmodule
