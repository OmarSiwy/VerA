// LRM 9.14 / Table 4-14: $abs is an alias of the 4.3.1 operator abs, so
// abs(-2.0) is +2.0 — sign stripped, magnitude untouched, exactly.
//
//! lrm 9.14
`include "check.vh"
module ch09_atomic_abs(p, n);
  inout p, n; electrical p, n;
  analog begin
    `CHECKX("$abs(-2.0)", $abs(-2.0), 2.0);
    I(p,n) <+ V(p,n) + $abs(-2.0);
  end
endmodule
