// §9.4.3 Table 9-23, the one conversion Verilog-AMS adds to C:
//
//   "%r or %R   Display 'real' in engineering notation, using the scale factors
//               defined in 2.6.2"
//
// and §2.6.2 Table 2-1, which is the entire alphabet that conversion may emit:
//
//   T 1e12   G 1e9   M 1e6   K,k 1e3   m 1e-3   u 1e-6
//   n 1e-9   p 1e-12   f 1e-15   a 1e-18
//
// "Engineering notation" is what fixes WHICH factor: the exponent is a multiple
// of three and the mantissa lies in [1, 1000), so exactly one symbol in Table
// 2-1 can be chosen for a given magnitude. That is what makes the three
// operands below have a single correct answer each:
//
//   0.0015   = 1.5   x 1e-3     -> mantissa 1.5,  symbol 'm'  (ASCII 109)
//   1.5e6    = 1.5   x 1e6      -> mantissa 1.5,  symbol 'M'  (ASCII 77)
//   2.0e-13  = 200.0 x 1e-15    -> mantissa 200,  symbol 'f'  (ASCII 102)
//
// 2e-13 is the interesting one: the other admissible split is 0.2 x 1e-12, and
// it is inadmissible precisely because 0.2 is below 1. A printer that reaches
// for the nearest symbol instead of normalising the mantissa answers "0.2p" and
// fails here. 1e3 is deliberately AVOIDED as an operand — Table 2-1 spells that
// row "K, k" and the LRM never says which of the two an output uses, so no
// fixture may pin it.
//
// WHY THE ASSERTION SCANS THE TEXT BACK INSTEAD OF COMPARING IT. The number of
// digits in the mantissa is not fixed by any clause ("1.5m" and "1.500000m" are
// both engineering notation), so a string equality would pin an implementation
// choice. §9.5.4.2's own conversions split the rendering into the two parts the
// LRM does fix: "%f ... Matches a floating point number" takes the mantissa, and
// "%c" — the one code for which "the normal skip over white space is
// suppressed" — takes the character that follows it, which is the Table 2-1
// symbol. (The symbol for 1e-15 is the letter f; that it is spelled like the %f
// conversion code is a coincidence of the two tables and nothing more.)
//
// The count is asserted too: two items matched and assigned means the mantissa
// was followed by a scale character AT ALL, which a plain "%g"-style rendering
// like "0.0015" does not produce.
//
//! lrm 9.4.3
//! lrm 2.6.2
//! lrm 9.5.3
//! lrm 9.5.4.2
//! lrm 9.4.3:1002
//! print none
`include "check.vh"
module s01_real_engineering_notation(p, n);
  inout p, n; electrical p, n;
  string milli, mega, femto;
  integer n1, n2, n3, c1, c2, c3;
  real m1, m2, m3;
  analog begin
    $sformat(milli, "%r", 0.0015);
    $sformat(mega,  "%r", 1.5e6);
    $sformat(femto, "%R", 2.0e-13);

    n1 = $sscanf(milli, "%f%c", m1, c1);
    n2 = $sscanf(mega,  "%f%c", m2, c2);
    n3 = $sscanf(femto, "%f%c", m3, c3);

    `CHECKI("§9.4.3 %r renders a mantissa followed by a Table 2-1 symbol", n1, 2);
    `CHECK("§2.6.2 0.0015 normalises to a mantissa of 1.5", m1, 1.5, 1e-12);
    `CHECKI("§2.6.2 and its scale symbol is 'm' (1e-3)", c1, 109);

    `CHECKI("§9.4.3 the same for a value above unity", n2, 2);
    `CHECK("§2.6.2 1.5e6 normalises to a mantissa of 1.5", m2, 1.5, 1e-12);
    `CHECKI("§2.6.2 and its scale symbol is 'M' (1e6)", c2, 77);

    `CHECKI("§9.4.3 %R is the same conversion as %r", n3, 2);
    `CHECK("§2.6.2 2e-13 normalises to 200, not to 0.2: the mantissa is in [1,1000)", m3, 200.0, 1e-9);
    `CHECKI("§2.6.2 and its scale symbol is 'f' (1e-15)", c3, 102);

    I(p,n) <+ V(p,n);
  end
endmodule
