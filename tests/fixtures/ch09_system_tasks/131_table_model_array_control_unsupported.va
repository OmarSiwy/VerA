// DEBT — this rejection is NOT conformance.
// The LRM permits what VerA refuses here. The substrings below record
// CURRENT behavior so the suite stays green on it; they do not claim it
// is right. `zig build ledger` counts this rule against VerA.
//
// VAMS-9.21-01  (ch9-system.html)
// Within the data set, each point shall be distinct in terms of its independent variable values.
// VAMS-9.21.1-01  (ch9-system.html)
// The numbers shall be real or integer.
//
//! reject E0801
//! reject $table_model
// EXPECT: error
module ch09_table_model_array_control_unsupported(p, n);
  inout p, n; electrical p, n;
  real x[0:1], f_x[0:1];
  analog I(p,n) <+ $table_model(V(p,n), x, f_x, "1LL;1");
endmodule
