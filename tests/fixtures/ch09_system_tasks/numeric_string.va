// §9.4.5: eight-bit codes, most significant first; suppress leading zero
// bytes only. Output retains interior/trailing NUL; §3.3 string storage removes them.
//! print none
//! lrm 3.3
//! lrm 9.4.5
//! lrm 9.5.2
//! lrm 9.5.3
//! lrm 9.4.2
//! lrm 9.4.2:1000
//! lrm 9.4.5:2
//! lrm 9.5.2:1
//! lrm 9.5.3:1
//! lrm 9.5.4.1
//! lrm 9.5.4.1:1000
//! lrm 9.4.5:1001
`include "check.vh"
module ch09_numeric_string(p, n);
  inout p, n; electrical p, n;
  integer value, fd, count, a, b, c;
  string text;
  analog begin
    value = 32'h41424344;
    $sformat(text, "%s", value);
    `CHECKI("integer byte order", text == "ABCD", 1);
    $sformat(text, "%S", 24'h414243);
    `CHECKI("uppercase conversion", text == "ABC", 1);
    $sformat(text, "%s", 64'h4142434445464748);
    `CHECKI("all eight literal bytes", text == "ABCDEFGH", 1);
    $sformat(text, "%s", 8'shff);
    `CHECKI("signed byte has no added sign bytes", text == "\377", 1);
    $sformat(text, "%s", 12'h141);
    `CHECKI("partial high byte zero filled", text == "\001A", 1);
    $sformat(text, "%s", {8'h41, 8'h42});
    `CHECKI("constant concatenation byte order", text == "AB", 1);
    value = -1;
    $sformat(text, "%s", value);
    `CHECKI("integer variable is four bytes", text == "\377\377\377\377", 1);
    $sformat(text, "%s", 64'hff41424344454647);
    `CHECKI("high signed carrier byte preserved", text == "\377ABCDEFG", 1);
    $sformat(text, "[%s]", 0);
    `CHECKI("zero has no leading bytes", text == "[]", 1);
    $sformat(text, "%s", 64'h0000000000410042);
    `CHECKI("string storage removes interior NUL", text == "AB", 1);
    $sformat(text, "%s", 24'h410000);
    `CHECKI("string storage removes trailing NUL", text == "A", 1);
    $sformat(text, "[%6s]", 24'h410042);
    `CHECKI("padding precedes NUL removal", text == "[   AB]", 1);
    $sformat(text, "[%6s]", "A\000B");
    `CHECKI("literal padding precedes NUL removal", text == "[   AB]", 1);
    $sformat(text, "%h", "A\000B");
    `CHECKI("literal packed numeric format retains NUL byte", text == "410042", 1);
    $swrite(text, "A\000B%s%c", "C\000D", 0);
    `CHECKI("string writer removes final output NUL", text == "ABCD", 1);
    $sformat(text, "[%6s][%-6s][%0s]", 16'h4142, 16'h4142, 16'h4142);
    `CHECKI("field padding and minimal field", text == "[    AB][AB    ][AB]", 1);
    $swrite(text, "%s", 16'h4142);
    `CHECKI("string writer uses same conversion", text == "AB", 1);
    // §9.4.2 Table 9-21. The want spells the same byte in OCTAL while the
    // format spells it with the table's escape, so the two sides are different
    // source text and the check fails unless both reach the byte the table
    // names: "\t" and "\011" agree only at tab (9), "\n"/"\012" at newline
    // (10), "\\"/"\134" at backslash (92), "\""/"\042" at quote (34), and
    // "\101" at 'A' (65). "%%" is the format layer's one percent (37), which
    // is why it is written in the format argument.
    $sformat(text, "a\tb");
    `CHECKI("Table 9-21 \\t prints the tab byte", text == "a\011b", 1);
    $sformat(text, "a\nb");
    `CHECKI("Table 9-21 \\n prints the newline byte", text == "a\012b", 1);
    $sformat(text, "a\\b");
    `CHECKI("Table 9-21 \\\\ prints one backslash", text == "a\134b", 1);
    $sformat(text, "a\"b");
    `CHECKI("Table 9-21 \\\" prints one quote", text == "a\042b", 1);
    $sformat(text, "[\101]");
    `CHECKI("Table 9-21 \\ddd prints the octal character", text == "[A]", 1);
    $sformat(text, "100%%");
    `CHECKI("Table 9-21 %% prints one percent", text == "100\045", 1);
    fd = $fopen("ch09_188_numeric_string.dat", "w");
    $fwrite(fd, "%s", 16'h4142);
    $fdisplay(fd, "%S", 8'h43);
    $fclose(fd);
    fd = $fopen("ch09_188_numeric_string.dat", "r");
    count = $fgets(text, fd);
    $fclose(fd);
    `CHECKI("file writer byte count", count, 4);
    `CHECKI("file writers use same conversion", text == "ABC\n", 1);
    fd = $fopen("ch09_188_numeric_string.dat", "w");
    $fwrite(fd, "A\000B");
    $fclose(fd);
    fd = $fopen("ch09_188_numeric_string.dat", "r");
    count = $fscanf(fd, "%c%c%c", a, b, c);
    $fclose(fd);
    `CHECKI("file literal retains three bytes", count, 3);
    `CHECKI("file literal retains interior NUL", a == 65 && b == 0 && c == 66, 1);
    $write("%s", 16'h4142);
    $display("%S", 8'h43);
    I(p,n) <+ V(p,n);
  end
endmodule
