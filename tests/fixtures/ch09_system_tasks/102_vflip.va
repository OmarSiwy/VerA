// §9.18 Table 9-29: the top-level value of $vflip is +1, and this module IS the
// top of the hierarchy — nothing instantiates it, so there is no $vflip_hier to
// multiply by. Allowed values are exactly +1 or -1, so the answer is exact.
//
//! lrm 9.18
//! lrm 9.18:1000
`include "check.vh"

module ch09_atomic_vflip(p, n);
  inout p, n; electrical p, n;
  analog begin
    `CHECKX("$vflip at the top of the hierarchy", $vflip, 1.0);
    I(p,n) <+ V(p,n) + $vflip;
  end
endmodule
