// §9.5.3: the format "can be a string variable whose content is interpreted
// as the format string". The legal neighbour of
// sformat_runtime_width_past_its_row_rejected.va: the same run-time format,
// with a width its 4096-byte row holds.
//
// HAND DERIVATION. At V(p) = 2.0 the format is "%4000d": 1 right-justified in
// 4000 columns, 3999 spaces then "1", compared with the same text folded from
// a replication when the model compiles.
//
//! lrm 9.5.3
//! bias V(p) = 2.0
//! checks 1
`include "check.vh"
module sformat_runtime_width_within_its_row(p, n);
  inout p, n; electrical p, n;
  string f, s;
  integer same;
  analog begin
    f = (V(p, n) > 1.0) ? "%4000d" : "%10d";
    $sformat(s, f, 1);
    same = (s == {{3999{" "}}, "1"});
    `CHECKI("a run-time width of 4000 fits its row", same, 1);
    I(p,n) <+ V(p,n);
  end
endmodule
