// §9.5.4.1: "$fgets reads characters from the file specified by fd into the
// string str until a newline character is read and transferred to str, or an
// EOF condition is encountered." No length bound. VerA used to read a line
// through a 4096-byte buffer and end the run past it (E1011); a channel's
// line buffer now grows to the longest line read (#29).
//
// HAND DERIVATION. The file holds "ab\n" and then one line of 2500 + 2500
// characters and a newline, 5001 bytes: "%2500d" of 1 is 2499 spaces then
// "1", and "%2500d\n" of 2 is 2499 spaces, "2" and the newline.
//   t = 0:  $fgets reads "ab\n": 3 characters, newline included.
//   t = 1n: $fgets reads the whole 5001-byte line, never a part of it: c is
//           5001 and line is the text the two writes made, rebuilt here from
//           replications.
//
//! lrm 9.5.4.1
//! analysis tran
//! time 0, 1n
//! checks 3
`include "check.vh"
module fgets_line_over_4096(p, n);
  inout p, n; electrical p, n;
  integer fd, c, same;
  string line;
  analog begin
    @(initial_step) begin
      fd = $fopen("fgets_line_over_4096.dat", "w");
      $fwrite(fd, "ab\n");
      $fwrite(fd, "%2500d", 1);
      $fwrite(fd, "%2500d\n", 2);
      $fclose(fd);
      fd = $fopen("fgets_line_over_4096.dat", "r");
    end
    c = $fgets(line, fd);
    if ($abstime == 0)
      `CHECKI("the first line", c, 3);
    else begin
      `CHECKI("the 5001-byte line, counted whole", c, 5001);
      same = (line == {{2499{" "}}, "1", {2499{" "}}, "2\n"});
      `CHECKI("and transferred whole", same, 1);
    end
    I(p, n) <+ V(p, n);
  end
endmodule
