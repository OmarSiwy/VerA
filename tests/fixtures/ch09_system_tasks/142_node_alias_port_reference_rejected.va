// §9.20: "It shall be an error for the analog_net_reference to be a port or to
// be involved in port connections."
//
// The preceding sentence fixes what the first argument may be: "The
// analog_net_reference shall be either a scalar or vector continuous node
// DECLARED IN THE MODULE containing the system function call." A port is
// already bound to whatever the instantiating netlist connected it to, and an
// alias would bind it a second time — "shall refer to the same circuit matrix
// position" as the hierarchical node — so the port would be shorted to a node
// its own instantiation never mentions. The legal fixtures 105 and 106 both
// pass `local_node`, a node declared in the module and connected to nothing;
// this one passes `p`, a declared inout port, and changes nothing else.
//
// A reject, so there is nothing to run and no `want` to write.
//
//! lrm 9.20
//! reject analog_net_reference to be a port
//! xfail VerA lowers $analog_node_alias/$analog_port_alias to a constant 0 (codegen.zig) without checking the first argument
module ch09_node_alias_port_reference_rejected(p, n);
  inout p, n; electrical p, n;
  integer status;
  analog initial begin
    status = $analog_node_alias(p, "$root.top.a");
  end
  analog begin
    I(p,n) <+ V(p,n) + status;
  end
endmodule
