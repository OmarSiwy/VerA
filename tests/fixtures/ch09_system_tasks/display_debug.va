// §9.2 Table 9-1: `$debug` is the one display task that is analog-ONLY (no
// digital-context support). §9.4 gives it $display's argument list, so the value
// it reports is an ordinary expression evaluated at the current solution point.
//
// The task itself returns nothing; what is checkable is the number it formats.
// §5.4.1 makes V(p,n) the potential difference in the order named, so at
// V(p) = 0.375 V and V(n) = 0.25 V it is 0.125 V — a dyadic rational, hence
// exact in IEEE-754 and printable by %g without rounding.
//
//! lrm 9.2
//! lrm 9.4.1
//! bias V(p) = 0.375, V(n) = 0.25
`include "check.vh"
module ch09_display_debug(p, n);
  inout p, n; electrical p, n;
  analog begin
    `CHECKX("the value $debug formats", V(p,n), 0.125);
    $debug("iteration=%d value=%g", 1, V(p,n));
    I(p,n) <+ V(p,n);
  end
endmodule
