// §9.18/Table 9-29 combines values at each instance. §6.3 permits constant
// expressions over the parent's parameters, so changing a model-card value
// must recompute the composition, including its real-valued angle remainder.
// The parent's angle is 359.75 degrees and the child's is k/2: k=0,1,2,3
// gives 359.75,0.25,0.75,1.25. Coordinates add k and -k/2 to 2 and -4.
// Flip +1/-1 are both legal; mfactor's 1+k/2 is strictly positive.
// The final check observes a unit conductance contribution: geometry itself
// cannot rotate, reflect or scale it (§6.3.6); only mfactor scales the flow.
//! lrm 6.3.6
//! lrm 9.18
//! lrm 9.18:1000
//! psweep k = 0, 1, 2, 3
//! bias V(p) = 1
//! checks 28
`include "check.vh"
module geometry_sweep_top(p);
  inout p; electrical p;
  parameter real k = 0;
  geometry_sweep_outer #(.$xposition(2), .$yposition(-4), .$angle(359.75), .k(k)) outer(p);
endmodule
module geometry_sweep_outer(p);
  inout p; electrical p;
  parameter real k = 0;
  geometry_sweep_leaf #(.$xposition(k), .$yposition(-k/2), .$angle(k/2),
                        .$hflip(k < 2 ? 1 : -1), .$vflip(-1),
                        .$mfactor(1+k/2), .k(k)) leaf(p);
endmodule
module geometry_sweep_leaf(p);
  inout p; electrical p;
  parameter real k = 0;
  analog begin
    `CHECKEQ("swept x", $xposition, 2+k, 0);
    `CHECKEQ("swept y", $yposition, -4-k/2, 0);
    `CHECKEQ("fractional wrapped angle", $angle, k == 0 ? 359.75 : k/2-0.25, 0);
    `CHECKEQ("swept hflip", $hflip, k < 2 ? 1 : -1, 0);
    `CHECKX("swept vflip", $vflip, -1.0);
    `CHECKEQ("swept mfactor", $mfactor, 1+k/2, 0);
    I(p) <+ V(p);
    `CHECKX("per-copy flow is independent of geometry", I(p), 1.0);
  end
endmodule
