// §9.18, Table 9-29's "Allowed values" column: $mfactor > 0, $hflip and
// $vflip +1 or -1, 0 <= $angle < 360. A literal outside them is E0890 at
// compile time (geometry_*_rejected.va). A value that reads the model card is
// known only when the host writes the card, so VerA checks it then: the
// device's `checkCard`, which the host calls after `derive`, names the first
// one outside its domain (specification/Vague_Decisions.md VD-079), and the testbench
// stops with E0890 (exit 1, VerA's executable error policy).
//
// The top passes its card parameter k to the child as `.$mfactor(k)`,
// `.$hflip(1 - 2*(k < 0))` and `.$angle(10*k)`. By hand, card by card:
//   k = 2: $mfactor 2 > 0, $hflip 1, $angle 20: allowed; the child's
//          contribution is 1 A per copy, so the parent's I(p) is
//          $mfactor * 1 = 2 (§6.3.6) — checked below;
//   k = 0: $mfactor 0 is not > 0, so checkCard names "u.$mfactor" and the
//          run ends before the second card evaluates anything.
// The legal neighbour is the first card itself; geometry_parameter_sweep.va
// sweeps four legal cards.
//! lrm 9.18
//! psweep k = 2, 0
//! bias V(p) = 1
//! exit 1
//! checks 2
`include "check.vh"
module geometry_card_mfactor_top(p);
  inout p; electrical p;
  parameter real k = 2;
  geometry_card_mfactor_leaf #(.$mfactor(k), .$hflip(1 - 2*(k < 0)), .$angle(10*k)) u(p);
  analog begin
    `CHECKX("the card's mfactor scales the child's flow", I(p), 2.0);
  end
endmodule
module geometry_card_mfactor_leaf(p);
  inout p; electrical p;
  analog begin
    I(p) <+ 1.0;
    `CHECKX("each copy contributes 1 A", 1.0, 1.0);
  end
endmodule
