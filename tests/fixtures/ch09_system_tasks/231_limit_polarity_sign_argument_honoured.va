// §9.17.3 Syntax 9-12: `$limit ( access_function_reference , string , arg_list )`.
// "It returns a real value that is derived from its first argument (the access
// function reference, such as a branch voltage)". The legal twin of
// 232_limit_scaled_probe_rejected: a reversed-polarity junction keeps the probe
// as the first argument and scales the RESULT, passing the polarity as VerA's
// trailing sign argument (§9.17.3 leaves arguments past the algorithm's own to
// the implementation; AGENTS.md §6 "`$limit` arguments").
//
// "When the simulator has converged, the return value of the $limit() function
// is the value of the access function reference, within appropriate
// tolerances". This is 226_limit_pnjlim_internal_node_honoured mirrored through
// ground: V(p) = -0.7, and with `type = -1` the junction current is
// type * Is * (exp(vd / 0.025) - 1) with vd = type * V(a,n). KCL at `a`:
//
//   (-0.7 - Va) / 100 = -1e-14 * (exp(-Va / 0.025) - 1)
//
// is 226's equation in -Va, so Va = -0.625763159 and vd = +0.625763159. Band:
// relative 1e-3, the solver's convergence tolerance, as in 226.
//
//! lrm 9.17.3
//! nowarn
//! solve
//! bias V(p) = -0.7, V(n) = 0
`include "check.vh"
module ch09_limit_polarity_sign_argument_honoured(p, n);
  inout p, n; electrical p, n, a;
  parameter integer type = -1;
  real vd;
  analog begin
    vd = type * $limit(V(a,n), "pnjlim", 0.025, 0.705018, type);
    I(p,a) <+ V(p,a) / 100.0;
    I(a,n) <+ type * 1e-14 * (exp(vd / 0.025) - 1.0);
    `CHECKR("the reversed junction settles at the mirrored root", V(a,n), -0.625763159, 1e-3);
    `CHECKR("and the scaled result is the forward voltage", vd, 0.625763159, 1e-3);
  end
endmodule
