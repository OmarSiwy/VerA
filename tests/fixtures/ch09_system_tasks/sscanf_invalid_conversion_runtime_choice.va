// §9.5.4.2: "If an invalid conversion character follows the %, the results of
// the operation are implementation dependent."
//
// A LITERAL invalid conversion is already refused at compile time: 169_sscanf_
// uppercase_conversion_rejected.va pins E0813 for "%D". That leaves the case
// the clause is actually about — a format the compiler cannot see — and the
// implementation-dependent result still has to be a result, not silence.
//
// THE FORMATS ARE STRING VARIABLES, so `checkScanFormat` cannot fold them
// (§9.5.4.2: "$sscanf reads from the string str", and a string variable is a
// legal format; b6_sformat_variable_format_mismatch_continues.va uses the same
// device for $sformat). VerA's choice is in str_kernels.zScan's `else => return`:
// the scan STOPS at the invalid character and reports the items assigned before
// it. Nothing after the bad conversion is consumed or assigned, and the return
// is the count so far — 0 when the bad character is the first directive.
//
// HAND DERIVATION.
//
//   a = b = c = 99, then "%d %q %d" against "12 abc 34":
//     %d        assigns a = 12, count 1
//     (space)   matches the format's white space
//     %q        invalid: stop. count stays 1.
//   so code = 1, a = 12, and b and c keep their 99 sentinels: the second %d
//   never ran.
//
//   then "%q" against "abc":
//     %q        invalid before any assignment: count 0.
//   so code = 0 and c is still 99.
//
// All integers, so exact. `//! checks 6` makes the count exact: an
// implementation that skipped the call, or one that let the scan run past the
// invalid conversion, fails a value rather than passing on silence.
//
//! lrm 9.5.4.2:6
//! checks 6
`include "check.vh"
module ch09_sscanf_invalid_conversion(p, n);
  inout p, n; electrical p, n;
  string fmt;
  integer code, a, b, c;
  analog begin
    a = 99; b = 99; c = 99;
    fmt = "%d %q %d";
    code = $sscanf("12 abc 34", fmt, a, b, c);
    `CHECKI("§9.5.4.2 the %d before the invalid conversion was assigned", code, 1);
    `CHECKI("§9.5.4.2 and its value survives the stopped scan", a, 12);
    `CHECKI("§9.5.4.2 the conversion after the invalid one did not run", b, 99);
    `CHECKI("§9.5.4.2 nor did the one after that", c, 99);

    fmt = "%q";
    code = $sscanf("abc", fmt, c);
    `CHECKI("§9.5.4.2 an invalid conversion first stops with nothing assigned", code, 0);
    `CHECKI("§9.5.4.2 and leaves the destination unchanged", c, 99);
    I(p, n) <+ V(p, n) + code + a + b + c;
  end
endmodule
