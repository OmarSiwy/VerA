// §9.21.1: "The state of the data source is captured on the first call to the
// table model function. Any change after this point is ignored." The clause
// does not say what a capture made during a step the solver then rejects
// keeps. §9.3 states the goal for every system function in the analog
// context: "a call to a such system task or function in an analog block
// during an iteration that is rejected should cause no side-effects on the
// next iteration". specification/Vague_Decisions.md VD-095 reads the two together: a
// first call fixes the data for the rest of its own evaluation, and the
// capture stays with the instance only once an ACCEPTED iteration made it. A
// rejected step's capture is undone with the step, and the next first call
// captures again.
//
// VerA's `$vera_reject_step(t_retry)` (specification/Vague_Decisions.md §6) rejects a
// step from its own accepted solution: the testbench undoes the step, solves
// and accepts t_retry, then solves the rejected time again.
//
// The data source is the two-point line xs = {0, 1}, ys = {0, $abstime},
// rewritten every evaluation, and the table is first called once
// $abstime > 1.25. Looked up at 0.5 it interpolates (§9.21.2 linear) to
// half the ys[1] it was captured with. `hit` is held (assigned under
// `above`) and still 0 past t = 1.5, so the step to 2 is rejected with a
// retry at 1.5, as in vera_reject_step_retry.va. The run is t = 0, 1, 2, 3:
//
//   t = 0, 1     no call yet: y keeps §3.2's 0.
//   t = 2        rejected attempt, the first call: ys = {0, 2}, y = 1.0.
//                Not asserted: the GOT is the literal 0.75 here (hit = 0
//                and t > 1.5 pick the attempt out).
//   t = 1.5      the retry. The attempt's capture went with it, so this is
//                a first call again: ys = {0, 1.5}, y = 0.75. Accepted, so
//                {0, 1.5} is kept.
//   t = 2        ys reads {0, 2}, ignored: y = 0.75.
//   t = 3        ys reads {0, 3}, ignored: y = 0.75.
//
// A tool that kept the rejected attempt's capture reads {0, 2} from t = 1.5
// on (y = 1.0); one that never captured reads 1.5 at t = 3. Six printed
// points, one verdict each. There is no invalid input to refuse: any data
// source may be captured.
//! lrm 9.21.1
//! lrm 9.3
//! analysis tran
//! time 0, 1, 2, 3
//! checks 6
`include "check.vh"
module table_capture_rejected_step_recaptures(p, n);
  inout p, n; electrical p, n;
  integer hit;
  real xs[0:1], ys[0:1];
  real y;
  analog begin
    I(p, n) <+ V(p, n) / 1k;
    if ($abstime > 1.5 && hit == 0) $vera_reject_step(1.5);
    xs[0] = 0.0; xs[1] = 1.0;
    ys[0] = 0.0; ys[1] = $abstime;
    if ($abstime > 1.25) y = $table_model(0.5, xs, ys, "1L");
    `CHECK("the table reads the capture an accepted point made",
           (hit == 0 && $abstime > 1.5) ? 0.75 : y, ($abstime > 1.25) * 0.75, 1e-12);
    @(above($abstime - 1.25)) hit = 1;
  end
endmodule
