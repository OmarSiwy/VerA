// §9.22, third paragraph: "The driver access functions described here only
// access drivers found in ordinary modules and not to those found in connect
// modules. Driver access functions can only be called from connect modules."
//
// §9.22.2 is one of those functions, printed inside §9.22 with the family's
// `signal_name` argument:
//
//   receiver_count_function ::= $receiver_count ( signal_name )
//
// and §9.2 Table 9-19 — "Connectmodule driver and receiver access system
// functions and operator" — gives it columns headed "Supported in digital
// context of connectmodule" and "Supported in analog context of connectmodule"
// and no column for any other design element. There is no context outside a
// connect module in which the table says Yes.
//
// This is an ordinary `module`, calling it from its analog block. The sibling
// rows 107/109/110 (driver_count/state/strength) pin the same fence for their
// subclauses; §9.22.2's receiver count had no rejection until this file.
//
// VerA reports E0818 "driver access function outside a connect module".
//
//! lrm 9.22.2
//! lrm 9.22
//! lrm 9.22:1000
//! reject-only E0818
//! reject `$receiver_count` can only be called from a connect module
`include "disciplines.vams"
module ch09_receiver_count_outside_connectmodule(p, n);
  inout p, n; electrical p, n;
  integer k;
  analog begin
    k = $receiver_count(p);              // illegal: not a connect module
    I(p, n) <+ V(p, n) + 0.0 * k;
  end
endmodule
