// §9.11 / Table 9-8: `$realtobits` yields the IEEE-754 bit PATTERN of its real
// argument, verbatim, and §2.6.2 fixes reals as IEEE Std 754 doubles — so the
// pattern is a number this comment can derive by hand:
//
//   1.0 = +1.0 x 2^0   sign 0, biased exponent 1023 = 0x3FF, zero mantissa
//                      -> 0x3FF0000000000000 = 4607182418800017408
//   0.5 = +1.0 x 2^-1  biased exponent 1022 = 0x3FE
//                      -> 0x3FE0000000000000 = 4602678819172646912
//
// The pattern comparisons use explicitly sized 64-bit literals and assert the
// resulting Boolean as numeric 1. This preserves all pattern bits without
// assuming any implementation-specific width for unsized decimal literals.
// It also avoids converting the pattern to a real-valued tolerance expression.
// IEEE1364-2005 §17.8 printed310–311 supplies the inherited conversion rule.
//
//! lrm 9.2
//! lrm 9.11
//! lrm 9.2:1000
//! lrm 9.11:1000
//! bias V(p) = 1.0
//! checks 2
`include "check.vh"
module ch09_atomic_realtobits(p, n);
  inout p, n; electrical p, n;
  analog begin
    `CHECKI("pattern of 1.0 is 0x3FF0000000000000", $realtobits(V(p,n)) == 64'h3FF0000000000000, 1);
    `CHECKI("pattern of 0.5 is 0x3FE0000000000000", $realtobits(0.5) == 64'h3FE0000000000000, 1);
    I(p,n) <+ $realtobits(V(p,n)) + V(p,n);
  end
endmodule
