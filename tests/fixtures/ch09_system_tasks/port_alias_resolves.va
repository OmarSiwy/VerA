// §9.20's `$analog_port_alias` half, and the one sentence that makes it a
// different function from `$analog_node_alias` rather than a stricter spelling
// of it:
//
//   "In addition, a node that is aliased to a valid hierarchical port reference
//    via the $analog_port_alias() function shall be allowed as an input to the
//    port access function (see 5.4.3) and shall measure the flow through the
//    port of the instance referred to by the hierarchical reference."
//
// `I(<n2>)` on an ordinary local net is not a legal port probe — §5.5.1 says
// the reference "must be a declared port of the module in which the port access
// function is used" — so the fact that this file COMPILES is already half the
// assertion. The other half is WHICH flow it reads: "the flow through the port
// of the instance referred to by the hierarchical reference", here the top's
// port `a`. Only the top's 1 kohm branch (a, g) touches a, so by Kirchhoff at
// the port (§5.4.3, "the flow into a port of a module"):
//
//     I(<n2>) = flow into a = V(a, g)/1000 = (5.0 - 0.0)/1000 = 5.0e-3 A
//
// A compiler that aliased the node but not the port would refuse the probe,
// and one that read an ordinary branch flow of the isolated net `n2` instead
// would read 0.
//
// RECONCILER, 2026-10-08. An earlier revision FORCED the port-flow unknown with
// `//! sweep flowZ28Z3caZ3eZ29 = 0.0625` and asserted 0.0625: a number the
// runner wrote in, at a point where Kirchhoff at `a` does not hold (the branch
// carries 5 mA). `//! solve` now frees that unknown; a and g stay biased, each
// driven by the testbench, so the biased point is a solution and 5.0e-3 is
// what §9.20 and §5.4.3 make the probe read there.
//
// The clause's own example aliases to `"top.r1.p"` — a port of a child
// INSTANCE — and this file deliberately does not: see the ponytail note in
// `Lower.bindAlias`. Flattening binds a child's port to the parent net it was
// connected to, so one instance's terminal flow is not a quantity the flat
// design still has, and §9.20's own answer for a reference this compiler cannot
// honour exactly is the honest zero, not a nearby number.
//
//! lrm 9.20
//! lrm 9.20:13
//! lrm 5.4.3
//! lrm 9.20:10
//! bias V(a) = 5.0, V(g) = 0.0
//! solve
//! checks 2
`include "check.vh"

module ch9_port_alias_top(a, g);
  inout a, g; electrical a, g;
  ch9_port_alias_checker ch1();
  analog begin
    I(a, g) <+ V(a, g) / 1000.0;
  end
endmodule

module ch9_port_alias_checker;
  electrical n2;
  integer status;
  analog initial begin
    status = $analog_port_alias(n2, "ch9_port_alias_top.a");
  end
  analog begin
    `CHECKI("a hierarchical reference that resolves to a port returns 1", status, 1);
    `CHECKR("and the aliased net reads the flow through the top's port a: 5/1000",
            I(<n2>), 5.0e-3, 1e-12);
  end
endmodule
