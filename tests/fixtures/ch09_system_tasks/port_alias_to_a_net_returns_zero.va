// §9.20: "The following rules shall be applied to determine whether the node
// or port referenced by the hierarchical_reference_string is considered
// valid. If any of these rules are violated then the system function shall
// return a value of zero (0). ... For the $analog_port_alias() system
// function, the resolved hierarchical node reference shall be a port." And:
// "If the return value is zero (0), then the node referenced by the
// analog_net_reference shall be treated as a normal continuous node declared
// in the module containing the system function call."
//
// The clause's own example: `$analog_port_alias(n2, "$root.top.a")` where
// top.a is a net and not a port, "The integer status will be assigned a value
// of 0."
//
// Here `m` is an internal net of the top module, driven to 2.5 V. Not a port.
//
//   $analog_port_alias(n2, "b6_pa_top.m") = 0     (the port rule)
//   $analog_node_alias(n1, "b6_pa_top.m") = 1     (the same reference IS a
//                                                  valid node: the 0 above is
//                                                  the port rule, nothing else)
//   V(n1) = V(m) = 2.5                            (n1 is m's matrix position)
//   V(n2) = 0                                     (n2 stays local: its only
//                                                  branch is 1 S to ground)
//
// Had n2 been aliased anyway, its 1 S would sit across m's 2.5 V source and
// V(n2) would read 2.5.
//
//! lrm 9.20
//! lrm 9.20:15
//! lrm 9.20:16
//! lrm 9.20:17
//! lrm 9.20:10
//! lrm 9.20:12
//! bias V(g) = 0.0
//! solve
//! checks 4
`include "check.vh"

module b6_pa_top(g);
  inout g; electrical g;
  electrical m;
  b6_pa_checker ch1();
  analog begin
    I(g) <+ 0.0;
    V(m) <+ 2.5;
  end
endmodule

module b6_pa_checker;
  electrical n1, n2;
  integer s_port, s_node;
  analog initial begin
    s_port = $analog_port_alias(n2, "b6_pa_top.m");
    s_node = $analog_node_alias(n1, "b6_pa_top.m");
  end
  analog begin
    I(n2) <+ V(n2);
    `CHECKI("§9.20 a port alias to a net that is not a port returns 0", s_port, 0);
    `CHECKI("§9.20 the same reference is a valid node for a node alias", s_node, 1);
    `CHECKX("§9.20 the node alias shares m's matrix position", V(n1), 2.5);
    `CHECKX("§9.20 the failed port alias leaves n2 a local node", V(n2), 0.0);
  end
endmodule
