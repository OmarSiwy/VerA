// §9.4.1 (specification/ch9-system.html):
//
//   "When a $monitor task is invoked with one or more arguments, the simulator
//    sets up a mechanism whereby for each accepted step, if the variable or an
//    expression in the argument list changes value compared with the last
//    accepted step — WITH THE EXCEPTION OF THE $abstime OR $realtime SYSTEM
//    FUNCTIONS — the entire argument list is displayed at the end of the time
//    step as if reported by the $strobe task."
//
// §9.5.2: "The $fstrobe and $fmonitor system tasks work just like their
// counterparts, $strobe and $monitor, except that they write to files".
//
// So a monitor whose only changing argument is $abstime has nothing that
// "changes value" in the clause's sense after its first report. ($realtime is
// the clause's other exemption; it is refused in an analog block, E0806, so
// $abstime is the one this fixture can carry.) The measurement is s01_05's:
// register once under `@(initial_step)`, and read the bytes the monitor has
// written with §9.5.5's $ftell at the TOP of each step, which is the total
// produced at the ends of steps 0 .. k-1.
//
// HAND DERIVATION.
//   `//! wave V(p) = 0.5`, V(n) at the reference: V(p,n)*4 is 2 at every step.
//   The record at t = 0 is "%0d %g" of (2, 0) (the zero width drops IEEE 1364 §17.1.1.3's automatic field) plus $strobe's newline: "2 0\n",
//   4 bytes (C's %g writes 0 as "0").
//
//   end of step t=0  first accepted step, reported   -> 4 bytes
//   end of step t=1  2 unchanged; only $abstime moved -> nothing
//   end of step t=2  likewise                        -> nothing
//   end of step t=3  likewise                        -> nothing
//
//   so $ftell at the top of each step reads 0, 4, 4, 4, and
//   `bytes - 4 * ($abstime > 0)` is 0 at every step.
//
// WHAT FAILS IT. An implementation that compares the rendered LINE sees
// "2 1", "2 2", ... as changes and writes 4 bytes every step: 0, 4, 8, 12 ->
// 0, 0, 4, 8. One that never reports leaves 0, 0, 0, 0 -> 0, -4, -4, -4.
//
//! lrm 9.4.1
//! lrm 9.5.2
//! lrm 9.5.5
//! lrm 5.10.2
//! lrm 9.4.1:1004
//! time 0, 1, 2, 3
//! wave V(p) = 0.5
//! print none
`include "check.vh"
module s01_monitor_time_exempt(p, n);
  inout p, n; electrical p, n;
  integer fd, bytes;
  analog begin
    @(initial_step) begin
      fd = $fopen("s01_07_monitor_time.dat", "w");
      $fmonitor(fd, "%0d %g", V(p,n) * 4.0, $abstime);
    end

    bytes = $ftell(fd);

    `CHECKI("§9.4.1 a change in $abstime alone produces no report", bytes - 4 * ($abstime > 0), 0);

    I(p,n) <+ V(p,n) + bytes;
  end
endmodule
