// §9.18: "$xposition and $yposition are the offsets, in meters, of the location
// of the center of the instance." Table 9-29 gives the combining rule: the
// top-level value is 0.0 m and the resolved value is
// $yposition_specified + $yposition_hier.
//
// This module is elaborated on its own, so it IS the top of the hierarchy and
// there is no enclosing instance to add an offset from: the resolved value is
// the top-level value, 0.0 m, exactly.
//
//! lrm 9.18
//! lrm 9.18:1000
`include "check.vh"
module ch09_atomic_yposition(p, n);
  inout p, n; electrical p, n;
  analog begin
    `CHECKX("Table 9-29 top-level $yposition", $yposition, 0.0);
    I(p,n) <+ V(p,n) + $yposition;
  end
endmodule
