// LRM 9.14 / Table 4-14: $floor is an alias of the 4.3.1 operator floor, which
// rounds towards MINUS infinity — not towards zero. floor(1.9) is 1; the
// negative argument is what separates floor from truncation, since floor(-1.9)
// is -2 where an integer cast would give -1.
//
//! lrm 9.14
`include "check.vh"
module ch09_atomic_floor(p, n);
  inout p, n; electrical p, n;
  analog begin
    `CHECKX("$floor(1.9)", $floor(1.9), 1.0);
    `CHECKX("$floor rounds down, not toward zero", $floor(-1.9), -2.0);
    I(p,n) <+ V(p,n) + $floor(1.9);
  end
endmodule
