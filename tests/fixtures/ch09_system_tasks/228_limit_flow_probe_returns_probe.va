// §9.17.3: "In all cases, the simulator is responsible for determining if
// limiting should be applied and what the return value is on a given iteration.
// In particular, the simulator may simply choose to have $limit() return the
// value of its first argument". The first argument is an
// access_function_reference (Syntax 9-12), and the clause allows "the potential
// (or flow)"; a flow has no node for the host to correct.
// VerA declines this site: it compiles, warns W0853 (the first argument is not
// a potential probe), and returns the probe unchanged. The warning is asserted
// by the unit test "a declined $limit is W0853 naming why"
// (lib/backend/codegen/test.zig) and by `//! warn` below; the checks assert
// what the clause fixes about the value.
//
// Two 100 ohm resistors in series with a 0 V source across V(p) = 1 V carry
// 1 / 200 = 5 mA, which is I(a,b), independent of any limiting.
//
//! lrm 9.17.3
//! lrm 9.17.3:2
//! warn W0853
//! warn its first argument is not a §4.4 potential probe
//! solve
//! bias V(p) = 1, V(n) = 0
`include "check.vh"
module ch09_limit_flow_probe_returns_probe(p, n);
  inout p, n; electrical p, n, a, b;
  real i;
  analog begin
    V(a,b) <+ 0.0;
    i = $limit(I(a,b), "pnjlim", 0.025, 0.7);
    I(p,a) <+ V(p,a) / 100.0;
    I(b,n) <+ V(b,n) / 100.0;
    `CHECKR("a limited flow returns the flow", i, 5e-3, 1e-3);
  end
endmodule
