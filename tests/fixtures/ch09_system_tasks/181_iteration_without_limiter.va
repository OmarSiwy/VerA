// The standalone runner advances one state generation per declared point.
// Reading iteration must not depend on the presence of a limiter/operator.
//! lrm 9.15
//! lrm 9.15:2
//! time 0, 1, 2, 3
`include "check.vh"
module ch09_iteration_without_limiter(p, n);
  inout p, n; electrical p, n;
  analog begin
    `CHECK("iteration is runtime state even without a limiter",
           $simparam("iteration") - ($abstime + 1.0), 0.0, 1e-12);
  end
endmodule
