// §9.11 / Table 9-8: `$unsigned  Yes  No`, the mirror of 134. The extension
// §9.11 defines is $bitstoreal and $realtobits and nothing else, so the
// signedness-reinterpretation pair stays digital-only.
//
// Nothing is asserted: an illegal call site has no defined result, and pinning
// one would over-specify a rule the LRM states as "not available here".
//
//! lrm 9.11
//! reject analog context
//! xfail VerA has no Table 9-8 analog-context check; it accepts $unsigned in an analog block
module ch09_atomic_unsigned_analog_rejected(p, n);
  inout p, n; electrical p, n;
  integer x;
  analog begin
    x = $unsigned(4'b1011);
    I(p,n) <+ V(p,n) + x;
  end
endmodule
