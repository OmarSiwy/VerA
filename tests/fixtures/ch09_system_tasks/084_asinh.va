// §9.2 Table 9-11 lists $asinh as supported in the analog context; §4.3
// Table 4-15 defines it as C `asinh(x)`, the arc-hyperbolic sine, for all x.
// §4.3 makes the `$` and traditional spellings the same function.
//
// asinh(x) = ln(x + sqrt(x^2 + 1)), so asinh(0.5) = ln(0.5 + sqrt(1.25))
//          = 0.48121182505960347.
//
//! lrm 9.14
//! bias V(p) = 0.5
`include "check.vh"
module ch09_atomic_asinh(p, n);
  inout p, n; electrical p, n;
  analog begin
    `CHECK("$asinh(0.5)", $asinh(V(p,n)), 0.48121182505960347, 1e-15);
    `CHECK("asinh is ln(x + sqrt(x*x + 1))", ln(V(p,n) + sqrt(V(p,n) * V(p,n) + 1.0)), 0.48121182505960347, 1e-15);
    `CHECK("asinh inverts sinh", $sinh($asinh(V(p,n))), 0.5, 1e-15);
    I(p,n) <+ V(p,n) + $asinh(V(p,n));
  end
endmodule
