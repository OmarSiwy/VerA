// AMS §9.19 physical264: $param_given takes a single parameter identifier.
// A declared real VARIABLE is not a parameter even when its value is constant.
// Legal neighbors are audit_binding_source_overrides.va's gain parameters.
// The distinctive rejection phrase below is the intended diagnostic contract,
// carried by E0822 (it used to be accepted without a diagnostic).
//! lrm 9.19
//! lrm 9.19:3
//! reject-only $param_given requires a parameter identifier
//! neighbour audit_binding_source_overrides.va
module audit_param_given_variable_rejected;
  real value;
  integer flag;
  analog flag = $param_given(value);
endmodule
