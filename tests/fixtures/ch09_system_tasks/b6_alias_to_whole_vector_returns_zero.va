// §9.20: "If any of these rules are violated then the system function shall
// return a value of zero (0). The hierarchical_reference_string shall refer to
// a scalar continuous node or a scalar element of a continuous vector node."
//
// "b6_av_top.bus" names the whole two-element vector: neither a scalar node
// nor a scalar element. So the call returns 0 and n1 stays local.
// "b6_av_top.m" is a scalar net of the same module, the control that shows
// the module path itself resolves.
//
//   $analog_node_alias(n1, "b6_av_top.bus") = 0
//   $analog_node_alias(n2, "b6_av_top.m")   = 1,  V(n2) = V(m) = 2.5
//   V(n1) = 0      (local; its only branch is 1 S to ground. Aliased to
//                   either element it would read 1.25 or 0.75 instead)
//
// The element form "b6_av_top.bus[1]" is the legal one; it has its own file,
// b6_alias_to_vector_element_resolves.va.
//
//! lrm 9.20
//! lrm 9.20:15
//! lrm 9.20:16
//! lrm 9.20:17
//! lrm 9.20:12
//! bias V(g) = 0.0
//! solve
//! checks 4
`include "check.vh"

module b6_av_top(g);
  inout g; electrical g;
  electrical m;
  electrical [1:0] bus;
  b6_av_checker ch1();
  analog begin
    I(g) <+ 0.0;
    V(m) <+ 2.5;
    V(bus[1]) <+ 1.25;
    V(bus[0]) <+ 0.75;
  end
endmodule

module b6_av_checker;
  electrical n1, n2;
  integer s_vec, s_scalar;
  analog initial begin
    s_vec = $analog_node_alias(n1, "b6_av_top.bus");
    s_scalar = $analog_node_alias(n2, "b6_av_top.m");
  end
  analog begin
    I(n1) <+ V(n1);
    `CHECKI("§9.20 a reference to a whole vector node returns 0", s_vec, 0);
    `CHECKI("§9.20 a scalar net of the same module returns 1", s_scalar, 1);
    `CHECKX("§9.20 the scalar alias shares m's matrix position", V(n2), 2.5);
    `CHECKX("§9.20 the refused vector alias leaves n1 local", V(n1), 0.0);
  end
endmodule
