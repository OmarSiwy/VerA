// §9.4.2: "The escape sequences shown in Table 9-21, when included in a string
// argument, print special characters." Table 9-21's first row is `\n`, "The
// newline character" — the display tasks' ONLY spelling of a newline inside a
// string argument, because the string argument is a §2.7 string literal and
// §2.7 closes the other door: "A string literal is a sequence of characters
// enclosed by double quotes (") and contained on a single line", and "Certain
// characters can only be used in a string literal when preceded by an
// introductory character called an escape character", Table 2-2 listing the
// newline first.
//
// So a display string that tries to print two lines by breaking the literal
// across them is not a string argument at all. The same call written
// `$strobe("first line\nsecond line")` compiles and prints the two lines
// (probed; 06_display_formats.va runs the table's escapes).
//
// ch02_lexical/19_multiline_string_rejected.va pins §2.7's rule for a string
// in general; this is the display-argument case Table 9-21 exists for.
//
// VerA reports E0138 "a string literal may not span lines".
//
//! lrm 9.4.2
//! lrm 2.7
//! reject-only E0138
//! reject a string literal may not span lines
//! neighbour 06_display_formats.va
`include "disciplines.vams"
module ch09_display_newline_only_by_escape(p, n);
  inout p, n; electrical p, n;
  analog begin
    $strobe("first line
second line");                           // illegal: a newline needs \n
    I(p, n) <+ V(p, n);
  end
endmodule
