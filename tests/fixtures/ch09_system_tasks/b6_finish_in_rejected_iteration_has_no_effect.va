// §9.7.1: "$finish called during a rejected iteration shall have no effect."
//
// THE REJECTED ITERATION, borrowed from 184_limit_veto_after_correction.va,
// whose two checks this file repeats. `//! solve` frees p; the branch is
// I = v - 1e-10. Newton's first step lands on v = 1e-10 at iteration 1, and
// there the block calls $discontinuity(-1), which §9.17.3 says is used "to
// prevent convergence": that iterate is not accepted, and the solver accepts
// the next one, iteration 2, at the same voltage. So the guarded $finish IS
// evaluated, and only in an iteration that is rejected.
//
// THE OBSERVABLE. Both checks print at the accepted solution. Had the $finish
// in iteration 1 taken effect, the run would have ended before the accepted
// solution existed and printed neither (`//! checks 2` then fails).
//
//   iteration at acceptance = 2  (the vetoed iterate was iteration 1)
//   V(p,n) = 1e-10
//
//! lrm 9.7.1
//! lrm 9.7.1:3
//! lrm 9.17.1
//! solve
//! bias V(n) = 0
//! checks 2
`include "check.vh"
module b6_finish_in_rejected_iteration_has_no_effect(p, n);
  inout p, n; electrical p, n;
  analog begin
    if ($simparam("iteration") == 1 && V(p, n) > 0.0) begin
      $discontinuity(-1);
      $finish(1);
    end
    I(p, n) <+ V(p, n) - 1e-10;
    `CHECK("the accepted vector is the iterate after the vetoed one", $simparam("iteration"), 2.0, 0.0);
    `CHECK("the run reached the accepted solution", V(p, n), 1e-10, 1e-18);
  end
endmodule
