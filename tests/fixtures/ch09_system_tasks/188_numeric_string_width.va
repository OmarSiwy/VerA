//! print none
//! lrm 9.4.5
`include "check.vh"
module ch09_numeric_string_width(p,n);
  inout p,n; electrical p,n;
  parameter select = 1;
  localparam code = 32'h41424344;
  string text;
  analog begin
    $sformat(text, "%s", select ? 64'h4142434445464748 : 64'h494A4B4C4D4E4F50);
    `CHECKI("ternary retains eight bytes", text == "ABCDEFGH", 1);
    $sformat(text, "%s", code);
    `CHECKI("localparam retains four bytes", text == "ABCD", 1);
    I(p,n) <+ V(p,n);
  end
endmodule
