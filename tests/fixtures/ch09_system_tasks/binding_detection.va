// §9.19. "$param_given() ... shall be one (1) if the parameter was overridden,
// either by a defparam statement or by a module instance parameter value
// assignment, and zero (0) otherwise", and "$port_connected() ... shall be one
// (1) if the port was connected to a net (by order or by name) when the module
// was instantiated".
//
// The testbench below overrides `gain` on the instance line, so $param_given is
// 1 rather than the 0 it would report for the declared default of 1.0 — and the
// override is visible a second way, in the 2.0 * 0.5 = 1.0 A the guarded
// contribution then carries. Both ports are bound to nets by the instantiation,
// so $port_connected(p) is 1.
// The untouched parameter must report zero, whereas an explicit override
// equal to the declared default must still report one. This distinguishes
// override provenance from either a constant answer or a value comparison.
//
//! lrm 9.19
//! lrm 9.19:1
//! lrm 9.19:4
//! lrm 9.19:6
//! param gain = 2.0, same_default = 3.0
//! bias V(p) = 0.5
//! checks 6
`include "check.vh"
module ch09_binding_detection(p, n);
  inout p, n; electrical p, n;
  parameter real gain = 1.0;
  parameter real untouched = 7.0;
  parameter real same_default = 3.0;
  analog begin
    if ($param_given(gain) && $port_connected(p)) I(p,n) <+ gain*V(p,n);
    else I(p,n) <+ V(p,n);
    `CHECKI("$param_given is 1 for a parameter overridden on the instance line",
            $param_given(gain), 1);
    `CHECKI("$port_connected is 1 for a port bound by the instantiation",
            $port_connected(p), 1);
    `CHECK("and the override is the 2.0 that scales the branch", gain*V(p,n), 1.0, 1e-15);
    `CHECKI("a parameter without an override reports zero", $param_given(untouched), 0);
    `CHECKI("an explicit override equal to the default still reports one", $param_given(same_default), 1);
    `CHECKX("the guarded contribution actually carries the overridden current", I(p,n), 1.0);
  end
endmodule
