// Host-only oracle: tests/host.py.
// AMS 9.7.3:12: the simulator must supply the swept value.
// observation: analysis dc
// observation: psweep drive = 1, 2, 3
// observation: print none
module diagnostic_info_dc_sweep;
  parameter real drive=1;
  analog if (drive == 2) $info("observe-info");
endmodule
