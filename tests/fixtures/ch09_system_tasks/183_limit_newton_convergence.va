// At the true DC solution I(p,n)=0 implies V(p,n)=2. A limiter permits only
// 0.5 V per iteration; accepting a clamped residual would give the wrong root.
//! lrm 9.17.3
//! lrm 9.17.1
//! lrm 9.17.1:1001
//! lrm 9.17.3:1001
//! solve
//! bias V(n) = 0
`include "check.vh"
module ch09_limit_newton_convergence(p, n);
  inout p, n; electrical p, n;
  analog function real slow_limit;
    input vnew, vold;
    real vnew, vold;
    begin
      slow_limit = vold + max(-0.5, min(0.5, vnew-vold));
      if (abs(slow_limit-vnew) > 1e-12) $discontinuity(-1);
    end
  endfunction
  analog begin
    I(p,n) <+ exp($limit(V(p,n), slow_limit)) - exp(2.0);
    `CHECK("Newton must converge to the unclamped equation", V(p,n), 2.0, 1e-6);
  end
endmodule
