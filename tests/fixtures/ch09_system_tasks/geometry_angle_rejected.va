// §9.18/Table 9-29 allows 0 <= $angle < 360. A specified 360 is outside
// that domain, although two valid angles may sum past 360 before resolution.
// geometry_hierarchical_overrides.va supplies the legal 300+100 neighbour;
// geometry_parameter_sweep.va covers a fractional wrap and specified zero.
//! lrm 9.18
//! lrm 9.18:1000
//! reject-only E0890
//! neighbour geometry_hierarchical_overrides.va
//! neighbour geometry_parameter_sweep.va
module geometry_angle_bad;
  geometry_angle_child #(.$angle(360)) child();
endmodule
module geometry_angle_child;
  analog $display("angle=%g", $angle);
endmodule
