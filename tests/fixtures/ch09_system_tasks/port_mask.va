// §9.19 "$port_connected() ... returns 1 if the port is connected and 0
// otherwise" for a TOP-LEVEL device: which ports the host's card connects is
// the host's to say, through the Model row's `port_connected__` mask (bit p =
// port p in declaration order; all ones by default). HiSIM_HV is the model
// that needs it: a 4-terminal card for its 6-port module must take the
// 4-node path (ESPice, 2026-10-02). tests/fixtures/ch09_system_tasks/port_mask_host.zig clears the bits
// of `sub` and `temp` and checks both the setup-time and the eval-time read.
`include "disciplines.vams"
module port_mask(d, g, s, b, sub, temp);
  inout d, g, s, b, sub, temp;
  electrical d, g, s, b, sub, temp;
  real gsub;
  analog begin
    gsub = $port_connected(sub) ? 1e-3 : 0.0;
    I(d, s) <+ ($port_connected(temp) ? 2e-3 : 1e-3) * V(d, s);
    I(d, s) <+ gsub * V(d, s);
  end
endmodule
