// §9.17.2: "The expression argument shall be non-negative. If the value is
// less than the simulator's minimum allowable time step, the simulator's
// minimum time step shall be used instead."
//
// `sim.spice.tran`'s minimum step is 1e-18 s (`Options.dt_min`). The timer
// fires once, at t = 1 ns, and its statement asks for a 1e-20 s bound, a
// hundredth of the minimum. Honoured as written, the next accepted point is
// 1 ns + 1e-20 s. The clause substitutes the minimum step, so no accepted
// point after the timer is closer to it than 1e-18 s.
//
// A bound below the minimum does not end the run on its own — one tiny step
// is numerically harmless and the controller grows the step again — so the
// observable is the step itself: every accepted point in (1 ns, 1.5 ns) must
// lie at least 1e-18 s (less a rounding margin) past the timer. 1 ns + 1e-20 s
// is representable (the f64 spacing at 1e-9 is about 2e-25), so the unfloored
// step does produce such a point and fails the check.
//
// The source is the module's own `V(p) <+ 1.0`, so the circuit itself never
// shortens a step.
//
//! lrm 9.17.2
//! lrm 9.17.2:2
//! solve
//! tran 1n, 10n
`include "check.vh"
module ch09_bound_step_below_minimum_step(p);
  inout p; electrical p;
  analog begin
    @(timer(1n)) $bound_step(1e-20);
    if ($abstime > 1n && $abstime < 1.5n)
      `CHECKI("§9.17.2 a step after a sub-minimum bound is the minimum step, not the bound", ($abstime - 1n) >= 0.999e-18, 1);
    V(p) <+ 1.0;
  end
endmodule
