// §9.7.2 $stop, EXECUTED: "a call to $stop during an accepted iteration causes
// simulation to be suspended at a converged time point", and "the mechanism
// for resuming simulation is left to the implementation". A batch testbench
// has no interactive kernel to suspend into, so VerA's implementation of
// suspension in this artifact is documented as: print the Table 9-25
// diagnostic and exit 0 — the run stands suspended forever, which for a
// non-resumable process and an exit are indistinguishable. What is NOT
// implementation-defined is that the solve stops HERE: nothing after the call
// may run.
//
// Same observable shape as 172/173:
//
//   point 0, V(p) = 1.0:  `ok=1` prints (1.0 < 1.5), then $stop(1) prints its
//                         level-1 time-and-location line and the run ends,
//                         status 0.
//   point 1, V(p) = 2.0:  never solved; a dropped $stop — the pre-fix
//                         behaviour — would print 2.0 < 1.5 = 0 against
//                         want 1 here, a hard `ok=0`.
//
//! lrm 9.7.2
//! lrm 9.7
//! lrm 9.7:1000
//! lrm 9.7.2:1001
//! sweep V(p) = 1.0, 2.0
`include "check.vh"
module ch09_stop_terminates(p, n);
  inout p, n; electrical p, n;
  analog begin
    `CHECKI("printed at the first point only: $stop suspends the run before the second", V(p) < 1.5, 1);
    $stop(1);
    I(p,n) <+ V(p,n);
  end
endmodule
