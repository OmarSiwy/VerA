// §9.18 Table 9-29 gives the top-level value of every hierarchical parameter
// system function, and the resolved value of an instance is that top-level
// value combined with whatever each level down specified. This module is
// elaborated as the top level and nothing overrides anything, so each function
// returns its Table 9-29 starting value:
//
//     $mfactor    1.0      $angle      0 degrees
//     $xposition  0.0 m    $hflip      +1
//     $yposition  0.0 m    $vflip      +1
//
// so the first sum is 1.0 + 0.0 + 0.0 + 0.0 = 1.0 and the second adds the two
// mirror flags for 3.0. Every term is a small integer in binary floating point,
// so the sums are exact and `CHECKX` is the right form.
//
//! lrm 9.18
//! lrm 9.18:1000
`include "check.vh"
module ch09_hierarchical_parameters(p, n);
  inout p, n; electrical p, n;
  real info;
  analog begin
    info = $mfactor + $xposition + $yposition + $angle;
    `CHECKX("Table 9-29 top level: mfactor 1 with position and angle at 0", info, 1.0);
    info = info + $hflip + $vflip;
    `CHECKX("an unmirrored instance adds +1 for each of hflip and vflip", info, 3.0);
    I(p,n) <+ info + 0.0*V(p,n);
  end
endmodule
