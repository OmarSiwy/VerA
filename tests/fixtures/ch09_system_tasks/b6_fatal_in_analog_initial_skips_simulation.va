// §9.7.3: "If $fatal is executed within an analog initial block, then after
// outputting the message, the initialization may be aborted, and in no case
// shall simulation proceed past initialization."
//
// Same shape as b6_finish_in_analog_initial_skips_simulation.va. The initial
// block sets `stage` to 1 and reports it with $display BEFORE the $fatal,
// since initialization "may be aborted" at the call. The analog block's check
// reads stage = 1 against want 0, ok=0, if the simulation proceeded at all.
//
// $fatal "terminates the simulation with an errorcode"; VerA's errorcode is
// the finish_number floored at 1 (173_fatal_terminates.va), so $fatal(1, ...)
// exits 1.
//
//! lrm 9.7.3
//! lrm 9.7.3:7
//! lrm 5.2.1
//! exit 1
//! checks 1
`include "check.vh"
`ifdef VERA_PERTURB
`define CHECKI_NOW(NAME, GOT, WANT) $display("%s got=%d want=%d ok=%d", NAME, GOT, (WANT) + 1, ((GOT) == (WANT) + 1))
`else
`define CHECKI_NOW(NAME, GOT, WANT) $display("%s got=%d want=%d ok=%d", NAME, GOT, WANT, ((GOT) == (WANT)))
`endif
module b6_fatal_in_analog_initial_skips_simulation(p, n);
  inout p, n; electrical p, n;
  integer stage;
  analog initial begin
    stage = 1;
    `CHECKI_NOW("analog initial runs up to its $fatal", stage, 1);
    $fatal(1, "initialization cannot continue");
  end
  analog begin
    `CHECKI("never printed: no simulation proceeds past a $fatal in analog initial", stage, 0);
    I(p, n) <+ V(p, n);
  end
endmodule
