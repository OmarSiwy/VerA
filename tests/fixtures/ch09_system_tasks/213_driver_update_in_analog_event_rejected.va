// §9.22.5: "The status of drivers for a given signal can be monitored with the
// event detection keyword driver_update. It can be used in conjunction with the
// event detection operator @ to detect updates to any of the drivers of the
// signal." Its one printed use is a DIGITAL process:
//
//   always @(driver_update clock)
//       statement;
//
// Two places say the digital context is the only one:
//
//  * §9.2 Table 9-19, the `@(driver_update)` row: "Supported in digital
//    context of connectmodule: Yes", "Supported in analog context of
//    connectmodule: No".
//  * The grammar. A.6.5 puts `driver_update expression` in `event_expression`,
//    the operand of the digital `event_control`. The analog block's
//    `analog_event_control ::= @ ( analog_event_expression )` takes
//    expression, posedge/negedge, a named event, initial_step, final_step,
//    analog_event_functions (cross/above/timer/absdelta) and their `or`/`,`
//    combinations — and no driver_update.
//
// So `@(driver_update d)` inside an `analog` block is not a sentence the
// language has. The same event control in an `always` block of a connect
// module is 38_driver_update_connectmodule.va, which compiles and runs.
//
// VerA refuses it at the parser: E0209 "expected an expression: found
// `driver_update`", which is A.6.5's analog_event_expression having no
// production that starts with the keyword.
//
//! lrm 9.22.5
//! lrm 9.2
//! lrm 9.2:1000
//! reject-only E0209
//! reject found `driver_update`
//! neighbour 38_driver_update_connectmodule.va
`include "disciplines.vams"
module ch09_driver_update_in_analog_event(p, n);
  inout p, n; electrical p, n;
  wire d;
  real hits;
  analog begin
    @(driver_update d) hits = hits + 1;  // illegal: not an analog event
    I(p, n) <+ V(p, n);
  end
endmodule
