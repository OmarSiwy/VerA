// §9.13: "Verilog-AMS HDL extends the probabilistic distribution functions so
// that they are supported in the analog context." Table 9-10 lists all 17 names
// and every row reads `Yes  Yes` — digital context AND analog context. So this
// file must COMPILE and run green; a compiler that refuses the call is the one
// that is wrong, which is why the expectation is a run and not a reject.
//
// Syntax 9-8 makes the seed optional for $arandom exactly as for $random
// (`$arandom [ ( analog_random_seed [, type_string] ) ]`), and "$arandom is
// upwardly compatible with $random ... and has the same behavior", so the
// §9.13.1 modulo example applies verbatim. No repeatability claim: with the
// seed omitted the simulator picks one.
//
//! lrm 9.13.1
//! xfail VerA refuses the whole §9.13 probabilistic family with E0801 rather than stubbing a seeded RNG stream; Table 9-10 marks every one of the 17 names analog-context Yes
`include "check.vh"
module ch09_arandom_no_seed(p, n);
  inout p, n; electrical p, n;
  integer a;
  analog begin
    a = $arandom;
    `CHECKI("$arandom has the same behavior: % 60 lands in [-59:59]",
            (a % 60 >= -59) && (a % 60 <= 59), 1);
    I(p,n) <+ V(p,n) + a;
  end
endmodule
