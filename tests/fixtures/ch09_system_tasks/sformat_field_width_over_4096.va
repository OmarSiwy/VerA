// §9.4.3 gives the real conversions "the full formatting capabilities
// available in the C language", and C bounds no field width or precision.
// VerA used to refuse a width above 4096 (E1011, its formatting row); the row
// and the field's scratch are now sized from the widths written (#29).
//
// HAND DERIVATION. Each string is compared with the same text built by
// replication (§3.3 Table 3-3), so no digit is typed twice.
//   %4097d of 1:     4096 spaces then "1" (C right-justifies in the field).
//   %06000d of 1:    the '0' flag pads with zeros after the (absent) sign:
//                    5999 zeros then "1".
//   %5000.2f of 1.5: "1.50" (two fractional digits, exact) right-justified in
//                    5000 columns: 4996 spaces then "1.50".
//   %.5000f of 0.5:  "0.5" then 4999 more zeros: 0.5 is exact in binary, so
//                    every digit past the first is 0. 5002 bytes.
//
//! lrm 9.4.3
//! lrm 9.5.3
//! bias V(p) = 0
`include "check.vh"
module sformat_field_width_over_4096(p, n);
  inout p, n; electrical p, n;
  string a, b, c, d;
  integer same;
  analog begin
    $sformat(a, "%4097d", 1);
    same = (a == {{4096{" "}}, "1"});
    `CHECKI("a width of 4097", same, 1);
    $sformat(b, "%06000d", 1);
    same = (b == {{5999{"0"}}, "1"});
    `CHECKI("a zero-filled width of 6000", same, 1);
    $sformat(c, "%5000.2f", 1.5);
    same = (c == {{4996{" "}}, "1.50"});
    `CHECKI("a real in a width of 5000", same, 1);
    $sformat(d, "%.5000f", 0.5);
    same = (d == {"0.5", {4999{"0"}}});
    `CHECKI("a precision of 5000", same, 1);
    I(p,n) <+ V(p,n);
  end
endmodule
