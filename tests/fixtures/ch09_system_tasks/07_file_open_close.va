// §9.5.1. Two things are fixed about the fd this $fopen returns, and neither is
// a matter of implementation choice.
//
// First, the open cannot fail: Table 9-24 gives type "w" as "Truncate to zero
// length or create for writing", so the "file does not exist" arm of "if a file
// cannot be opened ... a zero is returned for the mcd or fd" cannot apply. A
// type argument is present, so the result is a file descriptor and not a
// multichannel descriptor, and "the most significant bit (bit 31) of a fd is
// reserved and shall always be set". (For a mcd the same paragraph says the
// opposite — bit 31 "shall always be cleared" — which is the whole point of the
// bit, so the two overloads of $fclose below can tell which they were given.)
//
// Second, the fd is a NEW channel. "The remaining bits hold a small number
// indicating what file is opened. Three file descriptors are pre-opened; they
// are STDIN, STDOUT, and STDERR, which have the values 32'h8000_0000,
// 32'h8000_0001, and 32'h8000_0002." Those three name the standard streams, so
// a descriptor for this fixture's own log cannot be any of them: the small
// number has to be greater than 2. (§9.5.1 does allow reuse — "the $fopen function shall reuse
// channels that have been closed" — but the standard streams are never closed,
// so no reuse can reach them.) This catches an implementation that answers
// $fopen with STDOUT and quietly sends every later $fdisplay to the transcript.
//
//! lrm 9.5.1
//! xfail VerA has no file-descriptor surface: codegen.zig `void_tasks` lowers the whole §9.5 family to the constant `S.con(0.0)`, so $fopen answers 0 — bit 31 clear and channel number 0, failing both halves — and $fclose is a no-op. lower.zig:2362 records the reason: the file family "needs a descriptor the compiled device has no way to own"
`include "check.vh"
module ch09_file_open_close(p, n);
  inout p, n; electrical p, n;
  integer fd;
  analog begin
    fd = $fopen("ch09_07_open_close.log", "w");
    // Masked, not shifted: `>>` fills with zeros on a 32-bit integer, but VerA
    // carries integers in an i64 where a sign-extended fd would answer a shift
    // differently. `& 2147483648` is bit 31 whatever the width, and
    // `& 2147483647` is the small channel number below it.
    `CHECKI("truncate-or-create cannot fail, so bit 31 of the fd is set", (fd & 2147483648) != 0, 1);
    `CHECKI("a fresh channel, not one of the three pre-opened std descriptors", (fd & 2147483647) > 2, 1);
    $fclose(fd);
    I(p,n) <+ V(p,n);
  end
endmodule
