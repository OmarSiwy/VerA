// §9.1 Overview: "Verilog-AMS HDL is a superset of IEEE Std 1364 Verilog and
// hence all the system tasks in IEEE Std 1364 Verilog are supported. ... In
// addition, Verilog AMS HDL extends the behavior of several Verilog systems
// tasks and functions including allowing some of them to be used in an analog
// context."
//
// Two claims, and this file asserts one instance of each with the SAME
// functions, so the only thing that varies is the context:
//
//   * supported (the digital context, where IEEE 1364 put them): an `initial`
//     block — §7.2.2's discrete context — computes `$clog2(9)` into an integer
//     the analog block then reads;
//   * extended into the analog context: the analog block calls the same
//     `$clog2(9)`, plus §9.11's four conversions ("$bitstoreal and
//     $realtobits, $rtoi and $itor can be used in the analog context").
//
// THE DIGITS, BY HAND.
//   $clog2(9)   §9.14: "the ceiling of the log base 2 of the argument";
//               log2(9) = 3.17, ceiling 4            -> 4, in both contexts
//   $rtoi(2.7)  truncates toward zero (IEEE 1364 §17.8) -> 2
//   $itor(3)    the integer as a real                -> 3.0
//   $bitstoreal($realtobits(0.1))  the bit pattern round trip is the
//               identity on a real (§9.11 Table 9-8) -> 0.1, exactly
//
// Every want is an integer or an exact round trip, so every check is exact.
// Table 9-8 and Table 9-11 mark all five "Yes" in both columns.
//
//! lrm 9.1
//! lrm 9.11
//! lrm 9.14
//! lrm 9.1:1000
//! lrm 9.11:1000
//! lrm 9.14:1
`include "check.vh"
module ch09_ieee_1364_system_functions_in_both_contexts(p, n);
  inout p, n; electrical p, n;
  integer from_digital;
  initial from_digital = $clog2(9);
  analog begin
    `CHECKI("§9.1 an IEEE 1364 function in the digital context: $clog2(9)", from_digital, 4);
    `CHECKI("§9.1 the same function extended into the analog context", $clog2(9), 4);
    `CHECKI("$rtoi truncates toward zero", $rtoi(2.7), 2);
    `CHECKX("$itor is the integer as a real", $itor(3), 3.0);
    `CHECKX("$bitstoreal inverts $realtobits", $bitstoreal($realtobits(0.1)), 0.1);
    I(p, n) <+ V(p, n);
  end
endmodule
