// §9.4.6: "All the display tasks, except $debug, shall not display output
// unless an iteration has been accepted." §9.4.1: "The $display task provides
// the same capabilities as $strobe." So a display task's output belongs to
// the accepted point, which a DEVICE does not see from inside `eval` (it runs
// per Newton iteration, batched, possibly on a GPU). A VerA device built for
// a simulator records each display task its `say` runs, at the accepted point
// the host passes it, into a buffer the host lends (`contract.Say`), and the
// host prints the records (`contract.formatSay`); `//! display record` builds
// this testbench over that device, so every `ok=` below reached the
// transcript through the record channel, not through a print in the model.
//
// THE DIGITS. V(p) = 0.75, V(n) = 0.25: V(p, n) = 0.5, exact in binary. `k`
// is the integer 7. The third check sits under `V(p, n) > 0.1`, which holds,
// so its arm runs and records; the fourth sits under `V(p, n) > 9`, which
// does not, and would print `ok=0` if a guarded task were recorded whatever
// its guard. Three verdicts.
//
// `$monitor` needs §9.4.1's change detection across accepted steps, state a
// device does not keep, so a device does not record it and says so (W0850).
//
//! lrm 9.4.1
//! lrm 9.4.6
//! lrm 9.4.6:1
//! display record
//! warn W0850
//! bias V(p) = 0.75, V(n) = 0.25
//! print none
//! checks 3
`include "check.vh"
module say_device_records(p, n);
  inout p, n; electrical p, n;
  integer k;
  analog begin
    k = 7;
    I(p, n) <+ V(p, n) / 1k;
    `CHECK("V(p,n) printed by the host from the device's record", V(p, n), 0.5, 1e-12);
    `CHECKI("an integer value keeps its %d", k, 7);
    if (V(p, n) > 0.1) `CHECKX("a guarded task records when its arm runs", V(p), 0.75);
    if (V(p, n) > 9) `CHECKX("and only then", 0.0, 1.0);
    $monitor("%g", V(p));
  end
endmodule
