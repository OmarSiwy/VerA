// §9.11 / Table 9-8: `$signed  Yes  No` — supported in the digital context,
// NOT in the analog one. §9.11 names its whole extension in one sentence and
// $signed is not in it: only $bitstoreal and $realtobits are carried into the
// analog context.
//
// $signed reinterprets a sized vector's bit pattern as two's complement, which
// presupposes the bit-vector type system of the digital context; an analog
// block has integers and reals. So the call site is the whole claim and there
// is no return value to write a `want` for.
//
// WHERE THE RULE ACTUALLY LIVES. §9.11 is a PERMISSION — "Verilog AMS HDL
// extends the conversion functions ... so that $bitstoreal and $realtobits can
// be used in the analog context" — and forbids nothing on its own. The
// prohibition is Table 9-8's analog-context "No" cell, and every Table 9-1..9-20
// sits under §9.2 "Categories of System Tasks and Functions" (the nearest
// preceding heading to Table 9-8 in ch9-system.html). Both clauses are cited
// below; 9.2 is the one with teeth.
//
//! lrm 9.2
//! lrm 9.11
//! reject analog context
//! reject E0806
module ch09_atomic_signed_analog_rejected(p, n);
  inout p, n; electrical p, n;
  integer x;
  analog begin
    x = $signed(4'b1011);
    I(p,n) <+ V(p,n) + x;
  end
endmodule
