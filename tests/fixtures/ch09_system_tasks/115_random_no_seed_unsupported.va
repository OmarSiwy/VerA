// DEBT — this rejection is NOT conformance.
// The LRM permits what VerA refuses here. The substrings below record
// CURRENT behavior so the suite stays green on it; they do not claim it
// is right. `zig build ledger` counts this rule against VerA.
//
// VAMS-9.13.1-01  (ch9-system.html)
// The system function $random shall always return the same stream of values given the same initial random_seed.
//
//! reject E0801
//! reject $random
// EXPECT: error
module ch09_random_no_seed_unsupported(p, n);
  inout p, n; electrical p, n;
  analog I(p,n) <+ $random;
endmodule
