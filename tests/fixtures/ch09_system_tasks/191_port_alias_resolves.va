// §9.20's `$analog_port_alias` half, and the one sentence that makes it a
// different function from `$analog_node_alias` rather than a stricter spelling
// of it:
//
//   "In addition, a node that is aliased to a valid hierarchical port reference
//    via the $analog_port_alias() function shall be allowed as an input to the
//    port access function (see 5.4.3) and shall measure the flow through the
//    port of the instance referred to by the hierarchical reference."
//
// `I(<n2>)` on an ordinary local net is not a legal port probe — §5.5.1 says
// the reference "must be a declared port of the module in which the port access
// function is used" — so the fact that this file COMPILES is already half the
// assertion. The other half is WHICH unknown it reads. The port flow is forced
// by name, exactly as ch05_analog_behavior/port_flow_probe.va forces its own
// (`flow(<a>)` is one unknown, pinned at 62.5 mA, an exact binary fraction): a
// compiler that aliased the node but not the port would refuse the probe, and
// one that read an ordinary branch flow of the isolated net `n2` instead would
// read the 0 that nothing forced.
//
// The clause's own example aliases to `"top.r1.p"` — a port of a child
// INSTANCE — and this file deliberately does not: see the ponytail note in
// `Lower.bindAlias`. Flattening binds a child's port to the parent net it was
// connected to, so one instance's terminal flow is not a quantity the flat
// design still has, and §9.20's own answer for a reference this compiler cannot
// honour exactly is the honest zero, not a nearby number.
//
//! lrm 9.20
//! lrm 5.4.3
//! bias V(a) = 5.0, V(g) = 0.0
//! sweep flowZ28Z3caZ3eZ29 = 0.0625
`include "check.vh"

module ch9_port_alias_top(a, g);
  inout a, g; electrical a, g;
  ch9_port_alias_checker ch1();
  analog begin
    I(a, g) <+ V(a, g) / 1000.0;
  end
endmodule

module ch9_port_alias_checker;
  electrical n2;
  integer status;
  analog initial begin
    status = $analog_port_alias(n2, "ch9_port_alias_top.a");
  end
  analog begin
    `CHECKI("a hierarchical reference that resolves to a port returns 1", status, 1);
    `CHECKX("and the aliased net may then be read with the PORT access function",
            I(<n2>), 0.0625);
  end
endmodule
