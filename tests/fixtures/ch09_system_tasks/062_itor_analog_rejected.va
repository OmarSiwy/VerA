// §9.11 / Table 9-8: $itor is the mirror of 061. §9.11 extends exactly
// $bitstoreal and $realtobits into the analog context; Table 9-8 marks
// `$itor  Yes  No` — legal in the digital context, NOT in the analog one.
//
// A conversion whose only job is to widen an integer to a real is redundant in
// an analog block anyway: §4.2.1.3 already converts the integer operand of a
// mixed expression. That is why the LRM had no reason to carry $itor over, and
// why the fixture asserts nothing: an illegal call site has no return value to
// pin.
//
//! lrm 9.11
//! reject analog context
//! xfail VerA has no Table 9-8 analog-context check; lower.zig lowers $itor like any other math call
module ch09_atomic_itor_analog_rejected(p, n);
  inout p, n; electrical p, n;
  real x;
  analog begin
    x = $itor(3);
    I(p,n) <+ V(p,n) + x;
  end
endmodule
