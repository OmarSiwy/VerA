// §9.13.1, the scope rule on $arandom's third argument. Syntax 9-8 admits it:
//
//   analog_random_function ::= $arandom [ ( analog_random_seed [, type_string] ) ]
//   type_string            ::= "global" | "instance"
//
// and §9.13.1 fences it: "The type_string provides support for Monte-Carlo
// analysis and shall only by used in calls to $arandom from within a paramset."
//
// The module below is an ordinary module, so the call violates the rule on
// sight — no elaboration, no Monte-Carlo trial, no paramset needed to see it.
// The previous fixture wrapped the call in a `paramset` and so recorded the
// paramset boundary instead of this rule; the violating form needs no paramset
// at all, which is what makes it the cheap negative.
//
// Nothing is asserted: an illegal call site has no result. The LEGAL use —
// type_string inside a paramset, "one value per Monte-Carlo trial" for "global"
// and one per referencing instance for "instance" — needs paramset support to
// write down at all and has no fixture yet.
//
//! lrm 9.13.1
//! reject within a paramset
//! xfail VerA refuses the whole §9.13 family with E0801 and never reaches the type_string scope rule
module ch09_arandom_type_string_outside_paramset(p, n);
  inout p, n; electrical p, n;
  integer a;
  analog begin
    a = $arandom(7, "instance");
    I(p,n) <+ V(p,n) + a;
  end
endmodule
