// §9.5.1.2 Sharing of File Descriptors Between the Analog and Digital Contexts,
// verbatim and in full — the subclause is one sentence:
//
//   "The file I/O system functions and tasks in both the analog and digital
//    contexts can use file descriptors opened in either context, if the file
//    descriptors are opened for writing or appending."
//
// A file descriptor is not a host object with an owner: §9.5.1 gives it the
// shape of a 32-bit integer (bit 31 set, the rest "a small number indicating
// what file is opened"), and §9.5.2 says a file output task's "first argument
// shall be either a multichannel descriptor or a file descriptor" — i.e. an
// ordinary integral expression. So this subclause is the statement that the
// integer is PORTABLE between the two contexts, and the sentence is a
// permission. Refusing a write because the descriptor was opened three lines
// away in a different kind of block is what the clause forbids.
//
// THE DESIGN BELOW IS THE SMALLEST ONE THAT NEEDS THE PERMISSION. The `initial`
// block is the discrete (digital) context (§7.2.2) and opens the file for
// writing; the `analog` block is the continuous context and writes through the
// descriptor it was handed; §9.5.4.1's `$fgets` then reads the file back so the
// assertion is about the bytes that actually landed rather than about an
// argument value. Only ONE direction is expressible — an `initial` block runs
// before the analysis, so a descriptor the analog context opens cannot be used
// by the digital context first — and the clause grants both.
//
// WHAT IS ASSERTED, and why it is a number. `$fwrite(fd, "%d", 42)` writes the
// characters `42`; §9.5.4.1's `$fgets` "reads characters ... into str until a
// newline character is read and transferred to str", and §9.5.4.1 (printed
// p.233) returns the number of characters read. There is no newline in a
// two-byte file, so the count is 2, and the string is compared against the
// literal `42` as an integer (§4.2.14, the same trick 170_display_argument_-
// runs.va uses). Both were derived by compiling the ANALOG-ONLY half of this
// file and reading its transcript; the half the fixture adds is the `initial`
// block, and it adds no number.
//
// WHY IT CARRIES `xfail`. Neither half of the sharing exists. The `initial`
// block's statement is refused by E0433 before the descriptor is ever typed —
// "statement in an initial block is not a constant assignment: `fd` is assigned
// a value that is not constant", §7.2.2's ceiling on `initial` blocks, the same
// one ch07_mixed_signal/digital_initial_accepted.va documents — so
// `fd = $fopen(...)` is not a call site that can be
// reached, let alone one whose context could be judged. And behind that, the
// digital execution engine has no file table at all: `src/sim/digital.zig`
// dispatches four system tasks ($signed, $unsigned, $display, $finish) and none
// of them is §9.5's. The gap is VerA's and not the LRM's.
//
// WHEN IT GOES GREEN. A `--std=verilog-ams` compiler with a discrete kernel and
// a file table can run this file as written; the assertions are then a claim
// about the sharing rather than about acceptance.
//
//! lrm 9.5.1.2
//! lrm 9.5.1
//! lrm 9.5.4.1
//! xfail VerA has no digital-context file I/O: `fd = $fopen(...)` in an initial block is refused by §7.2.2's constant-assignment model (E0433), and src/sim/digital.zig implements none of §9.5 — so a descriptor opened in one context can never be handed to the other
`include "check.vh"
module ch09_file_descriptor_shared_across_contexts(p, n);
  inout p, n; electrical p, n;
  integer fd, rfd, code;
  string text;
  initial begin
    fd = $fopen("ch09_194_shared.log", "w");
  end
  analog begin
    $fwrite(fd, "%d", 42);
    $fclose(fd);
    rfd = $fopen("ch09_194_shared.log", "r");
    code = $fgets(text, rfd);
    `CHECKI("the analog context writes through the descriptor the digital context opened",
            code, 2);
    `CHECKI("the bytes in the file are the analog context's write",
            text == "42", 1);
    I(p,n) <+ V(p,n) + code;
  end
endmodule
