// §9.5.1.2 Sharing of File Descriptors Between the Analog and Digital Contexts,
// verbatim and in full — the subclause is one sentence:
//
//   "The file I/O system functions and tasks in both the analog and digital
//    contexts can use file descriptors opened in either context, if the file
//    descriptors are opened for writing or appending."
//
// A file descriptor is not a host object with an owner: §9.5.1 gives it the
// shape of a 32-bit integer (bit 31 set, the rest "a small number indicating
// what file is opened"), and §9.5.2 says a file output task's "first argument
// shall be either a multichannel descriptor or a file descriptor" — i.e. an
// ordinary integral expression. So this subclause is the statement that the
// integer is PORTABLE between the two contexts, and the sentence is a
// permission. Refusing a write because the descriptor was opened three lines
// away in a different kind of block is what the clause forbids.
//
// THE DESIGN BELOW IS THE SMALLEST ONE THAT NEEDS THE PERMISSION. The `initial`
// block is the discrete (digital) context (§7.2.2) and opens the file for
// writing; the `analog` block is the continuous context and writes through the
// descriptor it was handed; §9.5.4.1's `$fgets` then reads the file back so the
// assertion is about the bytes that actually landed rather than about an
// argument value. Only ONE direction is expressible — an `initial` block runs
// before the analysis, so a descriptor the analog context opens cannot be used
// by the digital context first — and the clause grants both.
//
// WHAT IS ASSERTED, and why it is a number. `$fwrite(fd, "%0d", 42)` writes the
// characters `42`. The `0` is load-bearing: a bare `%d` is AUTOMATICALLY SIZED
// (IEEE 1364-2005 §17.1.1.3: "the values written to the output file ... are
// sized automatically", and "leading zeros are suppressed and replaced by
// spaces"), so `%d` of the 32-bit constant 42 is space-padded to the widest
// value the expression can hold, and neither `code == 2` nor `text == "42"`
// would be true on a conforming tool. An earlier revision wrote `%d` and was
// wrong for exactly that reason; audit_integer_default_fields.va is the file
// that asserts the padding itself. §9.5.4.1's `$fgets` "reads characters ... into str until a
// newline character is read and transferred to str", and §9.5.4.1 (printed
// p.233) returns the number of characters read. There is no newline in a
// two-byte file, so the count is 2, and the string is compared against the
// literal `42` as an integer (§4.2.14, the same trick 170_display_argument_-
// runs.va uses). Both were derived by compiling the ANALOG-ONLY half of this
// file and reading its transcript; the half the fixture adds is the `initial`
// block, and it adds no number.
//
// HOW VerA RUNS IT. The `initial` block calls a §9.5 file function, so it has
// no constant reading (§7.2.2's E0433 shape) and runs on the digital kernel as
// the module's discrete half (lib/ir/lower/context.zig `usesFiles`); `fd` is
// then a digital-owned integer the analog block reads, a §7.3.1 discrete input.
// The simulation has ONE descriptor table: the mixed runner routes the digital
// kernel's file tasks through the device's own (`contract.FileIo`), so the
// descriptor the digital `$fopen` returns is a channel of the table the analog
// `$fwrite` writes through. A tool with two tables fails here: the analog write
// names no open channel, the file stays empty, and `code` is 0.
//
// ONE WRITE, NOT ONE PER ITERATION. The analog block runs on every Newton
// iteration, and an earlier revision wrote and CLOSED `fd` on each of them, so
// every iteration after the first wrote through a descriptor it had already
// closed. The write and the close now sit under `@(initial_step)` (§5.10.2,
// active on the first point of the analysis); the read-back opens and closes
// its own descriptor each time, as 046_fgets.va does.
//
//! lrm 9.5.1.2
//! lrm 9.5.1
//! lrm 9.5.4.1
//! lrm 9.5.1.2:1000
//! lrm 9.5.4.1:1000
`include "check.vh"
module ch09_file_descriptor_shared_across_contexts(p, n);
  inout p, n; electrical p, n;
  integer fd, rfd, code;
  string text;
  initial begin
    fd = $fopen("ch09_194_shared.log", "w");
  end
  analog begin
    @(initial_step) begin
      $fwrite(fd, "%0d", 42);
      $fclose(fd);
    end
    rfd = $fopen("ch09_194_shared.log", "r");
    code = $fgets(text, rfd);
    $fclose(rfd);
    `CHECKI("the analog context writes through the descriptor the digital context opened",
            code, 2);
    `CHECKI("the bytes in the file are the analog context's write",
            text == "42", 1);
    I(p,n) <+ V(p,n) + code;
  end
endmodule
