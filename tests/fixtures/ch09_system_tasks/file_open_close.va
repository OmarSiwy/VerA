// §9.5.1. Two things are fixed about the fd this $fopen returns, and neither is
// a matter of implementation choice.
//
// First, the open cannot fail: Table 9-24 gives type "w" as "Truncate to zero
// length or create for writing", so the "file does not exist" arm of "if a file
// cannot be opened ... a zero is returned for the mcd or fd" cannot apply. A
// type argument is present, so the result is a file descriptor and not a
// multichannel descriptor, and "the most significant bit (bit 31) of a fd is
// reserved and shall always be set". (For a mcd the same paragraph says the
// opposite — bit 31 "shall always be cleared" — which is the whole point of the
// bit, so the two overloads of $fclose below can tell which they were given.)
//
// Second, the fd is a NEW channel. "The remaining bits hold a small number
// indicating what file is opened. Three file descriptors are pre-opened; they
// are STDIN, STDOUT, and STDERR, which have the values 32'h8000_0000,
// 32'h8000_0001, and 32'h8000_0002." Those three name the standard streams, so
// a descriptor for this fixture's own log cannot be any of them: the small
// number has to be greater than 2. (§9.5.1 does allow reuse — "the $fopen function shall reuse
// channels that have been closed" — but the standard streams are never closed,
// so no reuse can reach them.) This catches an implementation that answers
// $fopen with STDOUT and quietly sends every later $fdisplay to the transcript.
//
// The three VALUES themselves are not queryable from the fixture language, so
// this file does not cite §9.5.1:1004 exactly: the check below only pins that
// a new channel is not one of them. Asserting the values needs a host view of
// the standard streams.
//
//! lrm 9.5.1
//! lrm 9.5.1:2
//! lrm 9.5.1:3
//! lrm 9.5.1:1003
`include "check.vh"
module ch09_file_open_close(p, n);
  inout p, n; electrical p, n;
  integer fd, fd2;
  analog begin
    fd = $fopen("ch09_07_open_close.log", "w");
    // Masked, not shifted: `>>` fills with zeros on a 32-bit integer, but VerA
    // carries integers in an i64 where a sign-extended fd would answer a shift
    // differently. `& 2147483648` is bit 31 whatever the width, and
    // `& 2147483647` is the small channel number below it.
    `CHECKI("truncate-or-create cannot fail, so bit 31 of the fd is set", (fd & 2147483648) != 0, 1);
    `CHECKI("a fresh channel, not one of the three pre-opened std descriptors", (fd & 2147483647) > 2, 1);
    // §9.5.1: "The $fopen function shall reuse channels that have been
    // closed." The channel just released is the one the next open must be
    // handed, so the small numbers agree; a fresh channel here is the leak the
    // sentence forbids. The path is opened "w" again, so the reuse is the only
    // thing this opening changes.
    $fclose(fd);
    fd2 = $fopen("ch09_07_open_close.log", "w");
    `CHECKI("§9.5.1 the closed channel is reused", (fd2 & 2147483647) == (fd & 2147483647), 1);
    $fclose(fd2);
    I(p,n) <+ V(p,n);
  end
endmodule
