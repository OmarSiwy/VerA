// §9.10: "$abstime returns the absolute time, that is a real value number
// representing time in SECONDS."
//
// Seconds is the whole claim, and it is the digit a tool gets wrong: the natural
// alternative is to hand back the `timescale tick count, which at 2.5 ns with a
// 1ns/1ps timescale would be 2.5 or 2500, both a factor of 1e9 or more away from
// what is asserted here. The one time point is placed off a round nanosecond so
// a truncation to whole ticks fails too.
//
//! lrm 9.10
//! lrm 9.10:1000
//! analysis tran
//! time 2.5e-9
`include "check.vh"
module ch09_abstime(p, n);
  inout p, n; electrical p, n;
  analog begin
    `CHECK("§9.10 $abstime is in seconds, not timescale ticks", $abstime, 2.5e-9, 1e-21);
    I(p,n) <+ $abstime + 0.0*V(p,n);
  end
endmodule
