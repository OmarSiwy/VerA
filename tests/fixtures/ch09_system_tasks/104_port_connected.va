// §9.19: $port_connected(port) shall return one (1) if the port was connected to
// a net (by order or by name) when the module was instantiated, and zero (0)
// otherwise. The testbench instantiates this device with both ports bound to
// solver unknowns, so both answers are 1 — and the `if` below therefore takes
// its true arm, making the contribution V(p,n) = 0.5 rather than 0.
`include "check.vh"

//! lrm 9.19
//! lrm 9.19:6
//! bias V(p) = 0.5

module ch09_atomic_port_connected(p, n);
  inout p, n; electrical p, n;
  analog begin
    `CHECKI("$port_connected(p) on a bound port", $port_connected(p), 1);
    `CHECKI("$port_connected(n) on a bound port", $port_connected(n), 1);
    if ($port_connected(p)) I(p,n) <+ V(p,n);
    else I(p,n) <+ 0.0;
  end
endmodule
