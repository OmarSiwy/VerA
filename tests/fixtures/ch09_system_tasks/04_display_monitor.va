// §9.4.1: "The $monitor task provides the ability to monitor and display the
// values of any variables or expressions specified as arguments to the task",
// and "the arguments for this task are specified in exactly the same manner as
// for the $strobe system task", the whole argument list being displayed "at the
// end of the time step as if reported by the $strobe task". (§9.4.2 is the
// escape-sequence table; it says nothing about $monitor.)
//
// So what $monitor is handed here is not the node p — it is the BRANCH POTENTIAL
// V(p,n), the §5.4.1 difference of the two node potentials. The bias makes that
// difference a number a human can write down and, deliberately, a different one
// from either node: 0.75 - 0.25 = 0.5. A monitor argument lowered to V(p) alone
// would read 0.75 and fail.
//
// Both operands are exact in binary, so the difference is exact; the 1e-15 band
// is there only so the assertion is about the model and not about the last bit
// of a subtraction.
//
//! lrm 9.4.1
//! bias V(p) = 0.75, V(n) = 0.25
`include "check.vh"
module ch09_display_monitor(p, n);
  inout p, n; electrical p, n;
  analog begin
    $monitor("monitored=%f", V(p,n));
    `CHECK("the monitored expression is the branch potential, not a node", V(p, n), 0.5, 1e-15);
    I(p,n) <+ V(p,n);
  end
endmodule
