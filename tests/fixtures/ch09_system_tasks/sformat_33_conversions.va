// §9.5.3 $sformat and §9.5.2 $fwrite take the §9.4.1 argument list, which
// names no bound. VerA used to refuse a 33rd conversion in one call (E1010:
// one Zig format call takes at most 32 arguments); a longer call is now
// printed in consecutive runs of 32 (#29). sformat_32_conversions.va is the
// widest call that was one run.
//
// HAND DERIVATION. The arguments are i mod 10 for i = 0..32, each through %0d
// (no IEEE 1364 §17.1.1.3 automatic field: each prints its digit alone),
// so s is those 33 digits: "012345678901234567890123456789012". The second
// call has 70 operands (three runs of 32, 32 and 6), 0..9 seven times, so t
// is {7{"0123456789"}}. The third writes 40 operands, 0..9 four times, with
// $fwrite and a newline, then reads the line back with $fgets: 41 characters,
// the 40 digits and the newline.
//
//! lrm 9.5.3
//! lrm 9.5.2
//! bias V(p) = 0
`include "check.vh"
module sformat_33_conversions(p, n);
  inout p, n; electrical p, n;
  integer fd, c, same;
  string s, t, line;
  analog begin
    $sformat(s, "%0d%0d%0d%0d%0d%0d%0d%0d%0d%0d%0d%0d%0d%0d%0d%0d%0d%0d%0d%0d%0d%0d%0d%0d%0d%0d%0d%0d%0d%0d%0d%0d%0d",
      0, 1, 2, 3, 4, 5, 6, 7, 8, 9, 0, 1, 2, 3, 4, 5, 6, 7, 8, 9, 0, 1, 2, 3, 4, 5, 6, 7, 8, 9, 0, 1, 2);
    `CHECKI("33 conversions in one $sformat", s == "012345678901234567890123456789012", 1);
    $sformat(t, "%0d%0d%0d%0d%0d%0d%0d%0d%0d%0d%0d%0d%0d%0d%0d%0d%0d%0d%0d%0d%0d%0d%0d%0d%0d%0d%0d%0d%0d%0d%0d%0d%0d%0d%0d%0d%0d%0d%0d%0d%0d%0d%0d%0d%0d%0d%0d%0d%0d%0d%0d%0d%0d%0d%0d%0d%0d%0d%0d%0d%0d%0d%0d%0d%0d%0d%0d%0d%0d%0d",
      0, 1, 2, 3, 4, 5, 6, 7, 8, 9, 0, 1, 2, 3, 4, 5, 6, 7, 8, 9, 0, 1, 2, 3, 4, 5, 6, 7, 8, 9, 0, 1, 2, 3, 4,
      5, 6, 7, 8, 9, 0, 1, 2, 3, 4, 5, 6, 7, 8, 9, 0, 1, 2, 3, 4, 5, 6, 7, 8, 9, 0, 1, 2, 3, 4, 5, 6, 7, 8, 9);
    `CHECKI("70 conversions in one $sformat", t == {7{"0123456789"}}, 1);
    @(initial_step) begin
      fd = $fopen("sformat_33_conversions.dat", "w");
      $fwrite(fd, "%0d%0d%0d%0d%0d%0d%0d%0d%0d%0d%0d%0d%0d%0d%0d%0d%0d%0d%0d%0d%0d%0d%0d%0d%0d%0d%0d%0d%0d%0d%0d%0d%0d%0d%0d%0d%0d%0d%0d%0d\n",
        0, 1, 2, 3, 4, 5, 6, 7, 8, 9, 0, 1, 2, 3, 4, 5, 6, 7, 8, 9,
        0, 1, 2, 3, 4, 5, 6, 7, 8, 9, 0, 1, 2, 3, 4, 5, 6, 7, 8, 9);
      $fclose(fd);
      fd = $fopen("sformat_33_conversions.dat", "r");
      c = $fgets(line, fd);
      $fclose(fd);
    end
    `CHECKI("40 conversions in one $fwrite, read back", c, 41);
    same = (line == {{4{"0123456789"}}, "\n"});
    `CHECKI("and the line is the 40 digits", same, 1);
    I(p,n) <+ V(p,n);
  end
endmodule
