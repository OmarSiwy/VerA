// §9.15 states the three branches of $simparam in one sentence each:
//
//   "If param_name is known, its value is returned. If param_name is not known,
//    and the optional expression is not supplied, then an error is generated.
//    If the optional expression is supplied, its value is returned if
//    param_name is not known and no error is generated."
//
// 22_simparam.va is the third branch — the same unknown name WITH a fallback,
// which must come back verbatim and silently. This file is the second: drop the
// second argument and the identical call must become an error.
//
// The pair is deliberate. The name is the same in both files, so the only
// difference is the presence of the fallback, and the rule under test is
// exactly that difference. The failure mode a naive implementation ships is
// returning 0.0 here — indistinguishable from a simulator that really does
// have a parameter called "vera_no_such_simparam" and really does read zero,
// which is why the LRM makes it an error rather than a default.
//
// A reject, so there is nothing to run and no `want` to write.
//
//! lrm 9.15
//! reject vera_no_such_simparam
//! xfail VerA answers every unknown $simparam with a default instead of diagnosing the missing-fallback case
module ch09_simparam_unknown_no_fallback_rejected(p, n);
  inout p, n; electrical p, n;
  analog begin
    I(p,n) <+ $simparam("vera_no_such_simparam") + 0.0*V(p,n);
  end
endmodule
