// §9.5.5, on the "a" file type: "When a file is opened for append ... All
// output is written at the end of the file."
//
// THE CORNER IS A SEEK BEFORE THE WRITE. `$fseek(fd, 0, 0)` aims the position
// at the FIRST byte, and a tool that treats "a" as an ordinary write handle
// then overwrites that byte: "123" + "4" at position 0 is "423". The clause
// says the seek does not move the APPEND position, so the file is "1234".
// The two candidate answers differ in the first digit, and $fscanf reads the
// whole number, so the check distinguishes them without inspecting bytes.
//
// WHEN THE FILE IS WRITTEN AND READ. §9.5.9 holds a write during an iterative
// solve until the iteration is accepted, so the write sits under
// `@(initial_step)` and the read happens at the next time point, where the
// file holds "1234" whichever way a tool orders the open's truncation against
// acceptance. Same shape as 047_fscanf.va.
//
// Two failures need two assertions. If the append open or write is lost the
// read is "123" and "%d" still matches one item, so the COUNT cannot see it;
// the VALUE can. If the file is never created the scan matches nothing and the
// count is 0; the value check cannot see that. Both are asserted.
//
//! lrm 9.5.5
//! lrm 9.5.5:1002
//! time 0, 1e-3
//! checks 2
`include "check.vh"
module ch09_append_writes_at_end_of_file(p, n);
  inout p, n; electrical p, n;
  integer fd, code, value;
  analog begin
    @(initial_step) begin
      fd = $fopen("ch09_append_writes_at_end_of_file.dat", "w");
      $fwrite(fd, "123");
      $fclose(fd);
      fd = $fopen("ch09_append_writes_at_end_of_file.dat", "a");
      code = $fseek(fd, 0, 0);
      $fwrite(fd, "4");
      $fclose(fd);
    end
    if ($abstime > 0.0) begin
      fd = $fopen("ch09_append_writes_at_end_of_file.dat", "r");
      code = $fscanf(fd, "%d", value);
      $fclose(fd);
      `CHECKI("§9.5.5 the scan matched the appended number", code, 1);
      `CHECKI("§9.5.5 output went to the end, not to the seek position", value, 1234);
    end
    I(p, n) <+ V(p, n) + code + value;
  end
endmodule
