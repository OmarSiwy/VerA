// $limit and ddt() read each other at an ACCEPTED point, where the limiter has
// stopped limiting.
//
//   §9.17.3: "On any iteration where the output value is not the same as the
//   value of the access function (within appropriate tolerances), the
//   simulator is prevented from terminating the iteration." And a user
//   limiting function "shall call $discontinuity(-1) ... when its return value
//   is not sufficiently close to the value of its first argument."
//
//   §4.5.3 ddt(expr): "Returns d/dt x(t)"; "In DC analysis, ddt() returns zero".
//
// THE HAND DERIVATION. V(p,n) is driven 0, 2, 4 at t = 0, 1, 2. clamp_limit
// moves at most `step` per iteration and calls $discontinuity(-1) while it
// clamps, so Newton keeps iterating until the limited value IS V(p,n):
//
//   limited   = V(p,n) = 2t at every accepted point
//   ddt(limited) = 2 per time unit after DC (0 at the DC point)
//   ddt(V(p,n))  = 2 likewise, so `dependent` steps abs(2)/4 = 0.5 per
//                  iteration and also converges, to V(n,p) = -2t
//
// A testbench that evaluated each point once, without iterating, reads the
// first clamped iterate instead (0.5 per point); §9.17.3 forbids accepting it.
//! lrm 9.17.3
//! lrm 4.5.3
//! time 0, 1, 2
//! wave V(p) = 0, 2, 4
`include "check.vh"
module ch09_limit_with_derivative(p, n);
  inout p, n; electrical p, n;
  real limited, dependent;
  analog function real clamp_limit;
    input vnew, vold, step;
    real vnew, vold, step;
    begin
      clamp_limit = vold + max(-step, min(step, vnew-vold));
      if (abs(clamp_limit-vnew) > 1e-12) $discontinuity(-1);
    end
  endfunction
  analog begin
    limited = $limit(V(p,n), clamp_limit, 0.5);
    dependent = $limit(V(n,p), clamp_limit, abs(ddt(V(p,n)))/4.0);
    `CHECK("an accepted point's limited value is the access function's, so its derivative is the ramp's",
           ddt(limited) - (($abstime == 0.0) ? 0.0 : 2.0), 0.0, 1e-12);
    `CHECK("and a limiter stepped by that derivative converges to its access function too",
           dependent + 2.0*$abstime, 0.0, 1e-12);
    I(p,n) <+ limited;
  end
endmodule
