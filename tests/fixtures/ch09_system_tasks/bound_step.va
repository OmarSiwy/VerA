// §9.17.2 `$bound_step(expression)` bounds the next time step and returns
// nothing, so what a fixture can pin is the ARGUMENT it hands the simulator and
// the waveform that argument is sized for. This is the LRM's own example
// (§9.17.2): 0.05/freq forces twenty points per cycle.
//
//   §2.6 scale factors: `1k` is 1000, so freq defaults to 1000 Hz and the
//   step bound is 0.05/1000 = 5e-5 s = 50 us, one twentieth of the 1 ms period.
//
//   A quarter period in, at t = 250 us, the source is at its positive peak:
//   sin(2*pi*1000*250e-6) = sin(pi/2) = 1.
//
// One `//! time` entry keeps the check unconditional — with a sweep of times
// the sine would take a different value at each and no single literal would be
// right for all of them.
//
//! lrm 9.17.2
//! lrm 9.17.2:1001
//! analysis tran
//! time 250u
`include "constants.vams"
`include "check.vh"
module ch09_bound_step(p, n);
  inout p, n; electrical p, n;
  parameter real freq = 1k from (0:inf);
  analog begin
    $bound_step(0.05/freq);
    `CHECK("twenty points per cycle of a 1 kHz source is a 50 us step bound",
           0.05/freq, 5e-5, 1e-18);
    `CHECK("$abstime a quarter period in puts the source at its peak",
           sin(2.0*`M_PI*freq*$abstime), 1.0, 1e-12);
    I(p,n) <+ sin(2.0*`M_PI*freq*$abstime) + 0.0*V(p,n);
  end
endmodule
