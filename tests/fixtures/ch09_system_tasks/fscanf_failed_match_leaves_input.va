// §9.5.4.2, the sentence a scanner that pre-reads a line cannot honour:
//
//   "If conversion terminates on a conflicting input character, the OFFENDING
//    INPUT CHARACTER IS LEFT UNREAD in the input stream."
//
// together with the return rule for the same case:
//
//   "The number of successfully matched and assigned input items is returned in
//    code; this number can be 0 in the event of an early matching failure
//    between an input character and the control string."
//
// A failed scan is therefore not merely reported — it must be RECOVERABLE. The
// file position after it is unchanged, so the application can scan the same
// bytes again with a different control string, or fall back to §9.5.4.1's
// $fgets, which is what this fixture does.
//
// THE FILE. "abc\n" — four bytes, offsets 0..3.
//
// HAND DERIVATION:
//
//   scan "%d"   leading white space: none. The field would start at 'a' (offset
//               0), which is not in the set "0,1,2,3,4,5,6,7,8,9" nor a sign, so
//               the directive terminates on a conflicting character before
//               converting anything.
//               -> code 0 (an early matching failure, not EOF: the input has
//                  not ended), and the 'a' is left unread, so $ftell is 0.
//   $fgets      §9.5.4.1: "reads characters from the file ... until a newline
//               character is read AND TRANSFERRED to str", and "the number of
//               characters read is returned in code". The whole four-byte line
//               including its newline is still there.
//               -> code 4, $ftell 4.
//   scan "%s"   after the line is gone, the input ends before any conversion:
//               -> EOF (negative), which is the clause's other case and the one
//                  the 0 above is explicitly NOT.
//
// The 0-versus-EOF distinction is the point of the third claim: both are
// "unsuccessful", and an implementation that collapses them loses the only
// signal an application has for telling "wrong data here" from "no data left".
//
// THE FAILURE THIS CATCHES. A scanner that consumes a line before converting
// reports $ftell = 4 after the failed %d and then finds nothing for the $fgets,
// which reads the next line — here, end of file — instead of the one that failed.
//
//! lrm 9.5.4.2
//! lrm 9.5.4.1
//! lrm 9.5.5
//! lrm 9.5.4.1:1000
//! lrm 9.5.4.2:1002
//! print none
`include "check.vh"
module s01_fscanf_failed_match(p, n);
  inout p, n; electrical p, n;
  integer fd, code, pos, got, gets_code, gets_pos, tail;
  string line, word;
  analog begin
    fd = $fopen("s01_10_fail.dat", "w");
    $fwrite(fd, "abc\n");
    $fclose(fd);

    fd = $fopen("s01_10_fail.dat", "r");
    code = $fscanf(fd, "%d", got);
    pos = $ftell(fd);
    gets_code = $fgets(line, fd);
    gets_pos = $ftell(fd);
    tail = $fscanf(fd, "%s", word);
    $fclose(fd);

    `CHECKI("§9.5.4.2 an early matching failure returns 0, not EOF", code, 0);
    `CHECKI("§9.5.4.2 the offending character is left unread, so nothing moved", pos, 0);
    `CHECKI("§9.5.4.1 $fgets then reads the whole four-byte line, newline included", gets_code, 4);
    `CHECKI("§9.5.5 and the position is now the end of that line", gets_pos, 4);
    `CHECKI("§9.5.4.2 only NOW is the input exhausted, which is the EOF case", (tail < 0), 1);
    `CHECKI("§9.5.4.1 the line read back is the one that failed to convert", (line == "abc\n"), 1);

    I(p,n) <+ V(p,n) + code + pos + gets_code;
  end
endmodule
