// §9.20: "If any of these rules are violated then the system function shall
// return a value of zero (0). ... The discipline of the analog_net_reference
// and the resolved hierarchical node reference shall be compatible (see
// 3.11)." And a zero leaves the analog_net_reference "a normal continuous
// node declared in the module containing the system function call."
//
// §3.11.1: "Disciplines with incompatible potential natures are
// incompatible." thermal's potential is Temperature (units "K"), electrical's
// is Voltage (units "V"): different base natures, different units, so no
// §3.11.1 nature rule makes them compatible.
//
//   $analog_node_alias(t2, "b6_ad_top.m") = 0   (thermal onto electrical)
//   $analog_node_alias(n1, "b6_ad_top.m") = 1   (electrical onto electrical:
//                                                the reference itself is good)
//   V(n1) = V(m) = 2.5
//   Temp(t2) = 0                                (t2 stays local; its only
//                                                branch is 1 W/K to ground)
//
//! lrm 9.20
//! lrm 9.20:15
//! lrm 9.20:16
//! lrm 9.20:17
//! lrm 9.20:12
//! lrm 3.11.1
//! bias V(g) = 0.0
//! solve
//! checks 4
`include "disciplines.vams"
`include "check.vh"

module b6_ad_top(g);
  inout g; electrical g;
  electrical m;
  b6_ad_checker ch1();
  analog begin
    I(g) <+ 0.0;
    V(m) <+ 2.5;
  end
endmodule

module b6_ad_checker;
  thermal t2;
  electrical n1;
  integer s_bad, s_good;
  analog initial begin
    s_bad = $analog_node_alias(t2, "b6_ad_top.m");
    s_good = $analog_node_alias(n1, "b6_ad_top.m");
  end
  analog begin
    Pwr(t2) <+ Temp(t2);
    `CHECKI("§9.20 an alias across incompatible disciplines returns 0", s_bad, 0);
    `CHECKI("§9.20 the same reference from an electrical node returns 1", s_good, 1);
    `CHECKX("§9.20 the electrical alias shares m's matrix position", V(n1), 2.5);
    `CHECKX("§9.20 the refused thermal node stays local", Temp(t2), 0.0);
  end
endmodule
