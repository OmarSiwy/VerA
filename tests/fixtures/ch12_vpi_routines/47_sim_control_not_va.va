//! lrm 4.7
//! lrm A.8.2
//! reject E0512
//! reject `vpi_sim_control`
module ch12_atomic_sim_control(p, n);
  inout p, n; electrical p, n;
  analog I(p,n) <+ vpi_sim_control(0);
endmodule
