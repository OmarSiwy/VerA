//! reject E0512
//! reject vpi_get_analog_freq
// EXPECT: error
module ch12_atomic_get_analog_freq(p, n);
  inout p, n; electrical p, n;
  analog I(p,n) <+ vpi_get_analog_freq(0);
endmodule
