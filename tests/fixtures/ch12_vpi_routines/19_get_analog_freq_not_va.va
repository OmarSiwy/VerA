//! lrm 4.7
//! lrm A.8.2
//! reject E0512
//! reject `vpi_get_analog_freq`
module ch12_atomic_get_analog_freq(p, n);
  inout p, n; electrical p, n;
  analog I(p,n) <+ vpi_get_analog_freq(0);
endmodule
