//! lrm 4.7
//! lrm 12.5
//! reject E0512
//! reject `vpi_get`
module ch12_atomic_get(p, n);
  inout p, n; electrical p, n;
  analog I(p,n) <+ vpi_get(0);
endmodule
