//! reject E0512
//! reject vpi_get
// EXPECT: error
module ch12_atomic_get(p, n);
  inout p, n; electrical p, n;
  analog I(p,n) <+ vpi_get(0);
endmodule
