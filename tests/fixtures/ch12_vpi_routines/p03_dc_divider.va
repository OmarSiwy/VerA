// The DC circuit the value-format and query fixtures read.
//
// One ideal 1.25 V source across one 500 ohm resistor. Ohm's law, which is all
// this has to be:
//
//     V(a, gnd) = 1.25 V                   exactly
//     I through r1 = 1.25 / 500 = 2.5e-3 A exactly
//
// 1.25 and 2.5e-3 are both exactly representable in binary64 (1.25 = 5*2^-2;
// 2.5e-3 is not, but is the correctly-rounded quotient of two exact operands,
// so an ideal solver reproduces it to the last bit). That is why these numbers
// and not 1/3: fixture 08 asserts the %e and %g SPELLINGS of the value, and a
// value whose decimal expansion depends on the solver's rounding could not be
// spelled in a fixture at all.
//
// Used by: 01 (as a transient, for the t=0 queries), 08, 91.
//
// WHAT THIS FILE ASSERTS ON ITS OWN. Exactly the two numbers above, and it
// asserts them by SOLVING — `//! solve` unties every unknown the harness would
// otherwise tie to the reference, so nothing here is pinned by hand and both
// wants are the clause's arithmetic:
//
//   §3.6 "the values of the associated node are determined by the
//   simultaneous solution of equations defined by the instances connected to
//   the node using Kirchhoff's conservation laws" — so the deck has ONE
//   solution and it is the one the header derives.
//
// `CHECKX` and not `CHECK` at both sites, for the reason the header already
// gives: 1.25 and 2.5e-3 are the exact binary64 values an ideal solver lands
// on, and fixture 08 goes on to assert their printed spellings. A tolerance
// here would let a solution that is merely close through, and then 08's %e
// column would be a different string.
//
// VerA DOES NOT SOLVE THIS DECK TODAY, and the `//! xfail` records why. When a
// module instance contributes a POTENTIAL to a node pair and another instance
// contributes a FLOW to the same pair, VerA keeps only the last one elaborated
// and silently drops the other: here `v1`'s branch equation V(a,gnd) − 1.25 = 0
// never reaches the residual at all — the flow unknown is declared and never
// written — so the deck solves to x = 0 and both checks read 0. Reversing the
// two instantiations reverses which one survives, which is what makes it a
// merge and not a missing feature. §5.4.2.2 is the sentence it contradicts: "A
// branch, either named or unnamed, is a source branch if either the potential
// or the flow of that branch is assigned a value by a contribution statement
// ... anywhere in the MODULE." A branch belongs to a module instance, so `v1`
// and `r1` own two different branches between a and gnd and neither can turn
// the other into a switch branch.
//
//! lrm 3.6
//! lrm 5.4.2.2
//! solve
//! xfail a potential contribution in one instance and a flow contribution in another, between the same two nodes, collide: VerA keeps only the last one elaborated, so v1's branch equation is dropped and the deck solves to zero
`include "check.vh"

module p03_vsrc(p, n);
    inout p, n;
    electrical p, n;
    parameter real dc = 1.25;
    analog begin
        `CHECKX("the ideal source holds its terminals 1.25 V apart", V(p, n), 1.25);
        V(p, n) <+ dc;
    end
endmodule

module p03_res500(p, n);
    inout p, n;
    electrical p, n;
    parameter real r = 500.0 from (0:inf);
    analog begin
        `CHECKX("and Ohm's law puts exactly 2.5 mA through the 500 ohm leg",
            V(p, n) / r, 2.5e-3);
        I(p, n) <+ V(p, n) / r;
    end
endmodule

module p03_dc_divider;
    electrical a, gnd;
    ground gnd;
    p03_vsrc   #(.dc(1.25))  v1(.p(a), .n(gnd));
    p03_res500 #(.r(500.0))  r1(.p(a), .n(gnd));
endmodule
