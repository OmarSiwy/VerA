//! lrm 4.7
//! lrm 12.26
//! reject E0512
//! reject `vpi_mcd_open`
module ch12_atomic_mcd_open(p, n);
  inout p, n; electrical p, n;
  analog I(p,n) <+ vpi_mcd_open(0);
endmodule
