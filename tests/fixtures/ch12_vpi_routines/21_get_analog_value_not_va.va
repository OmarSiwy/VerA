// Source-review evidence boundary: retained HDL test does not execute the VPI
// contract. Chapter12 behavioral obligations are tracked in COVERAGE.md.
//! lrm 4.7
//! reject E0512
//! reject `vpi_get_analog_value`
module ch12_atomic_get_analog_value(p, n);
  inout p, n; electrical p, n;
  analog I(p,n) <+ vpi_get_analog_value(0);
endmodule
