//! lrm 4.7
//! lrm 12.14
//! reject E0512
//! reject `vpi_get_systf_info`
module ch12_atomic_get_systf_info(p, n);
  inout p, n; electrical p, n;
  analog I(p,n) <+ vpi_get_systf_info(0);
endmodule
