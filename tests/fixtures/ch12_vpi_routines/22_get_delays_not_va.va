//! reject E0512
//! reject vpi_get_delays
// EXPECT: error
module ch12_atomic_get_delays(p, n);
  inout p, n; electrical p, n;
  analog I(p,n) <+ vpi_get_delays(0);
endmodule
