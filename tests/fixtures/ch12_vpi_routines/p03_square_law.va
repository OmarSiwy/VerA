// The design p03_94_function_partials.c runs: a 3 A source into node q, and a
// branch whose current is a user-defined analog system FUNCTION of V(q):
//
//     I(q, gnd) <+ $p03_sq(V(q, gnd), 1.0);
//
// With the application's $p03_sq(x, k) = k * x^2, KCL at q is x^2 = 3, so the
// solution is V(q) = sqrt(3). That value is reachable ONLY through the
// function's declared partial (§12.32.2): Newton's column for q is d/dx of the
// function, which the device learns from the derivative calltf puts (§12.22.1)
// and from nowhere else. A host that drops it has a zero column and cannot
// move off the initial guess. `electrical q = 1.0` is §3.6.3.2's nodeset — the
// guess — because at x = 0 the derivative 2x is itself 0.
//
// WHAT THIS FILE ASSERTS ON ITS OWN is only what holds with no application
// linked (01_analog_systf_resistor_call.va gives the reason): the block runs
// straight through the call (§5.3.1). No unknown is solved here — without
// `//! solve` the testbench evaluates at its own point and solves nothing, so
// the host-less zero answer cannot make it fail to converge.
//
//! lrm 5.3.1
`include "check.vh"

module p03_square_law;
    electrical gnd;
    electrical q = 1.0;
    ground gnd;
    integer seq;
    analog begin
        seq = 1;
        I(gnd, q) <+ 3.0;
        I(q, gnd) <+ $p03_sq(V(q, gnd), 1.0);
        seq = seq + 2;
        `CHECKI("the block runs straight through the analog function call", seq, 3);
    end
endmodule
