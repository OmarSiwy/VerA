// The second design p03_15_two_libraries_two_instances.c runs (VerA #84): a
// twin of p03_env_probe.va, statement for statement, with its own module and
// system function names (`$p03_twin`). Being a twin, its call object has the
// same object index and source token as `$p03_env`'s, so only the binding
// each library is attached through tells the two apart.
//
// No `//!` directive, so the suite does not collect it (tests/harness.zig
// `fixtureExt`): every number is asserted from C.
`include "check.vh"

module p03_env_twin;
    electrical a, b, gnd;
    ground gnd;
    real e;
    integer seq;
    analog begin
        seq = 1;
        e = $p03_twin(V(a, gnd));
        seq = seq + 2;
        V(a, gnd) <+ 2.0;
        V(b, gnd) <+ e;
        `CHECKX("the ideal source holds a at 2 V", V(a, gnd), 2.0);
        `CHECKI("the block runs straight through the analog function call", seq, 3);
    end
endmodule
