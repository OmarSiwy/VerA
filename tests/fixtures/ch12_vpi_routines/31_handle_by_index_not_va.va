//! reject E0512
//! reject vpi_handle_by_index
// EXPECT: error
module ch12_atomic_handle_by_index(p, n);
  inout p, n; electrical p, n;
  analog I(p,n) <+ vpi_handle_by_index(0);
endmodule
