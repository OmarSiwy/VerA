//! reject E0512
//! reject vpi_compare_objects
// EXPECT: error
module ch12_atomic_compare_objects(p, n);
  inout p, n; electrical p, n;
  analog I(p,n) <+ vpi_compare_objects(0);
endmodule
