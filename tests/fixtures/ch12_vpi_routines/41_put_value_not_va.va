//! lrm 4.7
//! lrm 12.30
//! reject E0512
//! reject `vpi_put_value`
module ch12_atomic_put_value(p, n);
  inout p, n; electrical p, n;
  analog I(p,n) <+ vpi_put_value(0);
endmodule
