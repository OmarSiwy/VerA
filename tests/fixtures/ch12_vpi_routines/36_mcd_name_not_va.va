//! lrm 4.7
//! lrm A.8.2
//! reject E0512
//! reject `vpi_mcd_name`
module ch12_atomic_mcd_name(p, n);
  inout p, n; electrical p, n;
  analog I(p,n) <+ vpi_mcd_name(0);
endmodule
