// VAMS-12.22.2  (ch12-vpi-routines.html) — the LRM's own $resistor() example.
//
// `$resistor(curr, V(p,n), r)` is a USER-DEFINED analog system task: it exists
// only because a C application registered it with vpi_register_analog_systf()
// and supplied resistor_compiletf()/resistor_calltf(), which is where
// `curr = V(p,n)/r` and its d(curr)/d(V) = 1/r derivative live. §12.22.2 gives
// the C for both.
//
// A compiler alone therefore has no definition of `$resistor` — and §2.8.3 says
// that is fine: `$` "introduces a language construct which enables development
// of user-defined system tasks and functions", and such constructs "are not
// design semantics, but refer to simulator functionality". An unregistered
// `$name` is grammatical source; §12.32 gives the application a compiletf
// routine so that IT, not the compiler, decides what an unknown systf means.
// Annex C.13/C.14 keep Clauses 11-12 in the Verilog-A subset as a C interface,
// which is not a rule about `.va` text. An earlier revision of this fixture
// demanded a rejection here, by analogy with the expression-position spelling
// in 02 — but that refusal is codegen declining to invent a VALUE for a
// contribution (invariant 5), and a statement has no value to invent.
//
// With no application linked, resistor_calltf() never runs, and exactly two
// things are observable from source. Both are §12.22.2 facts, not §2.6.1 ones:
//
//   - the analog block runs STRAIGHT THROUGH the call (§5.3.1 sequencing over
//     the §12.22.2 call form), so `seq` reaches 1+2 = 3;
//   - the output argument is the calltf's to write, and no calltf ran, so
//     `current` still holds the 0.0 it was initialized with.
//
// An earlier revision asserted only `r == 1000.0`, which is the chapter-2 SI
// scale-factor rule and is already pinned at ch02_lexical/07_si_scale_factors.va.
// That assertion has the same verdict with or without a VPI host, so it left
// this fixture unasserted about the construct it names.
//
//! lrm 12.22.2
`include "check.vh"
module ch12_analog_systf_resistor_call(p, n);
  inout p, n; electrical p, n;
  parameter real r = 1k;
  real current;
  integer seq;
  analog begin
    current = 0.0;
    seq = 1;
    $resistor(current, V(p,n), r);
    seq = seq + 2;
    `CHECKI("the block continues past an unregistered analog system task", seq, 3);
    `CHECKX("no calltf ran, so the output argument is untouched", current, 0.0);
    I(p,n) <+ current;
  end
endmodule
