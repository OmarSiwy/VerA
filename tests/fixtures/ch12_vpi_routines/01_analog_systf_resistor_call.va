// VAMS-12.22.2  (ch12-vpi-routines.html) — the LRM's own $resistor() example.
//
// `$resistor(curr, V(p,n), r)` is a USER-DEFINED analog system task: it exists
// only because a C application registered it with vpi_register_analog_systf()
// and supplied resistor_compiletf()/resistor_calltf(), which is where
// `curr = V(p,n)/r` and its d(curr)/d(V) = 1/r derivative live. §12.22.2 gives
// the C for both.
//
// A compiler alone therefore has no definition of `$resistor` — and §2.8.3 says
// that is fine: `$` "introduces a language construct which enables development
// of user-defined system tasks and functions", and such constructs "are not
// design semantics, but refer to simulator functionality". An unregistered
// `$name` is grammatical source; §12.32 gives the application a compiletf
// routine so that IT, not the compiler, decides what an unknown systf means.
// Annex C.13/C.14 keep Clauses 11-12 in the Verilog-A subset as a C interface,
// which is not a rule about `.va` text. An earlier revision of this fixture
// demanded a rejection here, by analogy with the expression-position spelling
// in 02 — but that refusal is codegen declining to invent a VALUE for a
// contribution (invariant 5), and a statement has no value to invent.
//
// With no application linked there is nothing for the call to do, so the only
// quantity this module fixes is `r`: `1k` is the §2.6.1 scale factor k = 10^3,
// on the parameter the call takes as its third argument. What $resistor
// computes is the application's business and the suite cannot assert it.
//
`include "check.vh"
module ch12_analog_systf_resistor_call(p, n);
  inout p, n; electrical p, n;
  parameter real r = 1k;
  real current;
  analog begin
    $resistor(current, V(p,n), r);
    `CHECKX("1k scale factor on the systf argument", r, 1000.0);
    I(p,n) <+ current;
  end
endmodule
