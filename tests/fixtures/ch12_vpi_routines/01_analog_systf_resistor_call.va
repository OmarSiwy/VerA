// Source-review evidence boundary: retained HDL test does not execute the VPI
// contract. Chapter 12's behaviour is exercised by the `.c` fixtures in build.zig's `vpi_runs`.
// VAMS-12.22.2  (ch12-vpi-routines.html) — the LRM's own $resistor() example.
//
// `$resistor(curr, V(p,n), r)` is a USER-DEFINED analog system task: it exists
// only because a C application registered it with vpi_register_analog_systf()
// and supplied resistor_compiletf()/resistor_calltf(), which is where
// `curr = V(p,n)/r` and its d(curr)/d(V) = 1/r derivative live. §12.22.2 gives
// the C for both.
//
// A compiler alone therefore has no definition of `$resistor` — and §2.8.3 says
// that is fine: `$` "introduces a language construct which enables development
// of user-defined system tasks and functions", and such constructs "are not
// design semantics, but refer to simulator functionality". An unregistered
// `$name` is grammatical source; §12.32 gives the application a compiletf
// routine so that IT, not the compiler, decides what an unknown systf means.
// Annex C.13/C.14 keep Clauses 11-12 in the Verilog-A subset as a C interface,
// which is not a rule about `.va` text. An earlier revision of this fixture
// demanded a rejection here, by analogy with the expression-position spelling
// in 02 — but that refusal is codegen declining to invent a VALUE for a
// contribution (invariant 5), and a statement has no value to invent.
//
// Exactly ONE thing is observable from the source, and it is observable whether
// or not an application is linked: the analog block runs STRAIGHT THROUGH the
// call — §5.3.1 sequences the enclosing sequential block over the §12.22.2 call
// form — so `seq` reaches 1+2 = 3. A compiler that stopped at, reordered around
// or swallowed the block tail at an unrecognized system task leaves 1 or 0.
// Same assertion, same reasoning as ch11_vpi/05_system_task_call_object.va.
//
// Two assertions were tried here and are deliberately NOT present:
//
//   - `r == 1000.0` is the chapter-2 SI scale-factor rule, already pinned at
//     ch02_lexical/07_si_scale_factors.va, and says nothing about §12.22.2;
//   - `current == 0.0` after the call. §12.22.2's resistor_calltf() computes
//     curr = V(p,n)/r, which at this operating point (no `//! bias`, so every
//     unknown is zero) is ALSO 0.0. The want coincides with the host-present
//     value, so the assertion cannot discriminate the hypothesis it names; and
//     no clause says an unregistered systf leaves its output argument alone, so
//     at any nonzero bias a host-linked conforming tool would fail it. The
//     output argument is out of reach from source. Leave it out.
//
//! lrm 5.3.1
`include "check.vh"
module ch12_analog_systf_resistor_call(p, n);
  inout p, n; electrical p, n;
  parameter real r = 1k;
  real current;
  integer seq;
  analog begin
    current = 0.0;
    seq = 1;
    $resistor(current, V(p,n), r);
    seq = seq + 2;
    `CHECKI("the block continues past an unregistered analog system task", seq, 3);
    I(p,n) <+ current;
  end
endmodule
