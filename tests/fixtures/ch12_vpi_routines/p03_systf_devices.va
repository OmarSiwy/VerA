// The two devices whose Jacobian entries come from a C plugin's derivtf, not
// from this compiler.
//
// p03_resistor_systf is VAMS-2023 12.22.2's OWN $resistor() example module:
//
//     module resistor(p, n);
//       electrical p, n;
//       parameter real r = 1k;
//       real curr;
//       analog begin
//         $resistor(curr, V(p, n), r);
//         I(p, n) <+ curr;
//       end
//     endmodule
//
// with the port directions the clause's fragment omits. 12.22.2's own
// resistor_calltf() computes g = 1/r, writes it to the derivative object
// obtained from vpi_handle_multi(vpiDerivative, i_handle, v_handle), and writes
// curr = V*g to the output argument. Driven by a 1 V source with r = 1 kohm:
//
//     V(a, gnd) = 1        exactly (ideal source)
//     curr      = 1/1000   = 1e-3 A exactly
//     d(curr)/dV = 1e-3    exactly
//
// p03_cube_systf is NOT from the LRM, and it is here for one reason: the
// $resistor above CANNOT distinguish a host that propagated the declared
// partial derivative from one that dropped it. A linear element's residual is
// solved by any Newton step of the right sign, and a zero Jacobian entry on a
// branch that is also driven by an ideal source still lands on the right answer.
// So $cube supplies a strictly nonlinear law with an exact root:
//
//     icube = (V + 1)^3 - 1,     d(icube)/dV = 3*(V + 1)^2
//
// driven by a 7 A injection, so KCL at q is (V+1)^3 - 1 = 7, i.e. (V+1)^3 = 8:
//
//     V(q, gnd)        = 1.0   exactly
//     d(icube)/dV at the solution = 3 * (1+1)^2 = 12.0 exactly
//
// (V+1)^3 rather than V^3 because d(V^3)/dV is 0 at the V = 0 cold start, which
// makes the first Newton step singular for reasons that have nothing to do with
// VPI. At V = 0 this law's derivative is 3, and Newton on u^3 = 8 from u = 1
// runs 1 -> 3.333 -> 2.462 -> 2.081 -> 2.0031 -> 2.0000073 -> 2, monotone. A
// host that ignores the plugin's partial gets a zero column and cannot converge
// at all, which is exactly the failure fixture 07 exists to catch.
//
// Used by: 07, 90.
//
// WHAT THIS FILE ASSERTS ON ITS OWN. Not the systf results — $resistor and
// $cube exist only once a C application has registered them (VAMS-2023 12.22),
// so with no plugin linked `curr` and `icube` keep their initial values and a
// CHECK on either would be pinning what happens when nothing happens. What
// this file owns is the ORACLE fixture 07 holds the plugin to, and every
// number in it is arithmetic over the operating point the header derives:
//
//   `//! bias` pins that operating point — V(a,gnd) = 1 V from the ideal
//   source, V(q,gnd) = 1 V from the 7 A injection — rather than solving for
//   it, for two independent reasons. The cube law lives in the plugin, so
//   without one the q row carries the bare −7 A injection and no solution
//   exists at all; and VerA cannot solve the `a` row either (see below). The
//   values pinned are not a measurement — they are the header's own hand
//   derivation: 1 V from the ideal source, and 1 V at q because (V+1)^3 = 8.
//
//   g = 1/r = 1e-3 S exactly at r = 1 kohm — the value 12.22.2's own
//   resistor_calltf() writes to the derivative object — and curr = V*g =
//   1e-3 A at the 1 V point. Both are exactly representable, hence `CHECKX`.
//
//   The cube law at its root: (1+1)^3 − 1 = 7 balances the 7 A injection
//   exactly, and its partial there is 3*(1+1)^2 = 12. These are the two
//   numbers fixture 07 compares the plugin's derivtf against, and writing them
//   here as functions of the pinned V(q,gnd) is what makes them a check on the
//   operating point rather than two literals talking to themselves: a q node
//   pinned anywhere else fails both.
//
// WHAT VerA CANNOT DO WITH THIS DECK, recorded here because it is why the bias
// is pinned and not solved: when a module instance contributes a POTENTIAL to a
// node pair and another instance contributes a FLOW to the same pair — v1 and
// r1 on (a, gnd) here — VerA keeps only the last one elaborated and silently
// drops the other, so v1's branch equation V(a,gnd) − 1 = 0 never reaches the
// residual. §5.4.2.2: "A branch, either named or unnamed, is a source branch if
// either the potential or the flow of that branch is assigned a value by a
// contribution statement ... anywhere in the MODULE." A branch belongs to a
// module instance, so v1 and r1 own two different branches between a and gnd
// and neither can turn the other into a switch branch. p03_dc_divider.va
// carries the `//! xfail` for it.

//! lrm 12.22.2
//! lrm 5.4.2.2
//! bias V(a) = 1.0
//! bias V(q) = 1.0
//! bias V(gnd) = 0.0
`include "check.vh"
module p03_vsrc1(p, n);
    inout p, n;
    electrical p, n;
    parameter real dc = 1.0;
    analog
        V(p, n) <+ dc;
endmodule

module p03_isrc7(p, n);
    inout p, n;
    electrical p, n;
    parameter real dc = 7.0;
    // I(p,n) is positive out of p through the branch, so wiring this (gnd, q)
    // injects +7 A into q.
    analog
        I(p, n) <+ dc;
endmodule

module p03_resistor_systf(p, n);
    inout p, n;
    electrical p, n;
    parameter real r = 1000.0 from (0:inf);
    real curr;
    analog begin
        `CHECKX("the conductance 12.22.2's resistor_calltf writes to the derivative object",
            1.0 / r, 0.001);
        `CHECKX("and the current it writes to the output argument at the 1 V point",
            V(p, n) / r, 0.001);
        $resistor(curr, V(p, n), r);
        I(p, n) <+ curr;
    end
endmodule

module p03_cube_systf(p, n);
    inout p, n;
    electrical p, n;
    real icube;
    analog begin
        `CHECKX("the cube law is balanced by the 7 A injection at exactly 1 V",
            pow(V(p, n) + 1.0, 3.0) - 1.0, 7.0);
        `CHECKX("and the partial the plugin's derivtf must report there is 12 S",
            3.0 * pow(V(p, n) + 1.0, 2.0), 12.0);
        $cube(icube, V(p, n));
        I(p, n) <+ icube;
    end
endmodule

module p03_systf_devices;
    electrical a, q, gnd;
    ground gnd;
    p03_vsrc1          #(.dc(1.0))    v1(.p(a), .n(gnd));
    p03_resistor_systf #(.r(1000.0))  r1(.p(a), .n(gnd));
    p03_isrc7          #(.dc(7.0))    i1(.p(gnd), .n(q));
    p03_cube_systf                    c1(.p(q), .n(gnd));
endmodule
