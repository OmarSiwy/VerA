// The design p03_93_get_real_in_calltf.c runs: one user-defined analog system
// FUNCTION, `$p03_env`, whose value drives node b, beside an ideal 2 V source
// on node a.
//
// WHAT THIS FILE ASSERTS ON ITS OWN is what holds with or without an
// application registering `$p03_env` (see 01_analog_systf_resistor_call.va for
// why a host-less compile may assert nothing about the function's value, §2.8.3
// and §12.32): the source holds a at exactly 2 V, and the analog block runs
// straight through the call (§5.3.1), so `seq` reaches 1 + 2 = 3. V(b) is the
// function's value — whatever a host returns — and is asserted only by the C
// application, which knows what its calltf put (§12.30 onto the call).
//
//! lrm 5.3.1
//! solve
//! time 0
`include "check.vh"

module p03_env_probe;
    electrical a, b, gnd;
    ground gnd;
    real e;
    integer seq;
    analog begin
        seq = 1;
        e = $p03_env(V(a, gnd));
        seq = seq + 2;
        V(a, gnd) <+ 2.0;
        V(b, gnd) <+ e;
        `CHECKX("the ideal source holds a at 2 V", V(a, gnd), 2.0);
        `CHECKI("the block runs straight through the analog function call", seq, 3);
    end
endmodule
