//! reject E0512
//! reject vpi_register_analog_systf
// EXPECT: error
module ch12_register_systf_not_va(p, n);
  inout p, n; electrical p, n;
  analog I(p,n) <+ vpi_register_analog_systf(0);
endmodule
