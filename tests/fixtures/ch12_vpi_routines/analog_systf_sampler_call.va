// Source-review evidence boundary: retained HDL test does not execute the VPI
// contract. Chapter 12's behaviour is exercised by the `.c` fixtures in build.zig's `vpi_runs`.
// VAMS-12.32.3  (ch12-vpi-routines.html) — the LRM's own sampnhold example,
// verbatim except for the port directions Annex A.2.1.2 requires and the
// assertion below.
//
// §12.32.3 prints this module as the illustration of vpi_register_analog_systf():
//
//   module sampnhold(out, in);
//      electrical out, in;
//      parameter real period = 1e-3;
//      analog begin
//        V(out) <+ $sampler(V(in), period);
//      end
//   endmodule
//
// So an unregistered analog system FUNCTION in expression position is legal
// source text. §2.8.3 makes `$name` grammatical and lists "defined using the
// VPI as described in Clause 11 and Clause 12" as one of its definition sites;
// §12.32 hands the application a compiletf routine so that IT, not the
// compiler, decides what an unknown systf means. (§12.31.4's cbUnresolvedSystf
// is NOT a normative disposition to cite here: that clause lists it under
// "Examples of possible feature related callbacks", and says features "might
// not exist in all VPI-compliant products", unlike actions which "shall occur
// in all VPI-compliant products".) No clause makes the source an error, so this
// is a RUN fixture and not a `//! reject` one — an earlier revision demanded a
// diagnostic here, which inverted the test: a conforming compiler failed it and
// only VerA passed.
//
// The only number §12.32.3 fixes without a linked host is the parameter.
// `1e-3` and `0.001` are the same binary64 value (0x3F50624DD2F1A9FC) — not
// exactly one one-thousandth, but bit-identical to each other, which is what
// CHECKX needs.
//
// What $sampler() RETURNS cannot be written down, and not merely because no
// host is linked: §12.32.3's own listing never initializes sampler->value
// before the first sampler_update_cb() fires at t = period, and sampler_calltf()
// hands that uninitialized field straight back through vpi_put_value(). So the
// LRM fixes no digits for V(out) at the DC point this fixture solves, and any
// want written for it would be invented. That is the limit of this fixture, and
// the reason the assertion below is a parameter default: what it proves is that
// the §12.32.3 source form is ACCEPTED, nothing about the value. Sample-and-hold
// BEHAVIOUR needs a fixture with a registered host, which this suite has no form
// for.
//
// VerA's answer, for the record: the contribution reads 0.0 and every call site
// gets a W0852 naming the name. That is deliberately not the silent zero the
// compiler refuses elsewhere — where the LRM fixes a number a substitute would
// contradict it, and here it fixes none (see the paragraph above), so the only
// thing to report is the absent host. `--deny=W0852` turns it back into a
// refusal for a build that must have one. The two `//! warn` lines pin both
// halves: the code, and that it names the name.
//
//! warn W0852
//! warn `$sampler`
`include "check.vh"
module ch12_analog_systf_sampler_call(out, in);
  inout out, in; electrical out, in;
  parameter real period = 1e-3;
  analog begin
    V(out) <+ $sampler(V(in), period);
    `CHECKX("12.32.3 sampler period", period, 0.001);
  end
endmodule
