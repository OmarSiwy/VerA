//! lrm 4.7
//! lrm 12.19
//! reject E0512
//! reject `vpi_handle`
module ch12_atomic_handle(p, n);
  inout p, n; electrical p, n;
  analog I(p,n) <+ vpi_handle(0);
endmodule
