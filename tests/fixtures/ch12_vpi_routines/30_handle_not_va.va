//! reject E0512
//! reject vpi_handle
// EXPECT: error
module ch12_atomic_handle(p, n);
  inout p, n; electrical p, n;
  analog I(p,n) <+ vpi_handle(0);
endmodule
