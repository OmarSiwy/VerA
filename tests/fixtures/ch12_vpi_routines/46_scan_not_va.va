//! lrm 4.7
//! lrm A.8.2
//! reject E0512
//! reject `vpi_scan`
module ch12_atomic_scan(p, n);
  inout p, n; electrical p, n;
  analog I(p,n) <+ vpi_scan(0);
endmodule
