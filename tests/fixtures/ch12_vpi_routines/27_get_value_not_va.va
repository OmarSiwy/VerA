//! lrm 4.7
//! lrm 12.16
//! reject E0512
//! reject `vpi_get_value`
module ch12_atomic_get_value(p, n);
  inout p, n; electrical p, n;
  analog I(p,n) <+ vpi_get_value(0);
endmodule
