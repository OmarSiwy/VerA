//! lrm 4.7
//! lrm 12.28
//! reject E0512
//! reject `vpi_printf`
module ch12_atomic_printf(p, n);
  inout p, n; electrical p, n;
  analog I(p,n) <+ vpi_printf(0);
endmodule
