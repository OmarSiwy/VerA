//! lrm 4.7
//! lrm 12.24
//! reject E0512
//! reject `vpi_mcd_close`
module ch12_atomic_mcd_close(p, n);
  inout p, n; electrical p, n;
  analog I(p,n) <+ vpi_mcd_close(0);
endmodule
