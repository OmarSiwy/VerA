//! lrm 4.7
//! lrm A.8.2
//! reject E0512
//! reject `vpi_get_str`
module ch12_atomic_get_str(p, n);
  inout p, n; electrical p, n;
  analog I(p,n) <+ vpi_get_str(0);
endmodule
