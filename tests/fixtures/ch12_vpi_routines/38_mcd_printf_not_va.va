// Source-review evidence boundary: retained HDL test does not execute the VPI
// contract. Chapter12 behavioral obligations are tracked in COVERAGE.md.
//! lrm 4.7
//! reject E0512
//! reject `vpi_mcd_printf`
module ch12_atomic_mcd_printf(p, n);
  inout p, n; electrical p, n;
  analog I(p,n) <+ vpi_mcd_printf(0);
endmodule
