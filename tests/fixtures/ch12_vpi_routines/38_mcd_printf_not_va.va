//! lrm 4.7
//! lrm 12.27
//! reject E0512
//! reject `vpi_mcd_printf`
module ch12_atomic_mcd_printf(p, n);
  inout p, n; electrical p, n;
  analog I(p,n) <+ vpi_mcd_printf(0);
endmodule
