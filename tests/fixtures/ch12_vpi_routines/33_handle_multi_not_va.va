//! reject E0512
//! reject vpi_handle_multi
// EXPECT: error
module ch12_atomic_handle_multi(p, n);
  inout p, n; electrical p, n;
  analog I(p,n) <+ vpi_handle_multi(0);
endmodule
