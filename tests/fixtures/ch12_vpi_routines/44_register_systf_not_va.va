//! lrm 4.7
//! lrm A.8.2
//! reject E0512
//! reject `vpi_register_systf`
module ch12_atomic_register_systf(p, n);
  inout p, n; electrical p, n;
  analog I(p,n) <+ vpi_register_systf(0);
endmodule
