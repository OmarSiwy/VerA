// Source-review evidence boundary: retained HDL test does not execute the VPI
// contract. Chapter 12's behaviour is exercised by the `.c` fixtures in build.zig's `vpi_runs`.
// VAMS-12.32  (ch12-vpi-routines.html) — uniqueness is a property of the
// REGISTRATION, not of the call sites.
//
// §12.32: "The task or function name shall be unique in the domain in which it
// is registered. That is, the same name can be shared by two sets of callbacks,
// provided that one set is registered in the digital domain and the other is
// registered in the analog." Read precisely, that constrains the REGISTRATION —
// vpi_register_analog_systf() — and says nothing about how many times the name
// may appear in source. It is cited to rule out the misreading, not as the rule
// under test.
//
// The rule under test is §12.33.1, which §12.32 imports wholesale for the
// analog domain ("The usage of the compiletf, sizetf, and calltf routines for
// the analog system task/function are identical to those of digital system
// task/functions registered with vpi_register_systf()"): "Callbacks to the
// application pointed to by the calltf routine shall occur each time the system
// task or function is invoked during simulation execution." *Each time* has
// content only if one registered name can be invoked more than once, so a
// second occurrence of a `$name` is a second INVOCATION, never a redefinition.
// §5.3.1 then sequences both invocations in the order written.
//
// The compiler-side failure this catches: interning `$name` on first sight and
// diagnosing the second occurrence, or binding both call sites to one entity.
// Every other fixture in ch11/ch12 calls its `$name` exactly once, so nothing
// else discriminates.
//
// Statement position (an analog system TASK, §12.22.2's call form), because
// expression position needs a VALUE and with no host there is none — see 02.
// The want is the sum of the three distinct powers of two the block adds,
// 1 + 2 + 4 = 7: it is reachable only if BOTH calls are accepted and neither
// aborts the block.
//
//! lrm 5.3.1
`include "check.vh"
module ch12_systf_name_repeated_call_sites(p, n);
  inout p, n; electrical p, n;
  integer seq;
  real cur;
  analog begin
    cur = 0.0;
    seq = 1;
    $fixture_vpi_task(cur, V(p,n), 1.0);
    seq = seq + 2;
    $fixture_vpi_task(cur, V(p,n), 2.0);
    seq = seq + 4;
    `CHECKI("repeated call sites of one system task name are not a redefinition", seq, 7);
    I(p,n) <+ 0.0;
  end
endmodule
