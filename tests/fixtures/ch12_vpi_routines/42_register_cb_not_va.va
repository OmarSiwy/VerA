//! lrm 4.7
//! lrm 12.31
//! reject E0512
//! reject `vpi_register_cb`
module ch12_atomic_register_cb(p, n);
  inout p, n; electrical p, n;
  analog I(p,n) <+ vpi_register_cb(0);
endmodule
