//! reject E0512
//! reject vpi_chk_error
// EXPECT: error
module ch12_chk_error_not_va(p, n);
  inout p, n; electrical p, n;
  analog I(p,n) <+ vpi_chk_error(0);
endmodule
