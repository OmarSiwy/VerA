//! lrm 4.7
//! lrm A.8.2
//! reject E0512
//! reject `vpi_chk_error`
module ch12_chk_error_not_va(p, n);
  inout p, n; electrical p, n;
  analog I(p,n) <+ vpi_chk_error(0);
endmodule
