//! lrm 4.7
//! lrm 12.2
//! reject E0512
//! reject `vpi_chk_error`
module ch12_atomic_chk_error(p, n);
  inout p, n; electrical p, n;
  analog I(p,n) <+ vpi_chk_error(0);
endmodule
