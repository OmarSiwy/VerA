`include "constants.vams"
// The small-signal circuit fixture 09 reads vpi_get_analog_freq() and the
// IMAGINARY half of Figure 12-3's s_vpi_analog_value against.
//
// 1 A of AC stimulus injected into node `a`, loaded by 1 kohm in parallel with
// C. The admittance at node a is
//
//     Y(w) = 1/R + jwC
//
// and C is chosen so that the susceptance equals the conductance at exactly
// 1 kHz:  C = 1e-3 / (2*pi*1e3), so at f = 1 kHz, wC = 2*pi*1e3*C = 1e-3 = 1/R.
//
//     Y = 1e-3 * (1 + j)
//     V(a) = 1 / Y = 1000 / (1 + j) = 1000 * (1 - j) / 2 = 500 - 500j
//
// So at f = 1 kHz the fixture's expected value is exactly
//
//     real part      = +500.0 V
//     imaginary part = -500.0 V
//
// and both are exactly representable, which is the point of picking the
// 45-degree point rather than a decade corner.
//
// The DC operating point of this deck is identically zero: ac_stim contributes
// nothing to the large-signal solution (VAMS-2023 4.5.11), the source has no DC
// term, and every element is linear. VAMS-2023 12.8 then fixes
// vpi_get_analog_freq() == 0 at that DC solution, which is the other half of
// fixture 09.
//
// Used by: 09, 10.
//
// WHAT THIS FILE ASSERTS ON ITS OWN. Fixture 09 owns the complex number — the
// real and imaginary halves of Figure 12-3's s_vpi_analog_value are a
// small-signal result and nothing inside an analog block can read one. What is
// assertable here is the three things that number is MADE of, and they are the
// three ways it could silently come out wrong:
//
//   §4.6.1, on the small-signal source functions: "The small-signal source
//   functions only affect the behavior of a module during small-signal
//   analyses. ... When not active, the small-signal source functions return
//   zero (0)." So in this dc solve `ac_stim` is exactly 0.0, and with it the
//   whole large-signal solution: V(a,gnd) = 0 V, which is the other half of
//   fixture 09 (§12.8 fixes vpi_get_analog_freq() == 0 at that solution).
//   `//! solve` leaves the node free, so that zero is solved for, not pinned.
//
//   THE 45-DEGREE SIZING, which is why the expected value is a round 500-500j
//   and not a decade corner: C is declared as 1e-3/(2*pi*1e3), so
//
//       2*pi*1e3*C == 1.0e-3 == 1/R      exactly
//
//   The equality is exact in binary64 and not merely close — the division and
//   the multiplication are by the same correctly-rounded operand, so the
//   round trip returns the literal 1e-3 bit for bit, and `CHECKX` says so.
//   Fixture 09 asserts the SPELLING of 500.0 and -500.0, and a susceptance a
//   few ulp off the conductance would move that string.
//
//   §4.5.6 ddx on the resistive leg: the conductance is 1/R = 1.0e-3 S
//   exactly, which is the number the susceptance above has to match.

//! lrm 4.6.1
//! lrm 4.5.6
//! lrm 12.8
//! solve
`include "check.vh"
module p03_acsrc(p, n);
    inout p, n;
    electrical p, n;
    parameter real mag = 1.0;
    // Negated so the branch current p->n is an injection INTO p when the
    // instance is wired (a, gnd): I(p,n) is defined positive flowing out of p
    // through the branch.
    real stim;
    analog begin
        stim = -ac_stim("ac", mag, 0.0);
        `CHECKX("ac_stim is inactive outside a small-signal analysis", stim, 0.0);
        I(p, n) <+ stim;
    end
endmodule

module p03_rc_ac;
    parameter real rload = 1.0e3;
    parameter real cload = 1.0e-3 / (2.0 * `M_PI * 1.0e3);
    electrical a, gnd;
    ground gnd;
    p03_acsrc #(.mag(1.0)) i1(.p(a), .n(gnd));
    p03_rload #(.r(rload)) r1(.p(a), .n(gnd));
    p03_cload #(.c(cload)) c1(.p(a), .n(gnd));
endmodule

module p03_rload(p, n);
    inout p, n;
    electrical p, n;
    parameter real r = 1.0e3 from (0:inf);
    analog begin
        `CHECKX("the large-signal operating point of this deck is identically zero",
            V(p, n), 0.0);
        `CHECK("and the resistive leg is a 1 mS conductance",
            ddx(V(p, n) / r, V(p)), 1.0e-3, 1e-18);
        I(p, n) <+ V(p, n) / r;
    end
endmodule

module p03_cload(p, n);
    inout p, n;
    electrical p, n;
    parameter real c = 1.0e-9 from (0:inf);
    analog begin
        `CHECKX("at 1 kHz the susceptance equals the conductance exactly",
            2.0 * `M_PI * 1.0e3 * c, 1.0e-3);
        I(p, n) <+ c * ddt(V(p, n));
    end
endmodule
