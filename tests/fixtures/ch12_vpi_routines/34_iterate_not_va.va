//! reject E0512
//! reject vpi_iterate
// EXPECT: error
module ch12_atomic_iterate(p, n);
  inout p, n; electrical p, n;
  analog I(p,n) <+ vpi_iterate(0);
endmodule
