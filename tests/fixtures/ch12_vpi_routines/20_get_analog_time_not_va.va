//! lrm 4.7
//! lrm A.8.2
//! reject E0512
//! reject `vpi_get_analog_time`
module ch12_atomic_get_analog_time(p, n);
  inout p, n; electrical p, n;
  analog I(p,n) <+ vpi_get_analog_time(0);
endmodule
