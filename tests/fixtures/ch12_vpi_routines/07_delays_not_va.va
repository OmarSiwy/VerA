//! reject E0512
//! reject vpi_get_delays
// EXPECT: error
module ch12_delays_not_va(p, n);
  inout p, n; electrical p, n;
  analog I(p,n) <+ vpi_get_delays(0, 0);
endmodule
