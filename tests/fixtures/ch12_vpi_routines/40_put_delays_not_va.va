//! reject E0512
//! reject vpi_put_delays
// EXPECT: error
module ch12_atomic_put_delays(p, n);
  inout p, n; electrical p, n;
  analog I(p,n) <+ vpi_put_delays(0);
endmodule
