//! reject E0512
//! reject vpi_remove_cb
// EXPECT: error
module ch12_atomic_remove_cb(p, n);
  inout p, n; electrical p, n;
  analog I(p,n) <+ vpi_remove_cb(0);
endmodule
