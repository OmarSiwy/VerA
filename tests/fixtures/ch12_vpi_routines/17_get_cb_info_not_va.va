//! reject E0512
//! reject vpi_get_cb_info
// EXPECT: error
module ch12_atomic_get_cb_info(p, n);
  inout p, n; electrical p, n;
  analog I(p,n) <+ vpi_get_cb_info(0);
endmodule
