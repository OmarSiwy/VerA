// Annex G Table G.4 item 2 (v2.2 -> v2.3, §3.4.2): "Add apostrophe before
// opening { in list of values (to distinguish a list of values from the
// concatenation operator)". The change text is its own justification: without
// the leading apostrophe `{2.1, 4.5}` is a concatenation, and a front end that
// accepts it as an array initialiser cannot tell the two constructs apart.
// Table G.1's "Array setting" row shows the same expression evolving from
// v1.0's `{2.1 = (1), 4.5 = (2)}` to a plain list, which §3.4.2 then required
// the apostrophe on.
//
// The legal '{...} form is covered by ch03_data_types/08_parameter_array.va and
// ch04_expressions/09_assignment_pattern.va.
//
// Either diagnosis is conforming -- a missing apostrophe, or an unsized
// concatenation in a real-valued initialiser -- so the phase, not a code, is
// pinned until VerA emits one.
//
//! lrm G.1
//! lrm 3.4.2
//! reject DiagnosticsReported
//! xfail VerA accepts a brace-only array initialiser; 3.4.2 requires the leading apostrophe so a list of values is distinguishable from a concatenation
module annex_g_brace_array(p, n);
  inout p, n; electrical p, n;
  parameter real coeffs[0:1] = {2.1, 4.5};
  analog I(p,n) <+ coeffs[0] * V(p,n);
endmodule
