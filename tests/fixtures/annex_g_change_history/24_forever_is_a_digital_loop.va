// G.2.1 Forever: "This statement is no longer supported." What it retired is
// the ANALOG forever — A.6.8's `analog_loop_statement` today is
//
//     analog_loop_statement ::= repeat ( analog_expression ) analog_statement
//             | while ( analog_expression ) analog_statement
//             | for ( ... ) analog_statement
//
// with no forever arm, and 04_obsolete_forever.va pins that refusal. The same
// clause of the same annex keeps the DIGITAL one:
//
//     loop_statement ::= forever statement | repeat ( expression ) statement
//             | while ( expression ) statement | for ( ... ) statement   // A.6.8
//
// so G.2.1 is a removal from one production and not from the language. This
// file is its positive side: the forever that survived, in the `initial`
// construct of a mixed module (§7.2.2's discrete context), running.
//
// VerA used to refuse this too — `forever` parsed nowhere, not even under
// `vera --run`, and the E0209 an analog forever gets ("expected an expression")
// was what a digital one got as well. The removal had been applied to both
// productions. Now `forever` is read in the discrete grammar and recorded as
// the `while (1)` loop IEEE 1364 §9.6 gives it the meaning of; the analog
// block still refuses it (04, E0209).
//
// DERIVATION, `timescale 1ns/1ns. The initial block zeroes `ticks` at t = 0 and
// then loops forever on `#1 ticks = ticks + 1`, so the n-th increment lands at
// t = n ns and, strictly between two ticks, ticks = floor(t / 1 ns):
//
//     t = 2.5 ns  -> 2        t = 5.5 ns  -> 5        t = 10.5 ns -> 10
//
// A forever that ran its body once would read 1 at every one of those points;
// one that did not run at all would read 0 (or x). The declared points are
// half-way between ticks on purpose: the mixed runner also stops the analog
// solver AT each tick, where which side of the increment the strobe falls on is
// §8's business and not this clause's, so the check pins only points whose
// fractional nanosecond is clear of 0 and passes the others unexamined.
//
//! lrm G.2.1
//! lrm A.6.8
//! lrm A.6.8:1000
//! analysis tran
//! time 0, 2.5n, 5.5n, 10.5n
`timescale 1ns/1ns
`include "check.vh"
module annex_g_forever_is_a_digital_loop(p, n);
    inout p, n;
    electrical p, n;
    integer ticks;
    real tn;

    initial begin
        ticks = 0;
        forever #1 ticks = ticks + 1;
    end

    analog begin
        tn = $abstime * 1e9;
        `CHECKI("between two ticks, a digital forever has incremented floor(t/1ns) times",
                ((tn - floor(tn)) > 0.25 && (tn - floor(tn)) < 0.75) ? (ticks == floor(tn)) : 1, 1);
        I(p, n) <+ V(p, n);
    end
endmodule
