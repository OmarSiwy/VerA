// G.2.3 Generate: the v1.0 statement `generate i (start, end [, incr])
// statement` "is a looping construct which is unrolled at elaboration time. It
// is the only looping statement that can contain analog operators." It is gone
// (06_obsolete_generate.va pins the refusal), and the second sentence is what
// replaced it — it is no longer true, because §5.9.3 gave the ordinary `for` a
// genvar form that does the same job:
//
//     "The analog_for statements are syntactically equivalent to for()
//      statements except the associated analog statement can contain analog
//      operators."                                                     §5.9.3
//
//     analog_loop_generate_statement ::=
//         for ( genvar_initialization ; genvar_expression ; genvar_iteration )
//             analog_statement                                          A.6.8
//
// So this file is Figure G-1's own example — the continuously running ADC,
// `generate i (bits-1,0)` over `V(out[i]) <+ transition(...)` — written the
// way the current language spells it, and run. The only other changes are the
// ones the example needs to be a model: `sample` is read from the input (the
// figure never assigns it, so as printed every bit is 0), and the output bus is
// internal, so the fixture has two ports to bias.
//
// Figure G-1's default increment is -1 when the lower bound is greater than the
// upper, so `i (bits-1,0)` visits 3, 2, 1, 0 for bits = 4; the genvar loop
// spells that out with `i = i - 1`.
//
// DERIVATION, bits = 4, fullscale = 1.0, so thresh = 0.5; V(in) = 0.7:
//
//     i = 3   0.7 > 0.5  -> bit 1   sample = 2*(0.7 - 0.5) = 0.4
//     i = 2   0.4 > 0.5? -> bit 0   sample = 2*0.4         = 0.8
//     i = 1   0.8 > 0.5  -> bit 1   sample = 2*(0.8 - 0.5) = 0.6
//     i = 0   0.6 > 0.5  -> bit 1   sample = 2*(0.6 - 0.5) = 0.2
//
// out[3..0] = 1011 = 11, which is floor(0.7 * 2^4) = floor(11.2), the answer
// a 4-bit converter must give. Each comparison clears its threshold by at
// least 0.1, so binary rounding of 0.7 cannot move a bit. The code is summed
// inside the same loop body that carries the `transition`, weighted by the
// genvar, so a loop that ran the wrong indices, the wrong number of times, or
// in the wrong order reads something other than 11. `transition` at the first
// point of a dc analysis is its input (§4.5.8), so each V(out[i]) is its bit.
//
//! lrm G.2.3
//! lrm 5.9.3
//! lrm A.6.8
//! lrm 5.9.2
//! lrm 5.9.2:1
//! lrm 5.9.3:1000
//! lrm A.4.2
//! lrm A.4.2:1000
//! bias V(in) = 0.7, V(gnd_ref) = 0.0
//! solve
`include "check.vh"
module annex_g_generate_replaced_by_analog_for(in, gnd_ref);
    inout in, gnd_ref;
    electrical in, gnd_ref;
    parameter integer bits = 4;
    parameter real fullscale = 1.0, dly = 0.0, ttime = 10n;
    electrical [0:bits-1] out;
    real sample, thresh;
    integer code;
    genvar i;

    analog begin
        thresh = fullscale / 2.0;
        sample = V(in, gnd_ref);
        code = 0;
        for (i = bits - 1; i >= 0; i = i - 1) begin
            V(out[i]) <+ transition(sample > thresh, dly, ttime);
            if (sample > thresh) begin
                code = code + (1 << i);
                sample = sample - thresh;
            end
            sample = 2.0 * sample;
        end
        I(in, gnd_ref) <+ V(in, gnd_ref) / 1e6;

        `CHECKI("the genvar loop converts 0.7 of full scale to 1011", code, 11);
        `CHECKX("out[3], the first bit the loop visits, is 1", V(out[3]), 1.0);
        `CHECKX("out[2] is 0", V(out[2]), 0.0);
        `CHECKX("out[1] is 1", V(out[1]), 1.0);
        `CHECKX("out[0], the last bit, is 1", V(out[0]), 1.0);
    end
endmodule
