// Annex G Table G.7 item 7922: "Remove error for contributing to a port
// declared with out `input` direction. This is now a warning" (5.6.1). §5.6.1
// now reads "Implementations may issue a warning if a contribution is made to
// an analog port declared with an input direction" -- MAY, and a warning, so
// the module shall compile and run. No reject fixture may be written for this
// rule in either direction; the prohibition was deleted in 2023.
//
// ch06_hierarchy/input_port.va already contributes to an input port and runs,
// but it carries `//! bias V(p) = 1.25` and asserts V(p) == 1.25 -- it checks
// the BIAS. A compiler that parsed the contribution and then silently dropped
// it, which is exactly what the deleted error used to justify, passes that
// fixture unchanged, because the node was force-biased and the contribution
// never had to do anything. So the relaxation is exercised and not proven.
//
// This is the proof. No `//! bias` on i, so the solve determines it and the
// only thing that can determine it is the contribution.
//
// DERIVATION. The single branch at node i is the contributed flow, so KCL at i
// is that flow alone equals zero:
//
//   V(i)*1.0e-3 - 1.0e-3 = 0   =>   V(i) = 1.0 exactly
//
// a 1 kohm conductance driven by a 1 mA source, whose operating point is 1 V
// and is exact in binary. The number separates all three wrong behaviours:
//   - the pre-2023 error       -> does not compile at all
//   - the contribution dropped -> node floats at the 0.0 initial guess
//   - the port treated as probe-only, contribution parsed and discarded -> 0.0
//
// p is an inout carrying its own resistor so the module has a second terminal
// and the input port is not the whole device; it plays no part in the digit.
//
// WHY `//! solve` IS HERE AND NO BIAS IS. VerA has always stamped the
// contribution correctly — with the residual printed the module shows
//
//   res[i] = -1.000000e-3        d res[i]/d x[i] = 1.000000e-3
//
// exactly the 1 mA source and the 1 kohm conductance derived above. But a
// residual is not an answer: the number this fixture is about is the one that
// makes that row zero, and reaching it takes a solve. `//! solve` is the line
// that says so — it unties every unknown no other directive names, so V(i) is
// the device's to determine and not the harness's to ground. Biasing i instead
// would delete the whole test, which is the mistake ch06_hierarchy/input_port.va
// makes and this file exists to correct.
//
//! lrm G.1
//! lrm 5.6.1
//! lrm 5.6.1:4
//! print none
//! solve
`include "check.vh"
module annex_g_input_port_contribution(i, p);
  input i;
  inout p;
  electrical i, p;
  analog begin
    I(i) <+ V(i) * 1.0e-3 - 1.0e-3;
    I(p) <+ V(p);
    `CHECKX("the contribution to the input port was honoured, not dropped", V(i), 1.0);
  end
endmodule
