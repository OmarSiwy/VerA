// Annex G Table G.1, last row ("Null statement: `;` -> limited to case,
// conditional, and event statements, Obsolete"). From v2.0 on the null
// statement is an empty ARM, not a free-standing statement: A.6.4 gives
// `analog_statement` no null alternative, and the one in
// `analog_statement_or_null` is reachable only from a conditional arm, a case
// item and an event statement. The free-standing form is a separate fixture,
// 09_null_statement_unconditional_rejected.va. What is pinned HERE is the part
// with an observable consequence -- what a legal null does to binding: a `;`
// FILLS the arm it stands in, so the `else` after `if (c) ;` still belongs to
// that `if`, and a `;` in the else arm still leaves the true arm to run.
//
// The bias makes the condition false, so the original conditional contribution
// takes its else arm: I(p,n) <+ V(p,n) = -0.5.
//
// Both wants are unreachable if the `;` is mis-parsed. Swallow the else after a
// null true arm and `y` stays 1.0; drop the true arm of an if whose else is
// null and `z` stays 1.0.
//
//! lrm G.2.2
//! lrm A.6.4
//! lrm A.6.4:1000
//! lrm A.6.6
//! lrm A.6.6:1000
//! bias V(p) = -0.5, V(n) = 0
//! print none
`include "check.vh"
module annex_g_null_statement(p, n);
  inout p, n; electrical p, n;
  real y;
  real z;
  analog begin
    y = 1.0;
    z = 1.0;
    if (V(p,n) > 0.0) ;
    else I(p,n) <+ V(p,n);
    // `;` as the true arm: the else still binds to this if, and runs.
    if (V(p,n) > 0.0) ;
    else y = 2.0;
    // `;` as the else arm: the true arm still runs.
    if (V(p,n) < 0.0) z = 3.0;
    else ;
    `CHECKX("null true arm, else still binds and runs", y, 2.0);
    `CHECKX("null else arm, true arm still runs", z, 3.0);
  end
endmodule
