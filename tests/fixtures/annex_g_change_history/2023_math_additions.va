// Annex G Table G.7 item 7780 ("Added support for math functions expm1() and
// ln1p()", clause column "4-14, 9-11, A.8.2, B.1"). §4.3.1 defines them exactly:
//
//     ln1p(x)  = ln(1 + x)        (x > -1)
//     expm1(x) = e^x - 1          (all x)
//
// The wants are CPython's libm log1p/expm1 at double precision, derived
// independently of VerA. At x = 0.5 the accurate and the naive forms agree to
// the last bit, so 1e-15 relative is honest for either implementation — the
// LRM only says ln1p "can be more accurate" for small |x|, it does not mandate
// the accurate kernel, so no assertion here leans on that.
//
// The negative argument is the real discriminator: ln1p(-0.5) = ln(0.5) is
// finite, while anything that forgot the "1 +" would be ln(-0.5) = NaN.
//
// The $-prefixed spellings are the ones the item added and are the ones written
// here: Table 4-14's first column gives `$ln1p(x)` and `$expm1(x)`, and Table
// 9-11 lists both as supported in the analog context. §9.14 makes them aliases
// of the §4.3.1 operators, so a compiler may implement either kernel.
//
//! lrm G.1
//! lrm 4.3.1
//! lrm 9.14
//! bias V(p) = 0.5, V(n) = 0
//! print none
`include "check.vh"
module annex_g_math_2023(p, n);
  inout p, n; electrical p, n;
  analog begin
    `CHECKR("$ln1p(0.5) is ln(1.5)", $ln1p(V(p,n)), 0.4054651081081644, 1e-15);
    `CHECKR("$expm1(0.5) is exp(0.5)-1", $expm1(V(p,n)), 0.6487212707001282, 1e-15);
    `CHECKR("$ln1p(-0.5) is ln(0.5), not ln(-0.5)", $ln1p(-0.5),
            -0.6931471805599453, 1e-15);
    // Both are exactly zero at zero: ln(1+0) and e^0 - 1.
    `CHECKX("$ln1p(0) is exactly 0", $ln1p(0.0), 0.0);
    `CHECKX("$expm1(0) is exactly 0", $expm1(0.0), 0.0);
    // The fixture's own contribution at the declared bias, which is the sum of
    // the two wants above.
    `CHECKR("the contributed sum at V(p,n)=0.5",
            $ln1p(V(p,n)) + $expm1(V(p,n)), 1.0541863788082926, 1e-15);
    I(p,n) <+ $ln1p(V(p,n)) + $expm1(V(p,n));
  end
endmodule
