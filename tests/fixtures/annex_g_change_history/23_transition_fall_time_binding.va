// §4.5.8, the half no fixture pinned against a literal: "transition() forces all
// positive transitions of expr to occur over rise_time and all NEGATIVE
// transitions to occur in fall_time", and the result "describes a piecewise
// linear function over time".
//
// Two separate claims live in that sentence and both are unchecked elsewhere:
//   (a) the output is LINEAR in time while transitioning, not some other
//       monotone curve with the same endpoints;
//   (b) which argument a falling edge uses is fall_time, not rise_time and not
//       an average of the two.
// ch10_directives/38_default_transition_ramp.va bounds a RISING ramp with
// rise_time == fall_time, so it cannot see (b) at all, and
// exhaustive/063_transition.va deliberately pins the implemented first-order lag
// rather than the LRM's ramp. 21_transition_time_tolerance.va is about the fifth
// argument and says nothing about the shape. Hence this file.
//
// THE GRID AND THE ONE AMBIGUITY IN IT. `//! wave V(in) = 1, 0, 0` on
// `//! time 0, 1n, 3n` is a level of 1 at the DC point and 0 from t = 1n on. The
// LRM does not say when a simulator handed a sampled input decides the step
// happened: at t = 1n, where the sample first differs, or anywhere in (0, 1n].
// Call the edge time te and the elapsed ramp time d = t - te.
//
// ASSERTION 1 IS INDEPENDENT OF te, which is why it can carry an exact literal.
// While both filters are still ramping, §4.5.8 gives
//
//   a = transition(x, 0, 4n, 8n) = v0 + (v1 - v0) * d/8n
//   b = transition(x, 0, 8n, 4n) = v0 + (v1 - v0) * d/4n
//
// -- same input, same edge, same td; only the FALLING argument differs, and it
// differs by exactly a factor of two. So
//
//   2a - b = 2*v0 + 2(v1-v0)*d/8n - v0 - (v1-v0)*d/4n = v0 = 1.0
//
// The elapsed time cancels identically. 1.0 is the level the waveform left, it
// is exact in binary, it holds at the DC point too (where §4.5.8 passes the
// input straight through, so a = b = 1 and 2a - b = 1), and it holds at every
// sampled point in any conforming implementation whatever its edge detection.
//
// It is not a tautology. It is 1.0 only if both outputs are linear in d with
// slopes in the ratio 2:1 and a common origin at v0 -- that is (a) and (b)
// together. A kernel that binds the falling edge to rise_time gives
// 1 - 3d/8n; one that averages rise and fall into a single time constant gives
// a = b and therefore 2a - b = a, which at t = 3n is nowhere near 1.
//
// ASSERTIONS 2 AND 3 place the ramp absolutely, and there the one-sample
// ambiguity is real, so they are written as the two-sided bracket it implies:
// te in [0, 1n] means, with fall_time = 8n and a unit excursion,
//
//   1 - t/8n  <=  out(t)  <=  1 - (t - 1n)/8n
//
// which at t = 3n is 0.625 <= out <= 0.75, the tight corner being the 0.75 an
// edge detected at t = 1n gives: 1 - 2n/8n. Any implementation that traverses
// the fall in 4n is at 0.5 or below there and misses the bracket by 0.125.
//
// The 1e-12 epsilon on each bound is the same allowance
// ch10_directives/38_default_transition_ramp.va documents: at t = 0 and t = 1n a
// correct ramp sits bit-for-bit ON a bound, and an inequality decided by the
// last ulp is deciding something the LRM does not fix. 1e-12 is some 4000 ulp at
// 1.0 and eleven orders below the 0.125 of discrimination, so it costs nothing.
//
//! lrm 4.5.8
//! analysis tran
//! time 0, 1n, 3n
//! wave V(in) = 1, 0, 0
//! bias V(n) = 0
//! print none
//! xfail VerA implements transition() as a first-order lag with ONE time constant for both directions — codegen's transitionTau returns (rise + fall) * 0.5 / 2.2, here 2.727n whichever way the edge goes — so the two filters below, which differ only in which argument is the fall time, return the SAME number and 2a - b collapses to a. Measured: a = 0.7317073170731707 at t = 1n and 0.4221388367729831 at t = 3n, where §4.5.8's ramp gives 1.0 and 0.75
`include "check.vh"
module annex_g_transition_fall_binding(in, n);
  inout in, n;
  electrical in, n;
  analog begin
    `CHECK("a falling edge is traversed in fall_time, linearly",
           2.0 * transition(V(in, n), 0, 4n, 8n) - transition(V(in, n), 0, 8n, 4n),
           1.0, 1e-12);
    `CHECKI("the fall is no faster than 1/8n",
            transition(V(in, n), 0, 4n, 8n) >= 1.0 - $abstime/8n - 1e-12, 1);
    `CHECKI("the fall is no slower than 1/8n",
            transition(V(in, n), 0, 4n, 8n) <= 1.0 - ($abstime - 1n)/8n + 1e-12, 1);
    I(in, n) <+ 0.0;
  end
endmodule
