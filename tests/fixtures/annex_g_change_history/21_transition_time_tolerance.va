// Annex G Table G.1, "Time tolerance on transition filter | N/A | supports
// additional time tolerance argument for transition() | Extension". The v2.0
// general form (§4.5.8) is
//
//   transition ( expr [ , td [ , rise_time [ , fall_time [ , time_tol ] ] ] ] )
//
// and the fifth argument had no v1.0 spelling at all. Nothing in the suite
// writes it: `grep -rnE 'transition *\([^)]*(,[^)]*){4}\)'` over the fixtures
// finds zero hits, so the extension is unexercised while its sibling row
// (time tolerance on timer()) is covered twice over.
//
// WHAT §4.5.8 FIXES ABOUT time_tol, and it is not a value:
//   "The transition function causes the simulator to place time points at both
//    corners of a transition. If time_tol is not specified, the transition
//    function causes the simulator to assure each transition is adequately
//    resolved."
//   "If a time_tol value of zero (0.0) is specified, the simulator shall apply
//    a suitable value."
// time_tol buys timestep placement, i.e. how finely the corners are resolved.
// It is not part of the waveform: the trapezoid is fixed by td, rise_time and
// fall_time alone. So the requirement is an IDENTITY with no digit behind it,
// which is what CHECKEQ exists for -- the value cancels from both sides and
// the tolerance is 0.0 because the two calls are the same filter.
//
// The edge here FALLS (1 -> 0) and rise_time /= fall_time on purpose. This is
// the mis-binding this fixture exists to catch: a front end that accepts five
// arguments by sliding time_tol into the fall_time slot would fall over 1 ps
// instead of 8 ns, and on a rising edge that mistake is invisible. On a falling
// edge the two waveforms diverge in ANY conforming implementation, whatever
// its ramp shape, so the identity is a real check and not a tautology.
//
// The one digit is the unchanging-input case: with no transition to smooth, the
// filter's output is its input at every time point, exactly -- 2.5, a value no
// argument of the call carries, so a front end returning td, fall_time or
// time_tol instead of the smoothed expression is caught.
//
// The RAMP VALUE is deliberately not pinned here. Where the trapezoid sits at a
// given time is §4.5.8's business, and two fixtures already own it:
// ch10_directives/38_default_transition_ramp.va bounds it (and carries the xfail
// for VerA's first-order-lag kernel) and exhaustive/063_transition.va pins the
// implemented kernel with its ceiling named. Restating that debt inside a
// fixture about argument binding would give one gap two markers that XPASS on
// the same day. What is asserted below is only what the fifth argument fixes.
//
//! lrm G.1
//! lrm 4.5.8
//! analysis tran
//! time 0, 1n, 3n
//! wave V(in) = 1, 0, 0
//! bias V(n) = 0
//! print none
`include "check.vh"
module annex_g_transition_time_tolerance(in, n);
  inout in, n;
  electrical in, n;
  analog begin
    `CHECKEQ("time_tol resolves the corners and does not move the waveform",
             transition(V(in, n), 0, 4n, 8n, 1p),
             transition(V(in, n), 0, 4n, 8n), 0.0);
    `CHECKEQ("time_tol = 0.0 means `pick a suitable one', not a different waveform",
             transition(V(in, n), 0, 4n, 8n, 0.0),
             transition(V(in, n), 0, 4n, 8n, 1p), 0.0);
    `CHECKX("a five-argument filter on an unchanging input is that input",
            transition(2.5, 0, 4n, 8n, 1p), 2.5);
    `CHECKI("never above the level it left", transition(V(in, n), 0, 4n, 8n, 1p) <= 1.0, 1);
    `CHECKI("never below the level it seeks", transition(V(in, n), 0, 4n, 8n, 1p) >= 0.0, 1);
    I(in, n) <+ 0.0;
  end
endmodule
