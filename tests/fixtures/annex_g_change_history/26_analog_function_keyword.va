// G.2.4: "The `default_function_type_analog directive is no longer supported.
// this compiler directive allowed user-defined functions to be treated as
// analog functions in Verilog-A if they did not have the key word analog as
// part of the definition." 07_obsolete_default_function_type.va pins the
// refusal of the directive.
//
// What replaced it is the keyword the directive let a model leave out. §4.7.1:
//
//     "An analog user-defined function declaration shall begin with the
//      keywords analog function, optionally followed by the type of the return
//      value from the function, then the name of the function and a semicolon,
//      and ending with the keyword endfunction."
//
// and §4.7 keeps the other kind as a separate thing: "Each function can be an
// analog user-defined function or a digital function (as defined in IEEE Std
// 1364 Verilog)." With the directive gone, the `analog` keyword is the ONLY way
// to declare the first kind, so this file is G.2.4's positive side: two analog
// functions spelled the current way, called from the analog block, returning
// the values their bodies compute.
//
//   `analog function real gain2;`   the typed form. 2 * 0.375 = 0.75, exact.
//   `analog function clamp;`        the untyped form, which §4.7.1 makes real
//                                   ("type can be real, integer, or string; if
//                                   unspecified, the default is real"): clamp(1.25, 1.0)
//                                   = 1.0 and clamp(0.5, 1.0) = 0.5, exact; a
//                                   function that fell back to integer would
//                                   still read 1 for the first but 0 for the
//                                   second.
//
// V(p, n) is biased to 0.375 so the argument of gain2 comes from the circuit
// and the call cannot be folded away as a constant.
//
//! lrm G.2.4
//! lrm 4.7.1
//! lrm 4.7.1:1
//! lrm 4.7.1:2
//! bias V(p) = 0.375, V(n) = 0.0
`include "check.vh"
module annex_g_analog_function_keyword(p, n);
    inout p, n;
    electrical p, n;

    analog function real gain2;
        input x;
        real x;
        gain2 = 2.0 * x;
    endfunction

    analog function clamp;
        input x, hi;
        real x, hi;
        clamp = (x > hi) ? hi : x;
    endfunction

    analog begin
        `CHECKX("the typed analog function doubles its argument", gain2(V(p, n)), 0.75);
        `CHECKX("the untyped analog function clamps 1.25 to 1.0", clamp(1.25, 1.0), 1.0);
        `CHECKX("and is real-valued: 0.5 passes through as 0.5", clamp(0.5, 1.0), 0.5);
        I(p, n) <+ V(p, n);
    end
endmodule
