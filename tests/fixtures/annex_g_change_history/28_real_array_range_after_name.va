// Annex G Table G.2 (v2.0 to v2.1, under G.1) item 12: "For variables, array specification is written
// after the name of the variable." The legal neighbour of
// 27_real_array_range_before_name_rejected.va: `real x[0:3];` declares four
// reals indexed 0..3 (§3.2, A.2.1.3 real_type ::= real_identifier
// { dimension }). Each element is written i + 0.5 and read back; the sum is
// 0.5 + 1.5 + 2.5 + 3.5 = 8.0, exact in binary64.
//
//! lrm G.1
//! lrm 3.2
//! lrm A.2.1.3
//! checks 2
`include "check.vh"
module annex_g_real_array_range_after_name(p);
  inout p; electrical p;
  real x[0:3];
  integer i;
  analog begin
    for (i = 0; i < 4; i = i + 1) x[i] = i + 0.5;
    `CHECKX("the last element holds 3.5", x[3], 3.5);
    `CHECKX("the four elements sum to 8.0", x[0] + x[1] + x[2] + x[3], 8.0);
    I(p) <+ V(p);
  end
endmodule
