// LRM 5.9: the analog looping statements are repeat, while and for --
// `forever` is not one of them.
//! reject E0205
//! reject forever
module annex_g_obsolete_forever(p, n);
  inout p, n; electrical p, n;
  analog forever begin
    I(p,n) <+ V(p,n);
  end
endmodule
