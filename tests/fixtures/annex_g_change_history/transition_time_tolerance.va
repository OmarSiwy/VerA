// Annex G Table G.1, "Time tolerance on transition filter | N/A | supports
// additional time tolerance argument for transition() | Extension". The v2.0
// general form (§4.5.8) is
//
//   transition ( expr [ , td [ , rise_time [ , fall_time [ , time_tol ] ] ] ] )
//
// and the fifth argument had no v1.0 spelling at all.
//
// ch04_expressions/transition.va:53 already writes the five-argument form
// once, in DC, where §4.5.8 passes the input straight through -- so what it
// proves is that the arity parses. This fixture is the transient half: that the
// fifth argument does not disturb the waveform, and in particular that a front
// end which accepts five arguments by BINDING THEM WRONG is caught.
//
// WHAT §4.5.8 FIXES ABOUT time_tol, and it is not a value:
//   "The transition function causes the simulator to place time points at both
//    corners of a transition. If time_tol is not specified, the transition
//    function causes the simulator to assure each transition is adequately
//    resolved."
//   "If a time_tol value of zero (0.0) is specified, the simulator shall apply
//    a suitable value."
// time_tol buys timestep placement, i.e. how finely the corners are resolved.
// It is not part of the waveform: the trapezoid is fixed by td, rise_time and
// fall_time alone. So the requirement is an IDENTITY with no digit behind it,
// which is what CHECKEQ exists for -- the value cancels from both sides and
// the tolerance is 0.0 because the two calls are the same filter.
//
// The edge here FALLS (1 -> 0) and rise_time /= fall_time on purpose. This is
// the mis-binding this fixture exists to catch: a front end that accepts five
// arguments by sliding time_tol into the fall_time slot would fall over 1 ps
// instead of 8 ns, and on a rising edge that mistake is invisible. On a falling
// edge the two waveforms diverge in ANY conforming implementation, whatever
// its ramp shape, so the identity is a real check and not a tautology.
//
// The one digit is the unchanging-input case: with no transition to smooth, the
// filter's output is its input at every time point, exactly -- 2.5, a value no
// argument of the call carries, so a front end returning td, fall_time or
// time_tol instead of the smoothed expression is caught.
//
// The RAMP VALUE is deliberately not pinned here, and the reason is separation,
// not that someone else already did it. Where the trapezoid sits at a given time
// is §4.5.8's business and VerA gets it wrong (a first-order lag, one time
// constant for both directions), so any fixture stating it must carry an
// `//! xfail`. This file states only what the FIFTH ARGUMENT fixes, and VerA
// gets that right, so it runs green and keeps reporting regressions in the
// argument binding while the ramp debt is held elsewhere:
//
//   transition_fall_time_binding.va -- the sibling, same grid, pins the
//     falling ramp against a literal and carries the xfail for the lag kernel;
//   ch10_directives/default_transition_ramp.va -- bounds a RISING ramp with
//     rise_time == fall_time, for `default_transition;
//   exhaustive/transition.va -- pins the implemented lag deliberately, with
//     its ceiling named, and is therefore not a §4.5.8 check at all.
//
// This fixture only checks argument binding and waveform identities. Actual
// timestep resolution for omitted/zero tolerance is asserted by
// tests/host.py. Those exact requirements are
// deliberately not credited to these waveform-only checks.
//
// The last check also pins §4.5.8's rise/fall defaulting: under a directive of
// 8n, transition(x, 0, 0, 0) must be the same filter as transition(x, 0, 8n,
// 8n). A tool that treats the explicit zeros as an instantaneous edge instead
// of "equal to zero (0.0)" leaves the left side at 0 where the right side is
// still partway down the 8n ramp, so the CHECKEQ fails.
//
//! lrm G.1
//! lrm 4.5.8
//! lrm 4.5.8:2
//! analysis tran
//! time 0, 1n, 3n
//! wave V(in) = 1, 0, 0
//! bias V(n) = 0
//! print none
`default_transition 8n
`include "check.vh"
module annex_g_transition_time_tolerance(in, n);
  inout in, n;
  electrical in, n;
  analog begin
    `CHECKEQ("explicit time_tol does not change the waveform",
             transition(V(in, n), 0, 4n, 8n, 1p),
             transition(V(in, n), 0, 4n, 8n), 0.0);
    // No backtick in the string: a `` ` `` followed by a letter inside a string
    // literal is a preprocessor hazard in a front end that scans strings.
    `CHECKEQ("zero time_tol does not change the waveform",
             transition(V(in, n), 0, 4n, 8n, 0.0),
             transition(V(in, n), 0, 4n, 8n, 1p), 0.0);
    `CHECKX("a five-argument filter on an unchanging input is that input",
            transition(2.5, 0, 4n, 8n, 1p), 2.5);
    `CHECKI("never above the level it left", transition(V(in, n), 0, 4n, 8n, 1p) <= 1.0, 1);
    `CHECKI("never below the level it seeks", transition(V(in, n), 0, 4n, 8n, 1p) >= 0.0, 1);
    `CHECKEQ("explicit zero rise and fall times take the directive's default",
             transition(V(in, n), 0, 0, 0), transition(V(in, n), 0, 8n, 8n), 0.0);
    I(in, n) <+ 0.0;
  end
endmodule
