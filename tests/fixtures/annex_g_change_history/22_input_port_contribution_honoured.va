// Annex G Table G.7 item 7922: "Remove error for contributing to a port
// declared with out `input` direction. This is now a warning" (5.6.1). §5.6.1
// now reads "Implementations may issue a warning if a contribution is made to
// an analog port declared with an input direction" -- MAY, and a warning, so
// the module shall compile and run. No reject fixture may be written for this
// rule in either direction; the prohibition was deleted in 2023.
//
// ch06_hierarchy/input_port.va already contributes to an input port and runs,
// but it carries `//! bias V(p) = 1.25` and asserts V(p) == 1.25 -- it checks
// the BIAS. A compiler that parsed the contribution and then silently dropped
// it, which is exactly what the deleted error used to justify, passes that
// fixture unchanged, because the node was force-biased and the contribution
// never had to do anything. So the relaxation is exercised and not proven.
//
// This is the proof. No `//! bias` on i, so the solve determines it and the
// only thing that can determine it is the contribution.
//
// DERIVATION. The single branch at node i is the contributed flow, so KCL at i
// is that flow alone equals zero:
//
//   V(i)*1.0e-3 - 1.0e-3 = 0   =>   V(i) = 1.0 exactly
//
// a 1 kohm conductance driven by a 1 mA source, whose operating point is 1 V
// and is exact in binary. The number separates all three wrong behaviours:
//   - the pre-2023 error       -> does not compile at all
//   - the contribution dropped -> node floats at the 0.0 initial guess
//   - the port treated as probe-only, contribution parsed and discarded -> 0.0
//
// p is an inout carrying its own resistor so the module has a second terminal
// and the input port is not the whole device; it plays no part in the digit.
//
// The `//! xfail` below is the ONE case in this suite where the gap is the
// harness and not the compiler, so it is worth being precise about what was
// measured. VerA does honour the contribution: with `//! residual` the same
// module prints
//
//   res[i] = -1.000000e-3        d res[i]/d x[i] = 1.000000e-3
//
// which is exactly the 1 mA source and the 1 kohm conductance derived above,
// stamped at the x[i] = 0 evaluation point. Solving that one row gives V(i) = 1.
// What is missing is the solve: src/backend/tb.zig is a residual-and-Jacobian
// harness (see its `renderRunner`, and README.md "one operating point, every
// unknown at zero"), it has no Newton loop, so V(i) stays at the initial guess
// and no assertion inside the analog block can see the stamp. The assertion is
// left stating the operating point, because that is the requirement; the day
// the harness solves, this XPASSes and the marker comes off.
//
//! lrm G.7
//! lrm 5.6.1
//! print none
//! xfail the generated testbench never solves — src/backend/tb.zig evaluates the residual and Jacobian at each declared operating point and has no Newton loop, so an unbiased unknown stays at the 0.0 initial guess and V(i) reads 0, not the 1.0 its own KCL row gives. VerA itself stamps the contribution correctly: res[i] = -1e-3 with d res[i]/d x[i] = 1e-3
`include "check.vh"
module annex_g_input_port_contribution(i, p);
  input i;
  inout p;
  electrical i, p;
  analog begin
    I(i) <+ V(i) * 1.0e-3 - 1.0e-3;
    I(p) <+ V(p);
    `CHECKX("the contribution to the input port was honoured, not dropped", V(i), 1.0);
  end
endmodule
