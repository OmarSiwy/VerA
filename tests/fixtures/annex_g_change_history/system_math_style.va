// Annex G Table G.7 item 7795 ("Support the alternative Verilog style for
// $min(), $max(), and $abs()", clause column "4.3.1, 9-11"). Table 4-14's first
// column gives `$min(x,y)`, `$max(x,y)` and `$abs(x)`, and Table 9-11 lists all
// three as supported in the analog context. The $-prefixed spellings are the SAME
// functions as the bare ones, and §4.3.1 pins their behaviour at the kink by
// defining them with the conditional operator:
//
//     min(x,y) is equivalent to (x < y) ? x : y
//     max(x,y) is equivalent to (x > y) ? x : y
//     abs(x)   is equivalent to (x > 0) ? x : -x
//
// So the selection is by COMPARISON, never by magnitude — the classic wrong
// answer is a max() that picks the larger |x| and returns -3.0 below.
//
// At the declared bias V(p,n) = -3.5 the fixture's own composite is
// min(abs(-3.5), max(1.0, -3.5)) = min(3.5, 1.0) = 1.0. Every want here is a
// dyadic rational, so exact equality is the right claim. $min of two integers
// is the integer-result rule of Table 4-14, hence CHECKI.
//
//! lrm G.1
//! lrm 4.3.1
//! lrm 9.14
//! lrm 4.3
//! lrm 4.3:1000
//! bias V(p) = -3.5, V(n) = 0
//! print none
//! checks 10
`include "check.vh"
module annex_g_system_math(p, n);
  inout p, n; electrical p, n;
  analog begin
    `CHECKX("$abs of a negative bias", $abs(V(p,n)), 3.5);
    `CHECKX("$abs leaves a positive alone", $abs(2.25), 2.25);
    `CHECKX("$min takes the lesser", $min(2.0, 3.0), 2.0);
    `CHECKX("$max takes the greater, not the larger magnitude",
            $max(-2.0, -3.0), -2.0);
    `CHECKX("$min takes the lesser, not the smaller magnitude",
            $min(-2.0, -3.0), -3.0);
    `CHECKI("$min of two integers", $min(7, 4), 4);
    `CHECKX("traditional abs has the same independently derived value", abs(V(p,n)), 3.5);
    `CHECKX("traditional min selects the lesser signed value", min(-2.0, -3.0), -3.0);
    `CHECKX("traditional max selects the greater signed value", max(-2.0, -3.0), -2.0);
    `CHECKX("the composite at V(p,n) = -3.5",
            $min($abs(V(p,n)), $max(1.0, V(p,n))), 1.0);
    I(p,n) <+ $min($abs(V(p,n)), $max(1.0, V(p,n)));
  end
endmodule
