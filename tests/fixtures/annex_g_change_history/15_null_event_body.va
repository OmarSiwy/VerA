// Annex G.2.2 NULL, third survivor: the body of an event statement. A.6.5 gives
//   analog_event_control_statement ::= analog_event_control analog_event_statement
// and A.6.4's analog_event_statement lists `{ attribute_instance } ;` as an
// alternative outright, so `@(<event>) ;` is legal and CONSUMES the event.
// 05_null_statement_scope.va pins the conditional, 14_null_case_arm.va the case
// arm.
//
// As with the case arm the risk is binding, not acceptance, and it is only
// observable when the event does NOT fire -- if it fires, both parses run the
// following statement once and agree. So the run is dc while the event list is
// ("tran"): per §5.10.2 and Table 5-1 an analysis list names the analyses the
// global event is active for, "tran" does not include dc, and the event body
// never runs.
//
// Derivation: y is 1.0, the inactive event's null body does nothing, then
// y = y + 1.0 gives 2.0 exactly (both operands and the sum are integral
// doubles, hence CHECKX). If the `;` is dropped and `y = y + 1.0` is taken as
// the event body instead, it is skipped with the event and y stays 1.0.
//
//! lrm G.2.2
//! lrm A.6.4
//! lrm A.6.5
//! lrm 5.10.2
//! lrm A.6.4:1000
//! lrm A.6.5:1000
//! analysis dc
//! print none
`include "check.vh"
module annex_g_null_event_body(p, n);
  inout p, n; electrical p, n;
  real y;
  analog begin
    y = 1.0;
    @(initial_step("tran")) ;
    y = y + 1.0;
    `CHECKX("the statement after a null event body still runs unconditionally", y, 2.0);
    I(p,n) <+ 0.0 * V(p,n);
  end
endmodule
