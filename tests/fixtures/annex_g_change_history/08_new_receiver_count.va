// Annex G Table G.7 item 7793 is "Support $receiver_count() function, 9.22.2" —
// the function this fixture exists to pin. READ THE CLAUSE NUMBER CAREFULLY:
// 9.22.2 is the annex's number, not this document's. In the shipped text §9.22.2
// is $driver_state; $receiver_count appears in an UNNUMBERED paragraph inside
// §9.22.1, and that paragraph opens "Non-normative: $receiver_count is not a
// subclause of 9.22 in Verilog-AMS 2.4. Where a simulator provides it,
// $receiver_count returns an integer representing the number of receivers
// associated with the signal in question."
//
// So there is no value to write down: the count is a property of the elaborated
// netlist AND the clause defers its very existence to the simulator. Asserting
// 0 would pin an implementation-defined number and fail a conforming compiler.
//
// What IS pinned is the CALL SITE, and it rests on the normative frame the
// paragraph sits inside, not on the paragraph:
//
//   - §9.22 intro, unqualified: "Driver access functions can only be called from
//     connect modules." The call below is in an ordinary module.
//   - Table 9-19 gives every member of the family "Supported in analog context
//     of connectmodule: No". The call below is in an `analog` block.
//
// Both are violated here, so the module shall be diagnosed. The inference is
// that $receiver_count is one of the family — which is why the paragraph's
// placement is spelled out above rather than asserted.
//
// NO CODE IS PINNED. VerA has no diagnostic for a connectmodule-only function
// used outside one, so there is no stable code to name, and guessing at one is
// how an xfail gets stuck: pin the wrong code and the XPASS never fires when the
// gap closes under a different code. E0801 "unsupported system function" in
// particular is the WRONG rule — it is VerA's capability class for functions it
// declines to implement at all (§9.13 $random, §9.21 $table_model), and it fires
// on the NAME in any context, whereas the LRM's rule is about the context and
// makes the identical call legal in the digital part of a connectmodule.
// `DiagnosticsReported` is honest: this module's only defect is the call, so any
// diagnostic at all means someone diagnosed it.
//
//! lrm G.7
//! lrm 9.22
//! reject DiagnosticsReported
//! xfail VerA lowers every 9.22 driver-access query to the constant 0 in any module (codegen.zig `driver_queries`) instead of diagnosing the call outside a connectmodule
module annex_g_receiver_count(p, n);
  inout p, n; electrical p, n;
  analog begin
    I(p,n) <+ V(p,n) * $receiver_count(p);
  end
endmodule
