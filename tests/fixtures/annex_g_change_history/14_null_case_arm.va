// Annex G.2.2 NULL: "This statement is no longer supported. Certain functions
// such as case, conditionals and the event statement do allow null statements
// as defined by the syntax." Three survivors. 05_null_statement_scope.va pins
// the conditional, 15_null_event_body.va pins the event statement, and this one
// pins the case arm: A.6.7 gives
//   analog_case_item ::= analog_expression { , analog_expression } :
//                        analog_statement_or_null
// and A.6.4's analog_statement_or_null is where the bare `;` lives.
//
// The failure mode worth catching is ARM BINDING, not acceptance: a parser that
// treats the `;` as absent makes the NEXT arm's statement the body of the
// matched arm. So the arms carry distinct values and only the correct parse
// leaves y untouched.
//
// Derivation: y is 2.0 before the case and mode is 1, which selects the null
// arm, so nothing runs and y stays 2.0 exactly (a literal round-trip, hence
// CHECKX). Every mis-parse gives a different number -- swallowing the `;` makes
// `y = 9.0` the body of arm 1 (9.0), falling through to default gives 9.0, and
// matching arm 0 gives 3.0.
//
//! lrm G.2.2
//! lrm A.6.4
//! lrm A.6.7
//! lrm A.6.4:1000
//! lrm A.6.7:1000
//! print none
`include "check.vh"
module annex_g_null_case_arm(p, n);
  inout p, n; electrical p, n;
  parameter integer mode = 1;
  real y;
  analog begin
    y = 2.0;
    case (mode)
      0: y = 3.0;
      1: ;
      default: y = 9.0;
    endcase
    `CHECKX("the null case arm matched and did nothing", y, 2.0);
    I(p,n) <+ 0.0 * V(p,n);
  end
endmodule
