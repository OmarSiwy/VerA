// §3.4.1: "If the type of a parameter is not specified, it is derived from the
// type of the final value assigned to the parameter, after any value overrides
// have been applied, as in IEEE Std 1364 Verilog."
//
// Neither parameter below carries a type. The only thing separating them is the
// spelling of the initializer — `4` against `4.0` — and §4.2.4 then makes the
// two divisions answer different things, because integer division truncates:
//
//     4   / 3   -> 1                      (both operands integer)
//     4.0 / 3   -> 1.3333333333333333     (real division, correctly rounded)
// The denominator must be integer: a real denominator would promote even an
// incorrectly integer-typed numerator and conceal the inference error.
//
// So the derived type is observable as a value rather than as a declaration.
// 04_parameter_types.va declares all three of its parameters with an explicit
// type and therefore says nothing about the derivation.
//
// The real want is the double nearest 4/3, printed to 17 significant digits:
// python3 -c "print(repr(4.0/3.0))" -> 1.3333333333333333.
//
//! lrm 3.4.1
//! lrm 3.4.1:1001
//! lrm 4.2.4
//! checks 3
`include "check.vh"
module ch03_untyped_parameter_type_derivation(p, n);
    inout p, n;
    electrical p, n;
    parameter counted = 4;
    parameter measured = 4.0;

    analog begin
        `CHECKI("an untyped parameter with an integer value divides as an integer", counted / 3, 1);
        `CHECKX("an untyped parameter with a real value divides as a real", measured / 3, 1.3333333333333333);
        `CHECKX("the two initializers are numerically equal before the division", measured - counted, 0.0);
        I(p, n) <+ measured * V(p, n);
    end
endmodule
