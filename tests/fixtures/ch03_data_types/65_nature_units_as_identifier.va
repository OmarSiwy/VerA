// §3.6.1.2, units: "The units attribute provides a binding between the value of
// the access function and the units for that value. ... If specified, the
// constant expression assigned to it shall be a string."
//
// `units = Volt;` writes an identifier where the string belongs. It is the exact
// mirror of 65_nature_access_as_string.va, and a separate file because it is a
// separate check — a compiler that treats every attribute value as an opaque
// token passes both, and one that special-cases only `access` passes this one.
//
// The units value is not decoration: §3.11.1's Units Value Rule decides net
// compatibility on it — "Two natures are compatible if they have the same value
// for the units attribute" — so an unstringly-typed units makes that comparison
// meaningless. 76_nature_compatibility_rules.va is the fixture that depends on
// it.
//
// The pinned substring is only the phase label: VerA has no diagnostic for this
// rule, so a code would pin the wrong one.
//
//! lrm 3.6.1.2
//! lrm 3.11.1
//! reject DiagnosticsReported
//! xfail VerA accepts a bare identifier as the `units` attribute of a nature; lower.zig does not type-check nature attribute values
nature ch3_units_ident; units=Volt; access=UnitsIdentV; abstol=1u; endnature
module ch3_nature_units_as_identifier; endmodule
