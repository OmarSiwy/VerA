// §9.15: $simparam("gmin") returns the host's value of Table 9-27's `gmin`,
// "Minimum conductance placed in parallel with nonlinear branches" — a value the
// compiler does not know: VerA publishes it as the host-written Model field
// `gmin__` (specification/Vague_Decisions.md VD-072), so `amount` is derived from it.
// §6.3.4 then makes the localparam `size` follow it, and §3.4.5 says a
// localparam "shall not be directly modified", so the host cannot patch `size`:
// the device has to derive it, after the host's write.
//
// The number, for any host whose gmin is below 0.5 S (every simulator's minimum
// conductance is orders of magnitude below that; the default here is 1e-12):
// §4.2.1.1 rounds the real to the nearest integer, so amount = 0, and IEEE 1364
// §17.11.1 "an argument value of 0 shall produce a result of 0", so size = 0.
//
//! lrm 3.4.5
//! lrm 6.3.4
`include "check.vh"
module dependent_control_unknown_local(p);
  inout p; electrical p;
  parameter integer amount = $simparam("gmin");
  localparam integer size = $clog2(amount);
  analog begin
    `CHECKI("§6.3.4 size derives from the host's gmin: $clog2(0)", size, 0);
    I(p) <+ V(p);
  end
endmodule
