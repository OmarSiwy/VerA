// Dependent operators preserve their widths and recompute conditional defaults.
//! lrm 4.2.4
//! lrm 4.2.11
//! lrm 4.2.12
//! lrm 6.3.4
//! lrm 6.3.4:1000
//! param amount = 4
//! param negative_count = -1
//! param wide_count = 32
//! param version = 2.2
//! param dividend = -7.5
//! param divisor = -2
//! param magnitude = 1e20
//! param guarded_divisor = 0
`include "check.vh"
module dependent_control_operators;
  parameter integer amount = 2;
  parameter integer negative_count = 2;
  parameter integer wide_count = 1;
  parameter real version = 2.51;
  parameter real dividend = 0;
  parameter real divisor = -1 from [-3:-1];
  parameter real magnitude = 0;
  parameter real guarded_divisor = 2 from [0:2];
  localparam integer left = 1 << amount;
  localparam integer right = -16 >> amount;
  localparam integer negative_left = 8 << negative_count;
  localparam integer negative_right = 8 >> negative_count;
  localparam integer wide_left = 1 << wide_count;
  localparam integer wide_right = -1 >> wide_count;
  localparam real ddltslp = (version * 10 % 10) < 3 ? 0 : 10;
  localparam real ddltict = (version * 10 % 10) < 3 ? 10 : 0;
  localparam real signed_remainder = dividend % divisor;
  localparam real positive_remainder = -dividend % divisor;
  localparam real positive_divisor = dividend % -divisor;
  localparam real both_positive = -dividend % -divisor;
  localparam real exact_remainder = magnitude % 3.0;
  localparam real guarded_remainder = guarded_divisor > 0.0 ? dividend % guarded_divisor : 17;
  analog begin
    `CHECKI("host left shift", left, 16);
    `CHECKI("host logical right shift of signed integer", right, 268435455);
    `CHECKI("negative left count is unsigned oversized", negative_left, 0);
    `CHECKI("negative right count is unsigned oversized", negative_right, 0);
    `CHECKI("left count at integer width", wide_left, 0);
    `CHECKI("right count at integer width", wide_right, 0);
    `CHECKX("HiSIMHV conditional remainder true arm", ddltslp, 0.0);
    `CHECKX("HiSIMHV conditional remainder false arm", ddltict, 10.0);
    `CHECKX("real remainder has dividend sign", signed_remainder, -1.5);
    `CHECKX("positive dividend with negative divisor", positive_remainder, 1.5);
    `CHECKX("negative dividend with positive divisor", positive_divisor, -1.5);
    `CHECKX("both positive real remainder operands", both_positive, 1.5);
    `CHECKX("real remainder avoids subtractive cancellation", exact_remainder, 1.0);
    `CHECKX("guarded real zero remainder stays untaken", guarded_remainder, 17.0);
  end
endmodule
