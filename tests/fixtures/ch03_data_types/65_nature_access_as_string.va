// §3.6.1.2, access: "The access attribute identifies the name for the access
// function. ... The constant expression assigned to it shall be an identifier
// (by name, not as a string)."
//
// `access = "AccessStr";` writes the string, not the identifier. The LRM makes
// the same point again two attributes down, in capitals of its own — "the
// constant expression assigned to idt_nature shall be the name (not a string)
// of a nature" — because the two forms are one character apart and mean
// different things: an identifier introduces a callable name into the module,
// a string is a value.
//
// Every other nature in the chapter writes `access=V;` correctly, so nothing
// else provokes this.
//
// Pin E0340, verified at the offending attribute, rather than accepting an
// unrelated failed compilation phase.
//
//! lrm 3.6.1.2
//! lrm 3.6.1.2:2
//! reject-only E0340
//! neighbour 10_nature_declarations.va
nature ch3_access_string; units="V"; access="AccessStr"; abstol=1u; endnature
module ch3_nature_access_as_string; endmodule
