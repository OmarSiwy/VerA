// §3.6.2 discipline declarations. A conservative discipline binds a potential
// nature and a flow nature, and §3.6.1.2 says the nature's `access` attribute
// is what names the access function — so a net declared `ch03_conservative`
// is read with V() and driven with I() for no reason other than that the two
// natures above say `access = V` and `access = I`.
//
// `c1`/`c2` are nets of the user-declared discipline, biased 2.5 V and 0.5 V,
// so the potential access function must return their difference.
//
// §3.6.2.1: "A signal-flow discipline may specify either the potential or the
// flow nature." `sf` is a net of the potential-only discipline, which makes it a
// signal-flow net with exactly ONE access function — the same `V`, because the
// same nature is bound — and no flow at all. Biased at 1.25 V it reads 1.25, and
// a compiler that required every net to be conservative cannot compile it.
// 64_flow_on_potential_only_net.va is the error side of that one-access-function
// claim.
//
//! lrm 3.6.2
//! lrm 3.6.2.1
//! lrm 3.6.1.2
//! lrm 1.3.3
//! bias V(c1) = 2.5, V(c2) = 0.5, sf = 1.25
`include "check.vh"
nature ch03_potential;
    units = "V";
    access = V;
    abstol = 1u;
endnature

nature ch03_flow;
    units = "A";
    access = I;
    abstol = 1p;
endnature

discipline ch03_conservative;
    domain continuous;
    potential ch03_potential;
    flow ch03_flow;
enddiscipline

discipline ch03_potential_only;
    potential ch03_potential;
enddiscipline

discipline ch03_flow_only;
    flow ch03_flow;
enddiscipline

module ch03_discipline_declarations(p, n);
    inout p, n;
    electrical p, n;
    ch03_conservative c1, c2;
    ch03_potential_only sf;

    analog begin
        `CHECKX("the bound potential nature's access function reads the branch", V(c1, c2), 2.0);
        `CHECKX("a signal-flow net has the potential access function of its one nature", V(sf), 1.25);
        I(p, n) <+ V(p, n);
        I(c1, c2) <+ 0.001 * V(c1, c2);
        V(sf) <+ 1.25;
    end
endmodule
