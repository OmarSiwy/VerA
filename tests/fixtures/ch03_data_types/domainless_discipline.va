// §3.6.2.3: "Disciplines without a domain binding and without a nature binding
// are known as domainless disciplines" — the LRM's `domainless` example, which
// it declares legal and then deprecates: "Usage of domainless disciplines ...
// is discouraged ... the definition of a domainless discipline may be made an
// error in FUTURE versions". Discouraged is not an error in this edition, so
// this file must RUN.
//
// The domain is determined by connectivity. A domainless net connects two
// electrical child ports in a divider; hierarchical probes observe the child
// pins without turning the domainless net into a local behavioral reference.
//
//! bias V(p) = 0.75
//! solve
//! checks 3
//! lrm 3.6.2.3
//! lrm 3.6.2.3:1
`include "check.vh"
discipline ch3_domainless;
enddiscipline

module ch3_domainless_resistor(a,b);
    inout a,b;
    electrical a,b;
    analog I(a,b) <+ V(a,b);
endmodule

module ch3_domainless_structural(p);
    inout p;
    electrical p;
    ch3_domainless link;
    electrical g;
    ground g;
    ch3_domainless_resistor upper(p,link);
    ch3_domainless_resistor lower(link,g);

    analog begin
        `CHECKX("a module carrying a domainless net still elaborates and solves", V(p), 0.75);
        `CHECK("connectivity resolves the domainless divider midpoint", V(upper.b), 0.375, 1e-9);
        `CHECK("both electrical instances share the resolved domainless net", V(lower.a), 0.375, 1e-9);
        I(p) <+ 0.0 * V(p);
    end
endmodule
