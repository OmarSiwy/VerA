// AMS 3.4.4: changing the size through a parameter override requires a new-size
// replacement array from the same overriding module. Here size changes from
// two to three, but no replacement is supplied. Padding the default is not legal.
//! lrm 3.4.4
//! lrm 3.4.4:5
//! reject-only E0921
//! neighbour audit_parameter_array_resize_with_value.va
module resize_array_target;
  parameter integer count = 2;
  parameter real coefficients[0:count-1] = '{1.0, 2.0};
  analog begin end
endmodule
module audit_parameter_array_resize_without_value_rejected;
  resize_array_target #(.count(3)) child();
endmodule
