// §3.2 Syntax 3-1 gives an array one `dimension` per bracketed range:
//
//     real_type ::= real_identifier { dimension } [ = constant_assignment_pattern ]
//
// and §3.2's own examples count them: `real gain_factor[1:30]` is one dimension,
// `integer flag_array[0:8][0:3]` two. A.8.5's array_analog_variable_rvalue
// subscripts an array with at most as many `[ analog_expression ]` as it has
// dimensions; IEEE 1364-2005 §5.2.2 says the same of every array: "an address
// for each dimension".
//
// `g` below has ONE dimension and is read with TWO subscripts. The first names
// a real element; a real has no bits (1364 §4.8.1), so the second names nothing.
//
// (The SHORT form, fewer subscripts than dimensions, is §5.7's slice and is
// legal; ch04_expressions/a01_01_partial_slice_assignment.va records that VerA
// refuses it with this same code. This file is the other direction.)
//
//! lrm 3.2
//! lrm A.8.5
//! inherited IEEE 1364-2005 5.2.2
//! reject-only E0356
//! neighbour ../ch04_expressions/a01_01_partial_slice_assignment.va
`include "disciplines.vams"
module ch3_array_extra_subscript(p, n);
  inout p, n; electrical p, n;
  real g[0:1];
  analog begin
    g[0] = 1.0;
    g[1] = 2.0;
    I(p, n) <+ g[1][0] * V(p, n);
  end
endmodule
