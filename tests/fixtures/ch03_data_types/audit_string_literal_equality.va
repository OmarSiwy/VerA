// AMS 3.3 Table 3-3: "If both operands are string literals, the operator
// is the same Verilog equality operator as for integer types."
// "A\0" is the 16-bit unsigned integer 0x4100; "A" is 0x41, zero-extended
// to 0x0041 for comparison. They differ: equality is 0 and inequality is 1.
// NUL removal belongs to conversion to string type, not this literal-only
// comparison. audit_string_comparison_context.va tests that other context.
//! lrm 3.3
//! checks 2
//! xfail STR-LITERAL-001: literal-only equality incorrectly removes NUL bytes
`include "check.vh"
module audit_string_literal_equality(p, n);
  inout p, n; electrical p, n;
  analog begin
    `CHECKI("literal equality preserves its integer bytes", ("A\0" == "A"), 0);
    `CHECKI("literal inequality preserves its integer bytes", ("A\0" != "A"), 1);
    I(p,n) <+ V(p,n);
  end
endmodule
