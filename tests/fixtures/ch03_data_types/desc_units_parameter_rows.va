// §3.4.3: "The standard attributes for descriptions and units, described in
// 2.9.2, can be used for parameters." ... "Simulators can use this
// information when generating help messages for a module" ... "Units and
// descriptions specified for block-level parameters shall be ignored by the
// simulator, but can be used for documentation purposes."
//
// §2.9.2: "The desc attribute is used to generate help messages when attached
// to parameter, variable and net declarations within a module. The attribute
// must be assigned a string." and "The units attribute is used to describe the
// units of the parameter or variable which it is attached to".
//
// A help message is the host's to print, so the evidence is what the device
// hands a host: its `decl_meta` table (`contract.DeclMeta`), one `//! meta`
// line per row, parameters in declaration order. By hand, row by row:
//
//   res    the clause's own example, `(* desc="Resistance", units="Ohms" *)`:
//          both strings, as written ("no dimensional analysis is performed").
//   ang    `(* units="degrees" *)`: units only; desc absent, so not printed.
//   dup    `(* desc="first", desc="second" *)`. §2.9: "If the same attribute
//          name is defined more than once for the same language element, the
//          last attribute value shall be used": desc="second".
//   g1,g2  one prefix on a two-name list. §2.9 Example 5 puts
//          `(* fsm_state=1 *) reg [3:0] state2, state3;` on both names, so
//          each of g1 and g2 is a row with desc="loop gain".
//   plain  no attribute: no row.
//   vb     a named block's parameter with desc and units: "shall be
//          ignored", so no row. Five rows in all.
//
// The CHECKs pin that an attributed parameter is still an ordinary one: res
// takes `//! param res = 250`, and I = V/res = (1.5 - 0.25)/250 = 5.0e-3
// exactly (1.25/250 is the correctly rounded 5e-3).
//
//! lrm 3.4.3
//! lrm 3.4.3:1
//! lrm 2.9.2
//! lrm 2.9:4
//! param res = 250
//! bias V(p) = 1.5, V(n) = 0.25
//! meta parameter res desc="Resistance" units="Ohms"
//! meta parameter ang units="degrees"
//! meta parameter dup desc="second"
//! meta parameter g1 desc="loop gain"
//! meta parameter g2 desc="loop gain"
//! checks 8
`include "check.vh"
module ch3_desc_units_parameter_rows(p, n);
    inout p, n;
    electrical p, n;
    (* desc="Resistance", units="Ohms" *)
    parameter real res = 1.0 from [0:inf);
    (* units="degrees" *) parameter real ang = 90.0;
    (* desc="first", desc="second" *) parameter real dup = 2.0;
    (* desc="loop gain" *) parameter real g1 = 1.0, g2 = 2.0;
    parameter real plain = 3.0;

    analog begin : blk
        (* desc="block bias", units="V" *) parameter real vb = 0.5;
        `CHECKX("an attributed parameter still takes its override", res, 250.0);
        `CHECKX("and computes as a parameter", V(p, n) / res, 5.0e-3);
        I(p, n) <+ V(p, n) / res + 0.0 * (ang + dup + g1 + g2 + plain + vb);
    end
endmodule
