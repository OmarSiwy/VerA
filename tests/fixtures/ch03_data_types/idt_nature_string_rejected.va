// §3.6.1.2, idt_nature: "If specified, the constant expression assigned to
// idt_nature shall be the name (not a string) of a nature which is defined
// elsewhere."
//
// `ch3_idt_str_self` writes its own name as the STRING "ch3_idt_str_self".
// This is idt_nature_self_reference.va with the identifier that the clause
// permits changed to the string form it forbids. E0340 is the form diagnostic
// (lib/analog/lower/discipline.zig's checkNatureAttrValue), not the
// unresolved-name or unrelated-nature diagnostic.
//
//! lrm 3.6.1.2
//! lrm 3.6.1.2:4
//! reject-only E0340
//! neighbour idt_nature_self_reference.va
`include "check.vh"
nature ch3_idt_str_self;
    units = "V";
    access = StrV;
    abstol = 1u;
    idt_nature = "ch3_idt_str_self";
endnature

nature ch3_idt_str_flow;
    units = "A";
    access = StrI;
    abstol = 1p;
endnature

discipline ch3_idt_str_disc;
    potential ch3_idt_str_self;
    flow ch3_idt_str_flow;
enddiscipline

module ch3_idt_nature_string_rejected(p, n);
    inout p, n;
    ch3_idt_str_disc p, n;

    analog begin
        StrI(p, n) <+ StrV(p, n);
    end
endmodule
