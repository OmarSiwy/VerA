// AMS 3.5 allows static expressions containing parameters and other genvars.
// Outer i is 1,2; inner j starts from i and takes i,i+1. Thus there are four
// iterations with pairs (1,1),(1,2),(2,2),(2,3). Their weighted sum is
// 11+12+22+23=68. The empty loop must execute zero times. Both counts and sum
// are independently observed; ordinary integer-loop acceptance alone does not
// establish the restriction against nonstatic genvar control expressions.
//! lrm 3.5
//! lrm 3.5:1000
//! checks 3
`include "check.vh"
module audit_genvar_static_dependencies;
  parameter integer first = 1, limit = 3;
  genvar i, j, k;
  real sum, trips, empty_trips;
  analog begin
    sum = 0.0;
    trips = 0.0;
    empty_trips = 0.0;
    for (i = first; i < limit; i = i + 1) begin
      for (j = i; j < i + 2; j = j + 1) begin
        sum = sum + 10*i + j;
        trips = trips + 1;
      end
    end
    for (k = limit; k < first; k = k + 1) begin
      empty_trips = empty_trips + 1;
    end
    `CHECKX("static nested bounds preserve genvar values", sum, 68.0);
    `CHECKX("nested trip count", trips, 4.0);
    `CHECKX("initially false condition executes no body", empty_trips, 0.0);
  end
endmodule
