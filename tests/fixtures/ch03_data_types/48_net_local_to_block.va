// §3.13.3: "The scope rules for net identifiers are the same as the scope rules
// for any other identifier declarations, except nets can not be declared
// anywhere other than in the port of a module or in the module itself. A net
// can only be declared inside a module scope; a net can not be declared local
// to a block."
//
// `inner` is declared inside the named analog block `blk`, which is the one
// place that sentence forbids. Moving the identical declaration up one level,
// beside `electrical p, n;`, makes the file legal — that is the whole defect.
// It is NOT a general ban on block-local declarations: §5.3 allows a
// block-local real and a block-local parameter, and
// ch05_analog_behavior/named_block_locals.va exercises both, so a compiler that
// rejected everything in a block for the wrong reason still has to be right
// about which kinds are excluded.
//
// The pinned substring is only the phase label. VerA has no scope-rule
// diagnostic here — today `electrical` in statement position falls through to
// an expression statement and reports E0214 — so pinning that code would pin
// the parser's recovery path rather than §3.13.3, and it would stop matching
// the day the declaration is parsed and then rejected properly.
//
//! lrm 3.13.3
//! reject DiagnosticsReported
module ch3_net_local_to_block(p, n);
    inout p, n;
    electrical p, n;

    analog begin : blk
        electrical inner;
        I(p, n) <+ V(p, n);
    end
endmodule
