// The actual lossy_tline classification changes after its host card is bound.
//! lrm 3.4.5
//! lrm 6.3.4
//! lrm 6.3.4:1000
//! param r = 1
//! param g = 1
//! param len = 2
`include "check.vh"
module dependent_control_rg;
  parameter real r = 0;
  parameter real l = 0;
  parameter real g = 0;
  parameter real c = 0;
  parameter real len = 0;
  localparam integer wave = (g == 0) && (l > 0) && (c > 0);
  localparam integer ok = wave
      || ((r > 0) && (g == 0) && (l == 0) && (c > 0))
      || ((r > 0) && (g > 0) && (l == 0) && (c == 0));
  analog begin
    `CHECKI("RG does not select wave equations", wave, 0);
    `CHECKI("RG card becomes valid", ok, 1);
    `CHECKX("RG length is bound", len, 2);
  end
endmodule
