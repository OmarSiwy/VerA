// §3.10: "It is not legal to have two different disciplines at the same level
// of precedence for the same net."
//
// `sig` is declared twice in the same module, once with each of two
// disciplines. Both declarations are in-context and local, so they share one
// level of precedence; nothing in the resolution order of §7.4/Annex F can
// choose between them. §3.10's next sentence makes the pair an error
// "regardless of whether the disciplines are compatible or not", and the two
// here are deliberately compatible — both are natureless with a continuous
// domain — so a compiler cannot discharge the conflict by comparing natures.
//
// 12_scalar_nets.va is the legal side: one declaration per net, with the net
// still readable and KCL/KVL still holding at it.
//
// E0902 is the discipline-resolution conflict; Annex F.2.1 and F.2.2 state the
// same error, so this pins the §3.10 sentence that both algorithms rest on.
//
//! lrm 3.10
//! lrm 3.10:1001
//! lrm F.2.1:3
//! lrm F.2.2:4
//! reject-only E0902
//! neighbour 12_scalar_nets.va
discipline ch03_conflict_a;
    domain continuous;
enddiscipline

discipline ch03_conflict_b;
    domain continuous;
enddiscipline

module ch03_conflicting_disciplines_in_context(sig);
    inout sig;
    ch03_conflict_a sig;
    ch03_conflict_b sig;
endmodule
