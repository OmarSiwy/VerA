// §§3.2, 5.8, 5.9: invalid array reads in untaken paths are never evaluated.
//! lrm 5.8
//! lrm 5.8.1
//! lrm 5.8.1:3
`include "check.vh"
module ch03_dynamic_multidim_guards(p);
    inout p;
    electrical p;
    parameter integer pick = 5;
    parameter integer stop = 4;
    real a[1:0][1:0] = '{'{10,11},'{20,21}};
    integer i, j;
    real x, y, z, total;
    analog begin
        i = pick; j = 0;
        x = 7;
        if (i >= 0 && i <= 1) x = a[i][j];
        y = (i >= 0 && i <= 1) ? a[i][j] : 8;
        z = 9;
        if (i == 0) begin
            if (j == 0) z = a[i][j];
            else z = 2 * a[i][j];
        end
        `CHECKX("untaken if does not evaluate invalid index", x, 7);
        `CHECKX("untaken ternary does not evaluate invalid index", y, 8);
        `CHECKX("untaken nested branch does not evaluate invalid index", z, 9);
        total = 0;
        for (i = -1; i < stop; i = i+1) begin
            if (i >= 0 && i <= 1) begin
                x = a[i][j];
                y = 2 * a[i][j];
                total = total + x + y;
            end
        end
        `CHECKX("guarded repeated reads survive loop invalid indices", total, 96);
        I(p) <+ 0 * V(p);
    end
endmodule
