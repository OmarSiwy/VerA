// §3.4.4 parameter arrays, from the LRM's `poles` example. The assignment
// pattern fills the declared range LEFT INDEX FIRST: with `[0:3]` the literal
// 1.0 lands at index 0 and 2.0 at index 3. Element 1 and element 3 differ, and
// both differ from the reversed order, so an implementation that filled the
// array backwards fails both lines below.
//
// §3.4.4 also says "array range in the parameter array declaration may depend
// on previously-declared parameters", so the upper bound is written as `last`
// rather than as the literal 3. The assertions are unchanged: they now also say
// the declared range tracked the parameter, because a compiler that failed to
// evaluate `last` cannot have made a four-element array at all.
//
//! lrm 3.4.4
//! lrm 3.2
//! lrm 3.2:2
//! lrm 3.4
//! lrm 3.4:2
`include "check.vh"
module ch03_parameter_array(p, n);
    inout p, n;
    electrical p, n;
    parameter integer last = 3;
    parameter real coefficients[0:last] = '{1.0, 3.198, 4.554, 2.0};

    analog begin
        `CHECKX("assignment pattern fills index 0 first", coefficients[0], 1.0);
        `CHECKX("interior element keeps its own value", coefficients[1], 3.198);
        `CHECKX("the other interior element is independently retained", coefficients[2], 4.554);
        `CHECKI("the array range came from a previously-declared parameter", last, 3);
        `CHECKX("last element is the last literal", coefficients[3], 2.0);
        I(p, n) <+ coefficients[0] * V(p, n) + coefficients[3];
    end
endmodule
