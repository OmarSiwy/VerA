// DEBT — this rejection is NOT conformance.
// The LRM permits what VerA refuses here. The substrings below record
// CURRENT behavior so the suite stays green on it; they do not claim it
// is right. `zig build ledger` counts this rule against VerA.
//
// VAMS-3.12-03  (ch3-datatypes.html)
// If one of the terminals of a branch is a vector net, then the other terminal shall either be a scalar net or a vector net of the same size.
// VAMS-3.12-04  (ch3-datatypes.html)
// If the range of the vector branch is not specified then the indexing of the vector branch shall start at 0.
//
//! reject DiagnosticsReported
module ch3_vector_branches(a,b); inout a,b; electrical [3:1] a; electrical [1:3] b; branch(a,b) paths; analog I(paths[0])<+V(paths[1]); endmodule
// EXPECT: error -- normative syntax/restriction snapshot for this rule family.
