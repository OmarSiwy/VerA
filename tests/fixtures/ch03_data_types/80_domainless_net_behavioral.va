// §3.6.3/§3.6.1.3 again, one step further than 31_domainless_discipline.va: a
// DOMAINLESS discipline binds neither a domain nor a nature (§3.6.2.3), so a net
// of it has no potential access function and cannot be contributed to. §3.6.2.4
// adds the second reason for this file: a net with no discipline that IS
// referenced in behavioral code "shall be treated as having no discipline with a
// domain binding of discrete", and a discrete net is not something an analog
// contribution can drive.
//
// As in 79, no code is pinned: VerA accepts the contribution, so there is no
// code to pin that would still mean this rule later.
//
//! lrm 3.6.3
//! lrm 3.6.2.3
//! reject DiagnosticsReported
//! xfail VerA resolves `V(link)` on a net of a domainless discipline and accepts the contribution; there is no access-function-not-found check in lower.zig
discipline ch3_domainless_beh;
enddiscipline

module ch3_domainless_behavioral(p);
    inout p;
    electrical p;
    ch3_domainless_beh link;

    analog begin
        V(link) <+ 1.0;
        I(p) <+ 0.0 * V(p);
    end
endmodule
