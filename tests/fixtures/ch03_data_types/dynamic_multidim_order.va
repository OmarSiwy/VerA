// §§3.4.8, 5.7 and 9.21.1: every array consumer walks declaration order.
//! lrm 5.7
//! lrm 5.7:4
//! lrm 5.7:8
`include "check.vh"
module ch03_dynamic_multidim_order(p);
    inout p;
    electrical p;
    real a[3:2][-1:0] = '{'{10,11},'{20,21}};
    real b[0:1][5:4];
    real xs[3:2] = '{0,2};
    real ys[-1:0] = '{10,30};
    integer i, j;
    analog begin
        b = a;
        i = 0; j = 5;
        `CHECKX("copy pairs leftmost elements", b[i][j], 10);
        `CHECKX("copy keeps inner declaration direction", b[0][4], 11);
        `CHECKX("copy keeps outer declaration direction", b[1][5], 20);
        `CHECKX("copy pairs rightmost elements", b[1][4], 21);
        b = '{'{31,32},'{41,42}};
        a = b;
        `CHECKX("pattern and copy share order", a[3][-1], 31);
        `CHECKX("pattern and copy last element", a[2][0], 42);
        // The two columns have opposite directions. Reversing either one
        // independently pairs the wrong abscissas and ordinates.
        `CHECKX("table columns use declaration order", $table_model(0.5, xs, ys, "1"), 15);
        I(p) <+ 0 * V(p);
    end
endmodule
