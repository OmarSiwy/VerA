// §3.6.1: "Each nature definition ... shall include all the required attributes
// specified in 3.6.1.2." §3.6.1.2 says of access: "This attribute is required
// for all base natures."
//
// `ch3_no_access` is a BASE nature carrying units and abstol but not access.
// The consequence is that a net of the discipline below has no potential access
// function under any spelling (§3.13.3, "a net can only be accessed through its
// access functions"), which is why the missing attribute is an error at the
// nature and not merely at first use.
//
// Third of the three required attributes; 35 covers abstol and
// 57_base_nature_missing_units.va covers units.
// The signal-flow port is output (§1.3.4.1), avoiding an unrelated inout error.
//
//! lrm 3.6.1.2
//! lrm 3.6.1.2:1001
//! lrm 3.6.1
//! lrm 3.6.1:2
//! reject-only E0332
nature ch3_no_access; units="V"; abstol=1u; endnature
discipline ch3_no_access_disc; potential ch3_no_access; enddiscipline
module ch3_missing_access(p); output p; ch3_no_access_disc p; analog begin end endmodule
