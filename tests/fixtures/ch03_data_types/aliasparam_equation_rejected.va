// §3.4.7: "the equations in the module shall reference the parameter by its
// original name, not the alias." An alias is a binding name, not a second
// expression spelling. 07_parameter_alias.va supplies the legal neighbour:
// its host binds the alias and equations read the original parameter.
//! lrm 3.4.7
//! reject E0373
module aliasparam_equation(p);
  inout p; electrical p;
  parameter real gain=1;
  aliasparam alternate=gain;
  analog I(p) <+ alternate*V(p);
endmodule
