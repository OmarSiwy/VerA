// A.2.1.3 gives a net declaration a list of names or a list of assignments:
//
//     net_declaration ::= ...
//             | discipline_identifier [ range ] list_of_net_identifiers ;
//             | discipline_identifier [ range ] list_of_net_decl_assignments ;
//     list_of_net_identifiers ::= ams_net_identifier { , ams_net_identifier }   // A.2.3
//     list_of_net_decl_assignments ::= net_decl_assignment { , net_decl_assignment }
//     net_decl_assignment ::= ams_net_identifier = expression                  // A.2.4
//
// and every net type alternative is split the same way. `electrical p = 1.5,
// n;` starts the second list and ends with an entry of the first, so it is
// neither. The legal neighbour, 91_nodeset_over_parameter.va, is this file
// with `p` and `n` declared on two lines.
//
// VerA refuses the mixed list with E0292 at `n`; the code is pinned.
//
//! lrm 3.6.3.2
//! lrm A.2.1.3
//! lrm A.2.1.3:1000
//! reject-only E0292
//! neighbour 91_nodeset_over_parameter.va
`include "check.vh"
module ch03_nodeset_over_parameter(p, n);
    inout p, n;
    electrical p = 1.5, n;        // illegal: an assignment and a bare name in one list
    parameter real vstart = 2.25;
    electrical mid = vstart;

    analog begin
        `CHECKX("a nodeset on a port net is a hint, not a clamp", V(p), 3.0);
        `CHECKX("a nodeset over a parameter is one too", V(mid), 2.0);
        `CHECKX("and the branch above it is an ordinary potential", V(p, mid), 1.0);
        I(p, mid) <+ V(p, mid) / 1000.0;
        I(mid, n) <+ V(mid, n) / 1000.0;
    end
endmodule
