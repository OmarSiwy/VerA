// §3.13.3 "The scope rules for net identifiers are the same as the scope rules
// for any other identifier declarations, except nets can not be declared
// anywhere other than in the port of a module or in the module itself. ...
// Access functions are uniquely defined for each net based on the discipline of
// the net. Each access function is used with the name of the net as its
// argument and a net can only be accessed through its access functions. The
// hierarchical reference character (.) can be used to reference a net across
// the module boundary according to the rules specified in IEEE Std 1364
// Verilog."
//
// §3.13.4 "The scope rules for branch identifiers are the same as the scope
// rules for net identifiers. ... The access function is used with the name of
// the branch as its argument ... The hierarchical reference character (.) can
// be used to reference a branch across the module boundary".
//
// The positive half of both. 42/48/49/64/70_*.va pin the refusals (wrong access
// function, a net or branch local to a block, a bare net name); this file
// declares a net and a branch AT MODULE SCOPE in a child and reads both from the
// parent through a hierarchical name and the net's own access function.
//
// DERIVATION. The child is a divider: two equal 1 kohm resistors from `a` to
// `mid` and `mid` to `b`. With V(p) = 1.0 and V(n) = 0.0 (the parent's ports
// wired to the child's a and b), KCL at `mid` gives V(mid) = 0.5, exact in
// binary64 for equal conductances. The named branch `lo` is (mid, b), so
// V(u.lo) = 0.5 as well. `//! solve` lets the device determine `mid`; p and n
// are pinned by bias.
//
//! lrm 3.13.3
//! lrm 3.13.4
//! lrm 3.13.3:1000
//! lrm 3.13.4:1000
//! bias V(p) = 1.0, V(n) = 0.0
//! solve
`include "check.vh"
module ch03_net_and_branch_hierarchical_reference(p, n);
  inout p, n;
  electrical p, n;
  ch03_hier_divider u(p, n);
  analog begin
    `CHECK("§3.13.3 a child's net read across the module boundary", V(u.mid), 0.5, 1e-12);
    `CHECK("§3.13.4 a child's branch read across the module boundary", V(u.lo), 0.5, 1e-12);
  end
endmodule

module ch03_hier_divider(a, b);
  inout a, b;
  electrical a, b;
  electrical mid;
  branch (mid, b) lo;
  analog begin
    I(a, mid) <+ V(a, mid) / 1k;
    I(lo) <+ V(lo) / 1k;
  end
endmodule
