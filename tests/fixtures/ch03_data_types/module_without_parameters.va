// §3.4: a module's parameters are declared items it may have, and A.1.2's
// module_item lists parameter_declaration as one choice among many, so a
// module with none is legal. Before #79 `vera --emit-osdi` could not build
// one: tools/osdi_dyn.zig indexed its zero-length parameter arrays (Model
// `given`/`vals`) with a runtime id. `zig build test` builds this file under
// `--emit-osdi` (build.zig, the `--emit-osdi` rows); here it runs as an
// ordinary testbench.
//
// By hand: V(p, n) = 1 across 1k is 1.0/1000.0, the correctly rounded
// quotient, the same double as the literal 1.0e-3, so CHECKX is exact.
//! lrm 3.4
//! bias V(p) = 1, V(n) = 0
//! checks 1
`include "check.vh"
module module_without_parameters(p, n);
    inout p, n;
    electrical p, n;
    analog begin
        `CHECKX("1 V across 1k, no parameter in the module", V(p, n) / 1k, 1.0e-3);
        I(p, n) <+ V(p, n) / 1k;
    end
endmodule
