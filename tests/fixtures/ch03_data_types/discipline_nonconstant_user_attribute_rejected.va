// §3.6.2.7: "Like natures, a discipline can specify user-defined attributes.
// Discipline user-defined attributes are useful for the same reasons as nature
// user-defined attributes (see 3.6.1.3)." §3.6.1.3: "... the value being
// assigned to the attribute shall be constant."
//
// `max_voltage = vmax_runtime;` names an identifier that is no constant at all
// — a discipline is declared at source-text level (§3.13.1), outside every
// module, so there is nothing it could resolve to. With `max_voltage = 48.0;`
// the file is discipline_user_attributes.va's legal discipline (checked by hand when this
// fixture was written). nonconstant_user_attribute.va is the nature half,
// E0340.
//
//! lrm 3.6.2.7
//! lrm 3.6.1.3
//! lrm 3.6.1.3:1
//! lrm 3.6.2.7:1000
//! reject-only E0340
//! neighbour discipline_user_attributes.va
nature ch3_dna_voltage;
    units = "V";
    access = V;
    abstol = 1u;
endnature

nature ch3_dna_current;
    units = "A";
    access = I;
    abstol = 1p;
endnature

discipline ch3_dna_disc;
    potential ch3_dna_voltage;
    flow ch3_dna_current;
    max_voltage = vmax_runtime;
enddiscipline

module ch3_discipline_nonconstant_user_attribute(p, n);
    inout p, n;
    ch3_dna_disc p, n;
    analog I(p, n) <+ V(p, n) / 1000.0;
endmodule
