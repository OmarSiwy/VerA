// §3.4.7 parameter aliases — the LRM's own `nmos2` example. An `aliasparam` is
// a second NAME for one parameter, not a second parameter: overriding either
// name leaves "the value of the parameter dtemp, as used in the module
// equations, [equal to] 5".
//
// `dtemp` is overridden to 25 below, so the literal below is what the equations
// must see. The relational line is the storage claim, which is the one thing
// §3.4.7 states as an identity with no value of its own to write down; note
// that §3.4.7 also says a conforming module shall reference the parameter by
// its ORIGINAL name in its equations, so reading `trise` here is a deliberate
// probe of the alias table rather than a pattern to copy.
//
//! param dtemp = 25
`include "check.vh"
module ch03_parameter_alias(p, n);
    inout p, n;
    electrical p, n;
    parameter real dtemp = 0 from [-273.15:inf);
    aliasparam trise = dtemp;

    analog begin
        `CHECKX("the override reaches the aliased parameter", dtemp, 25.0);
        `CHECKEQ("aliasparam names the same storage", trise, dtemp, 0.0);
        I(p, n) <+ dtemp + V(p, n);
    end
endmodule
