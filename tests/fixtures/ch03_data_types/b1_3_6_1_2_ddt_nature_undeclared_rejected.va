// §3.6.1.2, ddt_nature: "If specified, the constant expression assigned to
// ddt_nature shall be the name (not a string) of a nature which is DEFINED
// ELSEWHERE."
//
// b1_dchg names b1_no_such_nature, which neither this file nor annex D
// declares. This file is b1_3_6_1_2_ddt_nature_names_and_overrides.va with that
// one value changed from b1_dcur. 66_idt_nature_not_a_nature.va is the
// idt_nature twin, refused with E0341; this rule's diagnostic has to name
// ddt_nature.
//
//! lrm 3.6.1.2
//! lrm 3.6.1.2:7
//! reject-only ddt_nature
//! neighbour b1_3_6_1_2_ddt_nature_names_and_overrides.va
`include "check.vh"
nature b1_dcur;
    units = "A";
    access = B1Id;
    abstol = 1p;
endnature

nature b1_dcur_fine : b1_dcur;
    abstol = 1f;
endnature

nature b1_dchg;
    units = "coul";
    access = B1Qd;
    abstol = 1f;
    ddt_nature = b1_no_such_nature;
endnature

nature b1_dchg_child : b1_dchg;
    ddt_nature = b1_dcur_fine;
endnature

nature b1_dself;
    units = "Wb";
    access = B1Phd;
    abstol = 1n;
    ddt_nature = b1_dself;
endnature

nature b1_dvolt;
    units = "V";
    access = B1Vd;
    abstol = 1u;
endnature

nature b1_dvolt_fine : b1_dvolt;
    abstol = 1n;
endnature

nature b1_dvolt_child : b1_dvolt;
    ddt_nature = b1_dvolt_fine;
endnature

discipline b1_ddt_disc;
    potential b1_dvolt_child;
    flow b1_dcur;
enddiscipline

module b1_ddt_nature_overrides(p, n);
    inout p, n;
    b1_ddt_disc p, n;

    analog begin
        `CHECKX("the derived potential nature reads through its parent's access", B1Vd(p, n), 1.5);
        `CHECKX("ddt() with no tolerance is zero in DC", ddt(B1Vd(p, n)), 0.0);
        B1Id(p, n) <+ B1Vd(p, n) / 2.0;
    end
endmodule
