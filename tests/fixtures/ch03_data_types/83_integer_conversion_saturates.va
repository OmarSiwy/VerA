// §3.4.1 Table 3-1 / §4.2.1.1: a real value assigned where an integer is
// required "shall be converted to an integer by rounding". The LRM fixes the
// ROUNDING and stays silent on a value no integer width can hold — so the one
// thing a conforming compiler must not do with `1e300` is crash or invoke
// undefined behavior. This file used to panic THE COMPILER on its parameter
// line (exit 134, `@intFromFloat` out of bounds) before any diagnostic or
// device existed; the runtime casts below were the same cast compiled into a
// ReleaseFast artifact, i.e. silent UB.
//
// VerA's defined answer is saturation; NaN reads 0. A variable's 64-bit
// carrier clamps there. The parameter is declared `integer`, which §3.4.1
// converts to the 32-bit type, so `big` saturates at that type's ceiling,
// 2147483647: no 32-bit integer exceeds it (until 2026-10 this row asserted
// `big > 2147483647`, which only the defect of reading the raw 64-bit
// carrier could satisfy). The variable rows compare against §3.2's minimum
// integer ceiling: a saturated 1e300 must exceed it, a saturated -1e300 must
// sit below its negation, which is what a wrap (landing near 0 or flipping
// sign) fails. The multiplications by V(p,n) = 1 keep the runtime casts out
// of every constant fold's reach.
//
//! lrm 3.4.1
//! lrm 4.2.1.1
//! bias V(p) = 1.0, V(n) = 0
`include "check.vh"
module ch03_integer_conversion_saturates(p, n);
    inout p, n;
    electrical p, n;
    parameter integer big = 1e300;
    integer i_pos, i_neg;

    analog begin
        `CHECKI("a 1e300 integer parameter default saturates at the 32-bit ceiling", big, 2147483647);
        i_pos = 1.0e300 * V(p, n);
        `CHECKI("runtime real->integer assignment saturates high", i_pos > 2147483647, 1);
        i_neg = -1.0e300 * V(p, n);
        `CHECKI("runtime real->integer assignment saturates low", i_neg < -2147483647, 1);
        I(p, n) <+ V(p, n) * 1.0e-3;
    end
endmodule
