// §2.9 VerA's `(* vera_scratch = "uninit" *)`: what a read-before-write sees.
//
// The attribute is a promise by the author that every element is written
// before it is read in the evaluation. Breaking it is the author's bug. VerA's
// documented answer (specification/Vague_Decisions.md, the `vera_scratch` row): in a
// device built with runtime safety (Debug, ReleaseSafe) the storage is filled
// with NaN, value and every derivative lane, so the bug shows up as NaN in
// the outputs; in ReleaseFast/ReleaseSmall nothing is stored and the value is
// unspecified. The testbench is built Debug (`vera --emit-exe` default, see
// `lib/backend/tb/exe.zig`), so here the unwritten slot must read NaN.
//
// No digits can be written for NaN, and NaN is the one value unequal to
// itself (IEEE 754 §5.11), so the checks assert `u != u` as an integer.
//
// By hand, at V(a) = 0.5, V(b) = 0: k = 1 at t = 0, 2 at t = 1.
//   st[k] = V(a)^2 = 0.25 is written; st[k + 1] never is.
//   u = st[k + 1]: NaN, and ddx(u, V(a)) is NaN too (the array carries a
//   V(a) lane, since st[k]'s derivative 2 V(a) is read through it).
//   ddx(st[k], V(a)) = 2 V(a) = 1.0 is the written neighbour, unaffected.
// Only the written value reaches the contribution, so the solve stays finite.
//
// Three verdicts at two points.
//! lrm 2.9
//! analysis tran
//! bias V(a) = 0.5, V(b) = 0.0
//! time 0, 1
//! checks 6
`include "check.vh"
module vera_scratch_uninit_reads_nan_when_safe(a, b);
  inout a, b; electrical a, b;
  integer k;
  (* vera_scratch = "uninit" *) real st[0:3];
  real u, y;
  analog begin
    k = ($abstime < 0.5) ? 1 : 2;
    st[k] = V(a) * V(a);
    y = st[k];
    u = st[k + 1];
    I(a, b) <+ y * V(a, b);
    `CHECKI("unwritten slot reads NaN", u != u, 1);
    `CHECKI("its derivative lane is NaN", ddx(u, V(a)) != ddx(u, V(a)), 1);
    `CHECKX("the written slot's derivative", ddx(y, V(a)), 1.0);
  end
endmodule
