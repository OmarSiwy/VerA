// §3.6.2.4: "If a net has a wire type but is not connected to behavioral code
// (interconnect) and it resolved to domain discrete then its wire type shall be
// used in any net type resolution steps per IEEE Std 1364 Verilog."
//
// `w` is declared `wand` in the top and appears there only in port connections:
// interconnect, no discipline. That is also §3.6.2.4:1's second alternative — a
// net bound only to ports in module instantiations may be declared to have a
// net type such as `wand`. All three ports it joins are digital (their
// modules reference them in `assign` and `always`), so it resolves discrete,
// and its `wand` takes part in IEEE 1364-2005 §12.3.10 net type resolution.
// Table 12-1, row "wire, tri" (the internal nets: every child port here is an
// implicit wire), column "wand" (the external net): "ext", the external type.
// So the single simulated net is a wand, and §7.1.4 (wired-AND) resolves the
// drivers 1 and 0 to 0. Had the wire type been dropped, the net would be a
// plain wire, and 1 against 0 resolves to x.
//
// DERIVATION. `timescale 1ns/1ns. Both drivers are x until 1 ns, when b1_hi
// drives 1 and b1_lo drives 0: wand(1, 0) = 0. b1_rd starts `seen` at 1 and
// copies its input into it on every change; at 1 ns the input goes x -> 0, so
// seen = 0 from then on. Before 1 ns nothing changes the input, so seen stays 1.
//
//     t = 0       seen = 1
//     t = 1 ns    seen = 0    (the solve the change forces, below)
//     t = 5 ns    seen = 0    (wired-AND of 1 and 0; a wire would give x)
//
// POINTS. Three, not the two `//! time` lists: the change of `seen` at 1 ns,
// a value the analog block reads, forces an analog solve at that tick, after
// its updates (§8.4.7, §8.5; src/sim/mixed.zig `run`). One check, three
// points: 3.
//
//! lrm 3.6.2.4
//! lrm 3.6.2.4:1
//! lrm 3.6.2.4:5
//! analysis tran
//! bias V(p) = 0.5
//! time 0, 5n
//! checks 3
`timescale 1ns/1ns
`include "check.vh"
module b1_hi(o);
  output o;
  reg r;
  assign o = r;
  initial #1 r = 1'b1;
endmodule

module b1_lo(o);
  output o;
  reg r;
  assign o = r;
  initial #1 r = 1'b0;
endmodule

module b1_rd(i, p);
  input i;
  inout p;
  electrical p;
  reg seen;
  initial seen = 1'b1;
  always @(i) seen = i;
  analog begin
    `CHECKI("the wand interconnect resolves 1 and 0 to 0", seen, ($abstime < 0.5n) ? 1 : 0);
    I(p) <+ V(p) * 1.0e-3;
  end
endmodule

module b1_wand_interconnect(p);
  inout p;
  electrical p;
  wand w;
  b1_hi d1(w);
  b1_lo d0(w);
  b1_rd r(w, p);
endmodule
