// §3.4.7, first rule: "The type of an alias (real, integer, or string) shall be
// determined by the original parameter, as is its range of allowed values, if
// specified." §3.4.2: an override outside the range is an error.
//
// `m` is the alias of `cnt`, declared `from [0:5]`. The override names the
// alias with 9, which is outside the ORIGINAL's range, so the instance is in
// error even though the alias declaration itself states no range. This file is
// b1_3_4_7_alias_takes_original_type.va with the override 2.6 (legal, read
// back as 3) changed to 9; nothing else differs.
//
// E0361 is VerA's code for the §3.4.2 value half ("overridden parameter value
// is outside its range"), as in 45_parameter_range_above_inclusive_upper.va.
//
//! lrm 3.4.7
//! lrm 3.4.2
//! reject-only E0361
//! neighbour b1_3_4_7_alias_takes_original_type.va
`include "check.vh"
module b1_alias_type_child(p, n);
    inout p, n;
    electrical p, n;
    parameter integer cnt = 1 from [0:5];
    aliasparam m = cnt;

    analog begin
        `CHECKI("2.6 through the integer alias arrives as 3", cnt, 3);
        `CHECKI("the parameter is still an integer", cnt / 2, 1);
        I(p, n) <+ cnt * V(p, n);
    end
endmodule

module b1_alias_type_top(p, n);
    inout p, n;
    electrical p, n;

    b1_alias_type_child #(.m(9)) u(.p(p), .n(n));

    analog I(p, n) <+ 0.0;
endmodule
