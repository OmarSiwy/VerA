// §3.6.2: "A discipline shall be defined between the keywords discipline and
// enddiscipline. Each discipline shall have a unique identifier as the name of
// the discipline." §3.13.1 puts disciplines in the same single global scope as
// natures and modules.
//
// `ch3_twice_d` is declared twice with different nature bindings, so a net
// declared `ch3_twice_d n;` would have two different sets of access functions.
//
// Mirror of 67_duplicate_nature_name.va and a separate file: A.1.7 gives
// nature_declaration and discipline_declaration as different productions, so a
// compiler can register one kind uniquely and not the other.
//
// E0342 ("nature or discipline is already declared") is the same-kind code; the
// cross-kind collision is E0336. It replaces the phase label pinned before
// E0342 existed.
//
//! lrm 3.6.2
//! lrm 3.6.2:2
//! lrm 3.13.1
//! reject-only E0342
//! neighbour 11_discipline_declarations.va
nature ch3_twice_d_p; units="V"; access=TwiceDV; abstol=1u; endnature
nature ch3_twice_d_f; units="A"; access=TwiceDI; abstol=1p; endnature
discipline ch3_twice_d; potential ch3_twice_d_p; enddiscipline
discipline ch3_twice_d; potential ch3_twice_d_p; flow ch3_twice_d_f; enddiscipline
module ch3_duplicate_discipline_name; endmodule
