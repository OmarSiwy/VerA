// §3.2 an array is indexed by an ordinary expression, so the index may be
// computed at run time from a signal. §4.2.5 makes the relational the integer
// 1 here (V(p,n) = 1.0 > 0.0), the conditional selects 1, and `values[0:2]` is
// declared low-to-high so index 1 holds the SECOND element written, 2.0.
//
//! lrm 3.2
//! lrm 4.2.5
//! bias V(p) = 1.0, V(n) = 0.0
`include "check.vh"
module ch03_dynamic_array_index(p, n);
    inout p, n;
    electrical p, n;
    real values[0:2];
    integer index;

    analog begin
        values[0] = 1.0;
        values[1] = 2.0;
        values[2] = 3.0;
        index = V(p, n) > 0.0 ? 1 : 2;
        `CHECKI("index computed from a signal relational", index, 1);
        `CHECKX("element selected by a run-time index", values[index], 2.0);
        I(p, n) <+ values[index];
    end
endmodule
