// §3.3 "A string shall not contain the special character \0". Converting a
// literal to the string type is spelled out: all "\0" characters are IGNORED
// (removed), and if nothing survives the variable gets the empty string. The
// LRM's own example is `string s1 = "hello\0world"; // sets s1 to "helloworld"`.
//
// The `== "hello"` check is the discriminating one: a backend that treated the
// NUL as a C terminator would stop there and pass the other two.
//! lrm 3.3
//! lrm 3.3:2
`include "check.vh"
module ch3_string_nul(p);
  inout p;
  electrical p;
  string joined = "hello\0world";
  string empty = "\0";
  analog begin
    `CHECKI("NUL is removed, the rest is kept", (joined == "helloworld"), 1);
    `CHECKI("NUL does not terminate the literal", (joined == "hello"), 0);
    `CHECKI("a literal of only NULs becomes the empty string", (empty == ""), 1);
    I(p) <+ 0.0 * V(p);
  end
endmodule
