// §3.13.1: "Natures and disciplines are defined at the same level of scope as
// modules. Thus, identifiers defined as natures or disciplines have a global
// scope" — ONE namespace shared by natures, disciplines and modules. §3.6.1
// adds "Each nature definition shall have a unique identifier as the name of
// the nature."
//
// `ch3_collision` is declared twice into that single global scope, once as a
// nature and once as a discipline, so the second declaration collides with the
// first. Each declaration is individually well-formed; only the shared name is
// wrong. The collision is not cosmetic: A.1.7 `parent_nature ::=
// nature_identifier | discipline_identifier . potential_or_flow` and A.2.1.3
// `net_declaration ::= discipline_identifier ...` both take a bare identifier
// here, so with one name bound to both kinds those productions have no unique
// reading.
//
//! lrm 3.13.1
//! lrm 3.6.1
//! lrm 3.6.1:2
//! lrm 3.13.1:1000
//! reject-only E0336
//! neighbour 10_nature_declarations.va
nature ch3_collision; units="V"; access=CollisionV; abstol=1u; endnature
discipline ch3_collision; domain continuous; enddiscipline
module ch3_collision_user; endmodule
