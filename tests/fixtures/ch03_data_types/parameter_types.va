// §3.4.1 parameter type specification. The declared type WINS over the type of
// the default: "parameter real size = 10;  Here, size is coerced to 10.0". So
// `real_parameter / 4` is real division (2.5), while the integer parameter
// divides as an integer and 16 / 5 truncates to 3 (§4.2.1).
//
// A backend that let `real_parameter` stay an integer gets 2 for the first line;
// one that promoted `integer_parameter` gets 3.2 for the second. Neither can
// pass both.
//! lrm 3.4.1
//! lrm 3.4.1:1
//! lrm 3.4.1:1003
//! lrm 4.2.1
//! lrm 3.4
//! lrm 3.4:5
//! lrm 3.4.6
//! lrm 3.4.6:2
`include "check.vh"
module ch03_parameter_types(p, n);
    inout p, n;
    electrical p, n;
    parameter real real_parameter = 10;
    parameter integer integer_parameter = 16;
    parameter integer rounded_parameter = 2.5;
    parameter string string_parameter = "mode-a";

    analog begin
        `CHECKX("real parameter coerces its integer default to 10.0", real_parameter / 4, 2.5);
        `CHECKI("integer parameter divides as an integer", integer_parameter / 5, 3);
        `CHECKI("an integer parameter rounds a conflicting real default", rounded_parameter, 3);
        `CHECKI("the converted default retains integer division", rounded_parameter / 2, 1);
        `CHECKI("string parameter holds its default", string_parameter == "mode-a", 1);
        I(p, n) <+ real_parameter + integer_parameter;
    end
endmodule
