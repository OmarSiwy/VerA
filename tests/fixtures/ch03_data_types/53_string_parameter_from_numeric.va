// §3.4.1: "No conversion shall be applied for strings; it shall be an error to
// assign a numeric value to a parameter declared as string or to assign a
// string value to a real parameter ..."
//
// This file is the first half: a numeric initializer on a parameter DECLARED
// string. The contrast is the sentence immediately before it — "If the type of
// the parameter is specified as integer or real, and the value assigned to the
// parameter conflicts with the type of the parameter, the value is converted to
// the type of the parameter" — which is why 04_parameter_types.va's `parameter
// real size = 10` is legal. String is the type that does NOT get that
// conversion, and nothing else in the chapter says so.
//
// 53_real_parameter_from_string.va is the other half.
//
//! lrm 3.4.1
//! reject DiagnosticsReported
//! xfail VerA accepts a numeric initializer on a `parameter string`; there is no string/numeric parameter type check in lower.zig
module ch3_string_parameter_from_numeric(p, n);
    inout p, n;
    electrical p, n;
    parameter string device_type = 42;

    analog begin
        I(p, n) <+ V(p, n);
    end
endmodule
