// §2.9 VerA's `(* vera_scratch = "uninit" *)`: a scratch variable whose
// memory-backed storage starts every evaluation with NO store at all. The
// author promises each element is written before it is read in the same
// evaluation; this fixture keeps that promise and shows the result equals the
// zero-started `(* vera_scratch *)` form, value and derivative.
//
// §2.9: "attr_spec ::= attr_name [ = constant_expression ]", and a string is a
// constant expression. §2.9 leaves the meaning to the tool; this one is VerA's
// (AGENTS.md §6, specification/Vague_Decisions.md).
//
// WHY. A B-source tape evaluates on a runtime-indexed stack. Plain
// `vera_scratch` re-zeroes the whole stack (value and every derivative lane)
// on every evaluation; a tape that pushes before it pops never reads a zero.
//
// The tape, by hand, at V(a) = 0.5, V(b) = 0.25, pushing from base sp = 1 at
// t = 0 and sp = 2 at t = 1 (a runtime subscript, so the stack is memory-
// backed and its slots move between the two points):
//
//   push V(a)   push V(b)   add   ->  V(a) + V(b)          = 0.75
//   push V(a)               mul   ->  (V(a) + V(b)) V(a)   = 0.375
//   push 2                  sub   ->  0.375 - 2            = -1.625
//
//   Every sum and product is exact in binary, so CHECKX.
//   ddx(y, V(a)) = 2 V(a) + V(b) = 1.25, ddx(y, V(b)) = V(a) = 0.5 (§4.5.6).
//
// The same tape on `zr`, a plain `(* vera_scratch *)` stack, must give the
// same value: that is an identity between the two forms with nothing more to
// write down than the digits above, so it is the one CHECKEQ. `zr` also
// carries an initializer, which plain `vera_scratch` restarts at every
// evaluation: zr[0] is below both bases, never written, so it reads 9. (On
// the "uninit" form an initializer is E0539:
// reject_vera_scratch_uninit_initializer.va.)
//
// Six verdicts at two points.
//! lrm 2.9
//! analysis tran
//! bias V(a) = 0.5, V(b) = 0.25
//! time 0, 1
//! checks 12
`include "check.vh"
module vera_scratch_uninit_tape(a, b);
  inout a, b; electrical a, b;
  integer sp, sz;
  (* vera_scratch = "uninit" *) real st[0:7];
  (* vera_scratch *) real zr[0:7] = '{9, 9, 9, 9, 9, 9, 9, 9};
  real y, yz;
  analog begin
    sp = ($abstime < 0.5) ? 1 : 2;
    st[sp] = V(a); sp = sp + 1;
    st[sp] = V(b); sp = sp + 1;
    st[sp - 2] = st[sp - 2] + st[sp - 1]; sp = sp - 1;
    st[sp] = V(a); sp = sp + 1;
    st[sp - 2] = st[sp - 2] * st[sp - 1]; sp = sp - 1;
    st[sp] = 2.0; sp = sp + 1;
    st[sp - 2] = st[sp - 2] - st[sp - 1]; sp = sp - 1;
    y = st[sp - 1];

    sz = ($abstime < 0.5) ? 1 : 2;
    zr[sz] = V(a); sz = sz + 1;
    zr[sz] = V(b); sz = sz + 1;
    zr[sz - 2] = zr[sz - 2] + zr[sz - 1]; sz = sz - 1;
    zr[sz] = V(a); sz = sz + 1;
    zr[sz - 2] = zr[sz - 2] * zr[sz - 1]; sz = sz - 1;
    zr[sz] = 2.0; sz = sz + 1;
    zr[sz - 2] = zr[sz - 2] - zr[sz - 1]; sz = sz - 1;
    yz = zr[sz - 1];

    I(a, b) <+ 1e-3 * y;
    `CHECKX("tape value", y, -1.625);
    `CHECKX("ddx(y, V(a))", ddx(y, V(a)), 1.25);
    `CHECKX("ddx(y, V(b))", ddx(y, V(b)), 0.5);
    `CHECKI("stack pointer back at the base", sp - (($abstime < 0.5) ? 1 : 2), 1);
    `CHECKEQ("uninit stack equals the zeroed one", y, yz, 0.0);
    `CHECKX("zr[0], never written, restarts at its initializer", zr[0], 9.0);
  end
endmodule
