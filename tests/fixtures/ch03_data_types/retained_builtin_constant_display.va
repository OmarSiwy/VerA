// AMS §3.2: an analog integer initially has value zero and retains its value
// between evaluations. Capture that incoming value, then assign the literal
// 1. At t=0 the captured value is 0; at t=1 it is the preceding assignment's
// 1. The current value is 1 at both points, for four exact observations.
//
// This also exercises §9.4.1 display emission when a retained variable's
// final value is a builtin constant. Publishing that constant from the core
// must not create an undeclared cache reference in the display function.
// Retention/display has no invalid-input form; no rejection is invented.
//! lrm 3.2
//! lrm 9.4.1
//! time 0, 1
//! checks 4
`include "check.vh"
module retained_builtin_constant_display;
  integer retained, previous;
  analog begin
    previous = retained;
    retained = 1;
    `CHECKI("current retained value", retained, 1);
    if ($abstime == 0)
      `CHECKI("initial retained value", previous, 0);
    else
      `CHECKI("previous accepted value", previous, 1);
  end
endmodule
