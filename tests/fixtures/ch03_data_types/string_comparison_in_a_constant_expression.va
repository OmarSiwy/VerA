// A string comparison folded as a constant expression answers what the same
// comparison answers at runtime.
//
// Table 3-3 states both operators outright. Equality: "Checks whether the two
// strings are equal. Result is 1 if they are equal and 0 if they are not. Both
// strings can be of type string, or one of them can be a string literal which is
// implicitly converted to a string type for the comparison." Relational:
// "Relational operators return 1 if the corresponding condition is true using
// the lexicographical ordering of the two strings Str1 and Str2."
//
// The shape that makes it a CONSTANT-expression question and not a repeat of the
// runtime coverage is §5.9.3's genvar `for`: "The genvar for statement is
// unrolled at elaboration", so its bound is folded by the compiler and never
// reaches the runtime comparison at all. `mode` is "slow", so
//
//     (mode == "fast") ? 3 : 1   ->   1
//
// and the loop body runs ONCE. A folder that gets the comparison wrong runs it
// three times, and `acc` reads 3.0 instead of 1.0 — a wrong number from a
// correct-looking model, which is why the loop count is what is asserted rather
// than the comparison's own 0/1.
//
// The three checks below are the three answers a broken fold gives at once:
// `eq_lit` and `lt_lit` pin the operators directly over literals (Table 3-3's
// last sentence: "If both operands are string literals, the operator is the same
// Verilog equality operator as for integer types" — which for two equal-length
// literals is the same 1/0), and `acc` pins that the fold is the one the
// unroller used.
//
//! lrm 3.4.6
//! lrm 5.9.3
//! lrm 3.4.6:2
//! lrm 5.9.3:1000
//! bias V(p) = 0.5
`include "check.vh"
module ch3_string_const_compare(p, n);
  inout p, n; electrical p, n;
  localparam string mode = "slow";
  localparam integer eq_lit = ("slow" == "fast");
  localparam integer lt_lit = ("fast" < "slow");
  real acc;
  genvar i;
  analog begin
    acc = 0.0;
    for (i = 0; i < ((mode == "fast") ? 3 : 1); i = i + 1) acc = acc + 1.0;
    `CHECKX("§5.9.3 unrolled the bound the folded comparison gave: once", acc, 1.0);
    `CHECKI("Table 3-3 equality: two different strings are 0", eq_lit, 0);
    `CHECKI("Table 3-3 relational: lexicographic, so \"fast\" < \"slow\"", lt_lit, 1);
    I(p, n) <+ V(p, n);
  end
endmodule
