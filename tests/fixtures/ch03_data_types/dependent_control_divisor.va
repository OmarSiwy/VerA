// The chosen arm computes division and remainder at the integral width.
//! lrm 3.4.1
//! lrm 4.2.3
//! lrm 6.3.4
//! lrm 6.3.4:1000
//! param divisor = -3
`include "check.vh"
module dependent_control_divisor;
  parameter integer divisor = 2;
  parameter integer quotient = divisor != 0 ? -7 / divisor : 123;
  parameter integer remainder = divisor != 0 ? -7 % divisor : 456;
  parameter real real_quotient = divisor ? -7 / divisor : 1.5;
  localparam integer and_guard = (divisor != 0) && (7 / divisor < 0);
  localparam integer or_guard = (divisor == 0) || (7 % divisor > 0);
  analog begin
    `CHECKI("chosen integer division truncates", quotient, 2);
    `CHECKI("chosen integer remainder sign", remainder, -1);
    `CHECKX("integer division completes before real arm conversion", real_quotient, 2.0);
    `CHECKI("chosen AND right operand", and_guard, 1);
    `CHECKI("chosen OR right operand", or_guard, 1);
  end
endmodule
