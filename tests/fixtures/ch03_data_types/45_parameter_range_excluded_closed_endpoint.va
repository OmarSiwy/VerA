// §3.4.2: "Parentheses, ( and ), indicate exclusion of the end points from the
// value range. It is possible to include one end point and not the other using
// [ ) and ( ]." The second hole in the LRM's range is `exclude (30:40]`, whose
// upper end is CLOSED, so 40 is excluded and the override below is out of range.
// This is the endpoint that distinguishes `(30:40]` from `(30:40)`; its open
// twin, 30, is legal and is asserted in 45_parameter_range_legal_endpoints.va.
// The declaration is §3.4.2's own worked example, verbatim.
//
// The override is written as an INSTANTIATION. §3.4.2 says "Range checking
// applies to the value of the parameter for the instance and not against the
// default values specified in the device", so the default 0 is legal and only
// an override can state this rule — and it cannot be the suite's `//! param`
// directive: that is consumed by the testbench generator, which never runs on a
// reject fixture, so the compiler would be handed the legal default alone and
// the fixture would demand a diagnostic no conforming compiler can emit.
// 78_alias_double_override.va makes the same move for the same reason, and
// Annex C.8 keeps Clause 6 hierarchy in the Verilog-A subset.
//
// The pinned substring is a message fragment rather than a code: VerA has no
// range-checking diagnostic, so there is no code to pin, and
// `DiagnosticsReported` would be satisfied by today's unrelated E0204 and
// report a pass that proved nothing. Any diagnostic naming the range satisfies
// it. Note also that §3.4.2 puts the error at SIMULATION time; a compiler that
// aborted the run instead of diagnosing the elaborated instance would need the
// runner taught about that verdict.
//
//! lrm 3.4.2
//! lrm C.8
//! reject range
//! xfail VerA does not implement module instantiation: the instance is rejected with E0204 before any override is bound to a parameter, so 40 is never compared against the closed upper end of `exclude (30:40]`
module ch3_range_target_endpoint(p, n);
    inout p, n;
    electrical p, n;
    parameter real val3 = 0 from [0:inf) exclude (10:20) exclude (30:40];

    analog I(p, n) <+ val3 * V(p, n);
endmodule

module ch03_parameter_range_excluded_closed_endpoint(p, n);
    inout p, n;
    electrical p, n;

    ch3_range_target_endpoint #(.val3(40)) endpoint(.p(p), .n(n));

    analog I(p, n) <+ 0.0;
endmodule
