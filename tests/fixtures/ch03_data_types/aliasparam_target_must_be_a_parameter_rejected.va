// §3.4 Syntax 3-2, the production §3.4.7 describes:
//
//     aliasparam_declaration ::= aliasparam parameter_identifier = parameter_identifier ;
//
// The right-hand side names the ORIGINAL parameter, and the clause's rules all
// read off it: "The type of an alias (real, integer, or string) shall be
// determined by the original parameter, as is its range of allowed values".
//
// `res` below is aliased to `rr`, and nothing in the module declares `rr`
// (the parameter is `r`). An alias of nothing has no type, no range and no
// value, so an override through `res` could not mean anything.
//
// The legal alias is 07_parameter_alias.va.
//
//! lrm 3.4.7
//! reject-only E0303
//! neighbour 07_parameter_alias.va
`include "disciplines.vams"
module ch3_aliasparam_target_must_be_a_parameter(p, n);
  inout p, n; electrical p, n;
  parameter real r = 1.0;
  aliasparam res = rr;
  analog I(p, n) <+ V(p, n) / r;
endmodule
