// §3.4.1: "If the type of a parameter is not specified, it is derived from the
// type of the final value assigned to the parameter, after any value overrides
// have been applied ... Note that the type of a string parameter (see 3.4.6)
// and any of the array parameters (see 3.4.4) is mandatory."
//
// `device_type` would derive `string` from its initializer under the first
// sentence, and the second sentence is the exception that says it may not:
// because the derivation happens "after any value overrides have been applied",
// an untyped parameter has no type at all until override time, and §3.4.1's
// string rules ("No conversion shall be applied for strings") have to be
// decidable before then.
//
// Sibling of 60_parameter_array_untyped.va — the other half of the same
// sentence, and a different code path.
//
//! lrm 3.4.1
//! lrm 3.4.6
//! reject DiagnosticsReported
//! xfail VerA derives `string` for an untyped parameter with a string initializer; there is no mandatory-type check on string parameters in lower.zig
module ch3_string_parameter_untyped(p, n);
    inout p, n;
    electrical p, n;
    parameter device_type = "npn";

    analog begin
        I(p, n) <+ V(p, n);
    end
endmodule
