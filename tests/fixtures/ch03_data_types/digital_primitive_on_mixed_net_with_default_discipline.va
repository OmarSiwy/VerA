// §3.9: "For digital primitives the domain is discrete and thus the discipline
// is set via the default_discipline directive as it is for digital modules. If
// the discipline of digital connections (vpiLoConn) to a mixed net are unknown
// then the default_discipline must be specified (via the directive or other
// vendor specific method). If not specified, an error will result during
// discipline resolution."
//
// The legal counterpart of `digital_primitive_on_mixed_net_rejected.va`, on
// the same source shape: an `and` gate whose output `p` is an electrical net
// (a mixed net) and whose inputs are discipline-less wires. `` `default_
// discipline logic `` names the gate's discrete side, so the connection's
// discipline is no longer unknown, and the §3.11 Signal Domain Rule wants a
// connect statement between logic and electrical — `ch03_and_rules` supplies
// one. With both in place the file is accepted; the rejection fixture differs
// only by their absence.
//
// WHAT IS ASSERTED. As in ch08_scheduling/switch_primitive_accepted.va, the
// harness imposes node values, so the gate's discrete effect is not an analog
// observable. What is observable is that a module carrying a digital primitive
// on a mixed net still elaborates and evaluates its analog block: the bias
// holds p - n at 0.75 - 0.25 = 0.5 V and the contribution reads it back.
//
//! lrm 3.9
//! lrm 3.8
//! lrm 3.11
//! bias V(p) = 0.75, V(n) = 0.25
//! checks 1
`include "disciplines.vams"
`include "check.vh"
connectmodule ch03_and_bridge(d, e);
  inout d, e;
  logic d;
  electrical e;
endmodule

`default_discipline logic
module ch03_digital_primitive_on_mixed_net_accepted(p, n);
  inout p, n;
  electrical p, n;
  wire a, b;
  and g1(p, a, b);

  analog begin
    `CHECKX("the analog block still runs beside a digital primitive", V(p, n), 0.5);
    I(p, n) <+ 0.0;
  end
endmodule
`default_discipline

connectrules ch03_and_rules;
  connect ch03_and_bridge;
endconnectrules
