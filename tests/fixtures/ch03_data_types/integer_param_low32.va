// §3.4.1: "the parameter shall be converted to the type and range specified"
// when a parameter declaration carries a type, and `integer` is a 32-bit
// signed type (§3.2.1, after IEEE 1364-2005 4.8). The model card ABI carries
// every integer parameter as i64, so a host can write a value an `integer`
// cannot hold. The device must read the converted value.
//
// This file is the device `tests/fixtures/ch03_data_types/integer_param_host.zig` drives: the host
// writes word = 4294967297 (2^32 + 1, low 32 bits 1) and expects the branch
// current word * V(p) at V(p) = 0.5 to be 0.5 A, not 2147483648.5 A; and
// word = 4294967295 (low 32 bits all ones) to read -1, so -0.5 A. The
// fixture runner writes the same card (`//! param`, exact in its real-valued
// card API since 2^32 + 1 < 2^53), and the transcript asserts word = 1.
//
// The legal neighbour of the conversion is the default itself, which needs
// none; there is no invalid form (any i64 the host writes has low 32 bits).
//
//! lrm 3.4.1
//! lrm 3.2.1
//! param word = 4294967297
`include "check.vh"
module integer_param_low32(p);
  inout p; electrical p;
  parameter integer word = 1;
  analog begin
    `CHECKI("a card value of 2^32 + 1 reads its low 32 bits", word, 1);
    I(p) <+ word * V(p);
  end
endmodule
