// §3.2: "Integer variables whose values are assigned in an analog context
// default to an initial value of zero (0). ... Real variables are initialized
// to zero (0) at the start of a simulation."
//
// `count` and `gain` carry NO declaration initializer, which is the whole
// point: integer_real_variables.va declares `integer count = 3; real gain =
// 2.5;` and therefore says nothing about the default. Both are read as the
// first statements of the analog block, before anything writes to them, so the
// only value they can hold is the one §3.2 fixes.
//
// The third assertion is there because 0 and 0.0 are the value an
// uninitialized-memory read is most likely to produce by accident: a variable
// that is written and read back afterwards must be storage, not a constant
// folded to zero.
//
//! lrm 3.2
//! lrm 3.2:1002
`include "check.vh"
module ch03_integer_real_default_init(p, n);
    inout p, n;
    electrical p, n;
    integer count;
    integer digital_count;
    integer digital_was_x;
    real gain;

    initial begin
        // CHECKI is a $strobe, which reports at the end of the time step
        // (IEEE 1364-2005 §17.1.2), after `digital_count = 4`: bind the
        // default before it is overwritten.
        digital_was_x = digital_count === 32'bx;
        `CHECKI("a digital-context integer without initialization starts unknown",
            digital_was_x, 1);
        digital_count = 4;
        `CHECKI("the digital integer can subsequently be assigned", digital_count, 4);
    end

    analog begin
        `CHECKI("an integer with no initializer starts at 0", count, 0);
        `CHECKX("a real with no initializer starts at 0.0", gain, 0.0);
        count = 3;
        gain = 2.5;
        `CHECKX("the default is storage, not a folded constant", count * gain, 7.5);
        I(p, n) <+ count * gain * V(p, n);
    end
endmodule
