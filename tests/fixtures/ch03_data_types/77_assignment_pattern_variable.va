// §3.4.8 assignment patterns, the form the LRM's own `test` module uses on a
// variable rather than on a parameter:
//
//     in_val = '{V(in[0]),V(in[1]),V(in[2])};
//
// A whole-array assignment whose elements are NOT constant — each is a
// solution-dependent probe. That is what separates this from
// 08_parameter_array.va, where the pattern initializes a parameter and every
// element has to be a constant expression (§3.4).
//
// With p at 2.5 V and n at 0.75 V the three elements are 2.5, 0.75 and 1.75, all
// exact in binary. The digit-weighted sum is the assertion that the pattern
// filled left index first and did not alias two slots onto one:
// 2.5 + 10*0.75 + 100*1.75 = 185.0.
//
//! lrm 3.4.8
//! bias V(p) = 2.5, V(n) = 0.75
`include "check.vh"
module ch03_assignment_pattern_variable(p, n);
    inout p, n;
    electrical p, n;
    real probes[0:2];

    analog begin
        probes = '{V(p), V(n), V(p, n)};
        `CHECKX("element 0 of a non-constant assignment pattern", probes[0], 2.5);
        `CHECKX("element 1 of a non-constant assignment pattern", probes[1], 0.75);
        `CHECKX("element 2 of a non-constant assignment pattern", probes[2], 1.75);
        `CHECKX("the pattern filled left index first, one slot each", probes[0] + 10.0 * probes[1] + 100.0 * probes[2], 185.0);
        I(p, n) <+ probes[2] / 2.0;
    end
endmodule
