// The device of spice_op_nodeset_root.sp. §3.6.3.2: "Nets with continuous
// disciplines are allowed to have initializers on their net discipline
// declarations"; the analog solver uses the value as a nodeset for the net's
// potential. VerA applies a nodeset as Newton's starting point and never
// holds it (specification/Vague_Decisions.md VD-117), in every host.
//
// HAND DERIVATION. The internal net w carries a08_nodeset_01's cubic,
// f(V) = (V-1)(V-2)(V-3), roots 1, 2 and 3, f'(V) = 3V^2 - 12V + 11, and the
// port p copies V(w) through a voltage contribution. Newton from the
// nodeset 2.75: f = -0.328125, f' = 0.6875, next 3.2273; then 3.0507, 3.0035,
// 3.00002, so V(p) = 3. From a cold 0 (no nodeset used) it lands on 1; a
// clamped nodeset would hold 2.75. The 1e-9 band separates all three.
//
// This file checks the testbench host; the deck checks src/sim/spice on the
// same device, so both hosts must start Newton from the same nodeset.
//
//! lrm 3.6.3.2
//! lrm 3.6.3.2:1
//! bias V(n) = 0.0
//! solve
//! print none
//! checks 1
`include "check.vh"
module spice_nodeset_cubic(p, n);
    inout p, n;
    electrical p, n;
    electrical w = 2.75;

    analog begin
        `CHECK("Newton starts at the nodeset 2.75 and lands on the root 3", V(p, n), 3.0, 1e-9);
        I(w, n) <+ (V(w, n) - 1.0) * (V(w, n) - 2.0) * (V(w, n) - 3.0);
        V(p, n) <+ V(w, n);
    end
endmodule
