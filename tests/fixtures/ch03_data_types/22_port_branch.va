// §3.12.1: "A port branch is a special type of branch used to access the flow
// into a port of a module (see 5.4.3). It is a branch between the upper and
// lower connections of the port." Syntax 3-9 gives the form as an alternative
// of branch_declaration:
//
//     port_branch_declaration ::= branch ( < port_identifier > ) list_of_branch_identifiers ;
//
// and §3.12.1 prints the module below almost verbatim (its `$strobe` of
// I(probe_p) is replaced here by an assertion on the same quantity).
//
// §5.4.3 fixes the sign: the port access function "accesses the flow INTO a
// port of a module". The only current this module draws is the one it
// contributes from p to ground, so with p at 2.0 V through 1000 ohm the flow
// into the port is 2.0 / 1000.0 = 0.002 A exactly — the quotient and the
// literal round to the same double. A compiler that measured the flow out of
// the port instead reads -0.002.
//
// WHAT IS LEFT, AND WHERE. The declaration parses now and `I(probe_p)` resolves
// to the SAME unknown `I(<p>)` does — forcing that unknown from the operating
// point makes this file green, which is how the identity was checked. What is
// missing is the arithmetic: 0.002 is the value KCL gives the port flow, and
// the harness forces every unknown to its declared operating point instead of
// solving for it (see ch05_analog_behavior/indirect_contribution.va, the same
// wall). So the read returns 0. Writing the 0.002 in as a `//! bias` would make
// the file pass while deleting the only thing it asserts — that the port branch
// MEASURES the current, rather than being told it.
//
//! lrm 3.12.1
//! bias V(p) = 2.0
//! xfail VerA's testbench forces every solver unknown to its operating point instead of solving, so the port-flow unknown that `I(probe_p)` correctly resolves to reads 0 rather than the 0.002 KCL puts there
`include "check.vh"
module ch03_port_branch(p);
    inout p;
    electrical p;
    branch (<p>) probe_p;

    analog begin
        I(p) <+ V(p) / 1000.0;
        `CHECKX("a port branch measures the flow into the port", I(probe_p), 0.002);
    end
endmodule
