// §3.4.2: "The parameter value shall be within the range from the smallest
// value specified to the largest value specified", and "It shall be an error
// only if the value of the parameter is out of range during simulation." A
// value the host writes on the model card is checked when it is written
// (#80): the device's `checkRange`, which the testbench calls after `derive`,
// names it, and the run stops with E0377 (exit 1).
//
// By hand, card by card (`r` declared `from (0:inf) exclude 2`):
//   r = 3:  allowed, so the one CHECK runs and passes;
//   r = -1: below the open lower bound 0, in no `from` range, so
//           `checkRange` names `r` and the run ends there.
// range_card_value_excluded_rejected.va is the `exclude` half.
//! lrm 3.4.2
//! lrm 3.4.2:2
//! psweep r = 3, -1
//! bias V(p) = 1, V(n) = 0
//! reject-run E0377
//! reject-run `r` outside its declared range
//! neighbour range_card_value_inside.va
//! checks 1
//! print none
`include "check.vh"
module range_card_value_below_from_rejected(p, n);
    inout p, n;
    electrical p, n;
    parameter real r = 1 from (0:inf) exclude 2;
    analog begin
        `CHECKI("the card's r is inside (0:inf) and not 2", r > 0 && r != 2, 1);
        I(p, n) <+ V(p, n) / r;
    end
endmodule
