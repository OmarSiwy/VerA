// §3.4.2: "The parameter value shall be within the range from the smallest
// value specified to the largest value specified", an `exclude` removes a
// value from it, and "It shall be an error only if the value of the parameter
// is out of range during simulation." A `#(...)` override is judged at
// compile time (E0361, 45_parameter_range_excluded_interior.va); a value the HOST
// writes on the model card was not judged at all before #80. The device's
// `checkRange`, which the testbench calls after `derive`, now names it, and
// the run stops with E0377 (exit 1).
//
// By hand, card by card (`r` declared `from (0:inf) exclude 2`):
//   r = 3: inside (0:inf), not 2: allowed, so the one CHECK (r > 0 and
//          r != 2 is 1) runs and passes;
//   r = 2: inside (0:inf) but excluded, so `checkRange` names `r` and the
//          run ends before the second card evaluates anything.
//! lrm 3.4.2
//! lrm 3.4.2:2
//! psweep r = 3, 2
//! bias V(p) = 1, V(n) = 0
//! reject-run E0377
//! reject-run `r` outside its declared range
//! neighbour range_card_value_inside.va
//! checks 1
//! print none
`include "check.vh"
module range_card_value_excluded_rejected(p, n);
    inout p, n;
    electrical p, n;
    parameter real r = 1 from (0:inf) exclude 2;
    analog begin
        `CHECKI("the card's r is inside (0:inf) and not 2", r > 0 && r != 2, 1);
        I(p, n) <+ V(p, n) / r;
    end
endmodule
