// §3.3: "In Verilog-AMS, string literals behave exactly the same as in
// Verilog." IEEE 1364-2005 §3.6 (inherited through §1.1) makes a string literal
// an unsigned integer constant of 8 bits per character, so a literal is a
// number to every operator: "A" is 8'h41 = 65.
//
// A string-typed operand is not: §3.3 Table 3-3 lists the operators "defined
// on the string data type", ==, !=, <, <=, >, >=, concatenation and
// replication, each "of type string, or one of them can be a string literal",
// and "A string cannot be assigned to an integral type". So the same
// operators with a string VARIABLE in the literal's place are refused:
// string_variable_arithmetic_rejected.va (E0321),
// string_variable_compared_with_number_rejected.va (E0321) and
// string_variable_bitwise_rejected.va (E0322) are this file's three invalid
// neighbours, each differing from one line here only in that operand.
//
// DERIVATION. "A" = 65.
//   k_add = "A" + 1   = 66
//   k_eq  = "A" == 65 = 1
//   k_and = "A" & 1   = 65 & 1 = 1    (65 = 0b100_0001)
// and, for contrast, s == "A" with s a string variable holding "A" is
// Table 3-3's string equality: 1.
//
//! lrm 3.3
//! checks 4
`include "check.vh"
module string_literal_operand_is_a_number(p, n);
  inout p, n; electrical p, n;
  string s = "A";
  integer k_add, k_eq, k_and;
  analog begin
    k_add = "A" + 1;
    k_eq = ("A" == 65);
    k_and = "A" & 1;
    `CHECKI("a string literal is its byte value: \"A\" + 1", k_add, 66);
    `CHECKI("a literal against a number is integer equality", k_eq, 1);
    `CHECKI("a literal under a bitwise operator: 65 & 1", k_and, 1);
    `CHECKI("a string variable against a literal is string equality", (s == "A"), 1);
    I(p, n) <+ V(p, n);
  end
endmodule
