// §3.2: integer variables "can hold values ranging from -2^31 to 2^31-1", and
// "Arithmetic operations performed on integer variables produce 2's complement
// results." Unary minus and abs() are arithmetic operations, and at 32 bits
// 2's complement has no +2^31:
//
//     -(-2147483647-1)    -> -2147483648
//     abs(-2147483647-1)  -> -2147483648
//
// so each is negative, and `> 0` of each is 0. A wider integer answers
// +2147483648 and 1.
//
// 72 pins the wrap of `+` and `-` on variables. This pins negate and abs in a
// constant expression, where the comparison consumes the value before the
// narrowing store to the integer parameter could hide it, and on the variable
// `lo`, whose negation the compiler may fold because `lo` never changes. Both
// must give the 32-bit answer.
//
//! lrm 3.2
`include "check.vh"
module ch03_integer_negate_and_abs_wrap_in_a_constant(p, n);
    inout p, n;
    electrical p, n;
    parameter integer neg_pos = (-(-2147483647-1) > 0);
    parameter integer abs_pos = (abs(-2147483647-1) > 0);
    integer lo = -2147483648;

    analog begin
        `CHECKI("-(-2^31) is -2^31 in a constant expression", neg_pos, 0);
        `CHECKI("abs(-2^31) is -2^31 in a constant expression", abs_pos, 0);
        `CHECKI("-(-2^31) is -2^31 on a variable", (-lo > 0), 0);
        `CHECKI("abs(-2^31) is -2^31 on a variable", (abs(lo) > 0), 0);
        I(p, n) <+ V(p, n);
    end
endmodule
