// §3.2 arrays of integer and real variables. `[0:2]` declares THREE elements
// addressed 0, 1, 2, each its own storage — the digit-per-element sum below is
// 421 only if a write to one index leaves the other two alone, and only if
// index 0 is the first element rather than the last.
//
// §3.2 also says of the two indices: "Both indices shall be constant
// expressions and shall evaluate to a positive integer, a negative integer, or
// zero (0)". `offset[-2:2]` and `one[4:4]` are the two forms nothing else in
// the chapter writes — a negative lower bound, and a range whose bounds are
// equal, which declares exactly one element at index 4. A backend that assumed
// a zero lower bound indexes both of them wrong.
//
//! lrm 3.2
//! lrm 3.2:1
//! lrm 3.2:2
`include "check.vh"
module ch03_variable_arrays(p, n);
    inout p, n;
    electrical p, n;
    integer flags[0:2];
    real gains[0:2];
    integer offset[-2:2];
    real one[4:4];

    analog begin
        flags[0] = 1;
        flags[1] = 2;
        flags[2] = 4;
        gains[0] = 1.5;
        gains[1] = 2.5;
        gains[2] = 3.5;
        `CHECKI("each element is independent storage", flags[0] + 10 * flags[1] + 100 * flags[2], 421);
        `CHECKX("real array element 2", gains[2], 3.5);
        offset[-2] = 7;
        offset[0] = 8;
        offset[2] = 9;
        one[4] = 2.25;
        `CHECKI("a negative lower bound is its own element", offset[-2], 7);
        `CHECKI("the element at index 0 of a [-2:2] array is not the first", offset[0], 8);
        `CHECKI("negative and positive indices do not alias", offset[-2] + 10 * offset[0] + 100 * offset[2], 987);
        `CHECKX("[4:4] declares one element, at index 4", one[4], 2.25);
        `CHECKX("integer element times real element promotes", flags[0] * gains[0], 1.5);
        I(p, n) <+ flags[0] * gains[0] * V(p, n);
    end
endmodule
