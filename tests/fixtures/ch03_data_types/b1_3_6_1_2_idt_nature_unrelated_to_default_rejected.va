// §3.6.1.2, idt_nature:
//
//   "The idt_nature attribute is optional; the default value is the nature
//    itself. While it is possible to override the parent's value of idt_nature
//    using a derived nature, the nature thus specified shall be related (share
//    the same base nature) to the nature the parent uses for its idt_nature."
//
// b1_amp gives no idt_nature, so the nature it uses for its idt_nature is the
// default, b1_amp itself. Its derived nature b1_amp_child overrides it with
// b1_flux, a base nature of its own: base b1_flux is not base b1_amp, so the
// override is unrelated, exactly as if b1_amp had written `idt_nature = b1_amp`.
// This file is b1_3_6_1_2_idt_nature_related_overrides.va with that one
// override changed from b1_amp_fine (derived from b1_amp, legal).
//
// E0341 is VerA's code for the explicit-parent form of the same rule
// (b1_3_6_1_2_idt_nature_unrelated_to_explicit_rejected.va).
//
//! lrm 3.6.1.2
//! lrm 3.6.1.2:6
//! reject-only E0341
//! neighbour b1_3_6_1_2_idt_nature_related_overrides.va
`include "check.vh"
nature b1_flux;
    units = "Wb";
    access = B1Phi;
    abstol = 1n;
endnature

nature b1_flux_fine : b1_flux;
    abstol = 1p;
endnature

nature b1_volt;
    units = "V";
    access = B1V;
    abstol = 1u;
    idt_nature = b1_flux;
endnature

nature b1_volt_child : b1_volt;
    idt_nature = b1_flux_fine;
endnature

nature b1_amp;
    units = "A";
    access = B1I;
    abstol = 1p;
endnature

nature b1_amp_fine : b1_amp;
    abstol = 1f;
endnature

nature b1_amp_child : b1_amp;
    idt_nature = b1_flux;
endnature

discipline b1_idt_disc;
    potential b1_volt_child;
    flow b1_amp_child;
enddiscipline

module b1_idt_nature_overrides(p, n);
    inout p, n;
    b1_idt_disc p, n;

    analog begin
        `CHECKX("the derived potential nature reads through its parent's access", B1V(p, n), 1.5);
        `CHECKX("idt() with no tolerance returns its ic in DC", idt(B1V(p, n), 2.5), 2.5);
        B1I(p, n) <+ B1V(p, n) / 2.0;
    end
endmodule
