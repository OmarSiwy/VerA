// §3.4: "the initializer ... shall be a constant expression, that is, an
// expression containing only constant numbers and previously defined
// parameters."
//
// `scratch` is a real VARIABLE. It is declared before the parameter, so it
// satisfies the ordering half that 58_forward_parameter_reference.va tests, and
// it is still not admissible: the permitted set is constant numbers and
// parameters, and a variable is neither. Its value does not even exist until
// the analog block runs, which is after every parameter has had to be resolved.
//
// Replacing `scratch` with a literal, or with a parameter declared above, makes
// the file legal.
//
//! lrm 3.4
//! reject E0314
module ch3_variable_in_parameter_initializer(p, n);
    inout p, n;
    electrical p, n;
    real scratch;
    parameter real slope = scratch;

    analog begin
        scratch = 1.0;
        I(p, n) <+ slope * V(p, n);
    end
endmodule
