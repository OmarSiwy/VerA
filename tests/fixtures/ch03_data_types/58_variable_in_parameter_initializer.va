// §3.4: "the initializer ... shall be a constant expression, that is, an
// expression containing only constant numbers and previously defined
// parameters."
//
// `scratch` is a real VARIABLE. It is declared before the parameter, so it
// satisfies the ordering half that 58_forward_parameter_reference.va tests, and
// it is still not admissible: the permitted set is constant numbers and
// parameters, and a variable is neither. Its value does not even exist until
// the analog block runs, which is after every parameter has had to be resolved.
//
// Replacing `scratch` with a literal, or with a parameter declared above, makes
// the file legal.
//
// The pinned substring is only the phase label. VerA reports E0314 "unknown
// identifier: `scratch`", which is false of a name declared one line above — it
// is an accident of parameter lowering not seeing module-scope variables, so
// pinning that code would pin the accident rather than §3.4's
// constant-expression restriction, and it would stop matching the day VerA
// resolves the name and reports a proper not-a-constant-expression diagnostic,
// which is exactly when this fixture starts being worth something.
// 58_forward_parameter_reference.va does pin E0314, and honestly: there the
// name genuinely is not yet defined at the point of use.
//
//! lrm 3.4
//! reject DiagnosticsReported
module ch3_variable_in_parameter_initializer(p, n);
    inout p, n;
    electrical p, n;
    real scratch;
    parameter real slope = scratch;

    analog begin
        scratch = 1.0;
        I(p, n) <+ slope * V(p, n);
    end
endmodule
