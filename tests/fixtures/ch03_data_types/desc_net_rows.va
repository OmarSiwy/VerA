// §3.6.3.1: "Nets can be declared with a description attribute. This
// information can be used by the simulator to generate help messages for a
// module. Example: (* desc="drain terminal" *) electrical d;
// If a net is also a module port, the description attribute may also be
// specified on the port declaration line (in which the net is declared as
// input, inout, or output). If the description attribute is specified for the
// same net_identifier in both the net discipline declaration and the port
// declaration, then the last attribute value shall be used and the tool can
// give a warning that a duplicate attribute specification has occurred."
//
// §2.9.2 gives `desc` to "parameter, variable and net declarations" and
// `units` to "the parameter or variable", so a net row carries a description
// only; and it names no branch declaration, so a branch is never a row.
//
// The help message is the host's, so the evidence is the device's `decl_meta`
// table (`contract.DeclMeta`): nets after parameters and variables (here there
// are none), ports in port order, then the other nets in declaration order.
// By hand:
//
//   p     desc on the port declaration line only: desc="input terminal".
//   n     desc on the port line ("port line"), then on the net discipline
//         declaration two lines later ("net line"): "the last attribute
//         value shall be used", desc="net line".
//   d     the clause's own example: desc="drain terminal".
//   s     `(* units="V" *)` alone: §2.9.2 gives a net no units, so nothing a
//         row could carry; no row.
//   q     no attribute; and the branch `br` carries a desc but is not a net:
//         neither is a row. Three rows in all.
//
// The CHECKs run the circuit the attributes decorate: `//! bias V(p) = 1.0`
// with every other node solved (`//! solve`). p-d-s-n is three 1 kOhm
// resistors to n, with n at the reference, so V(d) = 2/3 V and V(s) = 1/3 V;
// the branch q-n carries 1 mA into a 1 kOhm resistor, V(q) = 1 V. Each is
// within 1e-12 of its fraction (the solve converges to the f64 answer).
//
//! lrm 3.6.3.1
//! lrm 3.6.3.1:1
//! lrm 3.6.3.1:2
//! lrm 2.9.2
//! bias V(p) = 1.0, V(n) = 0.0
//! solve
//! meta net p desc="input terminal"
//! meta net n desc="net line"
//! meta net d desc="drain terminal"
//! checks 7
`include "check.vh"
module ch3_desc_net_rows(p, n);
    (* desc="input terminal" *) inout p;
    (* desc="port line" *) inout n;
    electrical p;
    (* desc="net line" *) electrical n;
    (* desc="drain terminal" *) electrical d;
    (* units="V" *) electrical s;
    electrical q;
    (* desc="source branch" *) branch (q, n) br;

    analog begin
        I(p, d) <+ V(p, d) / 1k;
        I(d, s) <+ V(d, s) / 1k;
        I(s, n) <+ V(s, n) / 1k;
        I(br) <+ V(br) / 1k - 1m;
        `CHECK("the described drain node solves as an undecorated one", V(d), 0.6666666666666666, 1e-12);
        `CHECK("and so does the node with units", V(s), 0.3333333333333333, 1e-12);
        `CHECK("the described branch is an ordinary branch", V(q), 1.0, 1e-12);
    end
endmodule
