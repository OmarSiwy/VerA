// §3.4.1 derives an untyped parameter from its FINAL HDL instance override.
//! lrm 3.4.1
//! lrm 6.3
//! lrm 6.3.3
//! lrm 6.3.3:1
//! lrm 6.3.4
//! lrm 6.3.4:1000
`include "check.vh"
module precision_child;
  parameter code = 1;
  parameter copy = code;
  localparam localcopy = code;
  parameter integer narrowed = code;
  analog begin
    `CHECKI("override preserves64", code, 4702394921427289928);
    `CHECKI("dependent override preserves64", copy, 4702394921427289928);
    `CHECKI("local dependent override preserves64", localcopy, 4702394921427289928);
    `CHECKI("typed override narrows32", narrowed, 1162233672);
  end
endmodule
module integer_parameter_precision_override;
  precision_child #(.code(64'h4142434445464748)) child();
endmodule
