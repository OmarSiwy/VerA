// §3.6.1: "Each nature definition shall have a unique identifier as the name of
// the nature and shall include all the required attributes specified in
// 3.6.1.2." §3.6.1.2 says of units: "This attribute is required for all base
// natures."
//
// `ch3_no_units` is a BASE nature (no `:` parent) carrying access and abstol but
// not units. 35_base_nature_required_attributes.va is the same shape with
// abstol missing instead; the two are separate files because a compiler can
// check one required attribute and not the others, and the required set is
// three names long.
// The signal-flow port is output (§1.3.4.1), avoiding an unrelated inout error.
//
//! lrm 3.6.1.2
//! lrm 3.6.1.2:1001
//! lrm 3.6.1
//! lrm 3.6.1:2
//! reject-only E0332
nature ch3_no_units; access=NoUnitsV; abstol=1u; endnature
discipline ch3_no_units_disc; potential ch3_no_units; enddiscipline
module ch3_missing_units(p); output p; ch3_no_units_disc p; analog NoUnitsV(p)<+0.0; endmodule
