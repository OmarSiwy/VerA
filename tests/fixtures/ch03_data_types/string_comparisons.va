// §3.3 Table 3-3: `==` yields 1 when the strings are equal and 0 otherwise, and
// the four relationals use LEXICOGRAPHICAL ordering. For a = "a", b = "b":
//
//   (a==b) (a!=b) (a<b) (a<=b) (a>b) (a>=b)
//      0      1      1     1      0     0     -> r = 3
//
// The two single-operator checks are there so a pair of compensating errors
// cannot reach the sum by accident.
//! lrm 3.3
`include "check.vh"
module ch3_string_compare(p);
  inout p;
  electrical p;
  string a = "a", b = "b";
  integer r;
  analog begin
    r = (a==b) + (a!=b) + (a<b) + (a<=b) + (a>b) + (a>=b);
    `CHECKI("lexicographic less-than", (a < b), 1);
    `CHECKI("equality of two distinct strings", (a == b), 0);
    `CHECKI("all six operators on a<b sum to 3", r, 3);
    I(p) <+ r + 0.0 * V(p);
  end
endmodule
