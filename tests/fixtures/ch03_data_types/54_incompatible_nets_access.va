// §3.11: "Certain operations can be done on nets only if the two (or more) nets
// are compatible. For example, if an access function has two nets as arguments,
// they must be compatible." §3.11.1's Potential Incompatibility Rule decides
// this pair: "Disciplines with incompatible potential natures are
// incompatible", and its worked observation is the same shape — "electrical and
// rotational are incompatible disciplines because the natures for both potential
// and flow are not derived from the same base natures."
//
// The pair cannot be written with annex D's `electrical` and `rotational`
// directly. §3.13.3 says "a net can only be accessed through its access
// functions", and rotational's potential nature is `Angle`, whose access is
// `Theta`, so `V(elec, shaft)` would be rejected for the §3.13.3 rule that
// 42_wrong_access_function.va already owns (E0501) and would never reach the
// compatibility check at all. So this file declares `ch3_rot_i`, which keeps
// annex D's `Angle` as its potential and annex D's `Current` as its flow. That
// makes `I` a legal spelling for BOTH nets — §3.13.3 is satisfied — while the
// potential natures stay `Voltage` (units "V") and `Angle` (units "rads"), which
// no rule in §3.11.1 makes compatible: not the Self Rule, not the Base or
// Derived Nature Rules, and not the Units Value Rule, since the units differ.
// `I(elec, shaft)` is therefore an access function over two incompatible nets
// and nothing else in the file is wrong.
//
// 76_nature_compatibility_rules.va is the legal side — three pairs that each
// pass one of §3.11.1's nature rules, the third of them spanned through the
// flow half for exactly this reason.
//
// The pinned substring is only the phase label: VerA has no compatibility
// diagnostic, so a code would pin the wrong rule.
//
//! lrm 3.11
//! lrm 3.11.1
//! reject DiagnosticsReported
//! xfail VerA resolves I(elec, shaft) across nets whose potential natures are Voltage and Angle and stamps the branch; there is no §3.11 net compatibility check in lower.zig
discipline ch3_rot_i;
    potential Angle;
    flow Current;
enddiscipline

module ch3_incompatible_nets_access(p, n);
    inout p, n;
    electrical p, n;
    electrical elec;
    ch3_rot_i shaft;

    analog begin
        I(p, n) <+ I(elec, shaft) * V(p, n);
    end
endmodule
