// §§3.3, 5.3.2, 5.7: direction and shape belong to the current declaration.
//! lrm 5.7
//! lrm 5.7:1
//! bias V(p) = 1
`include "check.vh"
module ch03_dynamic_multidim_scope(p);
    inout p;
    electrical p;
    string a[1:0][2:3] = '{'{"a","b"},'{"c","d"}};
    integer i, j;
    real value;
    analog begin
        i = V(p); j = 3;
        `CHECKI("runtime string read", a[i][j] == "b", 1);
        a[i][j] = "changed";
        `CHECKI("runtime string write", a[1][3] == "changed", 1);
        `CHECKI("string neighbor preserved", a[0][3] == "d", 1);
        begin : inner
            real a[-1:0][7:6] = '{'{10,11},'{20,21}};
            i = -1; j = 6;
            `CHECKX("shadow array direction and shape", a[i][j], 11);
            a[i][j] = 33;
            `CHECKX("shadow array write", a[-1][6], 33);
        end
        i = 1; j = 3;
        `CHECKI("outer shape and type restored", a[i][j] == "changed", 1);
        begin : scalar_shadow
            real a;
            a = 19;
            value = a;
        end
        `CHECKX("scalar shadows array", value, 19);
        `CHECKI("array restored after scalar", a[i][j] == "changed", 1);
        I(p) <+ 0 * V(p);
    end
endmodule
