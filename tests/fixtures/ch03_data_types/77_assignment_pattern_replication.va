// §3.4.8 assignment patterns, the replication form, exactly as A.8.1 spells it:
//
//     assignment_pattern ::= '{ expression { , expression } }
//                          | '{ constant_expression { expression { , expression } } }
//
// The second alternative is ONE replication filling the whole pattern — a count,
// then a braced element list, then the closing `}`. There is no production for
// two comma-separated replication groups, so `'{2{1.5}, 2{2.5}}` is not a
// Verilog-AMS assignment pattern at all and a conforming compiler must reject
// it; this file used to write exactly that and book the rejection as a VerA gap.
//
// The LRM's own §3.4.8 examples are the nested two-dimensional form on a
// VARIABLE:
//
//     real distort[0:2][0:2] = '{ 3{ '{3{0.0}}}};
//     string above_0p5[0:2][0:2] = '{ 3{ '{3{" "}}}};
//
// `fill` is that shape with the two dimensions made DIFFERENT sizes, so the
// outer count 2 and the inner count 3 cannot be swapped without changing the
// answer, and with a nonzero element so an unfilled slot reads as §3.2's default
// 0.0 rather than as the value under test. The last element is checked because
// that is the one a compiler which applied the count once instead of N times
// leaves at 0.0.
//
// `steps` is the one-dimensional constant form: `constant_assignment_pattern ::=
// '{ constant_expression { constant_expression { , constant_expression } } }`
// carries a replication too, so a parameter array may be filled this way.
//
// 08_parameter_array.va is the plain `'{a, b, c, d}` form and
// 77_assignment_pattern_variable.va is the non-constant form; this is the third
// shape §3.4.8 shows and the only one with a repeat count.
//
//! lrm 3.4.8
//! lrm 3.3
//! lrm A.8.1
//! xfail VerA has no two-dimensional arrays: the second `[` of `real fill[0:1][0:2]` is E0207 "expected `;`", and lowering's dimBounds refuses more than one dimension anyway (E0307). The replication itself parses and unrolls now — `steps`, the one-dimensional half of this file, is the shape that works
`include "check.vh"
module ch03_assignment_pattern_replication(p, n);
    inout p, n;
    electrical p, n;
    parameter real steps[0:3] = '{4{1.5}};
    real fill[0:1][0:2] = '{ 2{ '{3{2.5}}}};

    analog begin
        `CHECKX("a one-dimensional constant replication fills element 0", steps[0], 1.5);
        `CHECKX("and the last element of the parameter array", steps[3], 1.5);
        `CHECKX("the nested replication fills the first row", fill[0][0], 2.5);
        `CHECKX("the inner count 3 reaches the end of a row", fill[0][2], 2.5);
        `CHECKX("the outer count 2 reaches the second row", fill[1][0], 2.5);
        `CHECKX("and the last element of the last row", fill[1][2], 2.5);
        I(p, n) <+ steps[0] * V(p, n);
    end
endmodule
