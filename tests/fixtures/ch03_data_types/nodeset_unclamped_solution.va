// AMS 3.6.3.2 supplies a nodeset to the analog solver, not a permanent
// potential constraint. Here only terminals p=3 and n=0 are prescribed.
// KCL at free node mid gives (mid-3)/1000 + mid/1000 = 0, hence mid=1.5.
// Its declared nodeset 5 must not clamp that unique solution. This does NOT
// establish that the initial guess was consumed: ignoring it also reaches 1.5.
// Initial-guess consumption and non-clamping are independent obligations.
//! lrm 3.6.3.2
//! bias V(p) = 3.0, V(n) = 0.0
//! solve
//! print none
//! checks 1
`include "check.vh"
module audit_nodeset_unclamped_solution(p, n);
  inout p, n;
  electrical p, n;
  electrical mid = 5.0;
  analog begin
    I(p, mid) <+ V(p, mid) / 1000.0;
    I(mid, n) <+ V(mid, n) / 1000.0;
    `CHECK("free node solves KCL rather than staying at nodeset", V(mid, n), 1.5, 1e-10);
  end
endmodule
