// §3.6.2.5 overriding a nature attribute from the discipline. The declaration
// below is the LRM's `ttl` example: "the keyword flow or potential, then the
// hierarchical separator . and the attribute name, and, finally, set all of this
// equal to (=) the new value (e.g., flow.abstol = 10u)" — the
// nature_attribute_override nonterminal of Syntax 3-5.
//
// `abstol` is a solver tolerance: §3.6.1.1 makes it the absolute convergence
// tolerance, and nothing in the LRM fixes a transcript value for it, so asserting
// a number for it would over-specify and a conforming compiler would fail. What
// §3.6.2.5 does fix is that the override changes ONE attribute of the bound
// nature and leaves the binding itself intact — the discipline still has a
// potential nature whose `access` is V and a flow nature whose `access` is I, so
// a net of it still solves and still reads. That is what the assertions pin;
// this file used to declare the override and stop, with no ports and no analog
// block.
//
// 2.5 - 0.5 = 2.0 V, and the flow contribution is what forces the flow half of
// the discipline — the overridden one — to be resolved at all.
//
//! bias V(t1) = 2.5, V(t2) = 0.5
//! lrm 3.6.2.5
`include "check.vh"
nature ch03_override_voltage;
    units = "V";
    access = V;
    abstol = 100u;
endnature

nature ch03_override_current;
    units = "A";
    access = I;
    abstol = 1u;
endnature

discipline ch03_override_discipline;
    potential ch03_override_voltage;
    flow ch03_override_current;
    flow.abstol = 10u;
enddiscipline

module ch03_discipline_override(t1, t2);
    inout t1, t2;
    ch03_override_discipline t1, t2;

    analog begin
        `CHECKX("a net of a discipline that overrides flow.abstol still reads with its potential access function", V(t1, t2), 2.0);
        I(t1, t2) <+ 0.5 * V(t1, t2);
    end
endmodule
