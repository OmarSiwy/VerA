// §3.6.2.5: "A discipline can override the value of the bound nature for the
// pre-defined attributes (except as restricted by 3.6.1.2) ... To do so from a
// discipline declaration, the bound nature and attribute needs to be defined".
//
// `pot_only` binds a potential nature and NO flow nature, then overrides
// `flow.abstol`. There is no bound flow nature whose abstol could be
// overridden, so the requirement that "the bound nature ... needs to be
// defined" is not met and the discipline is in error.
//
// Everything else is legal: the same discipline without the `flow.abstol`
// line compiles, and the override itself compiles when a flow nature IS bound
// (both probed). `x` is an internal net so no port-direction rule for a
// signal-flow discipline is involved.
//
// VerA refuses it with E0370 "discipline overrides an attribute of no bound
// nature".
//
//! lrm 3.6.2.5
//! lrm 3.6.2.5:1000
//! reject-only E0370
//! neighbour b1_3_6_2_5_discipline_overrides_flow_abstol.va
nature ch3_ovr_volt;
  units = "V";
  access = V;
  abstol = 1u;
endnature

discipline ch3_ovr_pot_only;
  potential ch3_ovr_volt;
  flow.abstol = 1n;        // illegal: no flow nature is bound
enddiscipline

module ch3_flow_override_without_flow();
  ch3_ovr_pot_only x;
  analog V(x) <+ 1.0;
endmodule
