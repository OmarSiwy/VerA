// Resolved semantic behavior is observed by tests/host.py.
// §3.6.1.2, idt_nature:
//
//   "The idt_nature attribute is optional; the default value is the nature
//    itself. While it is possible to override the parent's value of idt_nature
//    using a derived nature, the nature thus specified shall be related (share
//    the same base nature) to the nature the parent uses for its idt_nature."
//
// Two derived natures override idt_nature, each with a RELATED nature, so both
// overrides are legal:
//
//   b1_volt_child : b1_volt   b1_volt gives idt_nature = b1_flux explicitly;
//                             the override b1_flux_fine derives from b1_flux,
//                             so the two share the base nature b1_flux.
//   b1_amp_child : b1_amp     b1_amp gives NO idt_nature, so by the first
//                             sentence the nature the parent uses is b1_amp
//                             itself; the override b1_amp_fine derives from
//                             b1_amp, so the two share the base nature b1_amp.
//
// Each refusal below is this file with one override changed to an unrelated
// base nature:
//   idt_nature_unrelated_to_explicit_rejected.va  b1_volt_child -> b1_amp
//   idt_nature_unrelated_to_default_rejected.va   b1_amp_child  -> b1_flux
//
// The derived natures inherit `access` (§3.6.1.2), so B1V and B1I read and
// drive nets of the discipline built from them. The values asserted are fixed
// to the last bit: B1V(p, n) = 2.0 - 0.5 = 1.5, and §4.5.4 "When used in DC or
// IC analyses, idt() returns the initial condition (ic) if specified", 2.5.
// The tolerance the overrides imply is not asserted; §4.5.2 leaves it to the
// simulator.
//
//! lrm 4.5.4
//! lrm 3.6.1.2:5
//! lrm 3.6.1.2:6
//! bias p = 2.0, n = 0.5
//! checks 2
`include "check.vh"
nature b1_flux;
    units = "Wb";
    access = B1Phi;
    abstol = 1n;
endnature

nature b1_flux_fine : b1_flux;
    abstol = 1p;
endnature

nature b1_volt;
    units = "V";
    access = B1V;
    abstol = 1u;
    idt_nature = b1_flux;
endnature

nature b1_volt_child : b1_volt;
    idt_nature = b1_flux_fine;
endnature

nature b1_amp;
    units = "A";
    access = B1I;
    abstol = 1p;
endnature

nature b1_amp_fine : b1_amp;
    abstol = 1f;
endnature

nature b1_amp_child : b1_amp;
    idt_nature = b1_amp_fine;
endnature

discipline b1_idt_disc;
    potential b1_volt_child;
    flow b1_amp_child;
enddiscipline

module b1_idt_nature_overrides(p, n);
    inout p, n;
    b1_idt_disc p, n;

    analog begin
        `CHECKX("the derived potential nature reads through its parent's access", B1V(p, n), 1.5);
        `CHECKX("idt() with no tolerance returns its ic in DC", idt(B1V(p, n), 2.5), 2.5);
        B1I(p, n) <+ B1V(p, n) / 2.0;
    end
endmodule
