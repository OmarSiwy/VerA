// §3.4.7, first rule: "The type of an alias (real, integer, or string) shall be
// determined by the original parameter, as is its range of allowed values, if
// specified."
//
// `cnt` is an integer parameter with the range [0:5]; `m` is its alias. The
// override names the ALIAS (§3.4.7: aliases exist "to be used when overriding
// module parameter values") and the equations read the ORIGINAL, as rule 2
// requires.
//
// DERIVATION. The override value is the real 2.6. The alias is an integer
// because `cnt` is, so §3.4.1 applies: "If the type of the parameter is
// specified as integer or real, and the value assigned to the parameter
// conflicts with the type of the parameter, the value is converted to the type
// of the parameter (see 4.2.1.1)". §4.2.1.1 rounds a real to the nearest
// integer: 2.6 -> 3 (python3 round(2.6) = 3). 3 is inside [0:5].
//   cnt     = 3
//   cnt / 2 = 1    integer division (§4.2.5); a real 2.6 would give 1.3
//
// The range half is b1_3_4_7_alias_override_outside_original_range_rejected.va:
// this file with the override 2.6 changed to 9.
//
//! lrm 3.4.7
//! lrm 3.4.7:2
//! lrm 3.4.1
//! bias V(p) = 0.75, V(n) = 0.25
//! checks 2
`include "check.vh"
module b1_alias_type_child(p, n);
    inout p, n;
    electrical p, n;
    parameter integer cnt = 1 from [0:5];
    aliasparam m = cnt;

    analog begin
        `CHECKI("2.6 through the integer alias arrives as 3", cnt, 3);
        `CHECKI("the parameter is still an integer", cnt / 2, 1);
        I(p, n) <+ cnt * V(p, n);
    end
endmodule

module b1_alias_type_top(p, n);
    inout p, n;
    electrical p, n;

    b1_alias_type_child #(.m(2.6)) u(.p(p), .n(n));

    analog I(p, n) <+ 0.0;
endmodule
