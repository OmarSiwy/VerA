// §3.13.2: "Furthermore, the access function of each base nature shall be
// unique."
//
// specification/Vague_Decisions.md VD-096: VerA's preloaded annex D natures take part in
// this rule when the source includes D.1 itself (`disciplines.vams`, or its
// Verilog-A 1.0 name `discipline.h`, VD-093). This source does, so annex D's
// base nature Voltage (access V) is declared by the source, and so is
// ch3_vd096_volt with access V: two base natures, one access function. The
// same holds for Current and ch3_vd096_amp (access I). E0335 names each pair.
//
// The legal neighbour is the same text without the include
// (`annex_d_access_v_without_include.va`), which compiles and runs.
//
//! lrm 3.13.2
//! lrm 3.13.2:1
//! reject-only E0335
//! neighbour annex_d_access_v_without_include.va
`include "disciplines.vams"
nature ch3_vd096_volt; units = "V"; access = V; abstol = 1m; endnature
nature ch3_vd096_amp; units = "A"; access = I; abstol = 1n; endnature
discipline ch3_vd096_elec; potential ch3_vd096_volt; flow ch3_vd096_amp; enddiscipline
module ch3_vd096(p);
  inout p; ch3_vd096_elec p;
  analog I(p) <+ V(p) / 2k;
endmodule
