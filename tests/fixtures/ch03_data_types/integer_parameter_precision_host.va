// Runtime model-card derivation observes exact integer fields and computes
// integer intermediates in the integer domain. This supplied value is exactly
// representable by the fixture runner's real-valued card API.
//! lrm 3.4.1
//! lrm 6.3.4
//! lrm 6.3.4:1000
//! param base = 9007199254740996
//! param word = 2147483646
`include "check.vh"
module integer_parameter_precision_host;
  parameter base = 64'h0020000000000001;
  parameter copy = base;
  localparam low = base & 64'h00000000ffffffff;
  parameter integer word = 2147483647;
  localparam integer square = word * word;
  localparam integer quotient = (word + 2) / 2;
  analog begin
    `CHECKI("host override copied exactly", copy, 9007199254740996);
    `CHECKI("host override masked exactly", low, 4);
    `CHECKI("integer product wraps before precision loss", square, 4);
    `CHECKI("integer sum wraps before division", quotient, -1073741824);
  end
endmodule
