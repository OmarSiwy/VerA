// §3.6.1.2, idt_nature: "If specified, the constant expression assigned to
// idt_nature shall be the name (not a string) of a nature which is DEFINED
// ELSEWHERE."
//
// `ch3_idt_dangling` names `ch3_no_such_nature`, which this file never declares
// and neither does annex D. 66_idt_nature_self_reference.va is the legal side —
// there the name resolves, to the nature itself.
//
// E0341 ("`idt_nature` does not name a related nature") is VerA's code for this
// rule, and it replaces the phase label pinned before the code existed.
//
//! lrm 3.6.1.2
//! lrm 3.6.1.2:4
//! reject-only E0341
//! neighbour 66_idt_nature_self_reference.va
nature ch3_idt_dangling; units="V"; access=DanglingV; abstol=1u; idt_nature=ch3_no_such_nature; endnature
module ch3_idt_nature_not_a_nature; endmodule
