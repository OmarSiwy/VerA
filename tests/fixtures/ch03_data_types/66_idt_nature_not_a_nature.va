// §3.6.1.2, idt_nature: "If specified, the constant expression assigned to
// idt_nature shall be the name (not a string) of a nature which is DEFINED
// ELSEWHERE."
//
// `ch3_idt_dangling` names `ch3_no_such_nature`, which this file never declares
// and neither does annex D. 66_idt_nature_self_reference.va is the legal side —
// there the name resolves, to the nature itself.
//
// The pinned substring is only the phase label: VerA has no diagnostic for this
// rule, so a code would pin the wrong one.
//
//! lrm 3.6.1.2
//! reject DiagnosticsReported
//! xfail VerA accepts an undefined identifier as the `idt_nature` attribute of a nature; lower.zig does not resolve nature attribute references
nature ch3_idt_dangling; units="V"; access=DanglingV; abstol=1u; idt_nature=ch3_no_such_nature; endnature
module ch3_idt_nature_not_a_nature; endmodule
