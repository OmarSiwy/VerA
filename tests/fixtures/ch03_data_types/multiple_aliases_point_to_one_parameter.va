// §3.4.7: "Multiple aliases can point to the same parameter."
//
// `dtemp` has two alternate names, `trise` and `tcal`, both declared with
// `aliasparam`. This is the LRM's own `nmos2` shape widened to two aliases;
// each alias is an override name for the ONE parameter, not a second storage
// location. Two instances below override through DIFFERENT aliases: the first
// names `trise`, the second `tcal`, and each instance's original parameter has
// to hold its own override. A compiler that registered only the first (or
// last) alias fails one of the two reads; one that gave each alias its own
// storage leaves the originals at their default 0.
//
// The reads are §6.3 hierarchical parameter references to the original names,
// which §3.4.7 requires the equations to use: "the equations in the module
// shall reference the parameter by its original name, not the alias."
// 07_parameter_alias.va is the one-alias case; this file is what makes
// "multiple" observable.
//
//! lrm 3.4.7
//! lrm 3.4.7:1001
//! checks 3
`include "check.vh"
module ch03_multi_alias_target;
  parameter real dtemp = 0 from [-273.15:inf);
  aliasparam trise = dtemp;
  aliasparam tcal = dtemp;

  analog begin end
endmodule

module multiple_aliases_point_to_one_parameter;
  ch03_multi_alias_target #(.trise(5.0)) via_first();
  ch03_multi_alias_target #(.tcal(7.0)) via_second();

  analog begin
    `CHECKX("an override through the first alias reaches the original", via_first.dtemp, 5.0);
    `CHECKX("an override through the second alias reaches the same original", via_second.dtemp, 7.0);
    `CHECKX("the two instances keep their own values", via_first.dtemp + via_second.dtemp, 12.0);
  end
endmodule
