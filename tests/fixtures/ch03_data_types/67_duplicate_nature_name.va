// §3.6.1: "Each nature definition shall have a unique identifier as the name of
// the nature." §3.13.1 puts natures, disciplines and modules in one global
// scope, so there is nowhere for the second declaration to live.
//
// `ch3_twice_n` is declared twice, with different attributes so this cannot be
// read as one nature written out twice — §3.6.1.1 makes an "alias" only through
// derivation (`nature ttl_net_curr : ttl_curr; endnature`), which is not what
// this is.
//
// 39_nature_discipline_namespace_collision.va covers the nature-versus-
// discipline collision, which VerA already diagnoses at E0336; this is the
// same-kind duplicate, a different code path.
//
// The pinned substring is only the phase label: E0336 is worded and scoped for
// the cross-kind case, so pinning it here would pin the wrong rule.
//
//! lrm 3.6.1
//! lrm 3.13.1
//! reject DiagnosticsReported
//! xfail VerA keeps the last of two natures declared with the same name and reports nothing; the E0336 collision check in lower.zig only fires across natures and disciplines
nature ch3_twice_n; units="V"; access=TwiceA; abstol=1u; endnature
nature ch3_twice_n; units="A"; access=TwiceB; abstol=1p; endnature
module ch3_duplicate_nature_name; endmodule
