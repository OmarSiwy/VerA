// Host-rendered operator controls retain integer semantics and Model access.
//! lrm 3.4.1
//! lrm 4.5.7
//! bias V(p) = 2.0
`include "check.vh"
module integer_parameter_precision_control(p);
    inout p;
    electrical p;
    parameter integer ticks = 1;
    parameter real source = 5.5;
    parameter integer count = source;
    parameter real delay = count / 2;
    real delayed;
    analog begin
        delayed = absdelay(V(p), ticks + 1);
        `CHECKX("integer control keeps model argument", delayed, 2);
        `CHECKX("real-to-int-to-real rendering terminates", delay, 3);
        I(p) <+ delayed;
    end
endmodule
