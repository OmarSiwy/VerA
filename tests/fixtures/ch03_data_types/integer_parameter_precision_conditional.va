// Equal-width conditional localparams preserve all eight bytes after host writes.
//! lrm 3.4.5
//! lrm 6.3.4
//! lrm 9.4.3
//! lrm 6.3.4:1000
//! param select = 1
`include "check.vh"
module integer_parameter_precision_conditional;
  parameter integer select = 0;
  localparam code = select ? 64'h4142434445464748 : 64'h494a4b4c4d4e4f50;
  string text;
  analog begin
    $sformat(text, "%s", code);
    `CHECKI("conditional wide bits", code, 4702394921427289928);
    `CHECKI("conditional wide text", text == "ABCDEFGH", 1);
  end
endmodule
