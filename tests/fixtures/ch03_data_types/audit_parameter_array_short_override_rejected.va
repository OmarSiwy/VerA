// AMS 3.4.4 requires an instance override array to have exactly the declared
// size. This declaration has three elements but the replacement has only two.
// h01_11_dependent_range_and_array_override.va supplies the legal resizing case.
//! lrm 3.4.4
//! lrm 3.4.4:1
//! lrm 3.4.4:3
//! reject-only E0921
module short_array_target;
  parameter real coefficients[0:2] = '{1.0, 2.0, 3.0};
  analog begin end
endmodule
module audit_parameter_array_short_override_rejected;
  short_array_target #(.coefficients('{4.0, 5.0})) child();
endmodule
