// AMS 3.4.5: local parameters "cannot directly be modified" by named
// parameter value assignment. A source-level named override must therefore
// be rejected; ignoring a testbench host binding does not test this rule.
//! lrm 3.4.5
//! lrm 3.4.5:1000
//! reject-only E0907
//! neighbour 06_local_parameter.va
module localparam_override_target;
  parameter real base = 2.0;
  localparam real derived = 2.0 * base;
  analog begin end
endmodule
module audit_localparam_override_rejected;
  localparam_override_target #(.derived(9.0)) child();
endmodule
