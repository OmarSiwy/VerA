// AMS 3.4.4 requires an instance override array to have exactly the declared
// size. Two declared elements cannot accept a three-element replacement.
//! lrm 3.4.4
//! reject array
//! xfail PARAM-ARRAY-SIZE-002: long parameter array overrides are accepted
module long_array_target;
  parameter real coefficients[0:1] = '{1.0, 2.0};
  analog begin end
endmodule
module audit_parameter_array_long_override_rejected;
  long_array_target #(.coefficients('{4.0, 5.0, 6.0})) child();
endmodule
