// §3.4.2, string value sets, both of the LRM's examples verbatim:
//
//     parameter string transistortype = "NMOS" from '{ "NMOS", "PMOS" };
//     parameter string filename = "output.dat" exclude '{ "" };
//
// The set is a CONSTRAINT on the value, not part of it — the same rule the
// numeric ranges obey in 05_parameter_ranges.va — so the default is whatever
// precedes `from`/`exclude` and it survives the suffix unchanged. This file used
// to declare both lines and read neither, with no ports and no analog block.
//
// A parser that folded the first element of the `'{...}` assignment pattern into
// the initializer would leave `device_type` "NMOS" by accident but would make
// `filename` the empty string, which is why the `exclude` case is here: it is
// the one where the mistake changes the answer.
//
// The other half of §3.4.2 — the set REJECTING an out-of-set instance value —
// needs a string override, and `//! param` carries only numbers (see
// src/backend/tb.zig), so it has no fixture yet.
//
//! lrm 3.4.2
`include "check.vh"
module ch03_string_parameter_range(p);
    inout p;
    electrical p;
    parameter string device_type = "NMOS" from '{"NMOS", "PMOS"};
    parameter string filename = "output.dat" exclude '{""};

    analog begin
        `CHECKI("the default survives a `from '{...}` string value set", (device_type == "NMOS"), 1);
        `CHECKI("the value set does not leak its second element into the default", (device_type == "PMOS"), 0);
        `CHECKI("the default survives an `exclude '{...}` string value set", (filename == "output.dat"), 1);
        `CHECKI("the excluded empty string is not the default", (filename == ""), 0);
        I(p) <+ 0.0 * V(p);
    end
endmodule
