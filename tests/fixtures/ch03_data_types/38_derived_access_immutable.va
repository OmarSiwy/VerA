// §3.6.1.2, access: "It is illegal for a derived nature to change the access
// attribute; the derived nature always inherits the access attribute of its
// parent nature."
//
// `ch3_access_child : ch3_access_parent` sets access=ChangedV over the
// inherited AccessV. Contrast §3.6.1.2's abstol paragraph, which says the
// opposite for that attribute ("It is legal for a derived nature to change
// abstol"), so the parent's abstol is left alone here and the access override
// is the only defect.
//
//! lrm 3.6.1.2
//! lrm 3.6.1.2:3
//! reject-only E0334
//! neighbour 36_derived_nature_inheritance.va
nature ch3_access_parent; units="V"; access=AccessV; abstol=1u; endnature
nature ch3_access_child:ch3_access_parent; access=ChangedV; endnature
module ch3_bad_access; endmodule
