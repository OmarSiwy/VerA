// §3.2.1: "Module scope variables with a description or units attribute, or
// both, shall be known as output variables, and Verilog-AMS simulators shall
// provide access to their values. SPICE-like simulators print the names,
// values, units, and descriptions of output variables" ... "Units and
// descriptions specified for block-level variables shall be ignored by the
// simulator, but can be used for documentation purposes."
//
// This fixture checks the declaration metadata and locally assigned values.
// Actual external access and block-variable exclusion are checked by
// tests/host.py with a real host report. Metadata alone
// cannot establish either host reporting requirement. Here there is one row
// per output variable, in declaration order, carrying exactly the attributes
// the declaration wrote. By hand, from the clause's own example:
//
//   cgs   `(* desc="gate-source capacitance", units="F" *) real cgs;` - the
//         clause's declaration, both strings as written.
//   cdb   `(* units="F" *)`: an output variable by "units ... or both"; no desc.
//   ids   `(* desc="drain current" *)` on an `integer`: §3.2.1 says
//         "variables", not "real variables", so it is a row too.
//   tmp   no attribute: not an output variable, no row.
//   lv    a named block's variable with desc and units: "shall be ignored",
//         so no row. Three rows in all, all `variable`.
//
// The CHECKs pin the values the module computes into the variables, which is
// the other half of the clause (their values reach the module's own output):
// cgs = 4.21e-15 and cdb = 3.0e-15 as assigned, ids = 7 as assigned.
//
//! lrm 2.9.2
//! lrm 3.2.1:1
//! lrm 3.2.1:2
//! meta variable cgs desc="gate-source capacitance" units="F"
//! meta variable cdb units="F"
//! meta variable ids desc="drain current"
//! checks 7
`include "check.vh"
module ch3_desc_units_output_variable_rows(p, n);
    inout p, n;
    electrical p, n;

    (* desc="gate-source capacitance", units="F" *) real cgs;
    (* units="F" *) real cdb;
    (* desc="drain current" *) integer ids;
    real tmp;

    analog begin : blk
        (* desc="block local", units="V" *) real lv;
        cgs = 4.21e-15;
        cdb = 3.0e-15;
        ids = 7;
        tmp = 1.0;
        lv = 0.5;
        `CHECKX("an output variable holds what the module assigned", cgs, 4.21e-15);
        `CHECKX("so does one with units alone", cdb, 3.0e-15);
        `CHECKI("and an integer one", ids, 7);
        I(p, n) <+ V(p, n) + 0.0 * (cgs + cdb + ids + tmp + lv);
    end
endmodule
