// §3.6.2.1: "Disciplines with two natures are called conservative disciplines
// ... Conservative disciplines shall not have the same nature specified for
// both the potential and the flow."
//
// `ch3_both_n` is bound to BOTH halves of `ch3_both_d`. §3.6.2.1 also says the
// access function of the potential nature is the potential access function and
// the access function of the flow nature is the flow access function, so with
// one nature on both bindings `Both(net)` would have to be a potential and a
// flow at once and there is no reading of the module below that says which.
// 11_discipline_declarations.va declares the three well-formed shapes
// (conservative, potential-only, flow-only); this is the fourth, illegal, one.
//
// The pinned substring is only the phase label: VerA has no diagnostic for this
// rule, so a code would pin the wrong one and stop matching the day the right
// one lands.
//
//! lrm 3.6.2.1
//! reject DiagnosticsReported
//! xfail VerA binds the same nature to potential and flow without complaint; there is no same-nature check on a conservative discipline in lower.zig
nature ch3_both_n; units="V"; access=Both; abstol=1u; endnature
discipline ch3_both_d;
    domain continuous;
    potential ch3_both_n;
    flow ch3_both_n;
enddiscipline
module ch3_same_nature_both_bindings(p); inout p; ch3_both_d p; analog Both(p) <+ 0.0; endmodule
