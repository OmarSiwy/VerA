// §3.4.5 local parameters: "Local parameters can be assigned constant
// expressions containing parameters, which can be modified with defparam
// statements or module instance parameter value assignments."
//
// So a localparam is evaluated AFTER the override, not folded against the
// declared default. `base_gain` is overridden to 3.0 below, which makes
// `doubled_gain` 6.0; a backend that constant-folded `2.0 * base_gain` at
// elaboration time against the default would answer 4.0.
//
//! param base_gain = 3.0
`include "check.vh"
module ch03_local_parameter(p, n);
    inout p, n;
    electrical p, n;
    parameter real base_gain = 2.0;
    localparam real doubled_gain = 2.0 * base_gain;

    analog begin
        `CHECKX("the override reaches the parameter", base_gain, 3.0);
        `CHECKX("localparam is computed from the overridden parameter", doubled_gain, 6.0);
        I(p, n) <+ doubled_gain * V(p, n);
    end
endmodule
