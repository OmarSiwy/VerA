// §3.11.1, two of the six discipline rules:
//   "Natureless Discipline Rule: A natureless discipline is compatible with
//    all other disciplines of the same domain."
//   "Domainless Discipline Rule: A domainless discipline is compatible with
//    all disciplines as there is no nature or domain conflict."
//
// 30/31 declare such nets and 79/80 refuse an access through them; neither
// joins one to another discipline, which is where compatibility is decided
// (§3.11: "if two nets are connected via a port, the two nets must be
// compatible"). Here a natureless net `w` and a domainless net `d` in the
// parent each join two `electrical` ports: a 2.0 V source and a probe on `w`,
// a 3.0 V source and a probe on `d`. Compatible, each pair is one node, so
// each probe reads its source exactly: 2.0 and 3.0. A compiler that refused
// the binding fails to compile; one that kept the two sides as separate nodes
// leaves the probe floating at 0 (its own port has no other contribution).
//
// Each child's `V(a)`/`I(a)` is judged against its own `electrical a`
// (§4.4: "The access function name shall match the discipline declaration
// for the nets, ports, or branch given in the argument expression list"),
// not against the natureless or domainless net it joins, which binds no
// nature to respell it to. The parent itself still cannot access `w` or `d`
// (79/80). `//! solve` frees both nodes, so the probes read the solved
// circuit, not the harness's zero bias.
//
// No refusal neighbour: the natureless rule is scoped to "the same domain",
// and a different-domain binding is §6.5.7's connect-statement question
// (E0927, reject_mixed_port_no_connect_statement.va); two natured,
// incompatible disciplines are E0355 (incompatible_port_discipline_rejected.va).
//
//! lrm 3.11.1
//! lrm 3.11
//! solve
//! checks 2
`include "check.vh"
discipline ch3c_natureless;
  domain continuous;
enddiscipline
discipline ch3c_domainless;
enddiscipline
module ch3c_src(a);
  inout a; electrical a;
  parameter real v = 0.0;
  analog V(a) <+ v;
endmodule
module ch3c_probe2(a);
  inout a; electrical a;
  analog begin
    I(a) <+ V(a) * 1.0e-3;
    `CHECKX("the probe sees the 2.0 V source through the natureless net", V(a), 2.0);
  end
endmodule
module ch3c_probe3(a);
  inout a; electrical a;
  analog begin
    I(a) <+ V(a) * 1.0e-3;
    `CHECKX("the probe sees the 3.0 V source through the domainless net", V(a), 3.0);
  end
endmodule
module ch3c_compat;
  ch3c_natureless w;
  ch3c_domainless d;
  ch3c_src #(.v(2.0)) s1(w);
  ch3c_probe2 p1(w);
  ch3c_src #(.v(3.0)) s2(d);
  ch3c_probe3 p2(d);
endmodule
