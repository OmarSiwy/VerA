// §2.9 VerA's `vera_scratch` declaration attribute: the variable carries
// nothing from one evaluation to the next. Every evaluation starts it at its
// declaration's initializer, here none, so the §3.2 zero.
//
// §2.9: "An attribute_instance can appear in the Verilog-AMS description as a
// prefix attached to a declaration, a module item, a statement, or a port
// connection." And: "If a value is not specifically assigned to the attribute,
// then its value shall be 1." §2.9 leaves an attribute's meaning to the tool;
// this one is VerA's (specification/Vague_Decisions.md §6).
//
// WHY. §3.2: "Real variables are initialized to zero (0) at the start of a
// simulation", once, so a variable keeps its value between evaluations, and a
// read the compiler cannot prove follows a write of the same evaluation makes
// it held state. An array indexed at run time (a B-source tape's stack) is
// exactly that read; the attribute says no evaluation ever reads what an
// earlier one left.
//
// The observable difference from holding, by hand, at V(a) = 0.5, V(b) = 0,
// on the transient points t = 0 and t = 1:
//
//   w = 1 at t = 0, 2 at t = 1 (a runtime subscript, so the arrays are
//   memory-backed and indexed at run time).
//   st[w] = V(a)^2 = 0.25         st[1]: 0.25 at t = 0, 0 at t = 1 (no write)
//                                  st[2]: 0 at t = 0, 0.25 at t = 1
//                                  st[3]: never written, 0 at both
//   ht, the same with `= 0` (the attribute off), so held as §3.2 says:
//   ht[w] = 5                      ht[1]: 5 at t = 0, and still 5 at t = 1
//   ct, a named block's scratch integer array: ct[w] = 3
//                                  ct[1]: 3 at t = 0, 0 at t = 1
//   s, a scratch scalar written only while t < 0.5: 7 at t = 0, 0 at t = 1
//   y = st[w] = V(a)^2, so §4.5.6 ddx(y, V(a)) = 2 V(a) = 1.0 at both: the
//   derivative goes through the scratch array's store and load.
//
//   The branch current y V(a,b) + 5m V(a,b) then has d/dV(a) = 2 V(a) V(a,b)
//   + y + 5m = 0.5 + 0.25 + 0.005 = 0.755, the Jacobian the device stamps
//   (CHECK, not CHECKX: the sum rounds).
//
// Eight verdicts at two points.
//! lrm 2.9
//! lrm 2.9:3
//! lrm 3.2
//! analysis tran
//! bias V(a) = 0.5, V(b) = 0.0
//! time 0, 1
//! checks 16
`include "check.vh"
module vera_scratch_starts_each_evaluation(a, b);
  inout a, b; electrical a, b;
  integer w;
  (* vera_scratch *) real st[0:3];
  (* vera_scratch = 0 *) real ht[0:3];
  (* vera_scratch *) real s;
  real y;
  analog begin : body
    (* vera_scratch *) integer ct[0:3];
    w = ($abstime < 0.5) ? 1 : 2;
    st[w] = V(a) * V(a);
    ht[w] = 5.0;
    ct[w] = 3;
    if ($abstime < 0.5) s = 7.0;
    y = st[w];
    I(a, b) <+ y * V(a, b) + ht[1] * 1e-3 * V(a, b);
    `CHECKX("st[1], written at t = 0 only", st[1], ($abstime < 0.5) ? 0.25 : 0.0);
    `CHECKX("st[2], written at t = 1 only", st[2], ($abstime < 0.5) ? 0.0 : 0.25);
    `CHECKX("st[3], never written", st[3], 0.0);
    `CHECKX("ht[1], held without the attribute", ht[1], 5.0);
    `CHECKI("ct[1], a scratch block-local integer", ct[1], ($abstime < 0.5) ? 3 : 0);
    `CHECKX("s, a scratch scalar", s, ($abstime < 0.5) ? 7.0 : 0.0);
    `CHECKX("ddx through the scratch array", ddx(y, V(a)), 1.0);
    `CHECK("the stamped Jacobian, d I(a,b) / d V(a)", ddx(y * V(a, b) + ht[1] * 1e-3 * V(a, b), V(a)), 0.755, 1e-12);
  end
endmodule
