// §3.3 "Arrays and multidimensional arrays of string are also supported", and
// prints this declaration verbatim:
//
//     string paths[0:2][0:1] =
//         '{ '{"dir1", "fileA"}, '{"dir2", "fileA"},'{"dir1","fileB"}};
//
// Three rows of two. The repeated values are what make a flattening bug
// visible: "dir1" appears at [0][0] and [2][0], "fileA" at [0][1] and [1][1],
// so a transposed or wrongly-strided subscript still lands on a plausible
// string. The six checks fix every cell of the shape, so nothing can be read
// out of the wrong one and pass.
//
//! lrm 3.3
//! bias V(p) = 1.0
//! xfail VerA's parser takes only one dimension in a string array declaration: the second `[` is E0207
`include "check.vh"
module ch3_multistring(p);
    inout p;
    electrical p;
    string paths[0:2][0:1] =
        '{ '{"dir1", "fileA"}, '{"dir2", "fileA"},'{"dir1","fileB"}};

    analog begin
        `CHECKI("row 0 column 0", (paths[0][0] == "dir1"), 1);
        `CHECKI("row 0 column 1", (paths[0][1] == "fileA"), 1);
        `CHECKI("row 1 column 0", (paths[1][0] == "dir2"), 1);
        `CHECKI("row 1 column 1 repeats a value from row 0", (paths[1][1] == "fileA"), 1);
        `CHECKI("row 2 column 0 repeats a value from row 0", (paths[2][0] == "dir1"), 1);
        `CHECKI("row 2 column 1", (paths[2][1] == "fileB"), 1);
        I(p) <+ 0.0 * V(p);
    end
endmodule
