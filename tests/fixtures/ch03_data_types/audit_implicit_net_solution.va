// AMS 3.6.5 permits implicit structural nets, resolved through connected ports.
// The parent never references implicit_link behaviorally. In the child it is
// connected to the declared electrical port b and a resistor from a=1.5.
// With b free and no other connection, KCL gives (b-a)/1000=0, so b=1.5.
// Unlike 34_implicit_nets.va, these observations depend on the implicit net.
//! lrm 3.6.5
//! lrm 3.6.2.4
//! lrm 1.3.1
//! lrm 1.3.1:1
//! lrm 3.6.5:1000
//! bias V(p) = 1.5
//! solve
//! print none
//! checks 2
`include "check.vh"
module implicit_solution_child(a,b);
  inout a,b;
  electrical a,b;
  analog begin
    I(a,b) <+ V(a,b)/1000.0;
    `CHECK("implicit structural node follows resistor source", V(b), 1.5, 1e-10);
    `CHECK("free endpoint has zero branch drop", V(a,b), 0.0, 1e-10);
  end
endmodule
module audit_implicit_net_solution(p);
  inout p;
  electrical p;
  implicit_solution_child child(p,implicit_link);
endmodule
