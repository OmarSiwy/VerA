// §3.4.7, rule 4: "When overriding parameters, it shall be an error to specify
// an override for a parameter by its original name and one or more aliases, or
// by more than one alias, regardless of how the override is done (by name or
// using the defparam statement)."
//
// This is the LRM's own worked error, with its own declarations:
//
//     parameter real dtemp = 0 from [-`P_CELSIUS0:inf);
//     aliasparam trise = dtemp;
//     ...
//     nmos2 #(.trise(5), .dtemp(5)) m3(...);  //error
//
// "because an override is specified for the parameter dtemp and its alias, even
// though the values are equal." The equal values are the point: this is not a
// conflicting-value check that a compiler could discharge by comparing the two
// operands, it is a check on how many names one storage location was written
// through. 07_parameter_alias.va is the legal side — one override, through the
// alias — and 56_alias_identifier_collision.va is the other §3.4.7 negative,
// which is about the alias NAME rather than about an override.
//
// It is written as an instantiation because that is the only portable way to
// state an override in the source itself: the suite's `//! param` directive is
// consumed by the testbench generator and never reaches the compiler, so on a
// reject fixture it would assert nothing. Annex C.8 keeps Clause 6 hierarchy in
// the Verilog-A subset, and 34_implicit_nets.va already carries an instance for
// the same reason.
//
// The pinned substring is a message fragment rather than a code: VerA has no
// diagnostic for this rule, so there is no code to pin, and `DiagnosticsReported`
// would match today's unrelated E0204 and report a pass that proved nothing.
// Any diagnostic naming the alias satisfies it.
//
//! lrm 3.4.7
//! lrm C.8
//! reject alias
//! xfail VerA does not implement module instantiation: the instance is rejected with E0204 before any override is bound to a parameter, so the original-name-and-alias check is never reached
module ch3_alias_override_target(d, s);
    inout d, s;
    electrical d, s;
    parameter real dtemp = 0 from [-273.15:inf);
    aliasparam trise = dtemp;

    analog I(d, s) <+ dtemp * V(d, s);
endmodule

module ch3_alias_double_override(d, s);
    inout d, s;
    electrical d, s;

    ch3_alias_override_target #(.trise(5), .dtemp(5)) m3(.d(d), .s(s));

    analog I(d, s) <+ 0.0;
endmodule
