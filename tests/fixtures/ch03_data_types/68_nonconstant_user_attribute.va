// §3.6.1.3: "the value being assigned to the attribute shall be CONSTANT."
// §3.6.1.2 says the same of every attribute: "Attribute declaration assigns a
// constant expression to the attribute name."
//
// `maxval` is given `runtime_limit`, which is not a constant expression — it is
// not a literal, not a parameter, and not any identifier this file declares at
// all. A nature lives at source-text level (§3.13.1), outside every module, so
// there is no scope in which a variable could be in scope here even in
// principle.
//
// Mirror of 68_duplicate_user_attribute.va: same clause, other half of the
// sentence, separate check.
//
// The pinned substring is only the phase label: VerA has no diagnostic for this
// rule, so a code would pin the wrong one.
//
//! lrm 3.6.1.3
//! lrm 3.6.1.2
//! reject DiagnosticsReported
//! xfail VerA stores a bare identifier as a user-defined nature attribute value and reports nothing; lower.zig does not require nature attribute values to be constant expressions
nature ch3_nonconst_attr; units="V"; access=NonConstV; abstol=1u; maxval=runtime_limit; endnature
module ch3_nonconstant_user_attribute; endmodule
