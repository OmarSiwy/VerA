// §3.6.2: "It is possible to set the discipline of interconnect and digital nets
// through discipline declaration with hierarchical references to these nets. It
// shall be an error to hierarchically override the discipline of a net that was
// explicitly declared unless it is a compatible discipline."
//
// The legal half of a pair. `b1_hx_leaf.p` is EXPLICITLY declared b1_hx; the
// parent's `b1_hy ca.p;` overrides it hierarchically (Annex F.2.1 step 3:
// "overrides any discipline which may be declared for sig in the module where
// sig was declared"). b1_hx and b1_hy are compatible (§3.11.1): their potential
// natures both have units "V" and their flow natures both "A", and "Two natures
// are compatible if they have the same value for the units attribute" (Units
// Value Rule). So the override is the "unless" case and is legal.
//
// b1_3_6_2_incompatible_hierarchical_override_rejected.va is this file with the
// b1_hy natures' units changed to "rad" and "N*m": nothing else differs.
//
// The override is observable because the two disciplines name different access
// functions: Ypot(a, b) exists only if a and b took b1_hy from the overridden
// leaf (step 4 hands the child's discipline up to the undeclared top segments,
// as in annex_f_resolution/out_of_context_declaration.va). The bias fixes the
// branch: 0.75 - 0.25 = 0.5, exact.
//
//! lrm 3.6.2
//! lrm 3.6.2:4
//! lrm F.2.1
//! bias a = 0.75, b = 0.25
//! checks 1
`include "check.vh"
nature b1_hx_pot;
  units = "V";
  access = Xpot;
  abstol = 1u;
endnature
nature b1_hx_flow;
  units = "A";
  access = Xflw;
  abstol = 1p;
endnature
nature b1_hy_pot;
  units = "V";
  access = Ypot;
  abstol = 1u;
endnature
nature b1_hy_flow;
  units = "A";
  access = Yflw;
  abstol = 1p;
endnature
discipline b1_hx;
  potential b1_hx_pot;
  flow b1_hx_flow;
  domain continuous;
enddiscipline
discipline b1_hy;
  potential b1_hy_pot;
  flow b1_hy_flow;
  domain continuous;
enddiscipline
module b1_hx_leaf(p);
  inout p; b1_hx p;
endmodule
module b1_hier_override(a, b);
  inout a, b;
  b1_hx_leaf ca(a);
  b1_hx_leaf cb(b);
  b1_hy ca.p;
  b1_hy cb.p;
  analog begin
    `CHECKX("the overridden leaves give a and b the y access functions", Ypot(a, b), 0.5);
    Yflw(a, b) <+ Ypot(a, b);
  end
endmodule
