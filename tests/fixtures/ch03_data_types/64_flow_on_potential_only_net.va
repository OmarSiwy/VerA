// §3.6.2.1: "A signal-flow discipline may specify either the potential or the
// flow nature". §3.13.3: "Access functions are uniquely defined for each net
// based on the discipline of the net ... a net can only be accessed through its
// access functions."
//
// `ch3_sf_potential` binds a potential nature and no flow, so a net of it has
// exactly one access function, `SFV`, and `SFI` — which is the access function
// of `ch3_sf_current`, a nature this file declares and this discipline does not
// bind — is not one of them. `SFV(sf) <+ 1.5` would compile; the flow access is
// the whole defect.
//
// 11_discipline_declarations.va declares potential-only and flow-only
// disciplines to show both halves are optional and now makes a net of the
// potential-only one, which is the legal side of this rule.
//
// Distinct from 42_wrong_access_function.va, which misspells the access function
// so that the name resolves to nothing at all; here `SFI` is a perfectly good
// access function, just not of this net.
//
//! lrm 3.6.3
//! lrm 3.6.2.1
//! lrm 3.13.3
//! lrm 3.6.3:1
//! reject-only E0501
//! neighbour 11_discipline_declarations.va
nature ch3_sf_potential; units="V"; access=SFV; abstol=1u; endnature
nature ch3_sf_current; units="A"; access=SFI; abstol=1p; endnature

discipline ch3_sf_pot_only;
    potential ch3_sf_potential;
enddiscipline

module ch3_flow_on_potential_only_net(sf);
    output sf;
    ch3_sf_pot_only sf;

    analog begin
        SFI(sf) <+ 1.5;
    end
endmodule
