// §3.4.7 parameter aliases, through a host model card (#76). The LRM's
// `nmos2` example: after `nmos2 #(.trise(5)) m1(...);`, "the value of the
// parameter dtemp, as used in the module equations for both instances, is 5."
// So a write through the alias overrides the ORIGINAL, and:
//   - §9.19: "$param_given ... returns 1 if the parameter was overridden by a
//     defparam statement or by a module instance parameter value assignment";
//     a card write is the host's override (06_local_parameter.va), so
//     $param_given(dtemp) is 1;
//   - §6.3.4: a default that names another parameter (`dtemp = a`) is the
//     value only when the parameter was not overridden, so dtemp stays 5,
//     not a = 1.
// Before #76 the card's value reached dtemp and then `derive` overwrote it
// with `a`, and `$param_given(dtemp)` read 0: the alias's own `__given` was
// set, never the original's.
//
// The neighbour in the same file: `b = a` with alias `tb` the card does not
// write, so b is its §6.3.4 default a = 1 and $param_given(b) is 0. By hand,
// one operating point, four CHECKs:
//   dtemp = 5 (exact), $param_given(dtemp) = 1, b = 1 (exact), $param_given(b) = 0.
//! lrm 3.4.7
//! lrm 9.19
//! param trise = 5
//! checks 4
`include "check.vh"
module alias_card_write_sets_original_given(p, n);
    inout p, n;
    electrical p, n;
    parameter real a = 1.0;
    parameter real dtemp = a;
    parameter real b = a;
    aliasparam trise = dtemp;
    aliasparam tb = b;
    analog begin
        `CHECKX("the card's trise is dtemp's value, not its default a", dtemp, 5.0);
        `CHECKI("dtemp was overridden through its alias", $param_given(dtemp), 1);
        `CHECKX("b, whose alias the card leaves alone, is its default a", b, 1.0);
        `CHECKI("b was not overridden", $param_given(b), 0);
        I(p, n) <+ V(p, n);
    end
endmodule
