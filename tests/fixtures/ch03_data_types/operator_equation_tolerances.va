// Host-only transient solver observation. Explicit nature and literal
// tolerances accompany two independent integration states.
`include "disciplines.vams"
nature Rate;
    units = "V/s";
    access = RateValue;
    abstol = 1u;
endnature
module operator_equation_tolerances(in, derivative, integral);
    inout in, derivative, integral;
    electrical in, derivative, integral;
    analog begin
        V(derivative) <+ ddt(V(in), Rate);
        V(integral) <+ idt(V(in), 0.0, 0, 1n);
    end
endmodule
