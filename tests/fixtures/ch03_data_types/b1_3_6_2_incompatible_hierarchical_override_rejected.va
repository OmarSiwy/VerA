// §3.6.2: "It shall be an error to hierarchically override the discipline of a
// net that was explicitly declared unless it is a compatible discipline."
//
// `b1_hx_leaf.p` is EXPLICITLY declared b1_hx (potential units "V", flow "A").
// The parent overrides it with `b1_hy ca.p;`, and here b1_hy's natures carry
// units "rad" and "N*m". No §3.11.1 nature rule relates them: each is a base
// nature of its own (no shared base), and the units values differ. So b1_hx and
// b1_hy are incompatible, the §3.11.1 worked example's "electrical and
// rotational" case, and the override is an error.
//
// This file is b1_3_6_2_compatible_hierarchical_override.va with the two
// b1_hy units strings changed; nothing else differs. A compiler that applied
// the override without the compatibility test would build this file and read
// Ypot(a, b) = 0.5.
//
// The pattern is the word a diagnostic for this rule has to use; E0355
// ("incompatible disciplines") is VerA's code for the neighbouring §3.11 port
// rule.
//
//! lrm 3.6.2
//! lrm 3.6.2:4
//! reject-only incompatible
//! neighbour b1_3_6_2_compatible_hierarchical_override.va
`include "check.vh"
nature b1_hx_pot;
  units = "V";
  access = Xpot;
  abstol = 1u;
endnature
nature b1_hx_flow;
  units = "A";
  access = Xflw;
  abstol = 1p;
endnature
nature b1_hy_pot;
  units = "rad";
  access = Ypot;
  abstol = 1u;
endnature
nature b1_hy_flow;
  units = "N*m";
  access = Yflw;
  abstol = 1p;
endnature
discipline b1_hx;
  potential b1_hx_pot;
  flow b1_hx_flow;
  domain continuous;
enddiscipline
discipline b1_hy;
  potential b1_hy_pot;
  flow b1_hy_flow;
  domain continuous;
enddiscipline
module b1_hx_leaf(p);
  inout p; b1_hx p;
endmodule
module b1_hier_override(a, b);
  inout a, b;
  b1_hx_leaf ca(a);
  b1_hx_leaf cb(b);
  b1_hy ca.p;
  b1_hy cb.p;
  analog begin
    `CHECKX("the overridden leaves give a and b the y access functions", Ypot(a, b), 0.5);
    Yflw(a, b) <+ Ypot(a, b);
  end
endmodule
