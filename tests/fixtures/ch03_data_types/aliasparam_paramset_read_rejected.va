// A.1.9 carries the §3.4.7 alias declaration into a paramset. The right-hand
// expression must use the original gain, although the instance may override
// it through alternate. aliasparam_source_bindings.va is that legal neighbour.
//! lrm 3.4.7
//! reject-only E0373
//! neighbour aliasparam_source_bindings.va
module aliasparam_ps_top;
  aliasparam_bad_ps #(.alternate(3)) child();
endmodule
paramset aliasparam_bad_ps aliasparam_ps_child;
  parameter real gain=1;
  aliasparam alternate=gain;
  .g=alternate;
endparamset
module aliasparam_ps_child;
  parameter real g=0;
  analog $display("g=%g", g);
endmodule
