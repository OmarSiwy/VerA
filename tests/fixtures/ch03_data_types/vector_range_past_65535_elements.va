// A range (§3.6.3 Syntax 3-6, A.2.3's branch range) is a pair of constant
// expressions, and neither the LRM nor IEEE 1364-2005 §4.3.1 ("at least
// 65 536 (2^16) bits") bounds it below 65536 elements. Until #29 VerA
// numbered every element in a 16-bit table and refused a range past 65535
// elements (E1015) wherever it appeared. `pair[0:65536]` has 65537.
//
// A branch array is the range with no solver unknown per element: all 65537
// branches span the one declared pair (p, n), so §5.5.1 makes each V(pair[k])
// the potential difference V(p) - V(n) = 0.75 - 0.25 = 0.5. By hand:
//   V(pair[65536]) = 0.5    the element past the old bound
//   V(pair[65535]) = 0.5    the last element the old bound held
//   V(pair[0]) + V(pair[65536]) = 1.0
// Dyadic, so exact. A net vector this long is one unknown per element; the
// codegen unit test "`U` is enum(u8) to 256 unknowns..." covers 70000 of them.
//
// Legal neighbour of the old refusal: annex_a_syntax/39_branch_array.va.
//
//! lrm 3.6.3
//! lrm A.2.3
//! bias V(p) = 0.75, V(n) = 0.25
//! checks 3
`include "check.vh"
module vector_range_past_65535_elements(p, n);
  inout p, n;
  electrical p, n;
  branch (p, n) pair[0:65536];
  analog begin
    `CHECKX("the element past the old 65535 bound", V(pair[65536]), 0.5);
    `CHECKX("the last element the old bound held", V(pair[65535]), 0.5);
    `CHECKX("both ends of the range", V(pair[0]) + V(pair[65536]), 1.0);
    I(pair[0]) <+ V(pair[0]);
  end
endmodule
