// §3.3: "A string literal can be assigned to a string or an integral type. If
// their size differs, the literal is right justified and either truncated on
// the left or zero filled on the left, as necessary."
//
// The LRM's two worked examples, plus the empty-string row of Table 3-3. §3.2
// makes `integer` the integral type of the analog subset and fixes its width at
// 32 bits, which is what decides all three answers; the LRM writes them with
// `reg`, and annex C ("No digital behavior or events are supported in
// Verilog-A") puts `reg` out of subset, so the width comes from §3.2 instead.
//
//   "hello" is 5 bytes = 40 bits, truncated on the LEFT to 32 bits, leaving
//   "ello" = 0x65_6c_6c_6f                                     = 1701604463
//   "A" is 1 byte, zero filled on the left to 32 bits          =         65
//   {"H",""} — Table 3-3: `"" is converted to 8'b0` — so 0x48_00 = 18432
//
// The truncation case is the discriminating one: it is the only assertion in
// the chapter that fails if `integer` is wider than 32 bits, because a wider
// type keeps the leading "h" and answers 448378203247.
//
//! lrm 3.3
//! lrm 3.2
//! xfail VerA keeps a string literal as a string when it initializes an `integer` (the generated testbench then fails to format it as %d); there is no string-literal-to-integral conversion in lower.zig
`include "check.vh"
module ch03_string_literal_to_integral(p, n);
    inout p, n;
    electrical p, n;
    integer truncated = "hello";
    integer zero_filled = "A";
    integer with_nul = {"H", ""};

    analog begin
        `CHECKI("a literal wider than the integral type is truncated on the left", truncated, 1701604463);
        `CHECKI("a literal narrower than the integral type is zero filled on the left", zero_filled, 65);
        `CHECKI("the empty string literal contributes one zero byte", with_nul, 18432);
        I(p, n) <+ V(p, n);
    end
endmodule
