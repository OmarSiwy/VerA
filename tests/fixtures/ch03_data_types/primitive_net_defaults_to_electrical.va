// §3.9: "For analog primitives, the discipline will be defined by the
// attribute port_discipline on that instance. If no attribute is found then it
// will acquire the discipline of other compatible continuous disciplines
// connected to that net segment. If no disciplines are connected to that net,
// then the default discipline is set to electrical."
//
// analog_primitive_port_discipline.va instantiates no primitive at all, so it cannot see this rule.
// Here `mid` is never declared: it appears only as a terminal of two Table E.1
// `resistor` instances, which carry no port_discipline attribute, and no
// other discipline is connected to it. By the last sentence its discipline is
// electrical — so the two resistors' equations meet at one electrical node and
// divide the 1 V the bias holds across in/gnd:
//
//   V(mid, gnd) = 1.0 * 3k / (1k + 3k) = 0.75
//   V(in, mid)  = 1.0 - 0.75           = 0.25
//
// `//! solve` leaves `mid` to the equations. 1k/3k, not two equal values, so a
// swapped terminal order shows as 0.25/0.75. Were `mid` left without a
// discipline, it would carry no potential and the primitives no equations
// there. The node is read through the primitive instances' own ports (§6.7).
//
//! lrm 3.9
//! lrm 3.9:1001
//! bias V(in) = 1.0, V(gnd) = 0.0
//! solve
`include "check.vh"
module ch3_primitive_net_defaults_to_electrical(in, gnd);
    inout in, gnd;
    electrical in, gnd;
    resistor #(.r(1k)) r1(in, mid);
    resistor #(.r(3k)) r2(mid, gnd);

    analog begin
        `CHECK("an undeclared primitive-only net is an electrical node: the divider", V(r2.p, r2.n), 0.75, 1e-12);
        `CHECK("and the top half takes the rest", V(r1.p, r1.n), 0.25, 1e-12);
        I(in, gnd) <+ 0.0;
    end
endmodule
