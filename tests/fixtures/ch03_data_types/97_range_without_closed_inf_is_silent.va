// §3.4.2: "The keyword inf can be used to indicate infinity." Infinity is a
// legal value of a parameter only when a `from` range writes `inf` with a
// bracket that includes it ("Brackets, [ and ], indicate inclusion of the end
// points"); that is what W0651 reports (96_range_closed_on_inf_warns). None of
// these three ranges does:
//
//   `exclude 0`       - the LRM's own example, "parameter real res = 1.0 exclude
//                       0;" - excludes one value and writes no bound at all;
//   `from [0:hi]`     - the upper bound is another parameter, itself ranged
//                       `(0:inf)`, so it is finite;
//   `from [0:inf)`    - the LRM's own spelling, open on infinity.
//
// So the compile warns nothing. The defaults survive: 1 + 0.5 + 3 = 4.5.
//
//! lrm 3.4.2
//! nowarn
//! bias V(p) = 1, V(n) = 0
`include "check.vh"
module ch03_range_without_closed_inf_is_silent(p, n);
    inout p, n;
    electrical p, n;
    parameter real res = 1.0 exclude 0;
    parameter real hi = 10.0 from (0:inf);
    parameter real x = 0.5 from [0:hi];
    parameter real val3 = 3.0 from [0:inf);
    analog begin
        `CHECKX("the defaults sum", res + x + val3, 4.5);
        I(p, n) <+ (res + x + val3) * V(p, n);
    end
endmodule
