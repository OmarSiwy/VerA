// §3.4.2's legal side, through the model card: the neighbour of
// range_card_value_excluded_rejected.va and range_card_value_below_from_rejected.va
// (#80). Every card below lies in `from (0:inf)` and is not the excluded 2,
// so `checkRange` returns null after each `derive` and every card runs.
//
// By hand, card by card: r = 0.5, 1.5, 2.5, 3, 1e6 are each > 0, finite and
// != 2 (1.5 and 2.5 sit either side of the excluded point), so the CHECK
// (r > 0 and r != 2 is 1) passes once per card: 5 verdicts.
// An integer parameter's ranges are checked in the same way (`k`, the card
// leaves it at 3, inside [1:5]).
//! lrm 3.4.2
//! psweep r = 0.5, 1.5, 2.5, 3, 1e6
//! bias V(p) = 1, V(n) = 0
//! checks 5
//! print none
`include "check.vh"
module range_card_value_inside(p, n);
    inout p, n;
    electrical p, n;
    parameter real r = 1 from (0:inf) exclude 2;
    parameter integer k = 3 from [1:5];
    analog begin
        `CHECKI("the card's r is inside (0:inf) and not 2", r > 0 && r != 2, 1);
        I(p, n) <+ k * V(p, n) / r;
    end
endmodule
