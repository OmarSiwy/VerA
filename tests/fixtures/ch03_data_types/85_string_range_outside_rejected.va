// String set membership is case sensitive.
//! lrm 3.4.2
//! reject E0361
module string_range_outside_target(p);
    inout p;
    electrical p;
    parameter string kind = "NPN" from '{"NPN", "PNP"};
    analog I(p) <+ 0.0;
endmodule
module ch03_string_range_outside_rejected(p);
    inout p;
    electrical p;
    string_range_outside_target #(.kind("npn")) u(p);
endmodule
