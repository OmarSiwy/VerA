// §3.4.7's closing example, verbatim: an alias whose target is the hierarchical
// parameter system function rather than a parameter of the module.
//
//     aliasparam m = $mfactor;
//
// Syntax 3-2 does not cover it — `aliasparam_declaration ::= aliasparam
// parameter_identifier = parameter_identifier ;` has an identifier on the right
// — which is why §3.4.7 spells the form out in prose. §3.4.7's whole reason for
// existing is the override: "This allows an alternate name to be used when
// overriding module parameter values as described in 6.3."
//
// So the override below names the ALIAS, `m`, and the equations read the
// ORIGINAL, `$mfactor`, which rule 2 requires: "the equations in the module
// shall reference the parameter by its original name, not the alias." That is
// the one arrangement in which the alias is load-bearing — delete the
// `aliasparam` line and `//! param m = 4` has nothing to bind to. This file used
// to assert only that an un-overridden `$mfactor` is Table 9-29's 1.0, which
// stayed green with the alias deleted; 07_parameter_alias.va was rewritten out
// of that same defect.
//
// ch06_hierarchy reads `$mfactor` directly and never aliases it.
//
//! param m = 4
//! lrm 3.4.7
//! lrm 6.3.6
//! xfail VerA's parser takes only a parameter_identifier after `aliasparam ... =`: the `$mfactor` token is E0208
`include "check.vh"
module ch03_aliasparam_mfactor(p, n);
    inout p, n;
    electrical p, n;
    aliasparam m = $mfactor;

    analog begin
        `CHECKX("an override through the alias reaches $mfactor", $mfactor, 4.0);
        I(p, n) <+ V(p, n);
    end
endmodule
