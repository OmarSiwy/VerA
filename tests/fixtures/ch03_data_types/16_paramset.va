// §6.4 defines `paramset`, and Annex C.8 keeps it in Verilog-A: "The
// hierarchical structure defined in Clause 6 is applicable to both
// Verilog-AMS HDL and Verilog-A, except support for real value ports is only
// applicable to Verilog-AMS HDL". Paramset is Clause 6 and is not excepted, so
// a Verilog-A compiler may not refuse a compilation unit for containing one.
// VerA used to, at E0201 — a subset decision, not a conformance rule. It now
// reads past the declaration and drops it, which is all a paramset can mean
// without instantiation: §6.4 gives one effect only through an instance that
// names it.
//
// What is asserted here is only the part a single-module testbench can see:
// the paramset is legal, it contains no behavioral code (§6.4), and the module
// it is associated with still compiles and runs with its own §3.4 default. The
// override taking effect is observable only through an instance, so it belongs
// with the Clause 6 hierarchy fixtures, not here.
//
// A.1.9: a paramset needs >= 1 paramset_item_declaration (corrected 2026-10-08)
//! lrm 6.4
//! lrm C.8
//! bias V(p) = 1.0, V(n) = 0.0
`include "check.vh"
module ch03_paramset_target(p, n);
    inout p, n;
    electrical p, n;
    parameter real gain = 1.0;

    analog begin
        `CHECKX("the module keeps its own default alongside a paramset", gain, 1.0);
        `CHECKX("and still solves", V(p, n), 1.0);
        I(p, n) <+ gain * V(p, n);
    end
endmodule

paramset ch03_values ch03_paramset_target;
    parameter real unused_item = 0;
    .gain = 2.0;
endparamset
