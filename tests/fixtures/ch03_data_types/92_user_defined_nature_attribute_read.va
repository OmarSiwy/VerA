// §3.6.1.3 "In addition to the predefined attributes listed above, a nature
// can specify other attributes which can be useful for analog modeling. Typical
// examples include certain maximum and minimum values to define a valid range.
// A user-defined attribute can be declared in the same manner as any predefined
// attribute. The name of the attribute shall be unique in the nature being
// defined and the value being assigned to the attribute shall be constant."
//
// The positive half. 68_duplicate_user_attribute.va and
// 68_nonconstant_user_attribute.va pin the two "shall"s; this file declares two
// user-defined attributes the legal way — unique names, constant values, one of
// them a constant EXPRESSION — and reads them back through §5.5.3's
// `net.potential.attribute` reference, which is what makes an attribute "useful
// for analog modeling" rather than a comment.
//
// DERIVATION. maxval = 12.5 and minval = -(2.0 * 1.25) = -2.5, both exact in
// binary64. The model clamps V(p, n) = 0.5 into [minval, maxval], which leaves
// it 0.5.
//
//! lrm 3.6.1.3
//! lrm 3.6.1.3:1
//! lrm 5.5.3
//! bias V(p) = 0.75, V(n) = 0.25
`include "check.vh"
nature ch3_ranged_voltage;
    units = "V";
    access = VR;
    abstol = 1u;
    maxval = 12.5;
    minval = -(2.0 * 1.25);
endnature

nature ch3_ranged_current;
    units = "A";
    access = IR;
    abstol = 1p;
endnature

discipline ch3_ranged;
    potential ch3_ranged_voltage;
    flow ch3_ranged_current;
enddiscipline

module ch03_user_defined_nature_attribute_read(p, n);
    inout p, n;
    ch3_ranged p, n;
    real v;

    analog begin
        `CHECKX("§3.6.1.3 a user-defined nature attribute reads its constant", p.potential.maxval, 12.5);
        `CHECKX("§3.6.1.3 a constant-expression attribute is evaluated", p.potential.minval, -2.5);
        v = min(max(VR(p, n), p.potential.minval), p.potential.maxval);
        `CHECKX("the attributes bound a value as a valid range", v, 0.5);
        IR(p, n) <+ v;
    end
endmodule
