// §3.2 declares multidimensional arrays legal and prints both of these:
//
//     integer flag_array[0:8][0:3]; // a multidimensional integer array
//     real vtable[0:16][0:7][0:64]; // a multidimensional real array
//
// So `flag_array` is 9 rows of 4, addressed [0..8][0..3]. The pair
// [0][3] = 2 against [3][0] = 4 is the assertion that bites: a backend that
// flattened the subscripts in the wrong order, or transposed the dimensions,
// reads one where the other is written. [8][3] pins the last cell of the
// declared shape, and vtable[16][7][64] does the same for three dimensions.
//
//! lrm 3.2
//! bias V(p) = 1.0, V(n) = 0.0
//! xfail VerA's parser takes only one dimension in an array declaration: the second `[` is E0207
`include "check.vh"
module ch03_multidimensional_array(p, n);
    inout p, n;
    electrical p, n;
    integer flag_array[0:8][0:3];
    real vtable[0:16][0:7][0:64];

    analog begin
        flag_array[0][0] = 1;
        flag_array[0][3] = 2;
        flag_array[3][0] = 4;
        flag_array[8][3] = 7;
        vtable[16][7][64] = 2.5;
        `CHECKI("the first cell of a 9-by-4 integer array", flag_array[0][0], 1);
        `CHECKI("row 0 column 3", flag_array[0][3], 2);
        `CHECKI("row 3 column 0 is a different cell", flag_array[3][0], 4);
        `CHECKI("the last cell of the declared shape", flag_array[8][3], 7);
        `CHECKX("the last cell of a three-dimensional real array", vtable[16][7][64], 2.5);
        I(p, n) <+ flag_array[8][3] * V(p, n);
    end
endmodule
