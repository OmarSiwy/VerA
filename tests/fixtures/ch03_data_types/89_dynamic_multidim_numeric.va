// §§3.2, 3.4.8, 5.7: independently changing indices select one scalar.
//! lrm 3.2
//! bias V(p) = 1, V(n) = 0
`include "check.vh"
module ch03_dynamic_multidim_numeric(p, n);
    inout p, n;
    electrical p, n;
    parameter integer left = 3;
    localparam integer low = -2;
    real a[left:left-1][low:low+2] = '{'{10,11,12},'{20,21,22}};
    integer b[1:0][-1:0][4:3];
    integer i, j, k;
    integer row, col;
    real total;
    analog begin
        `CHECKX("descending outer initialization", a[3][-2], 10);
        `CHECKX("ascending inner initialization", a[2][0], 22);
        row = left - V(p);
        col = low + V(p);
        `CHECKX("two runtime indices", a[row][col], 21);
        a[row][col] = 77 * V(p);
        `CHECKX("selected real-cell derivative", ddx(a[row][col], V(p)), 77);
        `CHECKX("runtime write selected cell", a[2][-1], 77);
        `CHECKX("runtime write preserves first neighbor", a[2][-2], 20);
        `CHECKX("runtime write preserves second neighbor", a[2][0], 22);
        `CHECKX("runtime write preserves other row", a[3][-1], 11);
        a[left][col] = 88;
        `CHECKX("mixed parameter/runtime write", a[3][-1], 88);
        `CHECKX("mixed literal/runtime read", a[2][col], 77);
        for (i=0; i<=1; i=i+1)
            for (j=-1; j<=0; j=j+1)
                for (k=3; k<=4; k=k+1)
                    b[i][j][k] = 100*i + 10*(j+1) + k;
        `CHECKI("three-dimensional first endpoint", b[0][-1][3], 3);
        `CHECKI("three-dimensional last endpoint", b[1][0][4], 114);
        total = 0;
        for (k=4; k>=3; k=k-1)
            for (i=1; i>=0; i=i-1)
                for (j=0; j>=-1; j=j-1) begin
                    `CHECKI("independent runtime 3D reads", b[i][j][k] - (100*i+10*(j+1)+k), 0);
                    total = total + b[i][j][k];
                end
        `CHECKX("all eight independent cells", total, 468);
        // Invalid dimensions must not carry into a valid adjacent row.
        row = 3; col = 1;
        a[row][col] = 999;
        row = 1; col = 0;
        a[row][col] = 999;
        `CHECKX("invalid writes preserve cells", a[3][-2]+a[3][-1]+a[3][0]+a[2][-2]+a[2][-1]+a[2][0], 229);
        I(p,n) <+ 0 * V(p,n);
    end
endmodule
