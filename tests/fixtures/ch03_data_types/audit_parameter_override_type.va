// AMS 3.4.1: parameter type is derived "after any value overrides have been
// applied". Both overrides keep the numeric value 4 but reverse its type.
// With integer denominators, 4.0/3 is 4/3 and 4/3 is the integer 1. Defaults
// alone would give the opposite answers. Dependent untyped parameters must
// derive from the final overridden values too. These are HDL instantiation
// overrides, not numeric host bindings, so the source retains each value's type.
//! lrm 3.4.1
//! lrm 3.4.1:1001
//! lrm 6.3
//! lrm 6.3.3
//! lrm 6.3.3:1
//! lrm 6.3.4
//! lrm 6.3.4:1000
//! checks 4
`include "check.vh"
module parameter_override_type_child;
  parameter becomes_real = 4;
  parameter becomes_integer = 4.0;
  parameter real_copy = becomes_real;
  parameter integer_copy = becomes_integer;
  analog begin
    `CHECKX("integer default overridden with real infers real", becomes_real / 3, 1.3333333333333333);
    `CHECKI("real default overridden with integer infers integer", becomes_integer / 3, 1);
    `CHECKX("dependent parameter follows final real type", real_copy / 3, 1.3333333333333333);
    `CHECKI("dependent parameter follows final integer type", integer_copy / 3, 1);
  end
endmodule
module audit_parameter_override_type;
  parameter_override_type_child #(.becomes_real(4.0), .becomes_integer(4)) child();
endmodule
