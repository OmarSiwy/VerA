// §3.4 a parameter default is a constant_expression, and §6.3.4 lets it name a
// parameter declared before it. Every operator §4.2 defines is legal there —
// the clause restricts the OPERANDS (constants and earlier parameters), not the
// operator set. This fixture is the arithmetic half of §4.2 written into
// defaults over one earlier parameter, with the answers derived by hand at
// `w = 4`:
//
//   (1 << 4) - 1 = 15   §4.2.11 zero-fill, then §4.2.4
//   255 >> 4     = 15   §4.2.11 over §3.2.1's 32-bit `integer`
//   4 > 2        = 1    §4.2.5 yields an integer 0/1
//   (4*7) % 5    = 3    §4.2.4 remainder
//   (1 << 4) | 1 = 17   §4.2.9 bitwise
//   ~4           = -5   §4.2.9 over a 32-bit 2's complement value
//   !(4 > 10)    = 1    §4.2.8
//   4 > 2 ? 5 : 6 = 5   §4.2.12 — the CONDITION is what selects, not a fold of
//                       both arms, and the taken arm is the whole value
//
// None of these can be frozen at declaration time: §6.3.4 says an update of `w`
// updates everything derived from it, so the default survives as an expression
// over `w` and the model card carries the value it has under `w`'s DECLARED
// default. That value is what every assertion below reads.
//
// A backend that folds only `+ - * /` and answers 0 for the rest passes nothing
// here — and answers 0 SILENTLY, exit code 0, which is why this file exists.
//! lrm 3.4
//! lrm 4.2
//! lrm 6.3.4
//! lrm 3.4:1
//! lrm 4.1
//! lrm 4.1:1000
`include "check.vh"
module ch03_parameter_default_over_parameter(p, n);
    inout p, n;
    electrical p, n;

    parameter integer w      = 4;
    // §3.4's list form: one comma-separated list of assignments, each
    // initializer over a parameter defined before the list.
    parameter integer shl_m1 = (1 << w) - 1, shr_255 = 255 >> w;
    parameter integer gt2    = (w > 2);
    parameter integer rem5   = (w * 7) % 5;
    parameter integer msk    = (1 << w) | 1;
    parameter integer inv    = ~w;
    parameter integer notgt  = !(w > 10);
    parameter integer picked = (w > 2) ? 5 : 6;
    parameter real    picked_r = (w > 2) ? 1.5 : 2.5;

    analog begin
        `CHECKI("§4.2.11 a left shift in a default over a parameter", shl_m1, 15);
        `CHECKI("§4.2.11 a right shift zero-fills over 32 bits", shr_255, 15);
        `CHECKI("§4.2.5 a relational default is an integer 0/1", gt2, 1);
        `CHECKI("§4.2.4 remainder in a default", rem5, 3);
        `CHECKI("§4.2.9 bitwise or in a default", msk, 17);
        `CHECKI("§4.2.9 bitwise not is 32-bit 2's complement", inv, -5);
        `CHECKI("§4.2.8 logical not in a default", notgt, 1);
        `CHECKI("§4.2.12 the taken arm is the whole value", picked, 5);
        `CHECKX("§4.2.12 and it selects a real arm the same way", picked_r, 1.5);
        I(p, n) <+ V(p, n) / 1000.0;
    end
endmodule
