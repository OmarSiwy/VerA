// §3.2: "An integer declaration declares one or more variables of type integer.
// These variables can hold values ranging from -2^31 to 2^31-1", and
// "Arithmetic operations performed on integer variables produce 2's complement
// results."
//
// Two sentences, one width. The two literals below are that range's endpoints,
// and 2's complement wrap sends each one step past its end to the other:
//
//     2147483647 + 1 -> -2147483648
//     -2147483648 - 1 -> 2147483647
//
// A compiler with a wider integer answers 2147483648 and -2147483649 instead,
// which is why both directions are asserted: a 64-bit type is wrong at both
// ends, and a saturating one is wrong at both ends differently.
//
// (`lo` rather than `low` or `small`: `small` is a Verilog charge-strength
// keyword, annex B.)
//
//! lrm 3.2
//! xfail VerA lowers `integer` to i64 (src/backend/codegen.zig, "plain i64 (LRM §3.2 integer)"), so neither endpoint wraps: 2147483647 + 1 evaluates to 2147483648
`include "check.vh"
module ch03_integer_overflow_wrap(p, n);
    inout p, n;
    electrical p, n;
    integer hi = 2147483647;
    integer lo = -2147483648;

    analog begin
        `CHECKI("the largest integer is 2^31-1", hi, 2147483647);
        `CHECKI("the smallest integer is -2^31", lo, -2147483648);
        `CHECKI("one past the top wraps 2's complement to the bottom", hi + 1, -2147483648);
        `CHECKI("one below the bottom wraps 2's complement to the top", lo - 1, 2147483647);
        I(p, n) <+ V(p, n);
    end
endmodule
