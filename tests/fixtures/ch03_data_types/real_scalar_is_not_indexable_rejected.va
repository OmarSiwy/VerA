// §3.2: "Arrays of integers can be declared using a range which defines the
// upper and lower indices of the array", and likewise for reals; `real float;`
// (§3.2's own example) declares a scalar with no range at all.
//
// §1.1 builds Verilog-AMS on IEEE Std 1364, whose §4.8.1 lists what may not be
// done with a real: "Bit-select or part-select references of variables declared
// as real". So `x[0]` on the scalar real below names neither an array element
// (there is no array) nor a bit (a real has none).
//
// Indexing a real ARRAY is legal; 02_variable_arrays.va is that side.
//
//! lrm 3.2
//! inherited IEEE 1364-2005 4.8.1
//! reject-only E0309
//! neighbour 02_variable_arrays.va
`include "disciplines.vams"
module ch3_real_scalar_is_not_indexable(p, n);
  inout p, n; electrical p, n;
  real x;
  analog begin
    x = 1.0;
    I(p, n) <+ x[0] * V(p, n);
  end
endmodule
