// §3.7: "Compatible interconnect are nets of type wire, tri, and wreal where
// the IEEE Std 1364 Verilog net resolution is extended for wreal. When the two
// nets connected by a PORT are of net type wreal and wire/tri, the resulting
// single net will be assigned as wreal."
//
// The parent's `link` is a `wire`, and it meets a wreal port at BOTH ends: the
// output of `drv` and the input of `probe`. Each connection is the wire/wreal
// row of the merge rule, so the merged net must be wreal and the probe must
// read it as a real expression (§3.7's own `drv` example turns a wreal input
// into a potential). The one driver is the continuous assignment inside
// `drv`, which §3.7 permits: "A wreal net can be used for real-valued nets
// which are driven by a single driver, such as a continuous assignment."
//
// `wreal_connected_to_wand_rejected.va` is the other half: the compatible list
// is closed at wire/tri/wreal, and a `wand` connection is E0919. This fixture
// is the positive neighbour that rejection needs, because a `wire` on the same
// port must compile and carry the driver's value.
//
// DERIVATION. The assign is 2.5, exact in binary, and the probe reads the
// merged port back as a wreal. `V(out) <+ in` keeps the probe well-formed.
//
//! lrm 3.7
//! lrm 3.7:1001
//! lrm 6.5.3
//! solve
//! checks 1
`include "check.vh"
module ch03_wreal_wire_port_merge(out);
  output out;
  voltage out;
  wire link;
  ch03_wreal_wire_driver drv(link);
  ch03_wreal_wire_probe probe(link, out);
endmodule

module ch03_wreal_wire_driver(o);
  output o;
  wreal o;
  assign o = 2.5;
endmodule

module ch03_wreal_wire_probe(in, out);
  input in;
  output out;
  wreal in;
  voltage out;

  analog begin
    `CHECKX("a wire port merged with a wreal port delivers the driver as wreal", in, 2.5);
    V(out) <+ in;
  end
endmodule
