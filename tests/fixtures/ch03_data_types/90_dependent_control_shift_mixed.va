// VAMS §4.2.9: "When one or both operands are unsigned, the expression shall be
// interpreted as a comparison between unsigned values. If the operands are of
// unequal bit lengths, the smaller operand shall be zero-extended to the size of
// the larger operand." Each operand is evaluated at its own width, §3.2's 32
// bits for an analog integer, and then extended. (IEEE 1364 §5.5's propagation
// of the type down to context-determined operands is the digital context's
// rule; in this analog expression it gives the same digits, since zero-extending
// before or after a 32-bit `>>` agrees.)
//
//   32'h1 is unsigned (a based literal without `s`), so the comparison is
//   unsigned; operand >> count = -1 >> 0 is 32'hFFFF_FFFF at 32 bits, both
//   operands are 32 bits, and 32'hFFFF_FFFF > 1  ->  mixed = 1.
//
// A compiler that compared the signed carrier would evaluate -1 > 1 = 0.
//
//! lrm 4.2.9
//! lrm 4.2.9:2
//! lrm 4.2.9:4
//! lrm 4.2.11
//! lrm 4.2.9:1
`include "check.vh"
module dependent_control_shift_mixed(p);
  inout p; electrical p;
  parameter integer operand = -1;
  parameter integer count = 0;
  localparam integer mixed = (operand >> count) > 32'h1;
  analog begin
    `CHECKI("unsigned context: (-1 >> 0) > 32'h1", mixed, 1);
    I(p) <+ V(p);
  end
endmodule
