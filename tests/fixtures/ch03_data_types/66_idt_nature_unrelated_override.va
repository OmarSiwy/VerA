// §3.6.1.2, idt_nature: "While it is possible to override the parent's value of
// idt_nature using a derived nature, the nature thus specified shall be RELATED
// (share the same base nature) to the nature the parent uses for its
// idt_nature."
//
// `ch3_idt_parent` gives its idt_nature as `ch3_idt_target`. `ch3_idt_child`
// derives from that parent and overrides idt_nature with `ch3_idt_stranger`,
// which is a base nature of its own — no `:`, different units, no derivation
// path to `ch3_idt_target` — so the two share no base nature and §3.11.1's
// Derived Nature Rule does not relate them either.
//
// The override itself is legal ("it is possible to override the parent's value
// of idt_nature using a derived nature"); replacing `ch3_idt_stranger` with a
// nature derived from `ch3_idt_target` makes the file conform. That is the whole
// defect.
//
// The pinned substring is only the phase label: VerA has no diagnostic for this
// rule, so a code would pin the wrong one.
//
//! lrm 3.6.1.2
//! reject DiagnosticsReported
//! xfail VerA accepts a derived nature overriding `idt_nature` with an unrelated base nature; lower.zig does not relate nature attribute overrides to the parent's
nature ch3_idt_target; units="Wb"; access=TargetPhi; abstol=1u; endnature
nature ch3_idt_stranger; units="A"; access=StrangerI; abstol=1p; endnature
nature ch3_idt_parent; units="V"; access=ParentIdtV; abstol=1u; idt_nature=ch3_idt_target; endnature
nature ch3_idt_child : ch3_idt_parent; idt_nature=ch3_idt_stranger; endnature
module ch3_idt_nature_unrelated_override; endmodule
