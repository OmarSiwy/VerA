// §3.4.3: "The standard attributes for descriptions and units, described in
// 2.9.2, can be used for parameters." ... "The units and descriptions are only
// for documentation of the module; in particular, no dimensional analysis is
// performed on the units." ... "Units and descriptions specified for
// block-level parameters shall be ignored by the simulator".
//
// Three observable consequences, each with its value derived by hand:
//
//   res   (* desc="Resistance", units="Ohms" *), the clause's own example,
//         default 1.0 from [0:inf), overridden to 250 by `//! param`. The
//         attribute changes nothing about the parameter: it still takes the
//         override, and I(p,n) = V(p,n)/res = 1.25/250 = 5.0e-3 exactly
//         (1.25 = 1.5 - 0.25 and 1.25/250 is the correctly rounded 5.0e-3).
//   ang   (* units="degrees" *) = 90.0. "No dimensional analysis": the
//         parameter's value is the number 90, not pi/2 radians and not
//         anything the units string might suggest converting to.
//   vb    a block-level parameter of the named block `blk` with
//         (* units="V", desc="block bias" *), which "shall be ignored": the
//         declaration is legal and vb is its plain value 0.5.
//
//! lrm 3.4.3
//! lrm 3.4.3:1
//! param res = 250
//! bias V(p) = 1.5, V(n) = 0.25
`include "check.vh"
module ch3_parameter_units_are_documentation(p, n);
    inout p, n;
    electrical p, n;
    (* desc="Resistance", units="Ohms" *)
    parameter real res = 1.0 from [0:inf);
    (* units="degrees" *) parameter real ang = 90.0;

    analog begin : blk
        (* units="V", desc="block bias" *) parameter real vb = 0.5;
        `CHECKX("an attributed parameter still takes its override", res, 250.0);
        `CHECKX("and computes as a parameter", V(p, n) / res, 5.0e-3);
        `CHECKX("no dimensional analysis: 90 degrees reads as 90", ang, 90.0);
        `CHECKX("a block-level parameter's attributes are ignored", vb, 0.5);
        I(p, n) <+ V(p, n) / res;
    end
endmodule
