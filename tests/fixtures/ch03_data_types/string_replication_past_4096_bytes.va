// §3.3 Table 3-3: a replication of a string is "a string containing N
// concatenated copies of Str", for any non-negative N. VerA used to refuse a
// folded replication past 4096 bytes (E1011, the row a run-time string had);
// the folded text is now as long as the copies make it, and a run-time string
// built from it gets a row that holds it (#29).
//
// HAND DERIVATION. {5000{"x"}} is 5000 copies of "x". {50{t}}, where t is
// {100{"x"}}, is 50 * 100 = 5000 copies too: equal. The third string is
// built while the device runs ({s, u} with u known only at run time, one
// more byte), and compared with {5001{"x"}}: 5001 copies, equal.
//
//! lrm 3.3
//! bias V(p) = 0
`include "check.vh"
module string_replication_past_4096_bytes(p, n);
  inout p, n; electrical p, n;
  string s, t, u, w;
  analog begin
    s = {5000{"x"}};
    t = {50{{100{"x"}}}};
    `CHECKI("5000 folded copies equal 50 copies of 100", s == t, 1);
    u = (V(p, n) > 1.0) ? "y" : "x";
    w = {s, u};
    `CHECKI("a run-time concatenation past 4096 bytes is whole", w == {5001{"x"}}, 1);
    I(p, n) <+ V(p, n);
  end
endmodule
