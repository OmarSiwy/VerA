// §3.3 Table 3-3, the Replication row: "multiplier must be of integral type and
// can be nonconstant. If multiplier is nonconstant or Str is of type string, the
// result is a string containing N concatenated copies of Str, where N is
// specified by multiplier."
//
// Here the multiplier is a PARAMETER, and §3.4 says when a parameter's value is
// fixed: "Parameters represent constants, hence it is illegal to modify their
// value at runtime. However, parameters can be modified at compilation time to
// have values which are different from those specified in the declaration
// assignment." A replication count sizes the string it builds, so VerA takes
// the value at compilation — `N` is a SHAPE parameter — and the device refuses
// a card that later moves it (`checkShape`). The `//! param` line below is the
// card, and for a shape parameter it is the compile-time value.
//
// THE DERIVATION, by hand.
//
//   parameter integer N = 2;   // the declaration value: "HiHi"
//   //! param N = 3             // the card: three copies
//
//   {N{"Hi"}} = "HiHiHi"        (a string literal Str)
//   {N{b}}    = "HiHiHi"        (Str of type string, b = "Hi")
//
// "HiHi" — the declaration value's answer — is checked unequal, so a device
// built to the declared default cannot pass.
//
// string_replication_runtime_multiplier.va is the neighbour whose multiplier is
// a VARIABLE known only while the device runs; that one has no compile-time
// answer and stays an xfail.
//
//! lrm 3.3
//! lrm 3.4
//! lrm 3.4:3
//! param N = 3
//! bias V(p) = 1.0
`include "check.vh"
module ch3_string_replication_parameter_multiplier(p);
    inout p;
    electrical p;
    parameter integer N = 2;
    string a;
    string b;

    analog begin
        b = "Hi";
        a = {N{"Hi"}};
        `CHECKI("a parameter multiplier of a literal: the card's three copies", (a == "HiHiHi"), 1);
        `CHECKI("and not the declaration value's two", (a == "HiHi"), 0);
        a = {N{b}};
        `CHECKI("a parameter multiplier of a string variable", (a == "HiHiHi"), 1);
        I(p) <+ 0.0 * V(p);
    end
endmodule
