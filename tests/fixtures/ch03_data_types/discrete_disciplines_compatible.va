// §3.11: "Discrete Domain Rule: Digital nets with the same signal value type
// (i.e., real, integer) are compatible with each other if their disciplines are
// compatible (i.e., the discipline has a discrete domain or is empty."
//
// Two digital nets with different disciplines meet at a port:
//   w        in the top, annex D's `ddiscrete` (domain discrete, no nature)
//   b1_drv.o the child's output, `b1_logic`, a second natureless discipline
//            declared here with `domain discrete`
// Both carry a one-bit logic value, both disciplines have a discrete domain, so
// the nets are compatible and the connection is legal: the design compiles and
// the value crosses the port. (Same-domain incompatible disciplines would be
// §3.11's Signal Connection Rule error; ch07_mixed_signal/
// incompatible_port_discipline_rejected.va is the continuous form.)
//
// DERIVATION. `timescale 1ns/1ns. The child drives 0 at time 0 and 1 from 2 ns.
// The top starts `seen` at 0 and copies w into it on every change of w. At time
// 0 both writers of `seen` write 0; at 2 ns w rises and the always block writes
// 1. The analog points read the greatest digital tick <= t (§7.3.6.5):
//
//     t = 0       seen = 0
//     t = 2 ns    seen = 1    (the solve the change forces, below)
//     t = 5 ns    seen = 1
//
// POINTS. Three, not the two `//! time` lists: the change of `seen` at 2 ns,
// a value the analog block reads, forces an analog solve at that tick, after
// its updates (§8.4.7, §8.5; src/sim/mixed.zig `run`). One check, three
// points: 3.
//
//! lrm 3.11
//! lrm 3.11:2
//! analysis tran
//! time 0, 5n
//! checks 3
`timescale 1ns/1ns
`include "check.vh"
discipline b1_logic;
  domain discrete;
enddiscipline

module b1_drv(o);
  output o;
  b1_logic o;
  reg r;
  assign o = r;
  initial begin
    r = 1'b0;
    #2 r = 1'b1;
  end
endmodule

module b1_discrete_compatible(out);
  inout out;
  electrical out;
  ddiscrete w;
  reg seen;
  b1_drv u(w);
  initial seen = 1'b0;
  always @(w) seen = w;
  analog begin
    `CHECKI("the value crosses the port between two discrete disciplines", seen, ($abstime < 1n) ? 0 : 1);
    V(out) <+ seen ? 1.0 : 0.0;
  end
endmodule
