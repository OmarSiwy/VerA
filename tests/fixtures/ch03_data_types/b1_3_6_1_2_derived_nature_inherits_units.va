// §3.6.1.2, units: "It is illegal for a derived nature to define or change the
// units; the derived nature always inherits its parent nature units."
//
// 37_derived_units_immutable.va is the "illegal to define" half (E0333). This
// is the "always inherits" half, read back through §5.5.3's
// `net.potential_or_flow.attribute` reference, which returns a nature
// attribute's constant value, here a string:
//
//   b1_uv_alias : b1_uv            declares nothing          units "V"
//   b1_uv_tight : b1_uv            changes abstol only       units "V"
//   b1_ua_from_disc : b1_ud.flow   derived from a discipline's flow
//                                  (§3.6.2.6), which binds b1_ua: units "A"
//
// The comparisons are §3.3 string equality against a literal: 1 when equal.
// A derived nature that lost its parent's units has no "V" or "A" to compare,
// and one that took another nature's units reads the other string.
//
// 45_nature_declaration.va (annex A) declares the same shapes but asserts no
// units value.
//
//! lrm 3.6.1.2
//! lrm 3.6.1.2:10
//! lrm 3.6.2.6
//! lrm 5.5.3
//! bias p = 0.75, q = 0.25
//! checks 4
`include "check.vh"
nature b1_uv;
    units = "V";
    access = B1Vu;
    abstol = 1u;
endnature

nature b1_uv_alias : b1_uv;
endnature

nature b1_uv_tight : b1_uv;
    abstol = 1n;
endnature

nature b1_ua;
    units = "A";
    access = B1Iu;
    abstol = 1p;
endnature

discipline b1_ud;
    potential b1_uv_alias;
    flow b1_ua;
enddiscipline

nature b1_ua_from_disc : b1_ud.flow;
endnature

discipline b1_ud2;
    potential b1_uv_tight;
    flow b1_ua_from_disc;
enddiscipline

module b1_derived_nature_inherits_units(p, q);
    inout p, q;
    b1_ud p;
    b1_ud2 q;

    analog begin
        `CHECKI("a derived nature with no items has its parent's units", p.potential.units == "V", 1);
        `CHECKI("a derived nature that changes abstol keeps its parent's units", q.potential.units == "V", 1);
        `CHECKI("a nature derived from a discipline's flow has that nature's units", q.flow.units == "A", 1);
        `CHECKI("the flow of b1_ud is the base nature's own A", p.flow.units == "A", 1);
        B1Iu(p) <+ B1Vu(p);
        B1Iu(q) <+ B1Vu(q);
    end
endmodule
