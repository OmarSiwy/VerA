// §3.13.2: "the access function of each base nature shall be unique."
//
// Both natures here are BASE natures (neither has a `:` parent) and both name
// their access function DuplicateAccess, so `DuplicateAccess(net)` could not be
// resolved to one nature. They are given different units and abstols so this
// cannot be read as one nature declared twice — §3.6.1.1 makes an "alias" only
// through derivation, which is not what this is.
//
//! lrm 3.13.2
//! lrm 3.13.2:1
//! reject-only E0335
nature ch3_dup_a; units="V"; access=DuplicateAccess; abstol=1u; endnature
nature ch3_dup_b; units="A"; access=DuplicateAccess; abstol=1p; endnature
module ch3_duplicate_access; endmodule
