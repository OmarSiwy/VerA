// §3.3's second worked example annotates every line it prints, and two of them
// are replication into a string target:
//
//     integer i = 1;
//     b = {5{"Hi"}};     // OK
//     a = {i{"Hi"}};     // OK (non constant replication)
//     r = {i{"Hi"}};     // invalid (non constant replication)
//
// Table 3-3's Replication row says why: "multiplier must be of integral type
// and can be nonconstant. If multiplier is nonconstant or Str is of type
// string, the result is a string containing N concatenated copies." Only the
// third line is invalid, and only because `r` is an integral target — that
// case is a separate reject fixture, not this one.
//
// Five copies of the two characters "Hi" is the ten-character "HiHiHiHiHi".
// The second check is the same string one copy short: a comparison that
// answered "equal" on a prefix would pass the first check and fail this one.
//
//! lrm 3.3
//! lrm 3.3:4
//! bias V(p) = 1.0
`include "check.vh"
module ch3_string_repl(p);
    inout p;
    electrical p;
    integer i = 1;
    string a;
    string b;

    analog begin
        b = {5{"Hi"}};
        a = {i{"Hi"}};
        `CHECKI("constant replication of a string literal", (b == "HiHiHiHiHi"), 1);
        `CHECKI("five copies exactly — four is a different string", (b == "HiHiHiHi"), 0);
        `CHECKI("a non-constant multiplier with a string target is legal", (a == "Hi"), 1);
        i = 2 + V(p);
        a = {i{"Hi"}};
        `CHECKI("a changed runtime multiplier produces three copies", a == "HiHiHi", 1);
        i = 0;
        a = {i{"Hi"}};
        `CHECKI("zero runtime copies produce the empty string", a == "", 1);
        I(p) <+ 0.0 * V(p);
    end
endmodule
