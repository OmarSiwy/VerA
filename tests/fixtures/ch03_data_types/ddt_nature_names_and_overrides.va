// Resolved semantic behavior is observed by tests/host.py.
// §3.6.1.2, ddt_nature:
//
//   "If specified, the constant expression assigned to ddt_nature shall be the
//    name (not a string) of a nature which is defined elsewhere. It is possible
//    for a nature to be self-referencing with respect to its ddt_nature
//    attribute."
//   "The ddt_nature attribute is optional; the default value is the nature
//    itself. While it is possible to override the parent's value of ddt_nature
//    using a derived nature, the nature thus specified shall be related (share
//    the same base nature) to the nature the parent uses for its ddt_nature."
//
// Every ddt_nature below is legal:
//
//   b1_dchg        ddt_nature = b1_dcur, a nature declared in this file, by name.
//   b1_dself       ddt_nature = b1_dself, itself.
//   b1_dchg_child  overrides its parent's explicit b1_dcur with b1_dcur_fine,
//                  derived from b1_dcur: same base nature.
//   b1_dvolt_child b1_dvolt gives no ddt_nature, so the parent uses b1_dvolt
//                  itself; the override b1_dvolt_fine derives from b1_dvolt:
//                  same base nature.
//
// Each refusal is this file with one ddt_nature changed:
//   ddt_nature_string_rejected.va               b1_dchg: "b1_dcur"
//   ddt_nature_undeclared_rejected.va           b1_dchg: b1_no_such_nature
//   ddt_nature_unrelated_to_explicit_rejected.va b1_dchg_child: b1_dvolt
//   ddt_nature_unrelated_to_default_rejected.va  b1_dvolt_child: b1_dcur
//
// The values asserted are fixed to the last bit: B1Vd(p, n) = 2.0 - 0.5 = 1.5
// through the access the derived potential nature inherits, and §4.5.3 "In DC
// analysis, ddt() returns zero (0)". The tolerance the attribute implies is not
// asserted; §4.5.2 leaves it to the simulator.
//
//! lrm 4.5.3
//! lrm 3.6.1.2:7
//! lrm 3.6.1.2:8
//! lrm 3.6.1.2:9
//! bias p = 2.0, n = 0.5
//! checks 2
`include "check.vh"
nature b1_dcur;
    units = "A";
    access = B1Id;
    abstol = 1p;
endnature

nature b1_dcur_fine : b1_dcur;
    abstol = 1f;
endnature

nature b1_dchg;
    units = "coul";
    access = B1Qd;
    abstol = 1f;
    ddt_nature = b1_dcur;
endnature

nature b1_dchg_child : b1_dchg;
    ddt_nature = b1_dcur_fine;
endnature

nature b1_dself;
    units = "Wb";
    access = B1Phd;
    abstol = 1n;
    ddt_nature = b1_dself;
endnature

nature b1_dvolt;
    units = "V";
    access = B1Vd;
    abstol = 1u;
endnature

nature b1_dvolt_fine : b1_dvolt;
    abstol = 1n;
endnature

nature b1_dvolt_child : b1_dvolt;
    ddt_nature = b1_dvolt_fine;
endnature

discipline b1_ddt_disc;
    potential b1_dvolt_child;
    flow b1_dcur;
enddiscipline

module b1_ddt_nature_overrides(p, n);
    inout p, n;
    b1_ddt_disc p, n;

    analog begin
        `CHECKX("the derived potential nature reads through its parent's access", B1Vd(p, n), 1.5);
        `CHECKX("ddt() with no tolerance is zero in DC", ddt(B1Vd(p, n)), 0.0);
        B1Id(p, n) <+ B1Vd(p, n) / 2.0;
    end
endmodule
