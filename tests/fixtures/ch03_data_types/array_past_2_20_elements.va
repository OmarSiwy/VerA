// §3.2 declares an array by its two constant indices and bounds nothing
// about the element count. Until #29 VerA refused an array past 2^20 =
// 1048576 elements (E1016); `x[0:1048576]` has 1048577, one past it.
//
// The array is indexed at run time (`i`), so it is one storage of 1048577
// reals. §3.2's zero default holds for every element the block does not
// write; the writes are at both ends and past the old bound:
//   x[0] = 1.5, x[1048576] = 2.5, and i walks 1048575, 1048576
// so by hand:
//   x[1048575] (never written) = 0
//   x[i] at i = 1048576 = 2.5
//   x[0] + x[1048576] = 4.0
// Dyadic, so exact.
//
// Legal neighbour of the old refusal: 02_variable_arrays.va.
//
//! lrm 3.2
//! checks 3
`include "check.vh"
module array_past_2_20_elements(a);
  inout a; electrical a;
  real x[0:1048576];
  integer i;
  analog begin
    x[0] = 1.5;
    x[1048576] = 2.5;
    i = 1048575;
    `CHECKX("an unwritten element past 2^20 - 1 is zero", x[i], 0.0);
    i = i + 1;
    `CHECKX("the element at index 2^20, read at run time", x[i], 2.5);
    `CHECKX("both ends are distinct storage", x[0] + x[1048576], 4.0);
    V(a) <+ 0.0;
  end
endmodule
