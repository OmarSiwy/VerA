// §3.6.3/§3.6.1.3: a net's access function comes from the `access` attribute of
// the nature bound to its discipline. A NATURELESS discipline binds no nature
// (§3.6.2.3), so a net of it has no potential access function at all and `V` —
// which is `electrical`'s spelling, from `Voltage` in annex D — names nothing
// for it. Contributing to `V(link)` is therefore an error, and it is the one
// error 30_natureless_discipline.va deliberately stops short of: everything in
// that file is legal, and this is the first line that is not.
//
// No diagnostic code is pinned because VerA has none for this rule: it accepts
// the contribution, so pinning a code would pin the wrong rule and would stop
// matching on the day the right one lands. `DiagnosticsReported` says only
// "some diagnostic", which is the weakest claim that still fails on silence.
//
//! lrm 3.6.3
//! lrm 3.6.2.3
//! reject DiagnosticsReported
//! xfail VerA resolves `V(link)` on a net whose discipline binds no potential nature and accepts the contribution; there is no access-function-not-found check in lower.zig
discipline ch3_natureless_beh;
    domain continuous;
enddiscipline

module ch3_natureless_behavioral(p);
    inout p;
    electrical p;
    ch3_natureless_beh link;

    analog begin
        V(link) <+ 1.0;
        I(p) <+ 0.0 * V(p);
    end
endmodule
