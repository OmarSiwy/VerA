// §3.4.7 aliases are alternate override names, while equations use originals.
// The parent has its own alias alternate=base, but .alternate(3) names the
// CHILD's alias and is legal. A paramset instance binds alternate=4, its body
// reads original gain=4 and binds the associated module's alternate to 2*4=8.
// Reading child.gain and from_ps.gain by hierarchy must return 3 and 8.
// A coincidentally identical word inside a string is not an alias reference.
//! lrm 3.4.7
//! lrm 6.3.3
//! lrm 6.4.1
//! checks 5
`include "check.vh"
module aliasparam_bindings_top;
  parameter real base=2;
  aliasparam alternate=base;
  aliasparam_bindings_child #(.alternate(3)) child();
  aliasparam_good_ps #(.alternate(4)) from_ps();
  analog begin
    `CHECKX("original in the declaring parent", base, 2.0);
    `CHECKX("hierarchical original after child alias binding", child.gain, 3.0);
    `CHECKX("hierarchical original after paramset alias bindings", from_ps.gain, 8.0);
  end
endmodule
paramset aliasparam_good_ps aliasparam_bindings_child;
  parameter real gain=1;
  aliasparam alternate=gain;
  .alternate=2*gain;
endparamset
module aliasparam_bindings_child;
  parameter real gain=1;
  aliasparam alternate=gain;
  analog `CHECKI("alternate is only a string here", gain == 3 || gain == 8, 1);
endmodule
