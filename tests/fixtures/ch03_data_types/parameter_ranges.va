// §3.4.2 value range specification, copied from the LRM's own examples. The
// range is a CONSTRAINT on the value, not part of it: the default is whatever
// precedes `from`/`exclude`, and every bound listed here is legal for its
// parameter (-50 <= neg_rail < 0, 0 < pos_rail < 50, 1 <= gain <= 1000,
// 0 <= ranged < inf minus two holes, nonzero /= 0), so the file must compile.
//
// The assertions pin the half that a range suffix can silently eat. A parser
// that folded the `exclude` operand into the initializer would make `nonzero`
// zero and `ranged` 40; one that dropped the sign while scanning `[-50:0)`
// would make `neg_rail` +15.
//
// §3.4.2: "The keyword inf can be used to indicate infinity. If preceded by a
// negative sign, it indicates negative infinity." `unbounded` writes the
// negative form, which nothing else in the chapter does; -5 is inside
// (-inf:inf) and so is every other real, so the range constrains nothing and
// the default must survive it intact.
//
//! lrm 3.4.2
`include "check.vh"
module ch03_parameter_ranges(p, n);
    inout p, n;
    electrical p, n;
    parameter real neg_rail = -15 from [-50:0);
    parameter integer pos_rail = 15 from (0:50);
    parameter real gain = 1 from [1:1000];
    parameter real ranged = 0 from [0:inf) exclude (10:20) exclude (30:40];
    parameter real nonzero = 1.0 exclude 0;
    parameter real unbounded = -5 from (-inf:inf);

    analog begin
        `CHECKX("negative default survives a [lo:hi) suffix", neg_rail, -15.0);
        `CHECKI("integer default survives a (lo:hi) suffix", pos_rail, 15);
        `CHECKX("integer default coerced to real at the closed lower bound", gain, 1.0);
        `CHECKX("default survives two exclude ranges", ranged, 0.0);
        `CHECKX("`exclude 0` does not become the default", nonzero, 1.0);
        `CHECKX("a default inside a doubly-infinite range", unbounded, -5.0);
        I(p, n) <+ gain * V(p, n) + nonzero + ranged + neg_rail + pos_rail + unbounded;
    end
endmodule
