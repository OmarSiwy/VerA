// §3.13.3: "Access functions are uniquely defined for each net based on the
// discipline of the net. Each access function is used with the name of the net
// as its argument and a net can only be accessed through its access functions."
//
// Port `p` has discipline ch3_right_d, whose potential nature declares
// `access = RightAccess` (§3.6.1.2, access). RightAccess is therefore the ONLY
// potential access function for `p`. `V` names some other nature's access
// function, or none at all in this file, and either way it is not one of this
// net's access functions. `RightAccess(p) <+ 0.0` would compile — the wrong
// spelling is the whole defect.
//
//! lrm 3.13.3
//! reject E0501
nature ch3_right_n; units="V"; access=RightAccess; abstol=1u; endnature
discipline ch3_right_d; potential ch3_right_n; enddiscipline
module ch3_wrong_access(p); inout p; ch3_right_d p; analog V(p)<+0.0; endmodule
