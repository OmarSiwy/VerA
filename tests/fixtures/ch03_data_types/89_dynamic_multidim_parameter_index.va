// A model-card override changes each runtime subscript, never the baked default.
//! lrm 3.2
//! param selected = 1
`include "check.vh"
module ch03_dynamic_multidim_parameter_index(p);
    inout p;
    electrical p;
    parameter integer selected = 0;
    localparam integer left = 5;
    parameter real source[left:left-1][0:1] = '{'{10,11},'{20,21}};
    real a[left:left-1][0:1];
    real deep[0:1][0:0][0:0][0:0][0:0][0:0][0:0][0:0][0:0];
    integer i, j;
    analog begin
        i = left - selected; j = selected;
        `CHECKX("parameter-array runtime read", source[i][j], 21);
        a[left-selected][selected] = 9;
        `CHECKX("overridden parameter index writes chosen cell", a[4][1], 9);
        `CHECKX("parameter default cell is untouched", a[5][0], 0);
        deep[selected][0][0][0][0][0][0][0][0] = 37;
        `CHECKX("more than eight dimensions runtime read", deep[selected][0][0][0][0][0][0][0][0], 37);
        `CHECKX("more than eight dimensions constant read", deep[1][0][0][0][0][0][0][0][0], 37);
        `CHECKX("deep array unselected element unchanged", deep[0][0][0][0][0][0][0][0][0], 0);
        I(p) <+ 0 * V(p);
    end
endmodule
