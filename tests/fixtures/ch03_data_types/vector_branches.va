// §3.12: "If the range of the vector branch is not specified then the indexing
// of the vector branch shall start at 0." The LRM's own example:
//
//     electrical [3:5]a;
//     electrical [1:3]b;
//     branch (a,b) br1; // Branch br1 is of size 3 and can be indexed from 0 to 2
//
// So the branch is indexed 0..2 even though NEITHER terminal is, and §3.12
// pairs the corresponding scalar terminal nets: br1[0] is a[3]-b[1],
// br1[1] is a[4]-b[2], br1[2] is a[5]-b[3]. The biases below are chosen so all
// three differences are distinct and exact in binary:
//
//     br1[0] = 3.0  - 1.0  = 2.0
//     br1[1] = 4.0  - 0.5  = 3.5
//     br1[2] = 5.0  - 0.25 = 4.75
//
// A compiler that indexed the branch from its first terminal's msb, or that
// paired the terminals in reverse, hits a different one of the three.
//
// The size rule the branch must SATISFY here — same-size terminals — is
// violated on purpose in vector_branch_size_mismatch.va.
//
//! lrm 3.12
//! lrm 3.12:3
//! lrm 3.12:1001
//! bias V(a[3]) = 3.0, V(a[4]) = 4.0, V(a[5]) = 5.0
//! bias V(b[1]) = 1.0, V(b[2]) = 0.5, V(b[3]) = 0.25
`include "check.vh"
module ch3_vector_branches(a, b);
    inout a, b;
    electrical [3:5] a;
    electrical [1:3] b;
    branch (a, b) br1;
    branch (a, b[1]) shared_return;

    analog begin
        `CHECKX("an unranged vector branch is indexed from 0", V(br1[0]), 2.0);
        `CHECKX("its terminals pair one-to-one", V(br1[1]), 3.5);
        `CHECKX("and the last index of a size-3 branch is 2", V(br1[2]), 4.75);
        `CHECKX("a scalar second terminal broadcasts to the first vector element", V(shared_return[0]), 2.0);
        `CHECKX("a scalar second terminal broadcasts to the middle vector element", V(shared_return[1]), 3.0);
        `CHECKX("a scalar second terminal broadcasts to the last vector element", V(shared_return[2]), 4.0);
        I(br1[0]) <+ V(br1[0]) / 1000.0;
        I(br1[1]) <+ V(br1[1]) / 1000.0;
        I(br1[2]) <+ V(br1[2]) / 1000.0;
    end
endmodule
