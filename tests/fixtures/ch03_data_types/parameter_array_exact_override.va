// AMS 3.4.4 permits overriding a parameter array with exactly its declared
// size. Three replacement elements differ from every default; independently
// reading all three detects dropped overrides, truncation and reordered values.
//! lrm 3.4.4
//! lrm 3.4.4:3
//! checks 3
`include "check.vh"
module exact_array_target;
  parameter real coefficients[0:2] = '{1.0, 2.0, 3.0};
  analog begin
    `CHECKX("replacement first element", coefficients[0], 4.0);
    `CHECKX("replacement second element", coefficients[1], 5.0);
    `CHECKX("replacement third element", coefficients[2], 6.0);
  end
endmodule
module audit_parameter_array_exact_override;
  exact_array_target #(.coefficients('{4.0, 5.0, 6.0})) child();
endmodule
