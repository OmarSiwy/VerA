// AMS 3.6.4 makes local_reference the global reference node. A voltage
// source from p to that reference sets p=1.5; a resistor connects p to the
// distinct load_return terminal, held at zero by the testbench. It must be
// a distinct net: I(p) would name the same branch as V(p,local_reference)
// after ground resolution and test source-branch switching instead.
// If local_reference were a separate floating node, supernode KCL instead
// gives p/1000=0 and local_reference=-1.5. The p observation distinguishes it.
//! lrm 3.6.4
//! lrm 1.3.1.1
//! lrm 1.3.1.1:1
//! bias V(load_return) = 0.0
//! solve
//! print none
//! checks 2
`include "check.vh"
module audit_ground_reference_solution(p, load_return);
  inout p, load_return;
  electrical p, load_return, local_reference;
  ground local_reference;
  analog begin
    V(p, local_reference) <+ 1.5;
    I(p, load_return) <+ V(p, load_return) / 1000.0;
    `CHECK("declared ground is the global reference", V(p), 1.5, 1e-10);
    `CHECK("reference potential is zero", V(local_reference), 0.0, 1e-10);
  end
endmodule
