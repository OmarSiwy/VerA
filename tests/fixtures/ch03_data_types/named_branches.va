// §3.12 a named branch is a path between two nets, and "only one net need be
// specified, in which case the second net defaults to ground". With p at 2.0 V
// and n at 0.5 V that fixes both branch potentials:
//
//   V(differential_branch) = V(p) - V(n) = 1.5
//   V(ground_branch)       = V(p) - 0    = 2.0
//
// The second literal is the one that bites: a compiler that quietly made the
// missing terminal `n`, or that aliased both declarations onto the same p-n
// branch, reads 1.5 there and fails.
//
// §3.12 also fixes how many branches may exist over one pair: "There shall be
// at most one unnamed branch between any two nets or between a net and implicit
// ground (in addition to any number of named branches)." So `second_branch`
// over the SAME pair as `differential_branch` is legal, and both coexist with
// the single unnamed p-n branch that the bare `I(p, n)` contribution creates.
// All three span the same pair of nets, so all three read 1.5 — and they are
// three independent paths, so their flows add rather than collapsing into one.
// The divisors are powers of two, so 1.5/2 + 1.5/4 + 1.5/8 = 1.3125 is exact in
// binary and the want needs no tolerance.
// Read each branch's actual flow as well: recomputing V/R alone would still
// pass if the compiler incorrectly merged the independent branch identities.
//
//! lrm 3.12
//! lrm 3.12:2
//! lrm 3.12:1002
//! bias V(p) = 2.0, V(n) = 0.5
//! checks 9
`include "check.vh"
module ch03_named_branches(p, n);
    inout p, n;
    electrical p, n;
    branch (p, n) differential_branch;
    branch (p, n) second_branch;
    branch (p) ground_branch;

    analog begin
        `CHECKX("two-terminal branch potential is the difference", V(differential_branch), 1.5);
        `CHECKX("a second named branch over the same pair reads the same potential", V(second_branch), 1.5);
        `CHECKX("the one unnamed p-n branch reads that pair's potential too", V(p, n), 1.5);
        `CHECKX("one-terminal branch defaults its second net to ground", V(ground_branch), 2.0);
        `CHECKX("two named branches and the unnamed branch are three parallel paths", V(differential_branch) / 2.0 + V(second_branch) / 4.0 + V(p, n) / 8.0, 1.3125);
        I(differential_branch) <+ V(differential_branch) / 2.0;
        I(second_branch) <+ V(second_branch) / 4.0;
        I(p, n) <+ V(p, n) / 8.0;
        I(ground_branch) <+ V(ground_branch) / 16.0;
        `CHECKX("the first named branch retains its own flow", I(differential_branch), 0.75);
        `CHECKX("the second named branch retains a different flow", I(second_branch), 0.375);
        `CHECKX("the unnamed branch is independent of both named branches", I(p, n), 0.1875);
        `CHECKX("the one-terminal branch carries its own ground flow", I(ground_branch), 0.125);
    end
endmodule
