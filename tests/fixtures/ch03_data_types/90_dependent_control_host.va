// Host overrides update lazy, typed dependent defaults in declaration order.
//! lrm 3.4.1
//! lrm 3.4.5
//! lrm 4.2.3
//! lrm 4.2.7
//! lrm 4.2.12
//! lrm 6.3.4
//! lrm 6.3.4:1000
//! param first = 0.25
//! param second = 0.3
//! param choice = -1
//! param supplied = 99
`include "check.vh"
module dependent_control_host;
  parameter real first = 0;
  parameter real second = 0;
  parameter integer choice = 0;
  parameter real supplied = first < second ? 7.0 : 9.0;
  localparam integer both = (first > 0) && (second > 0);
  localparam integer either = (first < 0) || (second > 0);
  localparam integer fractional_compare = first < second;
  localparam integer nested = both ? (choice ? 17 : 19) : 23;
  parameter real mixed = choice ? 7 : 2.5;
  parameter integer rounded = choice ? -2.5 : 3.5;
  parameter real chained = nested ? mixed + both : 0.0;
  parameter integer values[2:1] = '{choice ? 11 : 13, both ? 29 : 31};
  analog begin
    `CHECKI("both changed from false to true", both, 1);
    `CHECKI("either changed from false to true", either, 1);
    `CHECKI("real operands are compared before conversion", fractional_compare, 1);
    `CHECKI("nested negative true condition", nested, 17);
    `CHECKX("real arm unification", mixed, 7.0);
    `CHECKI("declared integer rounds selected real", rounded, -3);
    `CHECKX("declaration-order dependent chain", chained, 8.0);
    `CHECKI("array left conditional", values[2], 11);
    `CHECKI("array right conditional", values[1], 29);
    `CHECKX("explicit dependent override wins", supplied, 99.0);
  end
endmodule
