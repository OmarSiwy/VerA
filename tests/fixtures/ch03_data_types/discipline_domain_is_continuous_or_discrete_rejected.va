// A.1.7 (Syntax 3-5 in §3.6.2):
//
//     discipline_domain_binding ::= domain discrete_or_continuous ;
//     discrete_or_continuous ::= discrete | continuous
//
// §3.6.2.2: "The domain binding of the discipline indicates if the signal
// value is to be represented in the continuous or discrete domain." Two values,
// two keywords. `analog` below is a keyword of the language but not one of the
// two a domain binding takes.
//
// The legal binding, `domain continuous;`, is 11_discipline_declarations.va.
//
//! lrm 3.6.2.2
//! lrm A.1.7
//! lrm A.1.7:1000
//! reject-only E0212
//! neighbour 11_discipline_declarations.va
`include "disciplines.vams"
discipline ch3_domain_analog
  potential Voltage;
  flow Current;
  domain analog;
enddiscipline
module ch3_discipline_domain_analog(p, n);
  inout p, n; electrical p, n;
  analog I(p, n) <+ V(p, n);
endmodule
