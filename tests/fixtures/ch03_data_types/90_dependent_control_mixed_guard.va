// Integer literals widened for real guards retain proof facts after if-conversion.
//! lrm 4.2.4
//! lrm 4.2.5
//! lrm 4.2.7
//! lrm 4.2.12
//! lrm 6.3.4
//! lrm 6.3.4:1000
//! param zero_divisor = 0
//! param nonzero_divisor = -2
`include "check.vh"
module dependent_control_mixed_guard;
  parameter real zero_divisor = 2 from [0:2];
  parameter real nonzero_divisor = 2 from [-2:2];
  localparam real greater = zero_divisor > 0 ? 7.5 % zero_divisor : 17;
  localparam real unequal = zero_divisor != 0 ? 7.5 % zero_divisor : 19;
  localparam real selected = nonzero_divisor != 0 ? 7.5 % nonzero_divisor : 23;
  localparam real reversed = 0 > nonzero_divisor ? -7.5 % nonzero_divisor : 29;
  analog begin
    `CHECKX("mixed greater-than guard skips zero remainder", greater, 17.0);
    `CHECKX("mixed inequality guard skips zero remainder", unequal, 19.0);
    `CHECKX("mixed inequality guard evaluates nonzero remainder", selected, 1.5);
    `CHECKX("reversed mixed comparison selects negative divisor", reversed, -1.5);
  end
endmodule
