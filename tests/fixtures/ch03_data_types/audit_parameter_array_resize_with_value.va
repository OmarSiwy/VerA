// §3.4.4: "Since array range in the parameter array declaration may depend on
// previously-declared parameters, the array size may be changed by overriding
// the appropriate parameters. If the array size is changed, the parameter
// array shall be assigned an array of the new size FROM THE SAME MODULE AS THE
// PARAMETER ASSIGNMENT that changed the parameter array size."
//
// The legal half of `audit_parameter_array_resize_without_value_rejected.va`.
// Here the instantiation changes `count` from 2 to 3 and, in the SAME override
// list, supplies a three-element replacement for `coefficients`. The target
// reads every element, including the one that does not exist in its declared
// default (index 2), so an implementation that kept the declared size or
// padded the old default fails rather than silently ignoring the new shape.
//
// The values are dyadic and distinct in every position, so an array resized
// but filled in the wrong order cannot pass all four element checks.
//
//! lrm 3.4.4
//! lrm 3.4.4:5
//! checks 5
`include "check.vh"
module ch03_resize_array_target;
  parameter integer count = 2;
  parameter real coefficients[0:count-1] = '{1.0, 2.0};

  analog begin
    `CHECKI("the size parameter was overridden", count, 3);
    `CHECKX("replacement first element", coefficients[0], 2.0);
    `CHECKX("replacement second element", coefficients[1], 4.0);
    `CHECKX("the element beyond the declared default", coefficients[2], 8.0);
    `CHECKX("the last element is at the OVERRIDDEN bound", coefficients[count-1], 8.0);
  end
endmodule

module audit_parameter_array_resize_with_value;
  ch03_resize_array_target #(.count(3), .coefficients('{2.0, 4.0, 8.0})) child();
endmodule
