// §3.4: "Parameters represent constants" whose value "can be modified at
// compilation time" — so the value in force everywhere a parameter is READ is
// the overridden one, not the declared default. The read under test is the
// EXPONENT of §4.3.1 pow(x, y): a compiler that treats "constant" as "fold the
// declared default at code generation" answers pow(2, 2) = 4 here, silently
// ignoring the model card, and its Jacobian says 4 instead of 12 — which is
// exactly the bug this fixture pins (both the value and the ddx derivative).
//
// The base abs(V(p,n)) + 1 is a solve quantity, so the pow cannot fold whole;
// only the exponent is parameter-shaped. At V(p,n) = 1 V the base is exactly
// 2.0, and with the override e = 3:
//
//   pow(2, 3)              = 8   exactly (dyadic, §4.3.1)
//   d/dV pow(base(V), e)   = e·base^(e-1)·dbase/dV = 3·4·1 = 12  exactly
//
// Every quantity is dyadic and libm pow is exact on them, so CHECKX.
//
//! lrm 3.4
//! lrm 4.3.1
//! lrm 3.4:3
//! param e = 3
//! bias V(p) = 1.0, V(n) = 0
`include "check.vh"
module ch03_param_override_pow_exponent(p, n);
    inout p, n;
    electrical p, n;
    parameter real e = 2.0 from (0:10);

    analog begin
        `CHECKX("the override is the value in force", e, 3.0);
        `CHECKX("pow reads the overridden exponent", pow(abs(V(p, n)) + 1.0, e), 8.0);
        `CHECKX("the Jacobian uses the overridden exponent too",
                ddx(pow(abs(V(p, n)) + 1.0, e), V(p)), 12.0);
        I(p, n) <+ pow(abs(V(p, n)) + 1.0, e) * 1.0e-3;
    end
endmodule
