// §3.4.2: "Brackets, [ and ], indicate inclusion of the end points in the value
// range. Parentheses, ( and ), indicate exclusion of the end points from the
// value range." and "The keyword inf can be used to indicate infinity." So
// `from [0:inf]` INCLUDES infinity as a legal value for `rs`, where the LRM's own
// example writes the open form, `from [0:inf)`. The source is legal; W0651 says
// the closed bracket admits a value no finite model card needs (the twin,
// 97_range_without_closed_inf_is_silent, is silent on every other range shape).
//
// The warning changes nothing about the value: `rs` keeps its default 2.
//
//! lrm 3.4.2
//! warn W0651
//! warn upper bound is closed on infinity
//! bias V(p) = 1, V(n) = 0
`include "check.vh"
module ch03_range_closed_on_inf_warns(p, n);
    inout p, n;
    electrical p, n;
    parameter real rs = 2.0 from [0:inf];
    analog begin
        I(p, n) <+ V(p, n) / rs;
        `CHECKX("a closed infinite bound leaves the default", rs, 2.0);
    end
endmodule
