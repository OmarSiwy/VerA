// AN ENGINE CEILING, PINNED FROM THE ENFORCING SIDE. §3.2 declares an array by
// its ranges and bounds nothing about the element count. VerA makes each
// element its own scalar and stops at 2^20 = 1048576 (specification/Vague_Decisions.md),
// refusing a larger array with E1016. [0:1048576] has 1048577 elements. Wider
// ranges overflowed the element count and aborted the compiler.
//
// Legal neighbour: 02_variable_arrays.va.
//
//! reject-only E1016
//! neighbour 02_variable_arrays.va
module array_over_2_20_elements_rejected(a);
  inout a; electrical a;
  real x[0:1048576];
  analog V(a) <+ 1.0;
endmodule
