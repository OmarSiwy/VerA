// §3.6.3.2: "Nets with continuous disciplines are allowed to have
// initializers on their net discipline declarations" -- its third example is
// the hierarchical form, `mechanical top.foo.w = 250.0;` -- and "If different
// nets of a node have conflicting initializers, then initializers on
// hierarchical net declarations win. If there are multiple hierarchical
// declarations, then the declaration on the highest level wins."
//
// ROADMAP §5.3 (AMS 3.6.3.2): VerA read the discipline of such a declaration
// (F.2.1 step 3) and dropped its initializer without a diagnostic.
//
// THE PROBE is a031's cubic, f(V) = (V-1)(V-2)(V-3), roots 1, 2, 3, solved by
// the testbench's Newton from the node's nodeset (a08_nodeset_01 derives the
// basins): from 2.75 it lands on 3; from 1.25 (f = 0.328, f' = 0.6875, next
// iterate 0.773) and from a cold 0 it lands on 1.
//
//   u.w   ns_cubic's internal net, local nodeset 1.25; the top declares
//         `electrical u.w = 2.75;`. Hierarchical wins: 3. Dropped: 1.
//   n     the top's net, local nodeset 1.25, bound to m's port p. The top
//         declares `electrical m.p = 2.75;` and m declares
//         `electrical v.q = 1.25;` on its child's port, the same node one
//         level down. Highest level wins: 3. The lower one winning, or the
//         local one: 1.
//
// Invalid neighbour: nodeset_hierarchical_not_constant_rejected.va (§3.6.3.2's
// "The initializer shall be a constant_expression", E0365).
//
//! lrm 3.6.3.2
//! lrm F.2.1
//! bias V(g) = 0.0
//! solve
//! print none
//! checks 2
`include "check.vh"
module ns_cubic(g);
  inout g; electrical g;
  electrical w = 1.25;
  analog I(w, g) <+ (V(w, g) - 1.0) * (V(w, g) - 2.0) * (V(w, g) - 3.0);
endmodule
module ns_leaf(q, g);
  inout q, g; electrical q, g;
  analog I(q, g) <+ (V(q, g) - 1.0) * (V(q, g) - 2.0) * (V(q, g) - 3.0);
endmodule
module ns_mid(p, g);
  inout p, g; electrical p, g;
  ns_leaf v(p, g);
  electrical v.q = 1.25;
endmodule
module ns_top(g);
  inout g; electrical g;
  electrical n = 1.25;
  ns_cubic u(g);
  ns_mid m(n, g);
  electrical u.w = 2.75;
  electrical m.p = 2.75;
  analog begin
    `CHECK("a hierarchical nodeset beats the child's local one", V(u.w, g), 3.0, 1e-9);
    `CHECK("of two hierarchical nodesets on one node, the higher level's wins", V(n, g), 3.0, 1e-9);
  end
endmodule
