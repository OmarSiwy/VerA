// §3.6.5: "Nets can be used in structural descriptions without being
// declared. In this case, the net's discipline and domain binding will be
// determined by discipline resolution (see 7.4 and Annex F)."
// Implicit nets ab1 and cb1 are never declared but used in module instances;
// their discipline is resolved to `electrical` from connected port disciplines.
//
//! lrm 3.6.5
`include "check.vh"
module ch03_implicit_net_sub(p, n);
  inout p, n;
  electrical p, n;
  analog I(p, n) <+ 0.0;
endmodule

module ch03_implicit_nets(i1, o1);
  inout i1, o1;
  electrical i1, o1;

  analog begin
    // ab1 is an implicit net (not declared) connected to sub1 and sub2;
    // discipline resolution binds it to `electrical` from port disciplines.
    // cb1 is likewise implicit.
    `CHECKX("implicit net resolves to a probe-able unknown", V(ab1), 0.0);
    `CHECKX("second implicit net resolves independently", V(cb1), 0.0);
    I(i1, o1) <+ V(ab1) + V(cb1);
  end

  ch03_implicit_net_sub sub1(i1, ab1);
  ch03_implicit_net_sub sub2(ab1, cb1);
  ch03_implicit_net_sub sub3(cb1, o1);
endmodule
