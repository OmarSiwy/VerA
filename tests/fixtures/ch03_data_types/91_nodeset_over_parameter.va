// §3.6.3.2's initializer "shall be a constant_expression", and §3.4 makes a
// parameter reference one — so `electrical mid = vstart;` is legal, and it is
// the form that matters in practice: a model card tunes where the solver starts
// without touching the netlist.
//
// The other spelling pinned here is the initializer on a net that is ALSO a
// module port. §6.5.2.2 lets `inout p;` and `electrical p = 1.5;` be two
// declarations of one net, and Syntax 3-6 puts the net_decl_assignment on the
// second one; nothing in the clause excludes a port from being the net.
//
// What is asserted is what 21_net_nodeset.va asserts and for the same reason: a
// nodeset is "used as a nodeset value ... by the analog solver", an initial
// guess and not a clamp, so the probes must carry the potentials the circuit
// gives them and neither 1.5 nor 2.25 may appear among them.
//
// Corrected 2026-10-08 (construct only, the wants are unchanged): the file
// declared `electrical p = 1.5, n;`. A.2.1.3 gives a net declaration either a
// list_of_net_identifiers or a list_of_net_decl_assignments, never a mix
// (E0292; reject_A_2_1_3_net_list_mixes_assignment.va is this file with the
// old line), so `p` and `n` are declared on two lines.
//
//! lrm 3.6.3.2
//! bias V(p) = 3.0, V(mid) = 2.0, V(n) = 0.0
`include "check.vh"
module ch03_nodeset_over_parameter(p, n);
    inout p, n;
    electrical p = 1.5;
    electrical n;
    parameter real vstart = 2.25;
    electrical mid = vstart;

    analog begin
        `CHECKX("a nodeset on a port net is a hint, not a clamp", V(p), 3.0);
        `CHECKX("a nodeset over a parameter is one too", V(mid), 2.0);
        `CHECKX("and the branch above it is an ordinary potential", V(p, mid), 1.0);
        I(p, mid) <+ V(p, mid) / 1000.0;
        I(mid, n) <+ V(mid, n) / 1000.0;
    end
endmodule
