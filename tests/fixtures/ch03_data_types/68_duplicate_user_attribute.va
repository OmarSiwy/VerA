// §3.6.1.3: "A user-defined attribute can be declared in the same manner as any
// predefined attribute. The name of the attribute shall be UNIQUE in the nature
// being defined and the value being assigned to the attribute shall be
// constant."
//
// `maxval` is declared twice in one nature with two different values, so
// `ch3_dup_attr.maxval` has no single reading. `maxval = 12.3` is the LRM's own
// user attribute, from the §3.6.1.1 example that 10_nature_declarations.va
// copies; the second line is the only addition.
//
// The pinned substring is only the phase label: VerA has no diagnostic for this
// rule, so a code would pin the wrong one.
//
//! lrm 3.6.1.3
//! reject DiagnosticsReported
//! xfail VerA keeps the last of two user-defined nature attributes with the same name and reports nothing; lower.zig does not check attribute-name uniqueness within a nature
nature ch3_dup_attr; units="V"; access=DupAttrV; abstol=1u; maxval=12.3; maxval=24.6; endnature
module ch3_duplicate_user_attribute; endmodule
