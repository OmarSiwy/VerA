// §3.6.1.3: "A user-defined attribute can be declared in the same manner as any
// predefined attribute. The name of the attribute shall be UNIQUE in the nature
// being defined and the value being assigned to the attribute shall be
// constant."
//
// `maxval` is declared twice in one nature with two different values, so
// `ch3_dup_attr.maxval` has no single reading. `maxval = 12.3` is the LRM's own
// user attribute, from the §3.6.1.1 example that 10_nature_declarations.va
// copies; the second line is the only addition.
//
// Pin E0343, verified at the offending attribute, rather than accepting an
// unrelated failed compilation phase.
//
//! lrm 3.6.1.3
//! lrm 3.6.1.3:1
//! reject-only E0343
//! neighbour 10_nature_declarations.va
nature ch3_dup_attr; units="V"; access=DupAttrV; abstol=1u; maxval=12.3; maxval=24.6; endnature
module ch3_duplicate_user_attribute; endmodule
