// A logical right shift by zero preserves both signed and unsigned operands.
//! lrm 3.2.1
//! lrm 4.2.11
//! lrm 6.3.4
//! lrm 6.3.4:1000
//! param count = 0
`include "check.vh"
module dependent_control_shift_sign;
  parameter integer count = 1;
  parameter integer operand = -1;
  localparam real signed_result = operand >> count;
  localparam real unsigned_result = 32'hffffffff >> count;
  localparam integer negative = (operand >> count) < 0;
  localparam real folded_signed = -1 >> 0;
  localparam real folded_unsigned = 32'hffffffff >> 0;
  localparam integer folded_negative = (-1 >> 0) < 0;
  integer i;
  analog begin
    `CHECKX("host zero shift preserves signed value", signed_result, -1.0);
    `CHECKX("host zero shift preserves unsigned value", unsigned_result, 4294967295.0);
    `CHECKI("host zero shift preserves signed comparison", negative, 1);
    `CHECKX("folded zero shift preserves signed value", folded_signed, -1.0);
    `CHECKX("folded zero shift preserves unsigned value", folded_unsigned, 4294967295.0);
    `CHECKI("folded zero shift preserves signed comparison", folded_negative, 1);
    for (i = 0; i < 2; i = i + 1) begin
      if (i == 0) begin
        `CHECKX("runtime zero shift preserves signed value", operand >> i, -1.0);
        `CHECKX("runtime zero shift preserves unsigned value", 32'hffffffff >> i, 4294967295.0);
        `CHECKI("runtime zero shift compares signed integer", (operand >> i) < 0, 1);
      end else begin
        `CHECKX("runtime signed right shift zero fills", operand >> i, 2147483647.0);
        `CHECKX("runtime unsigned right shift zero fills", 32'hffffffff >> i, 2147483647.0);
        `CHECKI("runtime nonzero right shift clears sign", (operand >> i) < 0, 0);
      end
    end
  end
endmodule
