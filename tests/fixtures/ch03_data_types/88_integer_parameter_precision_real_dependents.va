// Declared integer conversion reaches MIR defaults used by real dependents.
//! lrm 3.4.1
//! lrm 3.4.4
//! lrm 6.3.4
`include "check.vh"
module integer_parameter_precision_real_dependents;
    parameter integer a = 4294967297.0;
    parameter real b = a / 2;
    parameter real copy = a;
    parameter integer aa[1:0] = '{4294967297.0,4294967299.0};
    parameter real c = aa[1] / 2;
    parameter real d = aa[0] / 2;
    parameter integer negative = 4294967295.0;
    parameter real negative_quotient = negative / 2;
    parameter integer tie = 3.5;
    parameter real tie_quotient = tie / 3;
    analog begin
        `CHECKI("integer declaration wraps before use", a, 1);
        `CHECKX("real dependent divides converted integer", b, 0);
        `CHECKX("real dependent copies converted integer", copy, 1);
        `CHECKI("descending array first converted element", aa[1], 1);
        `CHECKI("descending array second converted element", aa[0], 3);
        `CHECKX("real dependent divides first array integer", c, 0);
        `CHECKX("real dependent divides second array integer", d, 1);
        `CHECKX("negative integer division truncates before real conversion", negative_quotient, 0);
        `CHECKX("integer rounding precedes dependent division", tie_quotient, 1);
    end
endmodule
