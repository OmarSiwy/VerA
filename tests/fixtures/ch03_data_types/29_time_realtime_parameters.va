// §3.4 lists `time` and `realtime` among the legal parameter/variable types.
// They are NOT the same type, and this pins the difference rather than merely
// compiling:
//
//   `realtime` is a real (IEEE Std 1364 §4.8), so 1.25 survives intact.
//   `time`     is an integral type, so a real assigned to one is converted by
//              §4.2.1.1 — round to nearest, ties away from zero. 2.6 -> 3, and
//              the scale-factored literal 1n = 1e-9 -> 0.
//
// A backend that aliased `time` onto `real` reads 2.6 and 1e-9 and fails; one
// that aliased `realtime` onto an integer reads 1 and fails.
`include "check.vh"
module ch3_time_params(p);
  inout p;
  electrical p;
  parameter time delay = 1n;
  parameter realtime ratio = 1.25;
  time ticks;
  realtime value;
  analog begin
    value = ratio;
    ticks = 2.6;
    `CHECKX("realtime keeps the fractional part", value, 1.25);
    `CHECKI("real assigned to a time variable rounds", ticks, 3);
    `CHECKI("1n into an integral time parameter rounds to 0", delay, 0);
    I(p) <+ value + 0.0 * V(p);
  end
endmodule
