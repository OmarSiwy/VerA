// §3.4's Syntax 3-2 lists `time` and `realtime` among the legal PARAMETER
// types: `parameter_type ::= integer | real | realtime | time | string`. They
// are not variable types under §3.2's Syntax 3-1, which declares integer and
// real only — the two variables below come from A.2.1.3's separate
// `time_declaration` and `realtime_declaration` productions. `time` and
// `realtime` are NOT the same type, and this pins the difference rather than
// merely compiling:
//
//   `realtime` is a real (IEEE Std 1364 §4.8), so 1.25 survives intact.
//   `time`     is an integral type, so a real assigned to one is converted by
//              §4.2.1.1 — round to nearest, ties away from zero. 2.6 -> 3, and
//              the scale-factored literal 1n = 1e-9 -> 0.
//
// A backend that aliased `time` onto `real` reads 2.6 and 1e-9 and fails; one
// that aliased `realtime` onto an integer reads 1 and fails.
//! lrm 3.4
//! lrm 3.4.1
`include "check.vh"
module ch3_time_params(p);
  inout p;
  electrical p;
  parameter time delay = 1n;
  parameter realtime ratio = 1.25;
  time ticks;
  realtime value;
  analog begin
    value = ratio;
    ticks = 2.6;
    `CHECKX("realtime keeps the fractional part", value, 1.25);
    `CHECKI("real assigned to a time variable rounds", ticks, 3);
    `CHECKI("1n into an integral time parameter rounds to 0", delay, 0);
    I(p) <+ value + 0.0 * V(p);
  end
endmodule
