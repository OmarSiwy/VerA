// §3.6.1: "Each nature definition ... shall include all the required
// attributes specified in 3.6.1.2." §3.6.1.2 says of abstol: "This attribute is
// required for all base natures."
//
// `ch3_incomplete_nature` is a BASE nature (no `:` parent) that declares units
// and access but not abstol, so it is incomplete and shall be diagnosed. The
// discipline and module below are well-formed on purpose — the only defect in
// the file is the missing attribute, so a rejection can only be about that.
// The signal-flow port is output, not inout (§1.3.4.1); the old inout
// declaration added an unrelated port error and has been corrected.
//
//! lrm 3.6.1.2
//! lrm 3.6.1.2:1001
//! lrm 3.6.1
//! lrm 3.6.1:2
//! reject-only E0332
//! neighbour 10_nature_declarations.va
nature ch3_incomplete_nature; units="V"; access=IncompleteV; endnature
discipline ch3_incomplete_disc; potential ch3_incomplete_nature; enddiscipline
module ch3_incomplete(p); output p; ch3_incomplete_disc p; analog IncompleteV(p)<+0.0; endmodule
