// §3.6.1.2, units: "It is illegal for a derived nature to define or change the
// units; the derived nature always inherits its parent nature units."
//
// `ch3_units_child : ch3_units_parent` redefines units from "V" to "A", which
// is exactly the construct that sentence forbids. The parent carries all three
// attributes §3.6.1.2 requires of a base nature, so the override is the only
// defect in the file.
//
//! lrm 3.6.1.2
//! lrm 3.6.1.2:10
//! reject-only E0333
//! neighbour b1_3_6_1_2_derived_nature_inherits_units.va
nature ch3_units_parent; units="V"; access=UnitsV; abstol=1u; endnature
nature ch3_units_child:ch3_units_parent; units="A"; endnature
module ch3_bad_units; endmodule
