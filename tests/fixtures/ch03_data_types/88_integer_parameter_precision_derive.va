// Integer derivation preserves existing numeric operations and declared arrays.
//! lrm 3.4.1
//! lrm 3.4.4
//! lrm 6.3.4
//! lrm 6.3.4:1000
//! param word = -2147483648
//! param realbase = 9.0
`include "check.vh"
module integer_parameter_precision_derive;
  parameter integer literal_quotient = 64'h8000000000000000 / -1;
  localparam integer literal_remainder = 64'h8000000000000000 % -1;
  parameter integer word = -7;
  parameter real realbase = 4.0;
  localparam integer magnitude = abs(word);
  localparam integer smaller = min(word, 6);
  localparam integer larger = max(word, 6);
  localparam integer root = sqrt(realbase);
  localparam integer power = pow(realbase, 2.0);
  localparam integer converted = realbase;
  localparam integer quotient = word / -1;
  localparam integer remainder = word % -1;
  parameter integer words[0:2] = '{64'h4142434445464748, word, 4294967297.0};
  parameter integer realwide = 4294967297.0;
  parameter realwidecopy = realwide;
  parameter integer positive_tie = 3.5;
  parameter integer negative_tie = -3.5;
  parameter intcopy = positive_tie;
  parameter real declaredreal = 4;
  parameter realcopy = declaredreal;
  analog begin
    `CHECKI("literal quotient applies target32 without overflow", literal_quotient, 0);
    `CHECKI("literal remainder applies target32 without overflow", literal_remainder, 0);
    `CHECKI("real initializer rounds and wraps32", realwide, 1);
    `CHECKI("real initializer dependent copy keeps32", realwidecopy, 1);
    `CHECKI("positive tie rounds away", positive_tie, 4);
    `CHECKI("negative tie rounds away", negative_tie, -4);
    `CHECKI("inferred integer follows declaration type", intcopy / 3, 1);
    `CHECKX("inferred real follows declaration type", realcopy / 3, 1.3333333333333333);
    `CHECKI("real array initializer wraps32", words[2], 1);
    `CHECKI("integer abs keeps32bit overflow", magnitude, -2147483648);
    `CHECKI("integer min derives", smaller, -2147483648);
    `CHECKI("integer max derives", larger, 6);
    `CHECKI("real function rounds to integer", root, 3);
    `CHECKI("real power converts to integer", power, 81);
    `CHECKI("real parameter converts to integer", converted, 9);
    `CHECKI("integer division overflow wraps32", quotient, -2147483648);
    `CHECKI("negativeunit remainder", remainder, 0);
    `CHECKI("declared integer array truncates32", words[0], 1162233672);
    `CHECKI("declared integer array derives", words[1], -2147483648);
  end
endmodule
