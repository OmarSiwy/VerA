// Changing a divisor to zero must never evaluate an untaken arm.
//! lrm 4.2.3
//! lrm 4.2.7
//! lrm 4.2.12
//! lrm 6.3.4
//! lrm 4.2.3:4
//! lrm 6.3.4:1000
//! param divisor = 0
//! param positive = -4
`include "check.vh"
module dependent_control_guarded;
  parameter integer divisor = 2;
  parameter real positive = 4;
  parameter integer quotient = divisor != 0 ? 7 / divisor : 123;
  parameter integer remainder = divisor != 0 ? 7 % divisor : 456;
  localparam integer and_guard = (divisor != 0) && (7 / divisor > 0);
  localparam integer or_guard = (divisor == 0) || (7 % divisor > 0);
  parameter real root = positive >= 0 ? sqrt(positive) : 17;
  parameter real nested = divisor ? (positive >= 0 ? sqrt(positive) : 13) : 19;
  analog begin
    `CHECKI("unselected integer division", quotient, 123);
    `CHECKI("unselected integer remainder", remainder, 456);
    `CHECKI("logical AND guards division", and_guard, 0);
    `CHECKI("logical OR guards remainder", or_guard, 1);
    `CHECKX("unselected sqrt", root, 17);
    `CHECKX("nested unselected sqrt", nested, 19);
  end
endmodule
