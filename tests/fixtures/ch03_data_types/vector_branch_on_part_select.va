// A.2.1.3 lets a branch terminal select part of a vector:
//
//     branch_terminal ::= net_identifier
//             | net_identifier [ constant_expression ]
//             | net_identifier [ constant_range_expression ] | ...     // A.2.1.3
//     constant_range_expression ::= constant_expression
//             | msb_constant_expression : lsb_constant_expression
//             | constant_base_expression +: width_constant_expression
//             | constant_base_expression -: width_constant_expression  // A.8.3
//
// §3.12: "If one of the terminals of a branch is a vector net, then the other
// terminal shall either be a scalar net or a vector net of the same size", and
// "When one terminal is a vector and the other is a scalar, a singular scalar
// branch connects to each scalar net in the vector terminal"; "If the range of
// the vector branch is not specified then the indexing of the vector branch
// shall start at 0" (33_vector_branches.va). A
// part-select is a vector of its elements in declaration order; IEEE
// 1364-2005 §5.2.1 gives the indexed forms, which "select bits starting at the
// base and ascending [+:] / descending [-:] the bit range" (its examples:
// `big_vect[0 +: 8] // == big_vect[7 : 0]` on `reg [31:0] big_vect`).
//
// DERIVATION. `electrical [3:0] a`, biased V(a[3]) = 0.5, V(a[2]) = 0.25,
// V(a[1]) = 0.125, V(a[0]) = 1.0; z = 0.
//   mid  = branch (a[2:1], z):  mid[0] is a[2], mid[1] is a[1]    0.25, 0.125
//   low  = branch (a[0 +: 2], z): [1:0] on a [3:0], low[0] is a[1] 0.125
//                                  and low[1] is a[0]              1.0
//   high = branch (a[3 -: 2], z): [3:2], high[0] is a[3]           0.5
// Five verdicts. Reading low[0] as a[0] would mean the +: range read
// against the declaration's direction.
//
//! lrm A.2.1.3
//! lrm 3.12
//! lrm 3.12:3
//! lrm A.8.3
//! lrm A.2.1.3:1000
//! bias V(a[3]) = 0.5, V(a[2]) = 0.25, V(a[1]) = 0.125, V(a[0]) = 1.0
//! print none
//! checks 5
`include "check.vh"
module vector_branch_on_part_select(a, z);
    inout [3:0] a;
    inout z;
    electrical [3:0] a;
    electrical z;
    branch (a[2:1], z) mid;
    branch (a[0 +: 2], z) low;
    branch (a[3 -: 2], z) high;

    analog begin
        `CHECKX("mid[0] is a[2]", V(mid[0]), 0.25);
        `CHECKX("mid[1] is a[1]", V(mid[1]), 0.125);
        `CHECKX("low = a[0 +: 2] = a[1:0], low[0] is a[1]", V(low[0]), 0.125);
        `CHECKX("low[1] is a[0]", V(low[1]), 1.0);
        `CHECKX("high = a[3 -: 2] = a[3:2], high[0] is a[3]", V(high[0]), 0.5);
        I(a[0], z) <+ V(a[0], z);
    end
endmodule
