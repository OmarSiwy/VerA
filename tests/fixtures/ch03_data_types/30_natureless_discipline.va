// §3.6.2.3: "It is possible to define a discipline with no nature bindings.
// These are known as natureless disciplines" — the declaration below is the
// LRM's `natureless` example verbatim, domain binding and all. Declaring one,
// and declaring a net of it, is legal, so this file must RUN; the clause it pins
// is that legality, which is observable as the module still elaborating and its
// other nets still solving with the natureless net present.
//
// The file used to be two lines with no ports and no analog block, so it could
// not run and asserted nothing. The behavioural half — a natureless net has no
// access function, so it cannot appear in a contribution — is the separate
// negative in 79_natureless_net_behavioral.va, because everything written here
// is legalised by §3.6.2.3 and there is nothing in it to reject.
//
//! bias V(p) = 1.25
//! lrm 3.6.2.3
//! lrm 3.6.2.3:1
`include "check.vh"
discipline ch3_natureless;
    domain continuous;
enddiscipline

module ch3_natureless_structural(p);
    inout p;
    electrical p;
    ch3_natureless link;

    analog begin
        `CHECKX("a module carrying a natureless net still elaborates and solves", V(p), 1.25);
        I(p) <+ 0.0 * V(p);
    end
endmodule
