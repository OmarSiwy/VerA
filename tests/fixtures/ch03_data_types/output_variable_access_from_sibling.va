// §3.2.1: "Module scope variables with a description or units attribute, or
// both, shall be known as output variables, and Verilog-AMS simulators shall
// provide access to their values." ... "Units and descriptions specified for
// block-level variables shall be ignored by the simulator, but can be used for
// documentation purposes."
//
// output_variable_description_and_units.va reads each output variable back inside the module that
// assigned it, which any variable would pass. This file checks the "provide
// access" half from OUTSIDE the declaring instance, through the one in-language
// channel the LRM gives for it: §9.16 `$simprobe`, which "queries the simulator
// for an output variable named param_name in a sibling instance".
//
// THE DERIVATION. `//! bias` pins V(p) = 0.75, V(n) = 0.25, so the device sees
// V(a,b) = 0.5 exactly. Its output variables are
//
//   cgs = 2.0e-15 * V(a,b) * 4 = 4.0e-15      (desc and units, the clause's own)
//   gm  = 0.5 * 3              = 1.5          (units only: still an output variable)
//
// and the monitor sibling reads both with a -1.0 fallback, a value neither can
// take, so an unresolved probe shows as got=-1 rather than as silence. Every
// product is of dyadic-exact operands except 2.0e-15 * 0.5 * 4, which is
// 2.0e-15 * 2.0 (an exact power-of-two scaling) = 4.0e-15 to the last bit, so
// CHECKR at 1e-15 relative is a band only an ulp slip could use.
//
// The device's `begin : blk` declares `(* units="V" *) real vtmp;` — a
// block-level variable with a units attribute, which "shall be ignored by the
// simulator": the attribute makes it neither illegal nor an output variable,
// so the block still computes with it: the second check's 1.5 is 0.5 * vtmp,
// and reads 0 or -1 if the attributed block variable were dropped.
//
//! lrm 3.2.1
//! lrm 3.2.1:1
//! lrm 9.16
//! lrm 3.2.1:2
//! analysis dc
//! bias V(p) = 0.75, V(n) = 0.25
`include "check.vh"
module ch3_output_variable_top(p, n);
  inout p, n;
  electrical p, n;
  ch3_output_variable_dev u_dev(p, n);
  ch3_output_variable_mon u_mon(p, n);
endmodule

module ch3_output_variable_dev(a, b);
  inout a, b;
  electrical a, b;
  (* desc="gate-source capacitance", units="F" *) real cgs;
  (* units="S" *) real gm;
  analog begin : blk
    (* units="V" *) real vtmp;
    vtmp = 3.0;
    cgs = 2.0e-15 * V(a, b) * 4;
    gm = V(a, b) * vtmp;
    I(a, b) <+ 0.0 * V(a, b);
  end
endmodule

module ch3_output_variable_mon(a, b);
  inout a, b;
  electrical a, b;
  real got_cgs, got_gm;
  analog begin
    got_cgs = $simprobe("u_dev", "cgs", -1.0);
    got_gm = $simprobe("u_dev", "gm", -1.0);
    `CHECKR("an output variable with desc and units is readable from a sibling", got_cgs, 4.0e-15, 1e-15);
    `CHECKX("a units-only output variable is readable from a sibling", got_gm, 1.5);
    `CHECKI("the sibling did not fall back", (got_gm == -1.0), 0);
    I(a, b) <+ 0.0 * V(a, b);
  end
endmodule
