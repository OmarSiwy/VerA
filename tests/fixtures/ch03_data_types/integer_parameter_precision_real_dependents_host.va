// Dependent conversions and integer arithmetic follow final host-written values.
//! lrm 3.4.1
//! lrm 6.3.4
//! lrm 6.3.4:1000
//! param source = 4294967303.0
`include "check.vh"
module integer_parameter_precision_real_dependents_host;
    parameter real source = 4294967297.0;
    parameter integer a = source;
    parameter real b = a / 2;
    parameter real copy = a;
    parameter integer aa[1:0] = '{source,source+2.0};
    parameter real c = aa[1] / 2;
    parameter real d = aa[0] / 2;
    parameter real product = a * 1073741824;
    analog begin
        `CHECKI("host-derived integer conversion", a, 7);
        `CHECKX("host-derived real quotient", b, 3);
        `CHECKX("host-derived real copy", copy, 7);
        `CHECKI("host-derived descending array first", aa[1], 7);
        `CHECKI("host-derived descending array second", aa[0], 9);
        `CHECKX("host-derived array quotient first", c, 3);
        `CHECKX("host-derived array quotient second", d, 4);
        `CHECKX("integer product wraps before conversion to real", product, -1073741824);
    end
endmodule
