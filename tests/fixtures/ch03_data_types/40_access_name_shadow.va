// §3.13.2: "Each access function name, defined before a module is parsed, is
// automatically added to that module's namespace UNLESS THERE IS ANOTHER
// IDENTIFIER DEFINED WITH THE SAME NAME AS THE ACCESS FUNCTION in that
// module's namespace." So `real ShadowV;` is legal even though ShadowV is the
// nature's access name — the declaration simply wins the name, and the net is
// still reached through the generic access function `potential()` (§4.4 lists
// `potential(b1)` as the alternative spelling of a potential access).
//
// The bias holds p at 2.0 while the variable holds 1.0, so the two cannot be
// confused. A compiler that let the access function keep the name reads 2.0
// out of `ShadowV`; one that bound the name to the net both ways reads 1.0
// out of `potential(p)`.
//
// `p` is an `output`: ch3_shadow_d binds a potential nature only, so §1.3.4.1
// confines it to an `input` or an `output` port (E0360), and `output` is the half
// that may be contributed to (E0425 is the other). Nothing about the shadowing
// rule depends on the direction — the `//! bias` still says what the terminal is
// tied to, which is all the two assertions need.
//
//! lrm 3.13.2
//! lrm 3.13.2:1001
//! lrm 1.3.4.1
//! bias p = 2.0
`include "check.vh"
nature ch3_shadow_n;
    units = "V";
    access = ShadowV;
    abstol = 1u;
endnature
discipline ch3_shadow_d;
    potential ch3_shadow_n;
enddiscipline
module ch3_shadow(p);
    output p;
    ch3_shadow_d p;
    real ShadowV;

    analog begin
        ShadowV = 1.0;
        `CHECKX("the same-named identifier owns the name, not the access function", ShadowV, 1.0);
        `CHECKX("the net is still reachable through the generic access function", potential(p), 2.0);
        potential(p) <+ ShadowV;
    end
endmodule
