// §3.13.2: "Each access function name, defined before a module is parsed, is
// automatically added to that module's namespace UNLESS THERE IS ANOTHER
// IDENTIFIER DEFINED WITH THE SAME NAME AS THE ACCESS FUNCTION in that
// module's namespace." So `real ShadowV;` is legal even though ShadowV is the
// nature's access name — the declaration simply wins the name, and the net is
// still reached through the generic access function `potential()` (§4.4 lists
// `potential(b1)` as the alternative spelling of a potential access).
//
// The bias holds p at 2.0 while the variable holds 1.0, so the two cannot be
// confused. A compiler that let the access function keep the name reads 2.0
// out of `ShadowV`; one that bound the name to the net both ways reads 1.0
// out of `potential(p)`.
//
//! lrm 3.13.2
//! bias p = 2.0
//! xfail VerA accepts the shadowing declaration but has no generic access function: `potential(p)` is E0209
`include "check.vh"
nature ch3_shadow_n;
    units = "V";
    access = ShadowV;
    abstol = 1u;
endnature
discipline ch3_shadow_d;
    potential ch3_shadow_n;
enddiscipline
module ch3_shadow(p);
    inout p;
    ch3_shadow_d p;
    real ShadowV;

    analog begin
        ShadowV = 1.0;
        `CHECKX("the same-named identifier owns the name, not the access function", ShadowV, 1.0);
        `CHECKX("the net is still reachable through the generic access function", potential(p), 2.0);
        potential(p) <+ ShadowV;
    end
endmodule
