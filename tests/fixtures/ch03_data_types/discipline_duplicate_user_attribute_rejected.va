// §3.6.2.7: "LIKE NATURES, a discipline can specify user-defined attributes.
// Discipline user-defined attributes are useful for the same reasons as nature
// user-defined attributes (see 3.6.1.3)." And §3.6.1.3, the rule the clause
// points at: "The name of the attribute shall be unique in the nature being
// defined and the value being assigned to the attribute shall be constant."
//
// A discipline's user attribute is declared "like" a nature's, so the same
// uniqueness rule holds in the discipline being defined: `max_voltage` twice,
// with two different values, leaves the discipline with no single reading of
// it. The first line is discipline_user_attributes.va's legal attribute; the second is the
// only addition, and without it the file is that fixture's legal discipline
// (checked by hand when this fixture was written).
//
// duplicate_user_attribute.va is the nature half of the same rule, E0343.
//
//! lrm 3.6.2.7
//! lrm 3.6.1.3
//! lrm 3.6.1.3:1
//! lrm 3.6.2.7:1000
//! reject-only E0343
//! neighbour discipline_user_attributes.va
nature ch3_dua_voltage;
    units = "V";
    access = V;
    abstol = 1u;
endnature

nature ch3_dua_current;
    units = "A";
    access = I;
    abstol = 1p;
endnature

discipline ch3_dua_disc;
    potential ch3_dua_voltage;
    flow ch3_dua_current;
    max_voltage = 48.0;
    max_voltage = 12.0;
enddiscipline

module ch3_discipline_duplicate_user_attribute(p, n);
    inout p, n;
    ch3_dua_disc p, n;
    analog I(p, n) <+ V(p, n) / 1000.0;
endmodule
