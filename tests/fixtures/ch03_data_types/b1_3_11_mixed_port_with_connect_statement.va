// §3.11: "Signal Domain Rule: It shall be an error to connect two ports or nets
// of different domains unless there is a connect statement (see 7.4) defined
// between the disciplines of the nets or ports."
//
// The "unless" half: the legal twin of
// b1_3_11_mixed_port_without_connect_statement_rejected.va, which is this file
// without the `connectrules` block at the bottom.
//
// The design is ch07_mixed_signal/m03_09_analog_signal_is_never_segmented.va's
// (renamed): `ddiscrete d` (discrete) is connected to two ports declared
// `electrical` (continuous). The connect statement `connect b1_d2a;` names a
// connect module between ddiscrete and electrical, so the mixed ports are
// legal and one b1_d2a is inserted (§7.8.3 merged, the default).
//
// DERIVATION (m03_09's). d = 1'b1, so the bridge is a 2 V source behind 1 kohm,
// loaded by 1 kohm and 3 kohm on the one analog node of the signal:
//     (V - 2)/1000 + V/1000 + V/3000 = 0  ->  7V = 6  ->  V = 6/7
// python3: 6/7 = 0.8571428571428571.
//
//! lrm 3.11
//! lrm 7.6
//! solve
//! checks 2
`include "check.vh"
connectmodule b1_d2a(cm, el);
  input cm;
  output el;
  ddiscrete cm;
  electrical el;
  parameter real rout = 1000.0 from (0.0:inf);
  parameter real vsup = 2.0;
  analog I(el) <+ (V(el) - vsup * ((cm == 1'b1) ? 1.0 : 0.0)) / rout;
endmodule

module b1_aload(p);
  input p;
  electrical p;
  parameter real rl = 1000.0 from (0.0:inf);
  analog I(p) <+ V(p) / rl;
endmodule

module b1_domain_top;
  ddiscrete d;
  assign d = 1'b1;
  b1_aload                 u1(d);
  b1_aload #(.rl(3000.0))  u2(d);
  analog begin
    `CHECK("u1's port sits on the bridged node", V(u1.p), 0.85714285714285710, 1e-12);
    `CHECK("u2's port sits on the same node", V(u2.p), 0.85714285714285710, 1e-12);
  end
endmodule

connectrules b1_rules;
  connect b1_d2a;
endconnectrules
