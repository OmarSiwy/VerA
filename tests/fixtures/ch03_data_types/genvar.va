// §3.5 genvars: an integer-valued index that "can only be assigned within the
// for-loop control", which is what makes an analog for loop statically
// unrollable (§5.9.3 analog_for). This fixture accumulates into a real inside
// the loop body to observe its trip count: index takes 0, 1, 2 and stops, so
// the sum is 0 + 1 + 2 = 3. It does not read the genvar after the loop or prove
// separate analog-operator state for each unrolled instance.
//
// An unroll that ran one iteration too few gives 1, one too many gives 6.
//! lrm 3.5
//! lrm 3.5:1000
//! checks 1
`include "check.vh"
module ch03_genvar(p, n);
    inout p, n;
    electrical p, n;
    genvar index;
    real acc;

    analog begin
        acc = 0.0;
        for (index = 0; index < 3; index = index + 1) begin
            acc = acc + index;
            I(p, n) <+ index * V(p, n);
        end
        `CHECKX("the body ran once per genvar value 0, 1, 2", acc, 3.0);
    end
endmodule
