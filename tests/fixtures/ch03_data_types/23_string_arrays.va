// §3.3 "Arrays and multidimensional arrays of string are also supported", with
// the LRM's own example `string names[1:3] = '{"first", "middle", "last"}`.
// The declared range starts at 1, so the assignment pattern's first element
// lands at index 1 — a backend that treated the pattern as 0-based would put
// "first" at 0 and read "middle" here.
//! lrm 3.3
`include "check.vh"
module ch3_string_arrays(p);
  inout p;
  electrical p;
  string names[1:3] = '{"first","middle","last"};
  analog begin
    `CHECKI("declared range 1:3 puts the first element at index 1", (names[1] == "first"), 1);
    `CHECKI("and the last at index 3", (names[3] == "last"), 1);
    `CHECKI("lexicographic ordering of string elements", (names[1] < names[2]), 1);
    I(p) <+ 0.0 * V(p);
  end
endmodule
