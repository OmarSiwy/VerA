// §3.6.2.4 undeclared nets: "It is possible for a module to have nets where
// there are no discipline declarations. If such a net appears bound only to
// ports in module instantiations, it may have no declaration at all". That is
// exactly `implicit_link` below — it is written only as an actual on the child
// instance and never in behavioral code, so the module is legal as written and
// the net's discipline comes from resolution (§7.4, Annex F).
//
// Annex C.8 keeps Clause 6 hierarchy inside the Verilog-A subset, so the
// instance is legal too. This file used to carry `//! reject ParseError`, which
// asserted a VerA limitation as if it were the rule and pinned only the PHASE,
// so any unrelated parse error kept it green. The three §3.6.2.4 sentences it
// also quoted (a net that resolves to nothing has no discipline, and gains a
// discrete domain binding only if behavioral code touches it) are about
// resolution across a hierarchy and belong with ch06/annex_f, not here.
//
// Two child conductances form a divider. The implicit net appears only as
// actual ports; probes name the children's declared pins. Its solved midpoint
// must be 0.75 V, so dropping the link or failing to resolve it cannot pass.
//
//! bias V(p) = 1.5
//! solve
//! checks 3
//! lrm 3.6.2.4
//! lrm 3.6.2.4:1
//! lrm C.8
//! lrm 3.6.2
//! lrm 3.6.2:3
`include "check.vh"
module ch3_implicit_child(a, b);
    inout a, b;
    electrical a, b;

    analog I(a, b) <+ 0.001 * V(a, b);
endmodule

module ch3_implicit_top(p);
    inout p;
    electrical p;
    electrical g;
    ground g;

    ch3_implicit_child u(p, implicit_link);
    ch3_implicit_child v(implicit_link, g);

    analog begin
        `CHECKX("the parent elaborates with an undeclared net bound only to an instance port", V(p), 1.5);
        `CHECK("the implicit link solves to the divider midpoint", V(u.b), 0.75, 1e-9);
        `CHECK("the lower instance sees that same implicit link", V(v.a, v.b), 0.75, 1e-9);
    end
endmodule
