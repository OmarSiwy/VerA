// §3.3 Table 3-3, the Replication row: "multiplier must be of integral type and
// can be nonconstant. If multiplier is nonconstant or Str is of type string, the
// result is a string containing N concatenated copies of Str, where N is
// specified by multiplier." The row is about the string TYPE, not a context:
// nothing in §3.3 confines it to digital or to analog blocks.
//
// 28_string_replication.va writes the clause's own `integer i = 1`, whose value
// lowering can still see; this file makes the multiplier depend on a probe, so
// no compile-time value exists and the device must build the string while it
// runs:
//
//   V(p) = 1.0 > 0.5, so i = 2
//   {i{"Hi"}}  = "HiHi"         (a string literal Str)
//   {i{b}}     = "HiHi"         (Str of type string, b = "Hi")
//   {(i - 2){"Hi"}} = ""        (N = 0: zero copies, the empty string)
//
// "HiHiHi" (i = 3, the other arm) is checked unequal, so a device that took the
// wrong arm or a fixed count cannot pass. 52_nonconstant_replication_to_integral.va
// is the illegal neighbour: the same replication into an integral target, E0354;
// replication_nonconstant_real_multiplier_rejected.va is the other: a
// nonconstant multiplier that is not "of integral type".
//
// This was an XFAIL (E0328, "a compiled device has no run-time string value")
// until 2026-09-24. The fixture was right and VerA was not: the row says "can be
// nonconstant" in so many words. Lowering now emits `$str$repeat`, which builds
// the N copies in the call site's scratch (str_kernels.zStrRepeat); E0328 is
// retired.
//
//! lrm 3.3
//! lrm 3.3:1
//! lrm 3.3:4
//! bias V(p) = 1.0
`include "check.vh"
module ch3_string_replication_runtime_multiplier(p);
    inout p;
    electrical p;
    integer i;
    string a;
    string b;

    analog begin
        i = V(p) > 0.5 ? 2 : 3;
        b = "Hi";
        a = {i{"Hi"}};
        `CHECKI("a probe-dependent multiplier of a literal: two copies", (a == "HiHi"), 1);
        `CHECKI("and not the other arm's three", (a == "HiHiHi"), 0);
        a = {i{b}};
        `CHECKI("a probe-dependent multiplier of a string variable", (a == "HiHi"), 1);
        a = {(i - 2){"Hi"}};
        `CHECKI("a probe-dependent multiplier of zero: the empty string", (a == ""), 1);
        I(p) <+ 0.0 * V(p);
    end
endmodule
