// §3.5 genvars: an integer-valued index that "can only be assigned within the
// for-loop control", which is what makes an analog for loop statically
// unrollable (§5.7.3 analog_loop_generate_statement). The LRM's own genvar
// example accumulates into a real inside the loop body, which is what pins the
// trip count here: the body runs for index 0, 1, 2 and stops, so the sum is
// 0 + 1 + 2 = 3 and the index that failed the guard is 3.
//
// An unroll that ran one iteration too few gives 1, one too many gives 6.
//! lrm 3.5
`include "check.vh"
module ch03_genvar(p, n);
    inout p, n;
    electrical p, n;
    genvar index;
    real acc;

    analog begin
        acc = 0.0;
        for (index = 0; index < 3; index = index + 1) begin
            acc = acc + index;
            I(p, n) <+ index * V(p, n);
        end
        `CHECKX("the body ran once per genvar value 0, 1, 2", acc, 3.0);
    end
endmodule
