// §3.6.3.1: "Nets can be declared with a description attribute. This
// information can be used by the simulator to generate help messages for a
// module." The attribute can appear on net declarations and on port
// declarations. If specified in both, the last value is used. This fixture
// verifies the compiler accepts description attributes on both forms.
//
//! lrm 3.6.3.1
`include "check.vh"
module ch03_net_descriptions(p, n);
  (* desc="input port terminal" *) inout p;
  (* desc="output port terminal" *) inout n;
  electrical p, n;
  (* desc="internal drain node" *) electrical d;
  analog begin
    `CHECKI("description attribute is accepted", 1, 1);
    I(p, d) <+ V(p, d);
    I(d, n) <+ V(d, n);
  end
endmodule
