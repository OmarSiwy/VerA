// AMS 3.3 Table 3-3: "If both operands are string literals, the operator
// is the same Verilog equality operator as for integer types." With one
// string-typed operand the literal instead converts to string, removing NULs.
// Thus string s="A" equals "A\0". The contrasting literal-only integer
// comparison is isolated in audit_string_literal_equality.va (STR-LITERAL-001).
// Remaining observations independently pin lexicographical prefix/equal cases:
// empty < a < aa, a <= a, aa > a, aa >= aa, and a != aa. A sum of booleans
// could hide compensating operator errors, so each has its own assertion.
//! lrm 3.3
//! lrm 3.3:2
//! checks 7
`include "check.vh"
module audit_string_comparison_context(p, n);
  inout p, n; electrical p, n;
  string short_text = "A";
  string prefix = "a", extension = "aa", empty = "";
  analog begin
    `CHECKI("typed equality removes NUL during conversion", (short_text == "A\0"), 1);
    `CHECKI("empty string sorts before a nonempty string", (empty < prefix), 1);
    `CHECKI("proper prefix sorts before its extension", (prefix < extension), 1);
    `CHECKI("less-or-equal includes equality", (prefix <= "a"), 1);
    `CHECKI("extension sorts after its proper prefix", (extension > prefix), 1);
    `CHECKI("greater-or-equal includes equality", (extension >= "aa"), 1);
    `CHECKI("prefix and extension are unequal", (prefix != extension), 1);
    I(p,n) <+ V(p,n);
  end
endmodule
