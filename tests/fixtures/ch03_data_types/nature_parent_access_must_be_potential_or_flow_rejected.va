// A.1.6 (Syntax 3-4 in §3.6.1):
//
//     nature_declaration ::= nature nature_identifier [ : parent_nature ] [ ; ]
//                            { nature_item } endnature
//     parent_nature ::= nature_identifier
//                     | discipline_identifier . potential_or_flow
//     potential_or_flow ::= potential | flow
//
// §3.6.2.6 is the clause for the second form: a nature derived from the
// potential or the flow nature of a discipline. After the `.` the grammar
// admits only the two keywords. `voltage` below is neither; it is not even the
// name of the nature `electrical` binds (that is `Voltage`, and a nature name
// is not a potential_or_flow either).
//
// The legal spelling, `: electrical.potential`, is 20_derived_nature_from_discipline.va.
//
//! lrm 3.6.2.6
//! lrm A.1.6
//! lrm 3.6.2.6:2
//! lrm A.1.6:1000
//! reject-only E0211
//! neighbour 20_derived_nature_from_discipline.va
`include "disciplines.vams"
nature ch3_parent_access_n : electrical.voltage
endnature
module ch3_nature_parent_access(p, n);
  inout p, n; electrical p, n;
  analog I(p, n) <+ V(p, n);
endmodule
