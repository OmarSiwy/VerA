// §3.11.1's three nature rules, one net pair each. §3.11 says why the pairs
// matter: "if an access function has two nets as arguments, they must be
// compatible."
//
//   Base Nature Rule     "A derived nature is compatible with its base nature."
//                        base_net (ch3_volt) with hi_net (ch3_hi_volt : ch3_volt)
//   Derived Nature Rule  "Two natures are compatible if they are derived from
//                        the same base nature."
//                        hi_net with lo_net, both derived from ch3_volt
//   Units Value Rule     "Two natures are compatible if they have the same value
//                        for the units attribute."
//                        base_net with other_net — ch3_other_volt has no
//                        derivation relationship to ch3_volt at all, and is
//                        compatible on the strength of units="V" alone
//
// The Units Value Rule is the surprising one and the reason this file exists:
// 10_nature_declarations.va declares a derived nature and then uses two nets of
// the SAME derived discipline, so it never spans two natures.
//
// Each pair is biased to a difference that is exact in binary, and the three
// differences are distinct, so a compiler that collapsed the nets onto one node
// or crossed two pairs fails on the value rather than on the compile.
// 54_incompatible_nets_access.va is the negative side.
//
// The POTENTIAL access function is `ch3_volt`'s `CV` for the first two pairs:
// §3.6.1.2 forbids a derived nature to change `access`, so ch3_hi_volt and
// ch3_lo_volt are both read with their base's name and only the natures differ.
//
// The Units Value Rule cannot be reached that way. `ch3_other_volt` is a BASE
// nature, and §3.13.2 makes the access function of each base nature unique, so
// it cannot spell itself `CV` — its access is `OV`, and §3.13.3 says "a net can
// only be accessed through its access functions", which makes `CV(base_net,
// other_net)` the same error 42_wrong_access_function.va and
// 64_flow_on_potential_only_net.va pin as E0501. The pair is therefore spanned
// through the FLOW half instead: both disciplines bind the one nature `ch3_amp`,
// so `CI(base_net, other_net)` is spelled legally for both nets — and it is
// still an access function over two nets, so §3.11 requires them compatible,
// which under the Potential Incompatibility Rule requires ch3_volt and
// ch3_other_volt to be compatible, which nothing but the Units Value Rule
// supplies. The accompanying number is the potential difference read through
// each net's OWN access function, 4.0 - 3.0.
//
//! lrm 3.11.1
//! lrm 3.11
//! lrm 3.11.1:2
//! bias base_net = 4.0, hi_net = 1.5, lo_net = 0.25, other_net = 3.0
`include "check.vh"
nature ch3_volt; units="V"; access=CV; abstol=1u; endnature
nature ch3_hi_volt : ch3_volt; abstol=1.0; endnature
nature ch3_lo_volt : ch3_volt; abstol=1n; endnature
nature ch3_other_volt; units="V"; access=OV; abstol=1u; endnature
nature ch3_amp; units="A"; access=CI; abstol=1p; endnature

discipline ch3_d_base;  potential ch3_volt;       flow ch3_amp; enddiscipline
discipline ch3_d_hi;    potential ch3_hi_volt;    flow ch3_amp; enddiscipline
discipline ch3_d_lo;    potential ch3_lo_volt;    flow ch3_amp; enddiscipline
discipline ch3_d_other; potential ch3_other_volt; flow ch3_amp; enddiscipline

module ch03_nature_compatibility_rules(p);
    inout p;
    electrical p;
    ch3_d_base base_net;
    ch3_d_hi hi_net;
    ch3_d_lo lo_net;
    ch3_d_other other_net;

    analog begin
        `CHECKX("Base Nature Rule: a derived nature is compatible with its base", CV(base_net, hi_net), 2.5);
        `CHECKX("Derived Nature Rule: two natures derived from the same base", CV(hi_net, lo_net), 1.25);
        `CHECKX("Units Value Rule: unrelated natures agreeing only on units", CV(base_net) - OV(other_net), 1.0);
        V(p) <+ 0.0;
        CI(base_net, hi_net) <+ CV(base_net, hi_net) / 2.0;
        CI(hi_net, lo_net) <+ CV(hi_net, lo_net) / 2.0;
        CI(base_net, other_net) <+ (CV(base_net) - OV(other_net)) / 2.0;
    end
endmodule
