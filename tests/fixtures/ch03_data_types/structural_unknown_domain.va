// Host-only resolved-domain observation. No behavioral reference decides the
// domain of the wire joining the two otherwise unused instance ports.
module structural_unknown_leaf(link);
    inout link;
    wire link;
endmodule
module structural_unknown_domain;
    wire link;
    structural_unknown_leaf a(link);
    structural_unknown_leaf b(link);
endmodule
