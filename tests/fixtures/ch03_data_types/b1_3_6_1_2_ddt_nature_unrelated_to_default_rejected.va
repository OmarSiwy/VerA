// §3.6.1.2, ddt_nature:
//
//   "The ddt_nature attribute is optional; the default value is the nature
//    itself. While it is possible to override the parent's value of ddt_nature
//    using a derived nature, the nature thus specified shall be related (share
//    the same base nature) to the nature the parent uses for its ddt_nature."
//
// b1_dvolt gives no ddt_nature, so the nature it uses is the default, b1_dvolt
// itself. Its derived nature b1_dvolt_child overrides it with b1_dcur, a base
// nature of its own: base b1_dcur is not base b1_dvolt. This file is
// b1_3_6_1_2_ddt_nature_names_and_overrides.va with that one override changed
// from b1_dvolt_fine (derived from b1_dvolt, legal).
//
//! lrm 3.6.1.2
//! lrm 3.6.1.2:9
//! reject-only ddt_nature
//! neighbour b1_3_6_1_2_ddt_nature_names_and_overrides.va
`include "check.vh"
nature b1_dcur;
    units = "A";
    access = B1Id;
    abstol = 1p;
endnature

nature b1_dcur_fine : b1_dcur;
    abstol = 1f;
endnature

nature b1_dchg;
    units = "coul";
    access = B1Qd;
    abstol = 1f;
    ddt_nature = b1_dcur;
endnature

nature b1_dchg_child : b1_dchg;
    ddt_nature = b1_dcur_fine;
endnature

nature b1_dself;
    units = "Wb";
    access = B1Phd;
    abstol = 1n;
    ddt_nature = b1_dself;
endnature

nature b1_dvolt;
    units = "V";
    access = B1Vd;
    abstol = 1u;
endnature

nature b1_dvolt_fine : b1_dvolt;
    abstol = 1n;
endnature

nature b1_dvolt_child : b1_dvolt;
    ddt_nature = b1_dcur;
endnature

discipline b1_ddt_disc;
    potential b1_dvolt_child;
    flow b1_dcur;
enddiscipline

module b1_ddt_nature_overrides(p, n);
    inout p, n;
    b1_ddt_disc p, n;

    analog begin
        `CHECKX("the derived potential nature reads through its parent's access", B1Vd(p, n), 1.5);
        `CHECKX("ddt() with no tolerance is zero in DC", ddt(B1Vd(p, n)), 0.0);
        B1Id(p, n) <+ B1Vd(p, n) / 2.0;
    end
endmodule
