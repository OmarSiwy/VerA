// §3.3 string declarations, from the LRM's own two lines:
//
//     parameter string default_name = "John Smith";
//     string myName = default_name;
//
// with `empty_name` added for the default the same clause fixes: "If an initial
// value is not specified in the declaration, the variable is initialized to "",
// the empty string. An empty string has zero length."
//
// Those are the two decidable facts here, and the file used to state neither —
// it declared all three names, read none of them, and had no ports, so it could
// not run at all. `==` on strings yields 1 when they are equal and 0 otherwise
// (Table 3-3), so each verdict is an integer operand and never a branch.
//
// The negative pair matters: an implementation that initialised an unset string
// to something non-empty, or that left `my_name` unset instead of copying the
// parameter, would still pass the two positive lines if `==` always returned 1.
//
//! lrm 3.3
//! lrm 3.3:1002
`include "check.vh"
module ch03_string_variables(p);
    inout p;
    electrical p;
    parameter string default_name = "John Smith";
    string empty_name;
    string my_name = default_name;

    analog begin
        `CHECKI("an uninitialised string is the empty string", (empty_name == ""), 1);
        `CHECKI("an uninitialised string is not the initialised one", (empty_name == my_name), 0);
        `CHECKI("a string parameter initialises a string variable", (my_name == "John Smith"), 1);
        I(p) <+ 0.0 * V(p);
    end
endmodule
