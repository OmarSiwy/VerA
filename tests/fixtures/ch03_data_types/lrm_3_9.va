// §3.9: "For analog primitives, the discipline will be defined by the attribute
// port_discipline on that instance. If no attribute is found then it will acquire
// the discipline of other compatible continuous disciplines connected to that net
// segment. If no disciplines are connected to that net, then the default
// discipline is set to electrical."
//
// An analog primitive on a net with no explicit discipline bindings acquires the
// electrical discipline by default, enabling its ports to be accessed.
//
//! lrm 3.9
//! bias V(p) = 1.5
`include "check.vh"
module lrm_3_9(p, n);
    inout p, n;
    electrical p, n;
    analog begin
        `CHECKX("an analog primitive defaults to electrical discipline", V(p, n), 1.5);
        I(p, n) <+ 0.0;
    end
endmodule
