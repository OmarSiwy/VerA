// §3.6.1.3: "the value being assigned to the attribute shall be CONSTANT."
// §3.6.1.2 says the same of every attribute: "Attribute declaration assigns a
// constant expression to the attribute name."
//
// `maxval` is given `runtime_limit`, which is not a constant expression — it is
// not a literal, not a parameter, and not any identifier this file declares at
// all. A nature lives at source-text level (§3.13.1), outside every module, so
// there is no scope in which a variable could be in scope here even in
// principle.
//
// Mirror of duplicate_user_attribute.va: same clause, other half of the
// sentence, separate check.
//
// Pin E0340, verified at the offending attribute, rather than accepting an
// unrelated failed compilation phase.
//
//! lrm 3.6.1.3
//! lrm 3.6.1.2
//! lrm 3.6.1.3:1
//! reject-only E0340
//! neighbour nature_declarations.va
nature ch3_nonconst_attr; units="V"; access=NonConstV; abstol=1u; maxval=runtime_limit; endnature
module ch3_nonconstant_user_attribute; endmodule
