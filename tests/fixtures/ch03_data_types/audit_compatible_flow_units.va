// AMS 3.11.1 Units Value Rule applies to flow natures as well as potentials.
// This independent base nature has a distinct access name but units "A",
// matching Current. Both potential bindings are Voltage, so V(p,other) is a
// legal shared access and the different flow bases must not cause rejection.
// Prescribed potentials 1.5 and 0.25 give 1.25; reversed order gives -1.25.
//! lrm 3.11
//! lrm 3.11.1
//! lrm 3.11.1:2
//! bias V(p) = 1.5, V(other) = 0.25
//! checks 2
`include "check.vh"
nature audit_compatible_flow;
  units="A"; access=OtherCurrent; abstol=1p;
endnature
discipline audit_compatible_flow_disc;
  potential Voltage;
  flow audit_compatible_flow;
enddiscipline
module audit_compatible_flow_units(p);
  inout p;
  electrical p;
  audit_compatible_flow_disc other;
  analog begin
    `CHECKX("flow units permit compatible potential access", V(p,other), 1.25);
    `CHECKX("compatibility permits reversed access", V(other,p), -1.25);
  end
endmodule
