// §3.2 integer and real variable declarations, each with a declaration
// initializer. §3.2 says an integer assigned in an analog context otherwise
// starts at 0 and a real starts at 0.0, so the initializer is the only thing
// standing between `count` and zero.
//
// The product pins §4.2.1.3: one real operand makes the whole expression real,
// so 3 * 2.5 is 7.5 and not the 7 an integer-typed product would give.
//! lrm 3.2
//! lrm 4.2.1.3
//! lrm 4.2.1.3:1000
`include "check.vh"
module ch03_integer_real_variables(p, n);
    inout p, n;
    electrical p, n;
    integer count = 3;
    real gain = 2.5;

    analog begin
        `CHECKI("integer variable keeps its declaration initializer", count, 3);
        `CHECKX("real variable keeps its declaration initializer", gain, 2.5);
        `CHECKX("integer * real promotes to real", count * gain, 7.5);
        I(p, n) <+ count * gain * V(p, n);
    end
endmodule
