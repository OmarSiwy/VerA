// §3.3: "Verilog-AMS provides a set of operators that can be used to
// manipulate combinations of string variables and string literals. The basic
// operators defined on the string data type are listed in Table 3-3." Table 3-3
// lists ==, !=, the four relational operators, concatenation and replication.
// There is no arithmetic operator in it.
//
// §3.4 draws the same line for parameters: "It shall be an error to assign a
// numeric value to a parameter declared as string or to assign a string value
// to a real parameter."
//
// `s + 1` below adds an integer to a string parameter. The legal string
// operations are 03_string_variables.va and audit_string_comparison_context.va.
//
//! lrm 3.3
//! reject-only E0321
//! neighbour 03_string_variables.va
//! neighbour audit_string_comparison_context.va
`include "disciplines.vams"
module ch3_string_arithmetic(p, n);
  inout p, n; electrical p, n;
  parameter string s = "ab";
  analog I(p, n) <+ (s + 1) * V(p, n);
endmodule
