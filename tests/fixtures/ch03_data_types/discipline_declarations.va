// §3.6.2 discipline declarations. A conservative discipline binds a potential
// nature and a flow nature, and §3.6.1.2 says the nature's `access` attribute
// is what names the access function — so a net declared `ch03_conservative`
// is read with Vx() and driven with Ix() for no reason other than that the two
// natures above say `access = Vx` and `access = Ix`.
//
// WHY Vx AND Ix (reconciler, 2026-10-08). An earlier revision wrote `access = V`
// and `access = I`. Both natures here are BASE natures (no `: parent`), and the
// standard definitions this file relies on for `electrical` already declare the
// base natures Voltage (access V) and Current (access I); §3.13.2: "the access
// function of each base nature shall be unique". Names no other nature uses
// keep the rule and make the claim sharper: a compiler that ignored the access
// attribute and fell back to V/I cannot read these nets at all.
//
// `c1`/`c2` are nets of the user-declared discipline, biased 2.5 V and 0.5 V,
// so the potential access function must return their difference.
//
// §3.6.2.1: "A signal-flow discipline may specify either the potential or the
// flow nature." `sf` is a net of the potential-only discipline, which makes it a
// signal-flow net with exactly ONE access function — the same `Vx`, because the
// same nature is bound — and no flow at all. Biased at 1.25 V it reads 1.25, and
// a compiler that required every net to be conservative cannot compile it.
// flow_on_potential_only_net.va is the error side of that one-access-function
// claim.
// The flow-only declaration is also instantiated: its source retains 0.125 A.
// The conservative net's actual Ix flow separately checks its second binding.
//
//! lrm 3.6.2
//! lrm 3.6.2.1
//! lrm 3.6.2.1:2
//! lrm 3.6.1.2
//! lrm 1.3.3
//! lrm 1.3.4
//! lrm 1.3.4:1
//! lrm 3.6.2:1
//! lrm 3.6.2.2
//! lrm 3.6.2.2:1
//! lrm 3.6.3:1
//! lrm 3.13.2
//! bias c1 = 2.5, c2 = 0.5, sf = 1.25
//! checks 4
`include "check.vh"
nature ch03_potential;
    units = "V";
    access = Vx;
    abstol = 1u;
endnature

nature ch03_flow;
    units = "A";
    access = Ix;
    abstol = 1p;
endnature

discipline ch03_conservative;
    domain continuous;
    potential ch03_potential;
    flow ch03_flow;
enddiscipline

discipline ch03_potential_only;
    potential ch03_potential;
enddiscipline

discipline ch03_flow_only;
    flow ch03_flow;
enddiscipline

module ch03_discipline_declarations(p, n);
    inout p, n;
    electrical p, n;
    ch03_conservative c1, c2;
    ch03_potential_only sf;
    ch03_flow_only flow_sf;

    analog begin
        `CHECKX("the bound potential nature's access function reads the branch", Vx(c1, c2), 2.0);
        `CHECKX("a signal-flow net has the potential access function of its one nature", Vx(sf), 1.25);
        I(p, n) <+ V(p, n);
        Ix(c1, c2) <+ 0.001 * Vx(c1, c2);
        Vx(sf) <+ 1.25;
        Ix(flow_sf) <+ 0.125;
        `CHECKX("a conservative net retains the flow of its second nature", Ix(c1, c2), 0.002);
        `CHECKX("a flow-only discipline supplies its one access function", Ix(flow_sf), 0.125);
    end
endmodule
