// §3.9: "For digital primitives the domain is discrete and thus the discipline
// is set via the default_discipline directive as it is for digital modules. If
// the discipline of digital connections (vpiLoConn) to a mixed net are unknown
// then the default_discipline must be specified (via the directive or other
// vendor specific method). If not specified, an error will result during
// discipline resolution."
//
// The `and` gate is a digital primitive, so each of its terminals is a
// discrete connection. Its output terminal `p` is declared `electrical`, a
// continuous discipline, so `p` joins a continuous and a discrete connection:
// it is a mixed net. Nothing in this text stream sets `default_discipline, and
// VerA has no vendor-specific method, so the discipline of the gate's
// connection to `p` is unknown — the case the last sentence makes an error.
//
// The two inputs `a` and `b` are discipline-less wires: connected to nothing
// continuous, they are not mixed nets and contribute nothing to the verdict.
// The analog block is legal on its own. So the one thing wrong with the file
// is the gate's connection to `p`, and E0960 names exactly that.
//
// The legal counterpart puts `` `default_discipline logic `` (a discrete
// discipline, §3.8) before the gate and a connect statement for the
// logic/electrical pair (§3.11's Signal Domain Rule) — see
// ch08_scheduling/switch_primitive_accepted.va, which does both for a `tran`.
//
//! lrm 3.9
//! lrm 3.9:2
//! reject-only E0960
//! neighbour digital_primitive_on_mixed_net_with_default_discipline.va
`include "disciplines.vams"
module ch3_digital_primitive_on_mixed_net(p, n);
    inout p, n;
    electrical p, n;
    wire a, b;
    and g1(p, a, b);
    analog I(p, n) <+ V(p, n);
endmodule
