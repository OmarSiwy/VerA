// §3.6.3.2: "Nets with continuous disciplines are allowed to have initializers
// on their net discipline declarations", with `electrical a = 5.0;` as the
// first example. Syntax 3-6 spells the form as a net_decl_assignment.
//
// What the initializer means is the other half of the clause: it "will be used
// as a NODESET VALUE for the potential of the net by the analog solver" — an
// initial guess, not a value. So the thing to assert is that the net is an
// ordinary net: it takes the potential the rest of the circuit gives it and is
// NOT clamped to 5.0. Asserting V(node) == 5.0 would pin the opposite of what
// §3.6.3.2 says.
//
// node sits between p at 3.0 and n at 0.0 and is held at 2.0, so both branch
// potentials are exact and nonzero, and 5.0 appears nowhere in the answers.
// This is a prescribed-bias evaluation, not a solved operating point: the
// imposed node=2.0 does not satisfy this equal-resistor divider's free-node KCL.
// audit_nodeset_unclamped_solution.va owns the independent solved-node claim.
//
//! lrm 3.6.3.2
//! lrm 3.6.3.2:1
//! bias V(p) = 3.0, V(node) = 2.0, V(n) = 0.0
`include "check.vh"
module ch03_net_nodeset(p, n);
    inout p, n;
    electrical p, n;
    electrical node = 5.0;

    analog begin
        `CHECKX("the initializer is a solver hint, not a clamp on the net", V(node), 2.0);
        `CHECKX("the net carries an ordinary branch potential above it", V(p, node), 1.0);
        `CHECKX("and below it", V(node, n), 2.0);
        I(p, node) <+ V(p, node) / 1000.0;
        I(node, n) <+ V(node, n) / 1000.0;
    end
endmodule
