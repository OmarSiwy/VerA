// §3.6.3.2 specifies a constant-array nodeset initializer for an analog
// bus and says a null element supplies no nodeset for that element. Its
// printed example contains an empty array element. That prose and example
// are the authority here; no invented Annex A grammar path is needed.
//
// This is a regression for the testbench's Newton initialization policy,
// not a portable requirement for which root every solver must select.
// All elements carry f(V)=(V-1)(V-2)(V-3), with derivative 3V^2-12V+11.
// The declared 2.75 V seed makes n[0] converge to 3 V. The null for n[1]
// leaves the runner's cold start at 0 V, which converges to 1 V. The 1e-9
// tolerance separates these roots while allowing numerical convergence.
// The explicit zero on n[2] also reaches 1 V with this runner.
//
// This fixture distinguishes a dropped initializer or copying n[0]'s seed
// into n[1]. It cannot distinguish a null from an explicit zero initializer
// under this runner's cold-start policy. nodeset_metadata_host.zig also runs
// this emitted device: it chooses a 7 V fallback and observes that n[1]
// retains it while n[2] is seeded to zero. Three assertions at one DC point
// give three CHECK verdicts here; the host separately checks the metadata.
//
//! lrm 3.6.3.2
//! bias V(g) = 0.0
//! solve
//! print none
//! checks 3
`include "check.vh"
module a08_nodeset_bus_null(g);
    inout g;
    electrical g;
    // The null element is the second one: `n[1]` is being told nothing.
    electrical [0:2] n = '{2.75, , 0.0};

    analog begin
        `CHECK("the initialized bus element is seeded, so it takes the high root", V(n[0], g), 3.0, 1e-9);
        `CHECK("the null element is told nothing and takes the cold-start root", V(n[1], g), 1.0, 1e-9);
        `CHECK("an explicit zero nodeset takes the same cold-start root", V(n[2], g), 1.0, 1e-9);
        I(n[0], g) <+ (V(n[0], g) - 1.0) * (V(n[0], g) - 2.0) * (V(n[0], g) - 3.0);
        I(n[1], g) <+ (V(n[1], g) - 1.0) * (V(n[1], g) - 2.0) * (V(n[1], g) - 3.0);
        I(n[2], g) <+ (V(n[2], g) - 1.0) * (V(n[2], g) - 2.0) * (V(n[2], g) - 3.0);
    end
endmodule
