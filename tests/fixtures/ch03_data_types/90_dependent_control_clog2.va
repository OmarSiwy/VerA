// §6.3.4: a parameter default may depend on another parameter, and "an update
// of [the base], whether by a defparam statement or in an instantiation
// statement ..., automatically updates [the dependent]". §9.12.1 / IEEE 1364
// §17.11.1 make `$clog2` a constant system function: "the ceiling of the log
// base 2 of the argument ... an argument value of 0 shall produce a result of 0".
//
// So `size` is legal and follows `amount`:
//
//   amount = 2 (declared)    $clog2(2) = 1
//   amount = 5 (//! param)   $clog2(5) = 3    (2^2 = 4 < 5 <= 8 = 2^3)
//
// The override is what makes this a §6.3.4 claim rather than a fold: a device
// that froze `size` at its declared-default value reads 1 at the override.
//
//! lrm 6.3.4
//! lrm 6.3.4:1000
//! param amount = 5
`include "check.vh"
module dependent_control_unsupported(p);
  inout p; electrical p;
  parameter integer amount = 2;
  localparam integer size = $clog2(amount);
  analog begin
    `CHECKI("§6.3.4 size follows the overridden amount: $clog2(5)", size, 3);
    I(p) <+ V(p);
  end
endmodule
