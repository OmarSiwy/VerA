// Resolved semantic behavior is observed by tests/host.py.
// §3.6.1.2, idt_nature: "If specified, the constant expression assigned to
// idt_nature shall be the name (not a string) of a nature which is defined
// elsewhere. It is possible for a nature to be self-referencing with respect to
// its idt_nature attribute. In other words, the value of idt_nature can be the
// nature that the attribute itself is associated with."
//
// `ch3_idt_self` names ITSELF as its idt_nature, which that paragraph
// explicitly permits, and the point of the attribute is that "if this operator
// is applied directly on nets, the tolerance can be taken from the node, which
// eliminates the need to give a tolerance with the operator" — so `idt()` is
// written here with no tolerance argument at all.
//
// The value asserted is not the tolerance, which the LRM leaves to the
// implementation. It is §4.5.4's DC rule: "When used in DC or IC analyses, idt()
// returns the initial condition (ic) if specified." The default analysis is DC,
// the initial condition is written as the literal 3.5, so the operator's value
// here is fixed by the LRM to the last bit.
//
//! lrm 4.5.4
//! lrm 3.6.1.2:4
//! bias SelfP = 2.0, SelfN = 0.5
`include "check.vh"
nature ch3_idt_self; units="V"; access=SelfV; abstol=1u; idt_nature=ch3_idt_self; endnature
nature ch3_idt_self_flow; units="A"; access=SelfI; abstol=1p; endnature

discipline ch3_idt_self_disc;
    potential ch3_idt_self;
    flow ch3_idt_self_flow;
enddiscipline

module ch3_idt_nature_self_reference(SelfP, SelfN);
    inout SelfP, SelfN;
    ch3_idt_self_disc SelfP, SelfN;

    analog begin
        `CHECKX("the self-referencing nature still names its own access function", SelfV(SelfP, SelfN), 1.5);
        `CHECKX("idt() with no tolerance argument returns its ic in DC", idt(SelfV(SelfP, SelfN), 3.5), 3.5);
        SelfI(SelfP, SelfN) <+ SelfV(SelfP, SelfN) / 2.0;
    end
endmodule
