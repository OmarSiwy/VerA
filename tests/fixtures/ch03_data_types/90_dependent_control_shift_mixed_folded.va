// The all-constant twin of 90_dependent_control_shift_mixed.va, so constant
// folding meets the same VAMS §4.2.9 rule: "When one or both operands are
// unsigned, the expression shall be interpreted as a comparison between
// unsigned values." 32'h1 is unsigned, so the comparison is unsigned, and the
// 32-bit operand -1 >> 0 = 32'hFFFF_FFFF is read as that unsigned value (IEEE
// 1364 §5.5's context propagation is the digital context's rule, and agrees
// here):
//
//   1 < 32'hFFFF_FFFF  ->  mixed = 1.
//
// A fold over the signed carrier gives 1 < -1 = 0.
//
//! lrm 4.2.9
//! lrm 4.2.11
//! lrm 4.2.9:1
`include "check.vh"
module dependent_control_shift_mixed_folded(p);
  inout p; electrical p;
  localparam integer mixed = 32'h1 < (-1 >> 0);
  analog begin
    `CHECKI("unsigned context: 32'h1 < (-1 >> 0)", mixed, 1);
    I(p) <+ V(p);
  end
endmodule
