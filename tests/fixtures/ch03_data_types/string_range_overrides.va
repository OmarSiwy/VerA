// Final instance values, not unused model defaults, are checked against sets.
//! lrm 3.4.2
//! lrm 6.3
//! lrm 3.4.2:2
//! lrm 3.4.2:3
//! lrm 6.3.3
//! lrm 6.3.3:1
`include "check.vh"
module string_range_target(p);
    inout p;
    electrical p;
    parameter string kind = "unused" from '{"NPN"} from '{"PNP"} exclude '{""};
    parameter string filename = "" exclude '{"", "bad.dat"};
    analog begin
        `CHECKI("second inclusion set accepts the override", kind == "PNP", 1);
        `CHECKI("exclude-only set accepts a different value", filename == "result.dat", 1);
        I(p) <+ 0.0;
    end
endmodule
module ch03_string_range_overrides(p);
    inout p;
    electrical p;
    string_range_target #(.kind("PNP"), .filename("result.dat")) u(p);
endmodule
