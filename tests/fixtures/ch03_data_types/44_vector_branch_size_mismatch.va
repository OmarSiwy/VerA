// §3.12: "If one of the terminals of a branch is a vector net, then the other
// terminal shall either be a scalar net or a vector net of the same size."
//
// `a` is size 4 and `b` is size 2, and neither is scalar, so there is no
// one-to-one pairing (Figure 3-1) and no vector-to-scalar fan-in (Figure 3-2)
// that this declaration could mean. It is an error.
//
// 33_vector_branches.va is the legal side of the same rule: [3:5] against
// [1:3], both size 3.
//
// The pinned substring is deliberately only the phase label, and it stays that
// way now that the rule is genuinely checked (E0353). A code here would be
// VerA's, and this file's claim is the LRM's: any conforming compiler must
// produce SOME diagnostic. It used to carry the same line for the opposite
// reason — the parser refused the net range itself, at E0208, long before
// anything compared two terminal sizes — so what changed is only that the
// weak pin is now weak on purpose rather than by necessity.
//
//! lrm 3.12
//! reject DiagnosticsReported
module ch3_vector_branch_size_mismatch(a, b);
    inout a, b;
    electrical [3:0] a;
    electrical [1:0] b;
    branch (a, b) bad;

    analog begin
        I(bad[0]) <+ V(bad[0]) / 1000.0;
    end
endmodule
