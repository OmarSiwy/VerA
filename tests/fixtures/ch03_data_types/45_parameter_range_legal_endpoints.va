// §3.4.2 endpoint semantics, on the LRM's own range:
//
//     parameter real val3=0 from [0:inf) exclude (10:20) exclude (30:40];
//
// "Brackets, [ and ], indicate inclusion of the end points in the value range.
// Parentheses, ( and ), indicate exclusion of the end points from the value
// range." Four of that range's endpoints are therefore LEGAL values and are
// decided by that sentence alone, with no arithmetic:
//
//     0   included    — `[0` is a closed lower bound
//     10  included    — `(10:20)` excludes the interior, not the endpoint
//     20  included    — `20)` is an open upper bound of the excluded interval
//     30  included    — `(30` is an open lower bound of the excluded interval
//
// (40 is excluded by `40]` and 15 lies inside `(10:20)`; those are the sibling
// reject fixtures.) 05_parameter_ranges.va asserts only that the DEFAULTS
// survive their suffixes, so a compiler that parses the range and throws it
// away passes it; here the value comes from an override, which §3.4.2 says is
// the value that gets checked: "Range checking applies to the value of the
// parameter for the instance and not against the default values specified in
// the device."
//
// Each parameter defaults to 5 — legal, and in none of the four holes — so every
// assertion below fails if the override did not land, and fails differently if
// the compiler wrongly rejected the endpoint.
//
//! param at_lower_bound = 0
//! param at_excluded_open_low = 10
//! param at_excluded_open_high = 20
//! param at_second_excluded_open_low = 30
//! lrm 3.4.2
//! lrm 3.4.2:1001
`include "check.vh"
module ch03_parameter_range_legal_endpoints(p, n);
    inout p, n;
    electrical p, n;
    parameter real at_lower_bound = 5 from [0:inf) exclude (10:20) exclude (30:40];
    parameter real at_excluded_open_low = 5 from [0:inf) exclude (10:20) exclude (30:40];
    parameter real at_excluded_open_high = 5 from [0:inf) exclude (10:20) exclude (30:40];
    parameter real at_second_excluded_open_low = 5 from [0:inf) exclude (10:20) exclude (30:40];

    analog begin
        `CHECKX("`[0` includes its endpoint", at_lower_bound, 0.0);
        `CHECKX("`exclude (10:20)` does not exclude 10", at_excluded_open_low, 10.0);
        `CHECKX("`exclude (10:20)` does not exclude 20", at_excluded_open_high, 20.0);
        `CHECKX("`exclude (30:40]` does not exclude 30", at_second_excluded_open_low, 30.0);
        I(p, n) <+ (at_lower_bound + at_excluded_open_low + at_excluded_open_high + at_second_excluded_open_low) * V(p, n);
    end
endmodule
