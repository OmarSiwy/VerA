// §3.3 Table 3-3: a replication of a string repeats it count times. VerA folds
// a constant one when the model compiles, up to E1011's 4096 bytes
// (specification/Vague_Decisions.md; string_replication_over_4096_bytes_rejected.va is
// the byte past it).
//
// HAND DERIVATION. {4096{"x"}} is 4096 copies of "x". Compared with the same
// text built as {64{s}} where s is {64{"x"}}, 64 * 64 = 4096 copies: equal.
//
//! lrm 3.3
//! bias V(p) = 0
`include "check.vh"
module string_replication_4096_bytes(p, n);
  inout p, n; electrical p, n;
  string s, t, u;
  analog begin
    s = {64{"x"}};
    t = {64{s}};
    u = {4096{"x"}};
    `CHECKI("4096 folded copies equal 64 copies of 64", t == u, 1);
    I(p, n) <+ V(p, n);
  end
endmodule
