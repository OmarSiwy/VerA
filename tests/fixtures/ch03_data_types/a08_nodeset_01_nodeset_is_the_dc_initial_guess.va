// §3.6.3.2 makes the initializer a nodeset value for the analog solver.
// This is a regression for the testbench's Newton initialization policy,
// not a requirement that every conforming solver select the same final root.
// The separate audit_nodeset_unclamped_solution.va checks a unique solution
// that differs from the nodeset, so the initializer cannot act as a clamp.
//
// HAND DERIVATION. The cubic current is f(V)=(V-1)(V-2)(V-3), with roots
// 1, 2 and 3. Its derivative is 3V^2-12V+11. The testbench starts Newton
// at the declared 2.75 V and repeatedly applies V <- V-f(V)/f'(V), reaching
// the 3 V root. A cold start at 0 V reaches 1 V; clamping the initializer
// would retain 2.75 V. These are distinct outcomes for this solver policy.
//
// The seed 2.75 is 11/4, exactly representable in binary. The 1e-9 tolerance
// allows numerical convergence while separating the candidate outcomes.
// The generated u_nodeset table supplies the initial value to the runner.
//
//! lrm 3.6.3.2
//! lrm 3.6.3.2:1
//! bias V(g) = 0.0
//! solve
//! print none
`include "check.vh"
module a08_nodeset_initial_guess(p, g);
    inout p, g;
    electrical g;
    // §3.6.3.2's own first example shape: `electrical a = 5.0;`.
    electrical p = 2.75;

    analog begin
        `CHECK("the nodeset seeds Newton, so it lands on the high root", V(p, g), 3.0, 1e-9);
        I(p, g) <+ (V(p, g) - 1.0) * (V(p, g) - 2.0) * (V(p, g) - 3.0);
    end
endmodule
