// §3.3 Table 3-3 concatenation: with at least one operand of type string the
// expression evaluates to the concatenated string, operands in written order.
// So {"hello", " ", "world"} is "hello world" — the middle literal is an
// operand like any other, not a separator the compiler may drop.
//! lrm 3.3
//! lrm 3.3:3
`include "check.vh"
module ch3_string_concat(p);
  inout p;
  electrical p;
  string a = "hello", b = "world", c;
  analog begin
    c = {a, " ", b};
    `CHECKI("operands concatenate in written order", (c == "hello world"), 1);
    `CHECKI("the interior literal is not dropped", (c == "helloworld"), 0);
    I(p) <+ 0.0 * V(p);
  end
endmodule
