// Resolved semantic behavior is observed by tests/host.py.
// §3.6.2.4: "It is possible for a module to have nets where there are no
// discipline declarations. ... If it is referenced in behavioral code, then it
// must have a net type. In these cases, the net shall be treated as having no
// discipline. If the net is referenced in behavioral code, then it shall be
// treated as having no discipline with a domain binding of discrete".
//
// `w` is declared `wire` and nothing else: a net type, no discipline. It is
// referenced in behavioral code (the `always` block, and the analog block's
// bare read), so it is a discrete net with no discipline. Being discrete is
// what makes each line below legal: a continuous net could be neither the
// target of `assign` (§7.2.3) nor read bare (a continuous net is read through
// an access function, §3.6.3), while §7.3.1 Table 7-1 lists `wire w1;` as a
// discrete bit read as an integer in the continuous context.
//
// DERIVATION. `timescale 1ns/1ns. r is 0 at time 0 and 1 from 2 ns; `assign`
// copies it onto w. `seen` starts 0, and the always block copies w into it on
// every change of w. At time 0 both writers of `seen` write 0 (w is 0), so it
// is 0 whichever runs first; at 2 ns w rises and the always block, waiting on
// @(w) by then, writes 1. §7.3.6.5: the analog point at t reads the greatest
// digital tick <= t.
//
//     t = 0       w = 0, seen = 0
//     t = 2 ns    w = 1, seen = 1    (the solve the change forces, below)
//     t = 5 ns    w = 1, seen = 1
//
// POINTS. Three, not the two `//! time` lists: a change at 2 ns of a value the
// analog block reads forces an analog solve at that tick, after its updates
// (§8.4.7, §8.5; src/sim/mixed.zig `run`). Two checks at three points: 6.
//
//! lrm 3.6.2.4
//! lrm 3.6.2.4:3
//! lrm 3.6.2.4:4
//! lrm 3.6.2:3
//! lrm 7.3.1
//! analysis tran
//! time 0, 5n
//! checks 6
`timescale 1ns/1ns
`include "check.vh"
module b1_wire_without_discipline(out);
  inout out;
  electrical out;
  reg r;
  wire w;
  reg seen;

  assign w = r;
  initial begin
    r = 1'b0;
    #2 r = 1'b1;
  end
  initial seen = 1'b0;
  always @(w) seen = w;

  analog begin
    `CHECKI("the always block saw the discrete net's value", seen, ($abstime < 1n) ? 0 : 1);
    `CHECKI("the analog block reads the net as a discrete bit", w, ($abstime < 1n) ? 0 : 1);
    V(out) <+ seen ? 1.0 : 0.0;
  end
endmodule
