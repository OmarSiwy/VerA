// §3.3 Table 3-3, the Concatenation row: "{Str1,Str2,...,Strn} Concatenation.
// Each operand can be of type string or a string literal". An operand of type
// string need not be known when the module is compiled: here `b` takes one of
// two values according to a probe, so the concatenation has to be built while
// the device runs.
//
//   V(p) = 1.0 > 0.5, so b = "world" (not "there")
//   {a, " ", b}        = "hello world"
//   {b, b}             = "worldworld"      (a run-time operand twice)
//   {2{b, "!"}}        = "world!world!"    (constant multiplier, run-time Str)
//
// The unequal checks name the other arm ("hello there") and the string with
// the interior literal dropped ("helloworld"), so a device that folded the
// wrong arm or skipped a constant piece between two run-time ones cannot pass.
// 27_string_concatenation.va is the all-known neighbour.
//
//! lrm 3.3
//! lrm 3.3:1
//! lrm 3.3:3
//! bias V(p) = 1.0
`include "check.vh"
module ch3_string_concatenation_runtime_operand(p);
    inout p;
    electrical p;
    string a, b, c;

    analog begin
        a = "hello";
        if (V(p) > 0.5) b = "world"; else b = "there";
        c = {a, " ", b};
        `CHECKI("a probe-dependent operand concatenates in written order", (c == "hello world"), 1);
        `CHECKI("and not the other arm", (c == "hello there"), 0);
        `CHECKI("the interior literal is not dropped", (c == "helloworld"), 0);
        c = {b, b};
        `CHECKI("a run-time operand twice", (c == "worldworld"), 1);
        c = {2{b, "!"}};
        `CHECKI("a constant multiplier of a run-time Str", (c == "world!world!"), 1);
        I(p) <+ 0.0 * V(p);
    end
endmodule
