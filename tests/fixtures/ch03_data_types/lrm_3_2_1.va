// §3.2.1 output variables: "Module scope variables with a description or
// units attribute, or both, shall be known as output variables". A compiler
// must accept such declarations without error and make their values accessible.
//
//! lrm 3.2.1
//! lrm 3.2.1:1
//! lrm 3.2
`include "check.vh"
module ch03_output_variables(p, n);
  inout p, n;
  electrical p, n;

  (* desc="gate-source capacitance" *) real cgs;
  (* units="F" *) real cdb;
  (* desc="bulk-source capacitance", units="F" *) real cbs;

  analog begin
    cgs = 4.21e-15;
    cdb = 3.0e-15;
    cbs = 2.5e-15;
    `CHECK("output variable with description", cgs, 4.21e-15, 1e-30);
    `CHECK("output variable with units", cdb, 3.0e-15, 1e-30);
    `CHECK("output variable with both description and units", cbs, 2.5e-15, 1e-30);
    I(p, n) <+ cgs + cdb + cbs;
  end
endmodule
