// A.1.7 (Syntax 3-5 in §3.6.2):
//
//     discipline_item ::= nature_binding
//                       | discipline_domain_binding
//                       | nature_attribute_override
//     nature_binding ::= potential_or_flow nature_identifier ;
//
// Every item starts with `potential`, `flow` or `domain`. The third line of the
// body below names a nature with no binding keyword, so it binds it to
// nothing: no item of the production starts with a bare nature identifier.
//
// (VerA also accepts `name = value;` here, for §3.6.2.7's user-defined
// attributes. That is not this line's shape: there is no `=`.)
//
//! lrm 3.6.2
//! lrm A.1.7
//! lrm 3.6.2:1
//! lrm A.1.7:1000
//! reject-only E0213
//! neighbour 11_discipline_declarations.va
`include "disciplines.vams"
discipline ch3_unbound_item
  potential Voltage;
  flow Current;
  Voltage;
enddiscipline
module ch3_discipline_item_needs_a_binding_keyword(p, n);
  inout p, n; electrical p, n;
  analog I(p, n) <+ V(p, n);
endmodule
