// Exact integral defaults and localparam derivation never pass through f64.
//! lrm 3.4.1
//! lrm 3.4.5
//! lrm 9.4.3
//! lrm 9.5.3
//! lrm 9.5.3:1
`include "check.vh"
module integer_parameter_precision;
  parameter base = 64'h0020000000000001;
  parameter copy = base;
  localparam textbits = 64'h4142434445464748;
  localparam textcopy = textbits;
  localparam highbits = 64'hf123456789abcdef;
  localparam smallbits = 24'hffffff;
  localparam lowmask = highbits & 64'h00000000ffffffff;
  parameter integer narrowed = 64'hf123456789abcdef;
  localparam integer typedcopy = highbits;
  localparam equal_adjacent = 64'h0020000000000000 == 64'h0020000000000001;
  string text;
  analog begin
    `CHECKI("base preserves bit beyond f64", base, 9007199254740993);
    `CHECKI("derived copy preserves bit beyond f64", copy, 9007199254740993);
    `CHECKI("localparam text bits", textbits, 4702394921427289928);
    `CHECKI("localparam text copy", textcopy, 4702394921427289928);
    `CHECKI("high bit remains exact", highbits, -1070935975390360081);
    `CHECKI("unsigned narrow literal remains positive", smallbits, 16777215);
    `CHECKI("wide mask remains exact", lowmask, 2309737967);
    `CHECKI("declared integer truncates32", narrowed, -1985229329);
    `CHECKI("declared integer copy truncates32", typedcopy, -1985229329);
    `CHECKI("adjacent integers differ", equal_adjacent, 0);
    `CHECKI("bit conversion preserves every bit", $realtobits($bitstoreal(base)), 9007199254740993);
    $swrite(text, "%s", textcopy);
    `CHECKI("all eight ASCII bytes preserved", text == "ABCDEFGH", 1);
  end
endmodule
