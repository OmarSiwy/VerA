// §7.3.6.2 digital event appearing in an analog event control: when the event
// occurs in the digital domain, "the statements under the event control shall
// be executed in the analog domain". `posedge d` is that digital event.
//
// C.7 removes it from this dialect — "No digital behavior or events are
// supported in Verilog-A" — so refusing `posedge` inside `@()` is conformance,
// not debt. (E0704, "posedge/negedge is digital-only", is the code that names
// the rule; the parser gets there first and reports the malformed event
// expression, which is why E0209 is pinned as well.)
//
//! lrm 7.3.6.2
//! lrm C.7
//! reject E0209
module ch7_digital_event(p);
  inout p; electrical p; integer d; real held;
  analog begin
    @(posedge d) held = V(p);
    I(p) <+ held;
  end
endmodule
