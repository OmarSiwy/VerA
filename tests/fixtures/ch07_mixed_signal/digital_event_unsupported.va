// §7.3.6.2 digital event appearing in an analog event control: when the event
// occurs in the digital domain, "the statements under the event control shall
// be executed in the analog domain". `posedge d` is that digital event.
//
// C.7 removes it from this dialect — "No digital behavior or events are
// supported in Verilog-A" — so refusing `posedge` inside `@()` is conformance,
// not debt. E0704, "posedge/negedge is digital-only", is the code that NAMES
// that rule, and it is now the code that fires. It could not before: the
// parser did not parse `posedge` in an event expression at all, so recovery
// reported a malformed expression (E0209) and lowering was never reached. The
// §5.10.1 edge forms now parse for the digital domain, so the analog domain
// refuses them on the domain rule instead of on a syntax artifact.
//
//! lrm 7.3.6.2
//! lrm C.7
//! lrm 7.3.4
//! reject E0704
module ch7_digital_event(p);
  inout p; electrical p; integer d; real held;
  analog begin
    @(posedge d) held = V(p);
    I(p) <+ held;
  end
endmodule
