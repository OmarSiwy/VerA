// §7.9 Driver-receiver segregation, verbatim:
//
//   "Within digital segments of a mixed-signal net, drivers and receivers of
//    ordinary modules shall be segregated, so transitions are not propagated
//    directly from drivers to receivers, but propagate through the analog
//    domain instead. In this case, the drivers and receivers of connect modules
//    shall be oppositely segregated; i.e., the connect module drivers shall be
//    grouped with the ordinary module receivers and the ordinary module drivers
//    shall be grouped with the connect module receivers."
//
// and §9.22.6 Receiver Net Resolution, which says how a connect module exercises
// that grouping:
//
//   "Since a single digital port is used in the connect module, the user must
//    specify the value that the receivers will see. ... This assignment of the
//    receiver value is done via the assign statement in which the digital port
//    will be used to read the driver values as well as to set the receiver
//    value. ... Anything else is done explicitly, such as:
//
//      reg out; // value of out determined in CM, see example in 9.22.7
//      assign d = out;
//
//    In this case, the digital port of the connect module will drive the
//    receivers with a value determined in the connect module. This value may
//    potentially be different from the value of the drivers of the connect
//    module digital port."
//
// THE ASSERTION IS THE WORD "DIFFERENT". Segregation is only observable when
// the connect module's value and the ordinary driver's value disagree — if they
// agree, a completely unsegregated implementation prints the same transcript.
// So this connect module drives the receivers with the LOGICAL INVERSE of the
// single ordinary driver, and the ordinary receiver is asserted to read that
// inverse. An implementation that propagates the driver straight through to the
// receiver (which is the correct behaviour for a purely digital net, and is
// §9.22.6's own default) prints the complement of every line below.
//
// 14_receiver_default_bypass.va is this file's twin: the same design with the
// `assign d = out;` removed, where §9.22.6's default DOES apply and the
// receiver reads the driver. The two transcripts are exact complements, which
// is the cleanest statement that the `assign` is what selects between them.
//
// WHY THERE IS NO ANALOG NUMBER IN THE ASSERTION. §7.9 says transitions
// "propagate through the analog domain instead", and the physically faithful
// fixture would pin a receiver transition against a threshold crossing time.
// That answer depends on the load, the connect module's impedances and the
// solver's timestep, i.e. on tolerances rather than on the clause. Determining
// the receiver value digitally inside the connect module keeps the SEGREGATION
// claim and drops the numerics, so this fixture cannot be tuned into passing.
//
//! lrm 7.9
//! lrm 7.9:3
//! lrm 7.9:4
//! lrm 9.22.6
//! lrm 9.22.6:1
//! lrm 9.22.6:2
//! lrm 9.22.3
//! lrm 7.9:2
//! lrm 9.22.3:1000
//! analysis tran
//! time 0, 50n
//! checks 3
//
// WHY THE CONNECT STATEMENT IS `inout ddiscrete, inout electrical`. The
// derivation below needs ordinary INPUT ports (receivers) and OUTPUT ports
// (drivers) on ONE digital segment of an electrical net. Read with its own
// directions (`input d`, `output a`), the connect module is §7.6 Example 1's
// d2a, which "can bridge a mixed input port whose upper connection is
// compatible with discipline ddiscrete and whose lower connection is
// compatible with electrical, or a mixed output port whose upper connection is
// compatible with discipline electrical and whose lower connection is
// compatible with ddiscrete". The output ports here match; an input port under
// an electrical upper connection does not, and §7.8.4 has every mixed port
// "match one (and only one) connect statement". Figure 7-9 is the same case:
// under `merged` the ttl inputs and outputs of one electrical signal still get
// two connect modules (bidir and d2a), because §7.8.3.1 groups ports only
// "provided the module is the same". So an earlier draft of this file, which
// kept the d2a directions and assumed one segment, was wrong, and
// lib/ir/elaborate/insert.zig's matching was right. §7.7.1's direction
// override "allows a module to be used both as a unidirectional and
// bidirectional connect module"; with it the statement is Example 3's bidir,
// which "can bridge any mixed port", and `merged` gives every ddiscrete port on
// `net` one instance and one segment.
//
// HAND DERIVATION — one ordinary driver, one ordinary receiver, one merged
// connect module. §9.22.1 numbers the ordinary drivers 0..N-1 and here N is 1,
// so index 0 is the only legal index and is unambiguous.
//
//   t=0   the connect module's `initial` sets out = 1'b1.
//         the ordinary driver's reg has not been assigned: its state is 1'bx.
//   t=5   receiver samples -> 1'b1, the connect module's value.
//         This line alone rules out any propagation from the driver, since 1
//         is not reachable from x by any resolution function.
//   t=10  driver := 1'b1.  driver_update fires; out := 0 (the inverse).
//   t=20  receiver samples -> 1'b0 while the driver holds 1'b1.
//   t=30  driver := 1'b0.  driver_update fires; out := 1.
//   t=40  receiver samples -> 1'b1 while the driver holds 1'b0.
//
//   Every sample is 5 or more ticks after the assignment that determines it, so
//   no intra-timestep ordering is asserted.
//
// HOW THIS FILE ASSERTS. Each sample is a check.vh CHECKI from a digital
// `initial`, and `//! checks 3` makes the count exact: a tool that never runs
// one of the asserting processes (in a connect module it did not insert, say)
// FAILs on the count rather than passing on silence.
// CHECKI is a $strobe, which prints at the END of its time step (IEEE 1364
// §17.1), so each `$finish` is one tick after the last sample — a same-tick
// `$finish` would end the run before that strobe. The transient runs to 50 ns
// so the digital half reaches it. A receiver that reads x fails its CHECKI
// too: `x == 1` is x, and x prints as `ok=x`, which the harness counts as a
// failure. This file used to assert through
// `$display` and a `.expected.txt` transcript, which the `.va` harness never
// reads (tests/harness.zig `fixtureExt`: a golden is honoured for `.v` only), so
// it asserted nothing. How `%b` spells a 32-bit integer is a digital display
// rule and is no longer claimed here.

`timescale 1ns/1ns
`include "disciplines.vams"
`include "check.vh"

connectrules m04_seg_rules;
  connect m04_seg_c2e merged inout ddiscrete, inout electrical;
endconnectrules

connectmodule m04_seg_c2e(d, a);
  input d;
  output a;
  ddiscrete d;
  electrical a;

  reg out;

  // §9.22.6: with this statement present, the receivers see `out`, not the
  // drivers. Without it the default `assign d_receivers = d_drivers` applies.
  assign d = out;

  initial out = 1'b1;

  always @(driver_update d)
    out = ($driver_state(d, 0) === 1'b1) ? 1'b0 : 1'b1;

  analog V(a) <+ 0.0;
endmodule

module m04_seg_drv(o);
  output o;
  ddiscrete o;
  reg o;
  initial begin
    #10 o = 1'b1;
    #20 o = 1'b0;
  end
endmodule

module m04_seg_ear(i);
  input i;
  ddiscrete i;
  initial begin
    #5  `CHECKI("receiver_reads_the_connect_module_not_the_driver", i, 1);
    #15 `CHECKI("receiver_is_the_inverse_of_a_one_driver", i, 0);
    #20 `CHECKI("receiver_is_the_inverse_of_a_zero_driver", i, 1);
    #1 $finish(0);
  end
endmodule

module m04_seg_load(a);
  inout a;
  electrical a;
  electrical g;
  ground g;
  analog I(a, g) <+ V(a, g) / 1.0e3;
endmodule

module m04_seg_top;
  electrical net;

  m04_seg_drv  dr(.o(net));
  m04_seg_ear  ear(.i(net));
  m04_seg_load ld(.a(net));
endmodule
