// Verilog-AMS LRM 2.4 §7.9 Driver-receiver segregation, verbatim:
//
//   "Within digital segments of a mixed-signal net, drivers and receivers of
//    ordinary modules shall be segregated, so transitions are not propagated
//    directly from drivers to receivers, but propagate through the analog
//    domain instead. In this case, the drivers and receivers of connect modules
//    shall be oppositely segregated; i.e., the connect module drivers shall be
//    grouped with the ordinary module receivers and the ordinary module drivers
//    shall be grouped with the connect module receivers."
//
// and §9.22.5 Receiver Net Resolution, which says how a connect module exercises
// that grouping:
//
//   "Since a single digital port is used in the connect module, the user must
//    specify the value that the receivers will see. ... This assignment of the
//    receiver value is done via the assign statement in which the digital port
//    will be used to read the driver values as well as to set the receiver
//    value. ... Anything else is done explicitly, such as:
//
//      reg out; // value of out determined in CM, see example in 9.22.6
//      assign d = out;
//
//    In this case, the digital port of the connect module will drive the
//    receivers with a value determined in the connect module. This value may
//    potentially be different from the value of the drivers of the connect
//    module digital port."
//
// THE ASSERTION IS THE WORD "DIFFERENT". Segregation is only observable when
// the connect module's value and the ordinary driver's value disagree — if they
// agree, a completely unsegregated implementation prints the same transcript.
// So this connect module drives the receivers with the LOGICAL INVERSE of the
// single ordinary driver, and the ordinary receiver is asserted to read that
// inverse. An implementation that propagates the driver straight through to the
// receiver (which is the correct behaviour for a purely digital net, and is
// §9.22.5's own default) prints the complement of every line below.
//
// 14_receiver_default_bypass.va is this file's twin: the same design with the
// `assign d = out;` removed, where §9.22.5's default DOES apply and the
// receiver reads the driver. The two transcripts are exact complements, which
// is the cleanest statement that the `assign` is what selects between them.
//
// WHY THERE IS NO ANALOG NUMBER IN THE ASSERTION. §7.9 says transitions
// "propagate through the analog domain instead", and the physically faithful
// fixture would pin a receiver transition against a threshold crossing time.
// That answer depends on the load, the connect module's impedances and the
// solver's timestep, i.e. on tolerances rather than on the clause. Determining
// the receiver value digitally inside the connect module keeps the SEGREGATION
// claim and drops the numerics, so this fixture cannot be tuned into passing.
//
//! lrm 7.9
//! lrm 9.22.5
//! lrm 9.22.2
//! timescale 1ns/1ns
//
// HAND DERIVATION — one ordinary driver, one ordinary receiver, one merged
// connect module. §9.22.1 numbers the ordinary drivers 0..N-1 and here N is 1,
// so index 0 is the only legal index and is unambiguous.
//
//   t=0   the connect module's `initial` sets out = 1'b1.
//         the ordinary driver's reg has not been assigned: its state is 1'bx.
//   t=5   receiver samples -> 1'b1, the connect module's value.
//         This line alone rules out any propagation from the driver, since 1
//         is not reachable from x by any resolution function.
//   t=10  driver := 1'b1.  driver_update fires; out := 0 (the inverse).
//   t=20  receiver samples -> 1'b0 while the driver holds 1'b1.
//   t=30  driver := 1'b0.  driver_update fires; out := 1.
//   t=40  receiver samples -> 1'b1 while the driver holds 1'b0.
//
//   Every sample is 5 or more ticks after the assignment that determines it, so
//   no intra-timestep ordering is asserted.

`timescale 1ns/1ns
`include "disciplines.vams"

connectrules m04_seg_rules;
  connect m04_seg_c2e merged input ddiscrete, output electrical;
endconnectrules

connectmodule m04_seg_c2e(d, a);
  input d;
  output a;
  ddiscrete d;
  electrical a;

  reg out;

  // §9.22.5: with this statement present, the receivers see `out`, not the
  // drivers. Without it the default `assign d_receivers = d_drivers` applies.
  assign d = out;

  initial out = 1'b1;

  always @(driver_update d)
    out = ($driver_state(d, 0) === 1'b1) ? 1'b0 : 1'b1;

  analog V(a) <+ 0.0;
endmodule

module m04_seg_drv(o);
  output o;
  ddiscrete o;
  reg o;
  initial begin
    #10 o = 1'b1;
    #20 o = 1'b0;
  end
endmodule

module m04_seg_ear(i);
  input i;
  ddiscrete i;
  initial begin
    #5  $display("receiver_reads_the_connect_module_not_the_driver %b", i);
    #15 $display("receiver_is_the_inverse_of_a_one_driver %b", i);
    #20 $display("receiver_is_the_inverse_of_a_zero_driver %b", i);
    $finish(0);
  end
endmodule

module m04_seg_load(a);
  inout a;
  electrical a;
  electrical g;
  ground g;
  analog I(a, g) <+ V(a, g) / 1.0e3;
endmodule

module m04_seg_top;
  electrical net;

  m04_seg_drv  dr(.o(net));
  m04_seg_ear  ear(.i(net));
  m04_seg_load ld(.a(net));
endmodule
