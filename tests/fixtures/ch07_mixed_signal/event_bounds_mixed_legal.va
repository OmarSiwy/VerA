// §5.10.3.1 requires both tolerances when expr_tol is supplied, but allows
// both to be omitted before enable. §5.10.3.4 permits non-negative delta and
// tolerances, and requires an integral enable. Its events include "During
// initialization or dc sweep analysis"; delta = 0 additionally samples every
// timestep at which the expression changes. With delta = 0, supplied
// tolerances "will have no effect and be ignored".
//
// DERIVATION: V(p) rises -1 -> 0.5 -> 1 V, so each digital cross monitor
// fires once. V(ref) stays 2 V, so its positive-delta absdelta monitor fires
// exactly once, during initialization, and samples 2 V. The zero-delta
// monitor follows V(p), so its final sample is 1 V. Its delta and enable
// read V(ref), a runtime expression: 2 - 2 = 0 and 2 > 1 = 1. The second
// monitor uses zero tolerances and the integral real enable 1.0. This checks
// the legal boundaries without assigning an implementation-chosen
// interpolation time a number.
// Four final-step assertions give checks = 4.
//! lrm 5.10.3.1
//! lrm 5.10.3.4
//! lrm 7.3.5
//! lrm 5.10.3.4:2
//! lrm 5.10.3.4:3
//! lrm 7.3.5:1000
//! analysis tran
//! time 0, 1n, 2n
//! wave V(p) = -1.0, 0.5, 1.0
//! bias V(ref) = 2.0
//! checks 4
`timescale 1ns/1ps
`include "check.vh"
module event_bounds_mixed_legal(p, ref);
  inout p, ref; electrical p, ref;
  integer n_both, n_omitted, n_init;
  real tracked, sampled;
  initial begin
    n_both = 0; n_omitted = 0; n_init = 0;
    tracked = 0.0; sampled = 0.0;
  end
  always @(cross(V(p), 1, 1p, 1m)) n_both = n_both + 1;
  always @(cross(V(p), 1, , , 1)) n_omitted = n_omitted + 1;
  always @(absdelta(V(p), V(ref) - 2.0, 1p, 1m, V(ref) > 1.0))
    tracked = V(p);
  always @(absdelta(V(ref), 0.25, 0.0, 0.0, 1.0)) begin
    sampled = V(ref);
    n_init = n_init + 1;
  end
  analog begin
    @(final_step) begin
      `CHECKI("digital cross with both tolerances fires", n_both, 1);
      `CHECKI("digital cross with omitted tolerances fires", n_omitted, 1);
      `CHECKI("positive delta initializes once and samples the signal", n_init == 1 && sampled == 2.0, 1);
      `CHECKX("zero delta tracks the final value", tracked, 1.0);
    end
    I(p) <+ 0.0;
    I(ref) <+ 0.0;
  end
endmodule
