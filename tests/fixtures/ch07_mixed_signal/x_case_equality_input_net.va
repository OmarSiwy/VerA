// §7.3.2's `a2d` example, verbatim as the child below: an INPUT WIRE `dnet` of
// a module with no discrete block of its own, read in the analog block with
// `dnet === 1'bx` and the other three states. m01_02 and xz_four_state_input_
// compared.va read a `reg` of the same module; this is the clause's own shape,
// where the four-state value arrives through a port.
//
// The parent drives the port from a `reg` (1, then x, then z, then 0, 20 ns
// apart) and reads the child's output net. IEEE 1364 §5.1.8 `===` never
// yields x, so each state picks exactly one arm:
//
//   [0, 20n)    dnet = 1   avar = 5
//   [20n, 40n)  dnet = x   avar = avar, the 5 held from the previous interval
//   [40n, 60n)  dnet = z   avar = 2.5
//   [60n, ..)   dnet = 0   avar = 0
//
// and V(anet) <+ avar makes V(a) that number (`//! solve`). A compiler that
// refused the x/z literals rejects the file; one comparing value bits only reads
// z as 0 and gives 0 at 50n.
//
//! lrm 7.3.2
//! lrm 7.3.2:1
//! solve
//! analysis tran
//! time 10n, 30n, 50n, 70n
`timescale 1ns/1ns
`include "disciplines.vams"
`include "check.vh"
module ch7_x_case_equality_input_net(p);
  inout p; electrical p;
  reg d;
  electrical a;
  initial begin
    d = 1'b1;
    #20 d = 1'bx;
    #20 d = 1'bz;
    #20 d = 1'b0;
  end
  a2d u(d, a);
  analog begin
    I(p) <+ V(p);
    `CHECKEQ("§7.3.2 a2d: === over the input net's 1, x, z, 0", V(a),
             ($abstime < 40n) ? 5.0 : ($abstime < 60n) ? 2.5 : 0.0, 1e-9);
  end
endmodule

module a2d(dnet, anet);
   input dnet;
   output anet;
   wire dnet;
   ddiscrete dnet;
   electrical anet;
   real avar;

   analog begin
      if (dnet === 1'b1)
         avar = 5;
      else if (dnet === 1'bx)
         avar = avar; // hold value
      else if (dnet === 1'b0)
         avar = 0;
      else if (dnet === 1'bz)
         avar = 2.5; // high impedance - float value

      V(anet) <+ avar;
   end
endmodule
