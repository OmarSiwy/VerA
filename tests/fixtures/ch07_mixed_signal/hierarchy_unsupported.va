// §7.2.3 mixed signal ports: whether a port is analog, digital or mixed is
// decided by the disciplines on BOTH of its connections, so the rule cannot be
// read off one module — it needs an instantiated child and an elaborated
// hierarchy. This file is the smallest thing that would need one.
//
// Hierarchy itself is not the subset rule: C.8 says "the hierarchical structure
// defined in Clause 6 is applicable to both Verilog-AMS HDL and Verilog-A",
// with only real value ports carved out. So instantiation is legal Verilog-A
// and this file must NOT be read as a claim that it is not.
//
// The rejection is still required of every compiler, for a different reason:
// `digital_child` is defined nowhere, here or in any included file, so there is
// no module to bind the port to. VerA reaches that verdict early and
// wholesale — E0204 (LRM 6.2.2), "module instantiation is not supported",
// because it elaborates a single flat module — and the code is pinned because
// codes are stable, not because §7.2.3 forbids the construct.
//
//! lrm 7.2.3
//! lrm 6.2.2
//! lrm C.8
//! reject E0204
module ch7_mixed_parent(p);
  inout p; electrical p;
  digital_child u(p);
endmodule
