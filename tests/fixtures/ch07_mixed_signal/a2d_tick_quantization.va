// §8.4.3.3 A/D boundary timing, verbatim: "In the analog kernel, time is a
// floating point value. In the digital kernel time is an integer value. Hence,
// A2D events generally do not occur exactly at digital integer clock ticks. For
// the purpose of reporting results and scheduling delayed future events, the
// digital kernel converts analog event times to digital times such that the error
// is limited to half the precision base for the module where the conversion
// occurs. For the examples below the timescale is 1ns/1ns, so the maximum
// scheduling error when swapping a digital module for its analog counterpart will
// be 0.5ns."
//
// §8.5.1 places the A2D events themselves: "Note that A2D events must be analog
// event controlled statements (e.g., @cross, @timer). These are scheduled just
// like other event controlled statements in Verilog-HDL (e.g., @posedge)."
//
// DERIVATION. `//! wave` walks V(vi) up a straight line of slope 0.1 V/ns
// (0 V at 0, 1.0 V at 10 ns); every declared point lies on that line, so the
// crossing times are read straight off it:
//
//   cross(V(vi) - 0.52, +1):  0.52 V is 0.02 V above the 5 ns sample, and
//                             0.02 / 0.1 = 0.2, so the crossing is at 5.2 ns.
//                             round(5.2) = 5  -> digital tick 5, error 0.2 ns.
//   cross(V(vi) - 0.76, +1):  0.76 V is 0.06 V above the 7 ns sample, and
//                             0.06 / 0.1 = 0.6, so the crossing is at 7.6 ns.
//                             round(7.6) = 8  -> digital tick 8, error 0.4 ns.
//
// Both errors are under the 0.5 ns the clause allows, and the pair is chosen so
// one rounds DOWN and the other rounds UP: a tool that truncates instead of
// rounding reports tick 7 for the second and fails, and a tool that reports the
// raw analog time as the tick fails both.
//
// $time is the digital time scaled to the module's `timescale` unit, so its unit
// here is the nanosecond and the wants are the integers 5 and 8. $abstime is
// seconds in the analog kernel (§9.10), so the same crossing reads 5.2e-9 there —
// the second check is what makes the first one mean "rounded", rather than
// "the analog solver happened to land on 5.0 ns".
//
// BOUNDED EVERYWHERE, PINNED ONLY WHERE NOTHING IS DECIDED BY PLACEMENT.
// §5.10.3.1 makes cross() control the timestep, so a conforming simulator
// solves at a point of its own within 1p of 5.2 ns and of 7.6 ns, and the
// $strobe-based checks below are asserted there too. At such a point V(vi) - 0.52
// may have either sign and the digital engine may or may not have consumed the
// A2D yet, so NO exact value is right there. An earlier draft wrote the want as
// `(V(vi) > 0.52) ? 5 : 0`, which is both a knife edge at the inserted point and
// a want the compiler under test computes. So every want below is the literal 1,
// and each got is:
//
//   - a BOUND that holds at every point of the run: each variable holds its
//     pre-event value or its post-event value, nothing else;
//   - PINNED to one of those only at declared points at least 0.5 ns clear of
//     the event that decides it: 0 at <= 5 ns (resp. <= 7 ns), the event value
//     at >= 6 ns for the 5.2 ns crossing, and at >= 9 ns for tick 8.
//
// Why tick 8 is pinned from 9 ns and not at the declared 8 ns point: tick 8 IS
// 8 ns. §7.3.6.5 has the analog block read "the greatest digital time tick which
// is less than or equal to the analog time", and whether the promotion of tick 8
// compares <= the 8 ns point's $abstime is a floating-point accident (3e-9 and
// 3 * 1e-9 differ by one ULP; 8e-9 and 8 * 1e-9 happen not to), not the clause.
// The first declared point clear of it is 10 ns.
//
// The 1 ps tolerance on the analog crossing time is the `time_tol` passed to
// cross() — §5.10.3.1 places the event "while the signal remains in the box
// defined by actual crossing and expr_tol and time_tol", so 1e-12 is the width
// this fixture itself asked for, not a fudge factor.
//
//! lrm 8.4.3.3
//! lrm 8.4.3.3:1001
//! lrm 8.5.1
//! lrm 8.5.1:7
//! lrm 5.10.3.1
//! lrm 8.4.3.2
//! lrm 8.4.3.2:1
//! lrm 8.4.3.3:2
//! analysis tran
//! time 0, 5n, 6n, 7n, 8n, 10n
//! wave V(vi) = 0, 0.5, 0.6, 0.7, 0.8, 1.0
`timescale 1ns/1ns
`include "check.vh"
module m02_a2d_tick_quantization(vi, vo);
  inout vi, vo; electrical vi, vo;
  integer tick_lo, tick_hi;
  real    ana_lo;
  // §3.2 gives integer variables assigned in digital code an initial x;
  // only ANALOG-context assignment defaults to
  // zero. Both of these are written from an `always`, so without this block they
  // are x until the first crossing and the pre-crossing arm of each CHECKI below
  // would compare x against 0. `ana_lo` is analog-context and needs no such
  // initialization; it is left alone deliberately, to keep the contrast visible.
  initial begin tick_lo = 0; tick_hi = 0; end
  always @(cross(V(vi) - 0.52, +1, 1p, 1u)) tick_lo = $time;
  always @(cross(V(vi) - 0.76, +1, 1p, 1u)) tick_hi = $time;
  analog begin
    @(cross(V(vi) - 0.52, +1, 1p, 1u)) ana_lo = $abstime;
    `CHECKI("a 5.2 ns A2D crossing is reported by the digital kernel at tick 5",
            (tick_lo == 0 || tick_lo == 5)
            && (($abstime <= 5n) ? (tick_lo == 0) : 1)
            && (($abstime >= 6n) ? (tick_lo == 5) : 1), 1);
    `CHECKI("a 7.6 ns A2D crossing rounds UP, to tick 8",
            (tick_hi == 0 || tick_hi == 8)
            && (($abstime <= 7n) ? (tick_hi == 0) : 1)
            && (($abstime >= 9n) ? (tick_hi == 8) : 1), 1);
    `CHECKI("while the analog kernel keeps the unrounded crossing time",
            (($abstime <= 5n) ? (ana_lo == 0.0) : 1)
            && (($abstime >= 6n) ? (abs(ana_lo - 5.2n) <= 1p) : 1), 1);
    V(vo) <+ tick_lo * 0.1;
  end
endmodule
