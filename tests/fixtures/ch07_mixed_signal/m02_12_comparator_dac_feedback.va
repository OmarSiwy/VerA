// The comparator/DAC loop M02 names, assembled from the two clauses that fix its
// timing. §8.4.3.3: "Consequently an A2D event that results in a D2A event being
// scheduled with zero (0) delay, shall have its effect propagated back to the
// analog kernel with zero (0) delay." §8.5.1 rows 3 and 3b put the nonblocking
// update ahead of the analog macro-process event, so the whole A2D -> digital ->
// D2A round trip completes INSIDE one digital time and the analog kernel's
// accepted solution at the crossing already carries the new DAC output.
//
// THE LOOP. Two comparator thresholds on the same analog input; each trip
// increments a 2-bit code through a NONBLOCKING assignment (zero delay); the code
// drives a 4-level DAC back into the analog domain. Per crossing the sequence
// inside one digital time is: analog solution -> A2D event (region 1 wakes the
// always block) -> code <= code + 1 queued (region 3) -> region 3 flush ->
// region 3b macro-process solve reading the new code.
//
// DERIVATION. V(vi) is a 0.1 V/ns ramp, every declared sample on the line:
//
//   trip 1: 0.52 V is 0.02 above the 5 ns sample -> 5 + 0.02/0.1 = 5.2 ns
//           round(5.2) = tick 5, code 2'd0 -> 2'd1
//   trip 2: 0.76 V is 0.06 above the 7 ns sample -> 7 + 0.06/0.1 = 7.6 ns
//           round(7.6) = tick 8, code 2'd1 -> 2'd2
//
//   DAC step = 0.25 V, so V(vdac) = 0.25 * code is the staircase 0, 0.25, 0.5 V.
//
// WHERE EACH TRIP LANDS IN ANALOG TIME. The headline claim is the zero-delay
// return: the D2A carrying code 1 reaches the analog kernel at the crossing's
// own analog time, 5.2 ns, not at the 5 ns tick and not at the next analog step.
// §8.4.3.3 says so above, and §7.3.6.1 says it again for exactly this shape:
// "Zero-delay scheduling is not rounded, so in the case where the digital event
// causes another event on the digital to analog boundary with zero delay, it
// will be handled at the current analog time." `code <= code + 1` carries no
// delay. So an analog `@(code)`, §7.3.4's expression form of an explicit D2A
// wake-up, stamps
//
//     t1 = 5.2e-9 +- 1p     (1p is the cross()'s own time_tol, §5.10.3.1's box)
//
// The second trip is the round-UP case, and there the LRM gives no worked
// example: the A2D is at analog 7.6 ns but the digital kernel executes it at
// tick 8, i.e. 0.4 ns AHEAD of the analog kernel. §7.3.6.1 ("handled at the
// current analog time") points at 7.6 ns; §7.3.6.5 (analog reads "the greatest
// digital time tick which is less than or equal to the analog time") and
// §7.3.6.2's "real promotion of the digital time" point at 8.0 ns. Picking one
// would pin a reading, not the clause, so t2 is BOUNDED:
//
//     7.6e-9 - 1p <= t2 <= 8.0e-9 + 1p
//
// which still fails a tool that defers the D2A to the next declared analog point
// after tick 8 (10 ns) or applies it a tick late (9 ns).
//
// SHAPE OF THE CHECKS, as in 04 and 07: every want is the literal 1. An earlier
// draft partitioned the staircase on V(vi) > 0.52, which is a want the compiler
// under test computes, and at the point a conforming simulator inserts within
// 1p of each crossing it is a knife edge: V(vi) - 0.52 may have either sign
// there and the strobe may fall before or after the A2D is consumed. So each
// got is bounded everywhere and pinned only at declared points at least 0.5 ns
// clear of the event that decides it:
//
//     code   0 at <= 5 ns,  >= 1 from 6 ns,  1 at 6 and 7 ns,  2 from 9 ns
//     t1     0.0 at <= 5 ns,  5.2n +- 1p from 6 ns
//     t2     0.0 at <= 7 ns,  in the band above from 9 ns
//
// The code-2 pin skips the declared 8 ns point for the reason 04 gives for
// tick 8: whether tick 8's promotion is <= that point's $abstime is a
// floating-point accident, not the clause.
//
// The checks are read at $strobe time, which IEEE 1364 §17.1 defines as the end of
// the time step, so what is asserted at each timepoint is the SETTLED value of the
// loop and not an intermediate iterate - which is the right oracle for a feedback
// fixture and the reason check.vh is built on $strobe.
//
// NOT CLAIMED HERE: anything about a loop that does not settle. §8.4.2's iterative
// A/D settlement is 01's subject; this ramp trips each comparator once and the
// loop is feed-forward after each trip, so there is a unique fixed point at every
// timepoint.
//
//! lrm 8.4.3.3
//! lrm 8.4.3.3:1
//! lrm 7.3.6.1
//! lrm 8.5.1
//! lrm 5.10.3.1
//! lrm 8.4.3.3:3
//! lrm 8.4.7:1002
//! analysis tran
//! time 0, 5n, 6n, 7n, 8n, 10n
//! wave V(vi) = 0, 0.5, 0.6, 0.7, 0.8, 1.0
`timescale 1ns/1ns
`include "check.vh"
module m02_comparator_dac_feedback(vi, vdac);
  inout vi, vdac; electrical vi, vdac;
  reg [1:0] code;
  real      t1, t2;
  initial code = 2'd0;
  always @(cross(V(vi) - 0.52, +1, 1p, 1u)) code <= code + 2'd1;
  always @(cross(V(vi) - 0.76, +1, 1p, 1u)) code <= code + 2'd1;
  analog begin
    // explicit D2A (§8.5): the `code` read here is the region-1b snapshot,
    // taken after the region-3 NBA that produced the new value
    @(code) begin
      if (code == 1) t1 = $abstime;
      if (code == 2) t2 = $abstime;
    end
    `CHECKI("each comparator trip reaches the DAC",
            (code <= 2)
            && (($abstime <= 5n) ? (code == 0) : 1)
            && (($abstime >= 6n) ? (code >= 1) : 1)
            && (($abstime >= 6n && $abstime <= 7n) ? (code == 1) : 1)
            && (($abstime >= 9n) ? (code == 2) : 1), 1);
    `CHECKI("the first trip's zero-delay D2A is seen at the analog crossing time, 5.2 ns",
            (($abstime <= 5n) ? (t1 == 0.0) : 1)
            && (($abstime >= 6n) ? (abs(t1 - 5.2n) <= 1p) : 1), 1);
    `CHECKI("the round-up trip's D2A is seen between its crossing and its tick",
            (($abstime <= 7n) ? (t2 == 0.0) : 1)
            && (($abstime >= 9n) ? (t2 >= 7.6n - 1p && t2 <= 8n + 1p) : 1), 1);
    V(vdac) <+ 0.25 * code;
  end
endmodule
