// §7.3.7 function calls, second sentence: "Analog functions cannot be called
// from within the digital context." The `initial` block below is that
// violation: §7.2.2 puts "assignment statements within an initial or always
// block" in the discrete (digital) context, and this one calls an
// `analog function`.
//
// The rule is MASKED here, not exercised. C.7: "No digital behavior or events
// are supported in Verilog-A", so the `initial` block is outside the subset and
// dies as an unsupported module item (E0205) before the call inside it is
// analysed. Conformance for this dialect, but the domain-crossing check itself
// never fires.
//
//! lrm 7.3.7
//! lrm C.7
//! reject E0205
module ch7_analog_function_from_digital;
  real sampled;
  analog function real analog_scale;
    input real value;
    analog_scale = 2.0 * value;
  endfunction
  initial sampled = analog_scale(1.0);
endmodule
