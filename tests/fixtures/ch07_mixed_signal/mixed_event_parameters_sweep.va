// Each host parameter sweep point starts a fresh analysis (§6.3.4).
// On the 0.1 V/ns ramp, base = 0.125 gives delta = 0.25 V, four absdelta
// events including initialization, first at 2.5 ns, and cross at 3.75 ns.
// base = 0.2 gives delta = 0.4 V, three events, first at 4 ns, cross at 6 ns.
// delta = 2*base, threshold = 3*base and both tolerances are read only by
// the monitors; the assertions use base directly to derive expectations.
// Four assertions per analysis over two points give checks = 8.
//! lrm 5.10.3.4
//! lrm 5.10.3.1
//! lrm 6.3.4
//! lrm 6.3.4:1000
//! psweep base = 0.125, 0.2
//! analysis tran
//! time 0, 10n
//! wave V(p) = 0.0, 1.0
//! checks 8
`timescale 1ns/1fs
`include "check.vh"
module mixed_event_parameters(p);
  inout p; electrical p;
  parameter real base = pow(2.0, -3.0);
  parameter real delta = 2.0 * base;
  parameter threshold = 3.0 * base;
  parameter real ttol = 1p;
  localparam real etol = 1u;
  parameter real analog_only = 7.0;
  integer n_delta, n_cross;
  real first_delta, crossed;
  initial begin n_delta = 0; n_cross = 0; first_delta = -1; crossed = -1; end
  always @(absdelta(V(p), delta, ttol, etol)) begin
    n_delta = n_delta + 1;
    if (n_delta == 2) first_delta = $realtime;
  end
  always @(cross(V(p) - threshold, +1, ttol, etol)) begin
    n_cross = n_cross + 1;
    crossed = $realtime;
  end
  analog begin
    @(final_step) begin
      `CHECKI("the parameterized crossing occurs once", n_cross, 1);
      if (base == 0.125) begin
        `CHECKI("first card's delta count", n_delta, 4);
        `CHECK("first card's delta time in ns", first_delta, 2.5, 1.05e-5);
        `CHECK("first card's cross time in ns", crossed, 3.75, 0.001001);
      end else begin
        `CHECKI("second card's delta count", n_delta, 3);
        `CHECK("second card's delta time in ns", first_delta, 4.0, 1.05e-5);
        `CHECK("second card's cross time in ns", crossed, 6.0, 0.001001);
      end
    end
    I(p) <+ 0.0;
  end
endmodule
