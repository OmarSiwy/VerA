// §7.8.3: "This parameter can be used in the connect statement to direct the
// segmentation of the signal at each level of the hierarchy, which can occur
// while inserting a connect module. IT CAN BE ONE OF TWO PREDEFINED VALUES,
// SPLIT OR MERGED. The default is merged."
//
// §7.7.4 introduces it — "Setting connect_mode to split or merged defines
// whether all ports of a common discrete discipline and port direction share an
// connect module or have individual connect modules" — and Syntax 7-6 closes
// the set:
//
//   connect_insertion ::= connect connectmodule_identifier [ connect_mode ]
//           [ parameter_value_assignment ] [ connect_port_overrides ] ;
//   connect_mode ::= merged | split
//
// `segmented` stands in the connect_mode slot (straight after the connect
// module's name, before the `;`), and it is neither keyword. It cannot be read
// as the other thing that may follow the name — a `connect_port_overrides`
// discipline — because every override form names TWO disciplines separated by
// a comma, and here the statement ends. So the statement is outside Syntax 7-6,
// and the refusal names the rule: a connect_mode is `merged` or `split`.
//
// The positive twin is `connect_mode_accepted.va` (both keywords, accepted),
// and `m03_01_merged_is_the_default_one_instance.va` /
// `m03_02_split_one_instance_per_port.va` run each value and assert the
// instance counts §7.8.3.1/§7.8.3.2 require.
//
//! lrm 7.8.3
//! lrm 7.7.4
//! lrm 7.7.4:1000
//! reject-only a connect_mode is `merged` or `split`
//! neighbour connect_mode_accepted.va
//! neighbour m03_01_merged_is_the_default_one_instance.va
//! neighbour m03_02_split_one_instance_per_port.va
`include "disciplines.vams"
connectmodule ch7_cm_a2d(el, dg);
  input el;
  output dg;
  electrical el;
  ddiscrete dg;
  reg dg;
  initial dg = 1'b0;
  always @(cross(V(el) - 0.5, 1)) dg = 1'b1;
endmodule

module ch7_cm_host(p);
  inout p;
  electrical p;
  analog I(p) <+ V(p) / 1k;
endmodule

connectrules ch7_cm_rules;
  connect ch7_cm_a2d segmented;
endconnectrules
