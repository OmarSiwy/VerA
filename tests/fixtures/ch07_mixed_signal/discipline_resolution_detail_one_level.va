// §7.4.4.2 detail mode, selected (`//! discipline-resolution detail`, VerA's
// `--discipline-resolution=detail`), on a signal both modes decide alike.
// "In this mode continuous disciplines propagate up and then back down to
// meet discrete disciplines": `shared` is undeclared at the one level where
// continuous (child2) and discrete (child1) meet, so continuous wins going up
// (F.2.2 step 4.a, "If any of the connections are analog, the net shall be
// considered analog") and there is no lower undeclared segment for the
// top-down pass (step 5) to re-decide. Basic mode (§7.4.4.1) gives the same
// electrical, which basic_resolution_continuous_beats_discrete.va pins with the same design.
//
// The connect statement bridges child1's discrete port (§7.8.4, E0927
// without it), so after insertion `shared` holds only continuous segments.
// V(shared) reads the harness's 0.5 back through a continuous access function:
// the access exists only if `shared` resolved continuous.
//
// Where the modes disagree: discipline_resolution_detail_figure_7_4.va
// (detail) against discipline_resolution_basic_figure_7_3.va (basic). §7.4.4.2
// states no prohibition, so it has no invalid neighbour (CLAUSES.tsv).
//
//! lrm 7.4.4.2
//! lrm F.2.2
//! lrm F.2.2:8
//! discipline-resolution detail
//! bias V(shared) = 0.5
//! checks 1
`include "check.vh"
discipline drd_discrete;
  domain discrete;
enddiscipline
module drd_discrete_child(port);
  inout port; drd_discrete port;
endmodule
module drd_electrical_child(port);
  inout port; electrical port;
endmodule
connectmodule drd_bridge(a, d);
  inout a; electrical a;
  inout d; drd_discrete d;
endmodule
connectrules drd_rules;
  connect drd_bridge;
endconnectrules
module drd_parent;
  drd_discrete_child child1(shared);
  drd_electrical_child child2(shared);
  analog begin
    `CHECKX("detail mode resolves the one-level meeting continuous, as basic does", V(shared), 0.5);
    I(shared) <+ V(shared);
  end
endmodule
