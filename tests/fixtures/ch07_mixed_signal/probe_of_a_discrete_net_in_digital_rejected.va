// §7.3.3: "All CONTINUOUS nets can be probed from a discrete context using
// access functions. All probes which are legal in a continuous context of a
// module are also legal in the discrete context of a module."
//
// §7.3.6.3 names what such a probe reads: "an analog primary (variable,
// potential, or flow) whose value is calculated in the continuous domain".
//
// The clause makes the discrete context's probes the SAME probes as the
// continuous context's, reached through the same access functions. An access
// function is the one a discipline binds (§3.6.1.2 `access = V`, §4.4): `V`
// exists on a net only if the net's discipline binds a potential nature to it.
// `dn` is `ddiscrete` — annex D's `discipline ddiscrete; domain discrete;
// enddiscipline`, natureless — so it has no potential, `V(dn)` names nothing,
// and it is not a continuous net §7.3.3 lets a digital process probe.
//
// The continuous-context twin of this line, `r = V(dn);` inside the `analog`
// block, is E0501 ("`V` is not an access function of `dn`"). The positive side
// of the clause is `m01_08_analog_probe_in_a_digital_expression.va`, which
// probes an `electrical` net from an `always` block and asserts the value.
//
// WHAT THIS PINS THAT NOTHING ELSE DOES. Before 2026-09-24 VerA accepted this
// module and handed `V(dn)` to the mixed-signal kernel: the §4.4 access check
// ran only on analog-block probes, so the same probe was refused in one
// context and accepted in the other — exactly the asymmetry §7.3.3 rules out.
//
// Everything else is legal: `q` is a `reg` with a delayed edge (the module is
// a mixed one, so the `always` really runs on the kernel), `r` is a real only
// the digital context writes, and `p` is an ordinary resistor to ground.
//
//! lrm 7.3.3
//! lrm 7.3.6.3
//! reject-only E0501
//! neighbour m01_08_analog_probe_in_a_digital_expression.va
`timescale 1ns/1ns
`include "disciplines.vams"
module ch7_probe_discrete(p, dn);
  inout p;
  electrical p;
  input dn;
  ddiscrete dn;
  wire dn;
  reg q;
  real r;

  initial begin
    q = 1'b0;
    #10 q = 1'b1;
  end

  always @(posedge q)
    r = V(dn);

  analog I(p) <+ V(p) / 1k;
endmodule
