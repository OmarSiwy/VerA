// §7.3.2.1 special floating point values: "Floating point arithmetic can
// produce special values representing plus and minus infinity and Not-a-Number
// (NaN) to represent a bad value. While use of these special numbers in digital
// expressions is not an error, it is illegal to assign these values to a branch
// through contribution in the analog context."
//
// inf_contribution.va covers +inf, the only one of the three that has a
// keyword. NaN has none, and it must not be faked with one: `inf - inf` would
// need `inf` in an expression, where annex A does not allow it (`inf` appears
// only in `value_range_expression`). So the value is formed by the arithmetic
// the clause itself names — 0.0/0.0 is the IEEE 754 invalid operation and its
// result is a quiet NaN — and then contributed to a branch, which is the one
// thing §7.3.2.1 forbids.
//
// There is no run-side assertion and there must not be one: every comparison
// against a NaN is false, so a `CHECK` here would assert a property of IEEE
// comparison rather than the contribution rule, and the LRM fixes no value for
// a branch a NaN reached.
//
//! lrm 7.3.2.1
//! reject contribution of a NaN
//! xfail VerA does not diagnose a NaN contribution; `I(p) <+ 0.0/0.0` yields only W0650
module ch7_nan_contribution(p);
  inout p; electrical p;
  real bad;
  analog begin
    bad = 0.0/0.0;
    I(p) <+ bad + 0.0*V(p);
  end
endmodule
