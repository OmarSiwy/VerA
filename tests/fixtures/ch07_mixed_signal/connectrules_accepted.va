// §7.7 connect specification statements. A `connectrules` block names the
// connect modules a mixed-signal elaborator may auto-insert at a
// discrete/continuous port boundary (§7.7.1).
//
// THIS FIXTURE'S VERDICT WAS INVERTED, the same turn connectmodule_accepted.va
// documents. It pinned `reject E0201` arguing from C.9 ("Clause 7 only applies
// to Verilog-AMS HDL") and C.16's keyword list that refusing the block "is
// conformance, not debt". Both quotes are real; annex C describes the
// Verilog-A SUBSET, and a compiler that implements Verilog-AMS is bound by
// clause 7 — A.1.2 makes `connectrules_declaration` a description alternative,
// so there is nothing left to refuse:
//
//     connectrules_declaration ::= connectrules connectrules_identifier ;
//         { connectrules_item } endconnectrules                    // A.1.8
//
// WHAT IS ASSERTED. Acceptance, so the verdict is a value that exists only if
// the whole file — block included — compiled, elaborated and ran; `V(p)` at
// the pinned bias is that value, from the ordinary module, exactly as
// connectmodule_accepted.va argues. The insertion statement names a REAL
// connect module, because acceptance is now semantic and not lexical:
// §7.7.1's `connect connectmodule_identifier ;` is judged at elaboration
// (E0915 when the name is not a §7.6 connect module), so a block whose content
// is nonsense no longer gets through.
//
// WHAT IS NOT CLAIMED. No insertion happens: §7.6 puts the insertion phase
// after discipline resolution, VerA emits one analog device with no discrete
// kernel to bridge to, and no net here is mixed. The insertion statement is
// parsed, validated, and configures nothing — the resolution statements of the
// same block ARE consumed (annex F.2.1 step 4.b; see
// annex_f_resolution/resolveto_resolution.va).
//
// The want is the bias read back, exact in binary, so `CHECKX` is the honest
// macro.
//
//! lrm 7.7
//! lrm 7.7.1
//! bias V(p) = 0.75
`include "check.vh"
connectmodule ch7_a2d(a, d);
  input a; output d; electrical a;
endmodule
module ch7_host(p);
  inout p; electrical p;
  analog begin
    `CHECKX("the §7.7 connectrules block is accepted and the ordinary module runs", V(p), 0.75);
    I(p) <+ V(p);
  end
endmodule
connectrules ch7_rules;
  connect ch7_a2d;
endconnectrules
