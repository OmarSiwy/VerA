// §7.7.2.1: "When there is an exact match for the set of disciplines
// specified as part of the discipline_list, the resolved discipline would be
// as per the rule specified in the exact match. When more than one specified
// rule applies to a given scenario a warning message shall be issued by the
// simulator and the first match would be used."
//
// The clause's own Example 2, transcribed with prefixed names:
//
//     connect x,y,a resolveto y;
//     connect x,y,a resolveto a;
//     connect x,y,b resolveto b;
//     "disciplines x,y,a would resolve to discipline y with a warning."
//
// THE SCENARIO. `s` is undeclared and its three child segments are x, y and
// a, so §7.4.1/F.2.1 step 4.b builds the candidate list {x, y, a}. Two rules
// list exactly that set: the first resolves to y, the second to a. So the
// LRM wants a warning, and y.
//
// HOW y IS OBSERVED (connect_rule_exact_then_subset_resolution.va's trick).
// Each discipline binds its own potential nature with its own access function
// (XV, YV, AV, BV); by §3.6.2.1 a net's access functions are its discipline's,
// so `YV(s)` compiles only if s resolved to y. A tool that took the LAST
// exact rule resolves to a and refuses `YV`. All four potential natures carry
// units "V" and share one flow nature, so the disciplines are compatible
// (§3.11.1) as §7.7.2 requires of a resolution list.
//
// The want is the bias read back through YV, 0.75, exact in binary. The
// `//! warn` line names VerA's wording for an exact-match tie; the LRM fixes
// that a warning is issued, not its text.
//
//! lrm 7.7.2.1
//! lrm 7.7.2.1:1
//! lrm 7.7.2.1:1001
//! lrm 7.7.2
//! warn multiple exact resolution rules apply
//! bias s = 0.75
`include "check.vh"
nature b5_rx_x_pot; units = "V"; access = XV; abstol = 1u; endnature
nature b5_rx_y_pot; units = "V"; access = YV; abstol = 1u; endnature
nature b5_rx_a_pot; units = "V"; access = AV; abstol = 1u; endnature
nature b5_rx_b_pot; units = "V"; access = BV; abstol = 1u; endnature
nature b5_rx_flow;  units = "A"; access = RXI; abstol = 1p; endnature
discipline b5_rx_x; potential b5_rx_x_pot; flow b5_rx_flow; domain continuous; enddiscipline
discipline b5_rx_y; potential b5_rx_y_pot; flow b5_rx_flow; domain continuous; enddiscipline
discipline b5_rx_a; potential b5_rx_a_pot; flow b5_rx_flow; domain continuous; enddiscipline
discipline b5_rx_b; potential b5_rx_b_pot; flow b5_rx_flow; domain continuous; enddiscipline

connectrules b5_rx_rules;
  connect b5_rx_x, b5_rx_y, b5_rx_a resolveto b5_rx_y;
  connect b5_rx_x, b5_rx_y, b5_rx_a resolveto b5_rx_a;
  connect b5_rx_x, b5_rx_y, b5_rx_b resolveto b5_rx_b;
endconnectrules

module b5_rx_x_leaf(p); inout p; b5_rx_x p; endmodule
module b5_rx_y_leaf(p); inout p; b5_rx_y p; endmodule
module b5_rx_a_leaf(p); inout p; b5_rx_a p; endmodule

module b5_resolveto_two_exact_rules_warn(s);
  inout s;
  b5_rx_x_leaf l1(s);
  b5_rx_y_leaf l2(s);
  b5_rx_a_leaf l3(s);
  analog begin
    `CHECKX("§7.7.2.1 two exact rules for {x, y, a}: warn and use the first, y", YV(s), 0.75);
    RXI(s) <+ YV(s);
  end
endmodule
