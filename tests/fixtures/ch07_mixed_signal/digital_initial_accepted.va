// §7.2.2 contexts: "assignment statements within an initial or always block"
// are in the discrete (digital) context. This is the `initial` half of that
// sentence — the §7.3.2 `converter` example drives its discrete net exactly
// this way — with A.6.3's `seq_block` as the initial's statement, and it is legal
// Verilog-AMS HDL. m02_10_macro_process_runs_after_nba.va is the other half of
// the sentence, an `always` block, and runs on the mixed-signal kernel.
//
// THIS FILE USED TO DEMAND E0205, arguing C.7 ("No digital behavior or events are
// supported in Verilog-A") deleted the block. That is a rule of the Verilog-A
// SUBSET; VerA targets Verilog-AMS, so the demand was for a diagnostic a
// conforming AMS compiler must not emit — the inversion discrete_discipline.va
// used to have, fixed the same way. C.7 is re-scoped, not deleted: it is what a
// `--std=verilog-a` gate would consult, and this compiler has no such gate.
//
// WHAT IS ASSERTED. §7.2.2's first sentence is the whole mechanism: "The domain
// of a variable is that of the context from which its value is assigned" hands
// `state` to the discrete context, and the clause's own "it shall be an error to
// assign to a given variable in both contexts" (E0432,
// both_contexts_assignment_rejected.va) is what guarantees nothing else writes
// it. The block runs once before the analysis, so 1 is what the continuous
// context reads, for the whole analysis, with no schedule consulted. A compiler
// that parsed the block and threw it away reads §3.2's initial 0 here.
//
// WHY `always` STAYS REFUSED, since one AMS ruling covers both keywords: an
// `always` block RE-RUNS on an event, so its variable's value is a function of a
// schedule, and there is no reading of it that does not need §8.5's simulation
// cycle. The `initial` block's constant has exactly one meaning. That asymmetry
// is VerA's ceiling stated at the one place it is true, and E0433 is the rest of
// it — a delay, a loop, an event control or a non-constant right-hand side
// inside an `initial` block is refused rather than guessed at.
//
//! lrm 7.2.2
//! lrm C.7
//! lrm A.6.3
//! lrm A.6.2
//! lrm A.6.2:1000
//! lrm A.6.3:1000
//! bias V(p) = 0.5
`include "check.vh"
module ch7_digital_initial(p);
  inout p; electrical p;
  integer state;
  initial begin state = 1; end
  analog begin
    `CHECKI("a variable assigned in the discrete context is read in the continuous one", state, 1);
    I(p) <+ V(p);
  end
endmodule
