// §7.7.1, Syntax 7-6:
//
//     connect_insertion ::= connect connectmodule_identifier [ connect_mode ]
//                           [ parameter_value_assignment ] [ connect_port_overrides ] ;
//
// "The connect module insertion statement declares which connect modules are
// automatically inserted when mixed nets of the appropriate types are
// encountered", and "This specifies the connect module connect_module_identifier
// is used to determine the mixed nets of the type used in the declaration of
// the connect module." The identifier names a CONNECT module: the port
// disciplines of its `connectmodule` declaration (§7.6) are what say which
// mixed nets it bridges.
//
// `ch7_plain` below is declared with `module`, so it has no connect-module
// declaration for the statement to read. The accepted insertion over a real
// connect module is connectrules_accepted.va.
//
//! lrm 7.7.1
//! reject-only E0915
//! neighbour connectrules_accepted.va
`include "disciplines.vams"
module ch7_plain(p, n);
  inout p, n; electrical p, n;
  analog I(p, n) <+ V(p, n);
endmodule
connectrules ch7_bad_insertion;
  connect ch7_plain;
endconnectrules
