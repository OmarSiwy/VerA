// §7.2.2: "The domain of an unassigned variable is undefined and left up to
// implementations to determine."
//
// `u` is written in no context at all, so this fixture does not choose its
// domain and pins no domain-dependent value. What it does pin is the whole
// observable consequence of the sentence: the implementation picks a domain,
// the variable is then readable from BOTH contexts — §7.3.2 carries a discrete
// value into analog, §7.3.3 a continuous one into digital — and either
// domain's §3.2 initialization leaves a real at 0: "Real variables are
// initialized to zero (0) at the start of a simulation." A tool that refused
// an unassigned variable in one of the contexts, or left it at x, fails.
//
// The digital read is a process (`initial seen = u;` is not a constant
// binding), so the module runs on the mixed-signal kernel. The check on `seen`
// waits until 1 ns: the analog check at time zero must not race the digital
// initial process.
//
//! lrm 7.2.2
//! lrm 7.2.2:2
//! lrm 3.2
//! analysis tran
//! time 0, 1n, 2n
//! bias V(p) = 0.5
`timescale 1ns/1ns
`include "check.vh"
module ch7_unassigned_variable(p);
  inout p; electrical p;
  real u;            // never assigned in either context
  real seen;

  initial seen = u;  // the discrete-context read

  analog begin
    `CHECKX("the unassigned real reads zero in the continuous context", u, 0.0);
    `CHECKX("and the discrete read of it sees the same zero",
            ($abstime >= 1n) ? seen : 0.0, 0.0);
    I(p) <+ V(p);
  end
endmodule
