// §7.7.2 discipline resolution connect statement: "the discipline identifiers
// before the resolveto keyword are the list of compatible disciplines and the
// discipline identifier after is the discipline to be used", the override
// §7.4.4.3 refers to when an interconnect already carries a discipline.
//
// C.9 settles the verdict for a Verilog-A compiler: "Clause 7 only applies to
// Verilog-AMS HDL", and C.16 lists `connect`, `connectrules` and `resolvedto`
// among the keywords "not used by Verilog-A". The module below keeps the
// refusal about the connect specification rather than about an empty file.
//
//! lrm 7.7.2
//! lrm C.9
//! lrm C.16
//! reject E0201
//! reject connectrules
module ch7_host(p);
  inout p; electrical p;
  analog I(p) <+ V(p);
endmodule
connectrules ch7_resolution;
  connect electrical, thermal resolveto electrical;
endconnectrules
