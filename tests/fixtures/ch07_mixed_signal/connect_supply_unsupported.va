// §7.8.6 supply sensitive connect modules: the supply a connect module measures
// against is passed in as a connect-statement parameter (§7.7.3), here a
// hierarchical name to the supply node.
//
// C.9 settles the verdict for a Verilog-A compiler: "Clause 7 only applies to
// Verilog-AMS HDL", and C.16 lists `connect` and `connectrules` among the
// keywords "not used by Verilog-A". The module below keeps the refusal about
// the connect specification rather than about an empty source file.
//
//! lrm 7.8.6
//! lrm C.9
//! lrm C.16
//! reject E0201
//! reject connectrules
module ch7_host(p);
  inout p; electrical p;
  analog I(p) <+ V(p);
endmodule
connectrules ch7_supply;
  connect ch7_a2d #(.vddname("$root.supply.vdd"));
endconnectrules
