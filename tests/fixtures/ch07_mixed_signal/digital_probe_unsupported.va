// §7.3.6.3 analog primary appearing in a digital expression: `V(p)` read from an
// `always` block "shall be evaluated using the analog value calculated for the
// time corresponding to a real promotion of the digital time at which the
// expression is evaluated".
//
// C.7 removes the digital context that would do the evaluating — "No digital
// behavior or events are supported in Verilog-A" — so the `always` block is an
// unsupported module item and the rejection is conformance, not debt. There is
// no digital time in this dialect to promote.
//
//! lrm 7.3.6.3
//! lrm C.7
//! reject E0205
module ch7_digital_probe(p);
  inout p; electrical p; real sampled;
  always @(p) sampled = V(p);
endmodule
