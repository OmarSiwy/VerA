// §7.3.6.3 analog primary appearing in a digital expression: `V(p)` read from an
// `always` block "shall be evaluated using the analog value calculated for the
// time corresponding to a real promotion of the digital time at which the
// expression is evaluated".
//
// VerA's CEILING, named by E0437. This file used to cite C.7 as conformance;
// that is a rule of the Verilog-A subset, and the source is legal Verilog-AMS.
// What is missing is the probe half of the kernel: reading an accepted analog
// solution at the promoted digital time. The positive row for the same clause is
// m01_08_analog_probe_in_a_digital_expression.va.
//
//! lrm 7.3.6.3
//! reject E0437
module ch7_digital_probe(p);
  inout p; electrical p; real sampled;
  always @(p) sampled = V(p);
endmodule
