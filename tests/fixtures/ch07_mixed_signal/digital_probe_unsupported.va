// DEBT — this rejection is NOT conformance.
// The LRM permits what VerA refuses here. The substrings below record
// CURRENT behavior so the suite stays green on it; they do not claim it
// is right. `zig build ledger` counts this rule against VerA.
//
// VAMS-7.3.6.3-01  (ch7-mixed-signal.html)
// The expression shall be evaluated using the analog value calculated for the time corresponding to a real promotion of the digital time at which the ex
// VAMS-7.3.6.5-01  (ch7-mixed-signal.html)
// The expression shall be evaluated using the digital value calculated for the greatest digital time tick which is less than or equal to the analog time
//
//! reject unsupported module item
// EXPECT: error -- continuous probe in a digital process is not VA codegen.
module ch7_digital_probe(p);
  inout p; electrical p; real sampled;
  always @(p) sampled = V(p);
endmodule
