// §7.3.2: "Discrete nets can contain bits which are set to x (unknown) or z
// (high impedance). Verilog-AMS HDL supports accessing of 4-state logic values
// within the analog context. The x and z states must be translated to
// equivalent analog real or integer values before being used within the analog
// context." The clause then lists the four features that do the translating;
// the first two are "the case equality operator (===)" and "the case
// inequality operator (!==)".
//
// The body below is the clause's own `a2d` example, verbatim, including its
// comments. The one thing added is a discrete driver, because the printed
// example leaves `dnet` an undriven input and therefore has no value sequence
// to assert. The sequence chosen is the one the SECOND example in the same
// clause (`converter`) uses: an assignment at time 0 and a later change,
// written with `#` delays on the digital timeline.
//
// DERIVATION, with `timescale 1ns/1ns` so every listed time is a whole tick:
//
//   t = 0      dnet = 1'b1   dnet === 1'b1   avar = 5.0
//   t = 10n    dnet = 1'b1   dnet === 1'b1   avar = 5.0
//   t = 20n    dnet = 1'bx
//   t = 30n    dnet = 1'bx   dnet === 1'bx   avar = avar, i.e. still 5.0
//   t = 40n    dnet = 1'bz
//   t = 50n    dnet = 1'bz   dnet === 1'bz   avar = 2.5
//
// so the oracle is ($abstime < 40n) ? 5.0 : 2.5. Both constants are exact in
// binary, and the three distinguishable wrong answers are all visible:
//   - a tool that let the x fall through to the final `else if` chain with no
//     match leaves avar at the §3.2 default 0.0 at t = 30n;
//   - a tool that made `===` behave like `==` gets x at t = 30n, and 1'bx == 1'b1
//     is itself x, so no branch is taken and the hold is reached by accident —
//     which is why the z point exists: `==` against 1'bz is also x, so such a
//     tool reads 5.0 at t = 50n instead of 2.5;
//   - a tool that read the net as 0 for both unknown states reads 0.0 twice.
//
// WHAT FAILS TODAY: only the x arm. The §7.3.2 comparison itself is green —
// `xz_four_state_input_compared.va` asserts it with a value on every arm — and
// the run reads 5.0 at t = 0, 10n and 2.5 from 40n. At 20n and 30n it reads
// 0.0: `avar = avar` reads the variable at the start of THIS evaluation, and
// VerA keeps an analog variable across evaluations only when an event
// statement writes it (lib/ir/lower/param.zig `scanHeld`). §3.2 initializes a
// real "at the start of a simulation", not at every evaluation, so the hold
// is the clause's and VerA's retention is the gap.
//
//! lrm 7.3.2
//! lrm 7.3.1
//! xfail §3.2 retention — VerA holds an analog variable across evaluations only when an event statement writes it (param.zig scanHeld), so the x arm's `avar = avar` reads 0.0, not the held 5.0; the §7.3.2 comparison is green in xz_four_state_input_compared.va
//! analysis tran
//! time 0, 10n, 30n, 50n
`timescale 1ns/1ns
`include "check.vh"
module m01_a2d_case_equality(anet);
  inout anet;
  electrical anet;
  reg dnet;
  real avar;

  initial begin
    dnet = 1'b1;
    #20 dnet = 1'bx;
    #20 dnet = 1'bz;
  end

  analog begin
    if (dnet === 1'b1)
      avar = 5;
    else if (dnet === 1'bx)
      avar = avar; // hold value
    else if (dnet === 1'b0)
      avar = 0;
    else if (dnet === 1'bz)
      avar = 2.5; // high impedance - float value

    `CHECKEQ("=== over 1, x and z picks 5, the held 5, then 2.5", avar, ($abstime < 40n) ? 5.0 : 2.5, 0.0);
    V(anet) <+ avar;
  end
endmodule
