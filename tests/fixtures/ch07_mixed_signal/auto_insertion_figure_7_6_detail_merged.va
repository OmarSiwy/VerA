// §7.8.1 Figure 7-6, Case 1, detail resolution (§7.4.4.2), merged: "d2a at
// top.mix.blk2, d2a at top.digital_blk.(blk1-blk2), and d2a at
// top.digital_blk.twoblks (three connect modules)".
//
// The design: every digital module (blk1..blk4 and mix's blk2, here one
// module `blk`) has one output port of discipline cmos1, `ablk`'s port is
// electrical, and NetD (top's `netd`), NetA (digital_blk's `out`), NetB
// (twoblks' `out`) and NetC (mix's `out`) are undeclared: the figure's
// Case 1, "All interconnects are undeclared". Each port is an output whose
// lower connection is cmos1, so the statement's d2a shape matches it when
// its upper connection is electrical (§7.6 Example 1: "a mixed output port
// whose upper connection is compatible with discipline electrical and whose
// lower connection is compatible with ddiscrete").
//
// Each connect module loads its electrical side with 1 kohm and ablk drives
// the node with 1 mA, so the node reads V = 1e-3 * 1000 / N for N
// instances: the count, and so where §7.8 inserted them, is what is asserted.
//
// Derivation (F.2.2): step 4 makes NetB and NetA cmos1 (all children
// digital) and NetC and NetD electrical ("If any of the connections are
// analog, the net shall be considered analog"); step 5, top-down, makes
// NetA analog because its parent NetD is ("Any others shall be considered
// analog"), electrical from its parent, and then NetB likewise. So the mixed
// ports are the five leaves'. §7.8.4: "All ports connecting to the same
// signal (upper connection), sharing the same connect module, and having
// merged parameter shall share a single instance": blk1 and blk2 share one
// on NetA in digital_blk, blk3 and blk4 one on NetB in twoblks, and mix's
// blk2 has its own on NetC. N = 3, V = 1/3. Basic mode gives 2
// (auto_insertion_figure_7_6_basic_merged.va), detail split 5
// (auto_insertion_figure_7_6_detail_split.va).
//
//! lrm 7.4.4.2
//! lrm 7.8.1
//! lrm F.2.2
//! lrm F.2.2:8
//! lrm F.2.2:14
//! discipline-resolution detail
//! solve
//! checks 1
`include "check.vh"
discipline cmos1; domain discrete; enddiscipline
connectmodule f76dm_d2a(d, a);
  input d; cmos1 d;
  output a; electrical a;
  analog I(a) <+ V(a) / 1000.0;
endmodule
connectrules f76dm_rules;
  connect f76dm_d2a input cmos1, output electrical;
endconnectrules
module f76dm_blk(out); output out; cmos1 out; endmodule
module f76dm_ablk(out);
  output out; electrical out;
  analog begin
    I(out) <+ -1.0e-3;
    `CHECK("3 connect modules load the node: V = 1 mA * 1 kohm / 3", V(out), 0.333333333333333, 1e-12);
  end
endmodule
module f76dm_twoblks(out);
  output out;
  f76dm_blk b3(out);
  f76dm_blk b4(out);
endmodule
module f76dm_digital_blk(out);
  output out;
  f76dm_blk b1(out);
  f76dm_blk b2(out);
  f76dm_twoblks t(out);
endmodule
module f76dm_mix(out);
  output out;
  f76dm_blk b2(out);
  f76dm_ablk a(out);
endmodule
module f76dm_top;
  f76dm_digital_blk d(netd);
  f76dm_mix m(netd);
endmodule
