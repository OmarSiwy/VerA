// §7.2.1 Domains: "Values calculated in the discrete domain change value
// instantaneously and only at integer multiples of a minimum resolvable time.
// For this reason, the derivative with respect to time of a digital value is
// always zero (0). Values calculated in the continuous domain, on the other
// hand, are continuously varying."
//
// THE DESIGN. `r` is a discrete reg (§7.2.1: "register contents ... are
// calculated in the discrete domain"), 0 from tick 0 and 1 from tick 10.
// §7.3.6.5 lets the analog block read it, and ddt() takes its time
// derivative. `n` is an internal continuous node driven by a 1 V/ns ramp,
// differentiated the same way: the continuous half of the sentence, and the
// control that shows ddt() is live in this run, so a 0 for the reg is not
// just a ddt() that returns 0 for everything.
//
// Each derivative is read as a current into a 1 kohm resistor (a §4.5.3
// transcapacitance of 1 pF), so the solver integrates it like any charge:
//
//     I(k) <+ V(k)/1k - 1p * ddt(r)      =>  V(k) = 1e-9 * ddt(r)
//     I(m) <+ V(m)/1k - 1p * ddt(V(n))   =>  V(m) = 1e-9 * ddt(V(n))
//
// DERIVATION, `timescale 1ns/1ns, analog points 0 (dc), 5n .. 25n (the mixed
// runner opens the analysis with a dc point at the first declared time).
//
//   ddt(r): r is constant between ticks, so its derivative is 0 at every
//   point whose last step holds no tick: V(k) = 0. The point AT the step
//   (10n) is left out on purpose: whether "always zero" reaches the instant
//   of the change, or a backward difference may show (1 - 0)/5n there, is not
//   settled by the sentence (b5-doubts2.tsv, 7.2.1:1000). So is 15n, whose
//   previous point is 10n: under §7.3.6.5 (m01_11) the analog side sees r = 1
//   at 10n already, but this file does not lean on that. Checked: t < 9n
//   (0 and 5n) and t > 19n (20n and 25n). Want 0, absolute 1e-12 V (a ddt of
//   1e3 /s, against the 2e8 /s a step would show).
//
//   ddt(V(n)): V(n) = 1e9 * t, so the derivative is 1e9 V/s at every t > 0
//   (the dc point, where ddt is 0, is skipped), and V(m) = 1.0. A linear ramp
//   is differentiated exactly by any backward difference; python3 gives
//   (1e9*t1 - 1e9*t0)/(t1 - t0) = 1e9 within 4e-16 relative on this grid.
//
// Checks: 4 for r (0, 5n, 20n, 25n) and 5 for the ramp (5n .. 25n).
//
// A tool that integrated the reg like a continuous waveform (a ramp between
// ticks) reads 1e8 /s at 15n and 20n; one that kept the step as a lasting
// charge reads a nonzero V(k) after it. Both miss 0.
//
//! lrm 7.2.1
//! lrm 7.2.1:1000
//! lrm 7.3.6.5
//! analysis tran
//! time 0, 5n, 10n, 15n, 20n, 25n
//! solve
//! checks 9
`timescale 1ns/1ns
`include "check.vh"
module b5_digital_value_has_zero_derivative;
  electrical n, m, k;
  reg r;

  initial begin
    r = 1'b0;
    #10 r = 1'b1;
  end

  analog begin
    V(n) <+ 1.0e9 * $abstime;
    I(k) <+ V(k) / 1000.0 - 1.0e-12 * ddt(r);
    I(m) <+ V(m) / 1000.0 - 1.0e-12 * ddt(V(n));
    if ($abstime < 9n || $abstime > 19n)
      `CHECK("§7.2.1 the time derivative of a digital value is 0", V(k), 0.0, 1e-12);
    if ($abstime > 0)
      `CHECK("§7.2.1 a continuous value varies: 1 pF x ddt of a 1 V/ns ramp into 1k", V(m), 1.0, 1e-9);
  end
endmodule
