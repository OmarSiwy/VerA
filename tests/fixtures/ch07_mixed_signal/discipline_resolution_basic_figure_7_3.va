// §7.4.4.1 basic discipline resolution on Figure 7-3, the design Figure 7-4
// repeats for detail mode: "In this mode (the default), both continuous and
// discrete disciplines propagate up the hierarchy to meet one another. At
// each level of the hierarchy where continuous and discrete meet for an
// undeclared net that net segment is declared continuous. This typically
// results in connect modules being inserted higher up the design
// hierarchy." The clause's results: "NetB resolves to cmos3 based on the
// first resolveto connect statement. NetA resolves to cmos1 based on the
// second resolveto connect statement. NetC resolves to electrical ... NetD
// resolves to electrical".
//
// The figure's nets in this file: NetD = top's `netd`, NetA = digital_blk's
// `out`, NetB = twoblks' `out`, NetC = mix's `out`. (The figure prints the
// resolveto lists without commas; A.1.8 separates them with commas.)
//
// §7.8.4 then selects a connect module for each port "if one of the
// connections to the port is digital and the other is analog", instantiated
// "in the context of the ports upper connection". Two ports are mixed:
// digital_blk's (upper NetD electrical, lower NetA cmos1), bridged in top,
// and mix's blk2 (upper NetC electrical, lower cmos2), bridged in mix. Every
// other port joins two digital segments (blk1/blk2/twoblks on cmos1 NetA,
// blk3/blk4 on cmos3 NetB; §3.11.1 makes natureless discrete disciplines
// compatible). Each bridge loads the node with 1 kohm and the analog block
// drives 1 mA: V = 1e-3 * 1000 / 2 = 0.5.
//
// Detail mode on the same design bridges every leaf instead, five bridges,
// V = 0.2: discipline_resolution_detail_figure_7_4.va.
//
//! lrm 7.4.4.1
//! lrm 7.8.4
//! lrm F.2.1
//! solve
//! checks 1
`include "check.vh"
discipline cmos1; domain discrete; enddiscipline
discipline cmos2; domain discrete; enddiscipline
discipline cmos3; domain discrete; enddiscipline
discipline cmos4; domain discrete; enddiscipline
connectmodule f73_d2a(d, a);
  input d; cmos1 d;
  output a; electrical a;
  analog I(a) <+ V(a) / 1000.0;
endmodule
connectrules f73_rules;
  connect cmos3, cmos4 resolveto cmos3;
  connect cmos1, cmos2, cmos3 resolveto cmos1;
  connect f73_d2a;
endconnectrules
module f73_blk1(out); output out; cmos1 out; endmodule
module f73_blk2(out); output out; cmos2 out; endmodule
module f73_blk3(out); output out; cmos3 out; endmodule
module f73_blk4(out); output out; cmos4 out; endmodule
module f73_ablk(out);
  output out; electrical out;
  analog begin
    I(out) <+ -1.0e-3;
    `CHECK("two connect modules load the node: V = 1 mA * 1 kohm / 2", V(out), 0.5, 1e-12);
  end
endmodule
module f73_twoblks(out);
  output out;
  f73_blk3 b3(out);
  f73_blk4 b4(out);
endmodule
module f73_digital_blk(out);
  output out;
  f73_blk1 b1(out);
  f73_blk2 b2(out);
  f73_twoblks t(out);
endmodule
module f73_mix(out);
  output out;
  f73_blk2 b(out);
  f73_ablk a(out);
endmodule
module f73_top;
  f73_digital_blk d(netd);
  f73_mix m(netd);
endmodule
