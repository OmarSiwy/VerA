// §7.8.3 connect_mode parameter: "It can be one of two predefined values, split
// or merged. The default is merged." And §7.8.3.1 merged: "This instructs the
// simulator to try to group all ports (whether they are input, output, or inout)
// and to use just one connector module, provided the module is the same."
//
// §7.8.4's insertion rule says the same thing normatively: "All ports connecting
// to the same signal (upper connection), sharing the same connect module, and
// having merged parameter shall share a single instance of the selected connect
// module."
//
// HOW A COUNT IS MADE INTO A NUMBER. An inserted instance is not visible from
// Verilog-AMS source, so this family of fixtures makes the INSERTION COUNT the
// only free variable in a resistive DC solve and then reads the node voltage.
// §7.8.2 sanctions the shape directly — "Figure 7-7 shows how to model the
// loading effect of each individual digital port on the analog node" — so the
// a2d connect module below is exactly the LRM's loading model: one `rin` to
// ground per inserted instance.
//
// The top module supplies a 1 kohm shunt and a 1 mA source. KCL at node `a`
// with N inserted bridges, each of rin = 1 kohm:
//
//     V/1000 - 1e-3 + N*V/1000 = 0   =>   V = 1/(N+1) volts
//
//   N = 0 (no insertion at all)  -> V(a) = 1.0
//   N = 1 (merged, this file)    -> V(a) = 0.5
//   N = 2 (split, fixture 02)    -> V(a) = 1/3
//
// The shunt exists so that a compiler which inserts NOTHING produces a finite
// WRONG ANSWER (1.0 V) rather than a singular matrix: the fixture must fail on
// its assertion, not on a solver crash.
//
// WHAT IS PINNED HERE. Two child instances present two `ddiscrete` INPUT ports
// on one `electrical` signal. §7.6 EXAMPLE 2 is the one that covers that shape:
// its `a2d` (`electrical in` as the input, `ddiscrete out` as the output) "can
// bridge ... a mixed input port whose upper connection is compatible with
// electrical and whose lower connection is compatible with ddiscrete" — exactly
// u1.din and u2.din here. Example 1 is the mirror `d2a` and does NOT cover this
// port; earlier revisions of this file cited it by mistake. The
// `connect m03_a2d;` statement carries no connect_mode, so §7.8.3's default
// `merged` applies, and §7.8.4 requires the two ports to SHARE one instance.
// Expected V(a) = 0.5 exactly.
//
// A compiler that inserted one bridge per port despite the default would read
// 0.333..., and one that inserted none would read 1.0. Both are distinguishable
// from 0.5 well outside the tolerance.
//
//! lrm 7.8.3
//! lrm 7.8.3.1
//! lrm 7.8.4
//! lrm 7.6
//! solve
//! xfail VerA performs no §7.8 connect-module insertion (lib/ir/elaborate.zig:54-58), so the design solves with no bridge and reads got=1 want=0.5
`include "check.vh"

connectmodule m03_a2d(el, cm);
  input el;
  output cm;
  electrical el;
  ddiscrete cm;
  reg cm;
  // §7.8.2 Figure 7-7: the loading effect of the digital port on the analog
  // node. One of these exists per INSERTED INSTANCE, which is the whole point.
  parameter real rin = 1000.0 from (0.0:inf);
  analog I(el) <+ V(el) / rin;
  initial cm = 1'b0;
endmodule

module m03_din(din);
  input din;
  ddiscrete din;
  // No digital process here: the port is a receiver by its DISCIPLINE alone
  // (§7.8.4 selects on the two connections' disciplines and the port
  // direction). An unread `reg seen` process only made the file stop at E0205
  // before it could reach its own assertion.
endmodule

module m03_top;
  electrical a;

  m03_din u1(a);
  m03_din u2(a);

  analog begin
    I(a) <+ V(a) / 1000.0;   // shunt so an uninserted design is still solvable
    I(a) <+ -1.0e-3;         // 1 mA into node a
    `CHECK("merged is the default: two ddiscrete input ports share ONE a2d, so V = 1/(1+1)",
           V(a), 0.5, 1e-12);
  end
endmodule

connectrules m03_rules;
  connect m03_a2d;
endconnectrules
