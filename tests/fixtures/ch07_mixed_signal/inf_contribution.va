// §7.3.2.1 special floating point values: "Floating point arithmetic can
// produce special values representing plus and minus infinity ... While use of
// these special numbers in digital expressions is not an error, it is illegal
// to assign these values to a branch through contribution in the analog
// context."
//
// The contribution below is the illegal half, and VerA does not yet diagnose
// it — that gap is not something the fixture can assert, since a `//! reject`
// here would only record an expectation the compiler does not meet.
//
// What IS assertable is the value itself. `inf` must be IEEE 754 +infinity and
// not some large finite stand-in, so it compares greater than the largest
// finite double, 2^1024 - 2^971 = 1.7976931348623157e308. A tool that folded
// `inf` to that maximum, or to zero, fails this line.
//
`include "check.vh"
module ch7_infinity_guard(p);
  inout p; electrical p;
  analog begin
    `CHECKI("inf is +infinity, above every finite double", (inf > 1.7976931348623157e308), 1);
    // The LRM forbids this at runtime; the snapshot records current codegen.
    I(p) <+ inf + 0.0*V(p);
  end
endmodule
