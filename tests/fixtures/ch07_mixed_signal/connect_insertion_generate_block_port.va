// §7.8.4: "A connection shall be selected for a port only if one of the
// connections to the port is digital and the other is analog", and "The
// connect module for a port shall be instantiated in the context of the
// ports upper connection." §6.9.3: "Discipline resolution can only occur
// after elaboration of the generate constructs once the connections of all
// nets have been resolved." A port of an instance inside a generate block is
// a port like any other.
//
// THE DESIGN. top's undeclared `shared` connects echild's electrical port
// and the cug_d port of a leaf instantiated inside the generate block `g`.
//
// DERIVATION, basic resolution (§7.4.4.1, Annex F.2.1 step 4):
//   top.shared: children e.port (electrical) and g.l.port (cug_d): analog,
//     electrical.
//   Mixed ports: g.l's port (upper electrical, lower cug_d), in top.
//   One instance, in top: N = 1.
// The bridge loads `shared` with 1 kohm and top drives 1 mA into it:
// V(shared) = 1e-3 * 1000 = 1.0. A tool that joined the generate block's
// port with no bridge leaves `shared` with no conductance.
//
//! lrm 7.8.4
//! lrm 7.8.4:1
//! lrm 7.8.4:5
//! lrm 6.9.3
//! solve
//! checks 1
`include "check.vh"
discipline cug_d; domain discrete; enddiscipline
connectmodule cug_bridge(a, d);
  inout a; electrical a;
  inout d; cug_d d;
  analog I(a) <+ V(a) / 1000.0;
endmodule
connectrules cug_rules;
  connect cug_bridge;
endconnectrules
module cug_leaf(port); inout port; cug_d port; endmodule
module cug_echild(port); inout port; electrical port; endmodule
module cug_top;
  cug_echild e(shared);
  generate
    if (1) begin : g
      cug_leaf l(shared);
    end
  endgenerate
  analog begin
    I(shared) <+ -1.0e-3;
    `CHECK("one bridge, on g.l's port in top: V = 1 mA * 1 kohm", V(shared), 1.0, 1e-12);
  end
endmodule
