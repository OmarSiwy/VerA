// §7.1: "Connect modules are used in the language to resolve the mixed-signal
// interaction between modules. These modules can be manually inserted (by the
// user) or automatically inserted (by the simulator) based on rules provided by
// the user." A connect module is a module (A.1.2's third `module_keyword`), and
// nothing in §7.5-§7.8 forbids naming one in an instantiation; §7.7/§7.8 only
// add the AUTOMATIC route. So a user may place a bridge by hand.
//
// The bridge is §7.6 EXAMPLE 2's direction, an a2d (`electrical` input,
// `ddiscrete` output), carrying §7.8.2 Figure 7-7's loading model: one `rin` to
// ground on its analog side. m03_01_merged_is_the_default_one_instance.va counts
// AUTOMATIC insertions with the same load; here exactly one instance is written
// by hand and there is no connectrules block, so nothing else is inserted.
//
// KCL at node `a`: a 1 kohm shunt, a 1 mA source, and the bridge's rin = 1 kohm:
//
//     V/1000 - 1e-3 + V/1000 = 0   =>   V(a) = 0.5 V
//
// A compiler that dropped the instance reads 1.0 V.
//
// The bridge's DIGITAL half is asserted too, because it is the half a connect
// module exists for: `initial cm = 1'b1` runs in the discrete context, and the
// bridge's own analog block reads the reg back through §7.3.1 Table 7-1's `reg`
// row as the integer 1. A compiler that inlined only the analog half never sets
// cm, so that check cannot read 1.
//
//! lrm 7.1
//! lrm 7.6
//! lrm 7.3.1
//! solve
//! xfail E0913: VerA refuses a connect module by name; the flatten inlines a child's analog blocks and drops its digital processes, so `initial cm` would never run
`include "check.vh"
connectmodule ch7_manual_a2d(el, cm);
  input el;
  output cm;
  electrical el;
  ddiscrete cm;
  reg cm;
  parameter real rin = 1000.0 from (0.0:inf);
  initial cm = 1'b1;
  analog begin
    `CHECKI("the hand-placed bridge's digital half ran: Table 7-1 reads reg cm as 1", cm, 1);
    I(el) <+ V(el) / rin;
  end
endmodule

module ch7_manual_top;
  electrical a;
  ddiscrete d;

  ch7_manual_a2d u(a, d);

  analog begin
    I(a) <+ V(a) / 1000.0;
    I(a) <+ -1.0e-3;
    `CHECK("a hand-placed a2d loads node a with its rin: V = 1/(1+1)", V(a), 0.5, 1e-12);
  end
endmodule
