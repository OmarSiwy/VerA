// §7.7.3: "An attribute method can be used with the connect statement to
// specify parameter values to pass into the Verilog-AMS HDL connect module and
// override the default values. ANY PARAMETERS DECLARED IN THE CONNECT MODULE
// CAN BE SPECIFIED."
//
// The list the statement may name is the connect module's declared parameters.
// `#(.vth(0.5))` in A.1.8's `connect_insertion` is A.4.1's
// `parameter_value_assignment`, the production a module instance uses — and on
// an instance a name the module does not declare is an error (§6.3, E0907).
// `ch7_a2d_np` declares exactly one parameter, `threshold`; `vth` is not it.
//
// The positive twin is `connect_parameter_accepted.va` (the same statement with
// `.threshold(0.5)`), and `m03_06_connect_rule_parameter_is_applied.va` runs a
// bridge whose parameter came from the connect statement and asserts it.
//
// WHY THIS NEEDED A FIX. Before 2026-09-24 the names were judged only when an
// inserted bridge was inlined, like any instance's. A connect statement that no
// mixed port selects — this one: the design has no digital segment at all — was
// never judged, so a misspelled parameter passed silently until the day a port
// first matched. The statement is written once, in the `connectrules` block, and
// is now judged there, once, whatever the hierarchy.
//
// Everything else is legal: `ch7_a2d_np` is a `connectmodule` with one
// continuous input and one discrete output (a Table 7-2 pair), and the host
// module is an ordinary resistor.
//
//! lrm 7.7.3
//! lrm 7.7.3:1000
//! reject-only is not a parameter of connect module
//! neighbour connect_parameter_accepted.va
//! neighbour m03_06_connect_rule_parameter_is_applied.va
`include "disciplines.vams"
connectmodule ch7_a2d_np(a, d);
  input a;
  output d;
  electrical a;
  ddiscrete d;
  reg d;
  parameter real threshold = 2.5;
  initial d = 1'b0;
  always @(cross(V(a) - threshold, 1)) d = 1'b1;
endmodule

module ch7_np_host(p);
  inout p;
  electrical p;
  analog I(p) <+ V(p) / 1k;
endmodule

connectrules ch7_np_rules;
  connect ch7_a2d_np #(.vth(0.5));
endconnectrules
