// §7.2.1 gives the discrete domain its meaning — a discipline whose `domain` is
// `discrete` binds its nets to the digital solver — and §7.4.2 is where such a
// net meets discipline resolution. Annex C.4 then removes the binding from this
// dialect: "From 3.6.2.2, Domain binding: the domain binding type discrete
// shall be an error in Verilog-A."
//
// What C.4 makes an error is the BINDING, and the distinction is not a reading:
// C.17 governs the definition and says the opposite of C.4 about it — "A
// Verilog-A implementation shall silently ignore any definition of a discipline
// with a domain of discrete." So a file that only DEFINES `ch7_discrete` and
// never names it on a net demands nothing: a conforming Verilog-A tool ignores
// the definition and compiles clean, which would make this fixture fail the
// tool that obeys the LRM. (It did exactly that until this note was written.)
//
// Hence `ch7_discrete d;` in the module below. That net is the domain binding,
// it is the one thing here that is not ordinary and legal, and it is what a
// diagnostic must be about. The rest — one electrical port, one contribution —
// is deliberately unremarkable.
//
// The pinned substring is the two words together. `discrete` alone would also
// match a diagnostic that merely quoted the discipline's name, since
// `ch7_discrete` contains it, and an unknown-identifier error is not the C.4
// rule. annex_c_analog_subset/07_discrete_domain_binding_rejected.va pins the
// same rule on Annex D's own `ddiscrete`.
//
//! lrm 7.2.1
//! lrm C.4
//! lrm C.17
//! reject domain discrete
//! xfail VerA has no subset gate on domain binding: it records the discipline's discrete flag (ir/lower.zig sets is_discrete) and a net bound to it compiles clean
discipline ch7_discrete;
  domain discrete;
enddiscipline
module ch7_discrete_decl(p);
  inout p; electrical p;
  ch7_discrete d;
  analog I(p) <+ V(p);
endmodule
