// §7.2.1 gives the discrete domain its meaning: a discipline whose `domain` is
// `discrete` declares a net belonging to the digital portion of a mixed-signal
// design, and §7.4.2 is where such a net meets discipline resolution. Declaring
// one and binding a net to it is therefore ordinary Verilog-AMS.
//
// This file USED to demand a diagnostic, on Annex C.4 bullet 1 ("From 3.6.2.2,
// Domain binding: the domain binding type discrete shall be an error in
// Verilog-A"). That is a rule of the Verilog-A SUBSET. VerA targets
// Verilog-AMS, so the fixture was demanding a diagnostic a conforming AMS
// compiler must not emit, and a tool obeying the standard failed it. The AMS
// rule is the one written down here now.
//
// Two halves, and both need saying because C.17 already separates them for the
// subset: the DEFINITION of `ch7_discrete` (a discipline with `domain
// discrete` and no nature) must be accepted, and the BINDING `ch7_discrete d;`
// must be accepted too. Nothing else in the module is unusual, deliberately —
// the discrete net's inertness is the claim.
//
// §3.6.3 is why the assertion is on `p` and never on `d`: "Nets declared with a
// natureless discipline ... do not have declared natures, so such nets can not
// be used in analog behavioral descriptions". There is no value of `d` an
// analog block may read, so the observable is that `d` costs the continuous
// half nothing. The oracle is §1.3.1 with one biased node: V(p) is 0.75 V
// exactly, binary-exact.
//
//! lrm 7.2.1
//! lrm 7.4.2
//! lrm 3.6.3
//! bias V(p) = 0.75
`include "check.vh"
discipline ch7_discrete;
  domain discrete;
enddiscipline
module ch7_discrete_decl(p);
  inout p; electrical p;
  ch7_discrete d;
  analog begin
    `CHECKX("a net bound to a discrete-domain discipline leaves the analog node alone", V(p), 0.75);
    I(p) <+ V(p);
  end
endmodule
