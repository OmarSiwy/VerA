// §7.3: "Read operations of nets and variables in both domains are allowed from
// both contexts. Write operations of nets and variables are only allowed from the
// context of their domain." This file verifies that a discrete variable assigned
// in the discrete context (initial block) can be read in the continuous context.
//
//! lrm 7.3
//! lrm 7.3:1000
//! bias V(p) = 0.5
`include "check.vh"
module ch7_cross_domain_read(p);
  inout p;
  electrical p;
  integer counter;
  initial counter = 42;
  analog begin
    `CHECKI("a discrete variable assigned in discrete context is readable in continuous context", counter, 42);
    I(p) <+ V(p);
  end
endmodule
