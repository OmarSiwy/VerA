// §5.10.3.3: the next event uses the latest start_time and period. Changes
// here occur at digital times which precede the old pending timer event.
// Start 0, period 2 ns: initialization fires at 0. At 1 ns period becomes
// 3 ns, so the next event is 3 (the obsolete 2 ns event is canceled).
// At 4 ns period becomes 2 ns: 4 is on the new grid, so it fires immediately.
// At 5 ns period becomes 5 ns: the same reasoning gives a 5 ns event.
// At 6 ns period becomes zero: its start 0 is past, so the one-shot is spent.
// At 7 ns start becomes 9 ns, then at 8 ns start becomes 8 ns: fire at 8,
// replacing the obsolete 9 ns event. Thus event times in ns are 0,3,4,5,8.
// Five time assertions plus the final count give checks = 6. An omitted or
// positive time tolerance permits the deadline itself; comparisons allow one
// digital precision tick, not a fixed-grid assumption about analog timepoints.
// The tick is 100 fs, so the band (1e-4 ns) is finer than the 0.1% a perturbed
// run moves a want by, 1e-3 ns at the 0 ns want (`benchmark -- --perturb`).
// The invalid tolerance neighbour is a10_12_timer_negative_time_tol_rejected.
//! lrm 5.10.3.3
//! lrm 5.10.4
//! lrm 7.3.6.1
//! analysis tran
//! time 0, 10n
//! checks 6
`timescale 1ns/100fs
`include "check.vh"
module timer_runtime_controls(p);
  inout p; electrical p;
  event ev;
  real start, period, t0, t1, t2, t3, t4;
  integer hits;
  initial begin
    start = 0; period = 2n; hits = 0;
    t0 = -1; t1 = -1; t2 = -1; t3 = -1; t4 = -1;
    #1 period = 3n;
    #3 period = 2n;
    #1 period = 5n;
    #1 period = 0;
    #1 start = 9n;
    #1 start = 8n;
  end
  always @(ev) begin
    if (hits == 0) t0 = $realtime;
    if (hits == 1) t1 = $realtime;
    if (hits == 2) t2 = $realtime;
    if (hits == 3) t3 = $realtime;
    if (hits == 4) t4 = $realtime;
    hits = hits + 1;
  end
  analog begin
    @(timer(start, period)) -> ev;
    @(final_step) begin
      `CHECKI("latest absolute controls determine every event", hits, 5);
      `CHECK("initial start is delivered in ns", t0, 0, 0.0001);
      `CHECK("period changed between events replaces pending 2 ns", t1, 3, 0.0001);
      `CHECK("new periodic grid can fire at the control-change time", t2, 4, 0.0001);
      `CHECK("a second new grid can fire at its current multiple", t3, 5, 0.0001);
      `CHECK("changed one-shot start replaces its pending deadline", t4, 8, 0.0001);
    end
    I(p) <+ 0;
  end
endmodule
