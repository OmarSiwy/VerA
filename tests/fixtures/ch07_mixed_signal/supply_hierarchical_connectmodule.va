// §7.8.6 supply sensitive connect module examples: a `connectmodule` that
// bridges a discrete port to a continuous one by scaling against a supply
// reached through a hierarchical name.
//
// THIS FIXTURE'S VERDICT WAS INVERTED. It used to pin `reject E0201` on the
// keyword and argue from annex C (C.9 "Clause 7 only applies to Verilog-AMS
// HDL", C.16's keyword list). See connectmodule_accepted.va for why that
// argument does not reach the conclusion: annex C describes the Verilog-A
// SUBSET, A.1.2's `module_keyword ::= module | macromodule | connectmodule`
// leaves a Verilog-AMS compiler no way to refuse the spelling, and the old
// expectation contradicted ch09_system_tasks/38_driver_update_connectmodule.va,
// which requires the same keyword accepted.
//
// WHAT THIS FILE PINS THAT connectmodule_accepted.va DOES NOT is the second
// thing §7.8.6's example needs in order to be writable at all: the supply is
// reached with a `$root`-prefixed hierarchical name INSIDE AN ACCESS FUNCTION,
// `V($root.global_supply.vdd)`. §6.7's Syntax 6-9 is one production for both
// positions —
//
//     hierarchical_identifier ::=
//         [ $root . ] { identifier [ [ constant_expression ] ] . } identifier
//
// — and §6.7.1 puts an access function's terminal on it: "potential and flow
// access for named and unnamed branches (including port branches) can be done
// hierarchically". So the prefix is legal on a probe terminal, and a compiler
// that took it only in a value position (VerA did: E0208 "expected an
// identifier: found $root") cannot read §7.8.6's example at all.
//
// THE ASSERTIONS, AND WHAT THEY DO NOT CLAIM. Two CHECKs, both in the ordinary
// module, both against decimal literals:
//
//   - `V(p)` at the pinned bias — the verdict that exists only if the whole
//     file, connect module and all, compiled, elaborated and ran;
//   - `V($root.ch7_host.p)`, the §7.8.6 spelling exercised where it can actually
//     be RESOLVED. §6.2.1: "$root is used to unambiguously refer to a top-level
//     instance or to an instance path starting from the root of the instantiation
//     tree", so the absolute path to this module's own port names the same node
//     the bare name does and the value is the same 0.75. Asserting the digit
//     rather than an equality is what stops a compiler that silently dropped the
//     terminal from passing.
//
// THE SUPPLY SENSITIVITY ITSELF IS STILL UNREACHED, and nothing here pretends
// otherwise: `ch7_supply_sensitive` is never instantiated (§7.6 makes a connect
// module the insertion phase's to place, and no fixture yet drives one), so its
// analog body is accepted and never evaluated, `global_supply.vdd` is a path into
// a design this file does not build, and `transition(cm == 1)` never runs.
// §7.8.6's numbers need the insertion phase plus a discrete driver; that is a
// separate requirement and it has no fixture. What is asserted is the two lines
// above and nothing more.
//
//! lrm 7.8.6
//! lrm 6.7.1
//! lrm 6.2.1
//! lrm 6.2.1:1000
//! lrm 6.7.1:1
//! bias V(p) = 0.75
`include "check.vh"
module ch7_host(p);
  inout p; electrical p;
  analog begin
    `CHECK("the §7.8.6 connect module is accepted and the ordinary module runs",
           V(p), 0.75, 1e-15);
    `CHECK("§6.7.1 a $root-prefixed path is a legal access-function terminal",
           V($root.ch7_host.p), 0.75, 1e-15);
    I(p) <+ V(p);
  end
endmodule
connectmodule ch7_supply_sensitive(cm, electrical_out);
  input cm; output electrical_out;
  ddiscrete cm; electrical electrical_out;
  analog V(electrical_out) <+ V($root.global_supply.vdd) * transition(cm == 1);
endmodule
