// §5.10.4: "Named events can be triggered from always and initial blocks, or
// from an analog event statement. This allows control over the enabling of
// multiple actions in other procedures." The clause then prints the shape this
// file uses, an `event` triggered by `-> ana_event` under an analog `@(timer)`
// and waited on by `always @(ana_event)`.
//
// §7.3.6.1 supplies the timing: "When it is determined the event has occurred
// in the analog domain, the statements under the event control shall be
// scheduled in the digital domain at the nearest digital time tick to the time
// of the analog event."
//
// DERIVATION, `timescale 1ns/1ns` so 1 tick = 1 ns and every firing time below
// is already ON a tick — the "nearest tick" rounding has nothing to do, which
// is deliberate: rounding is M02's business, not this row's.
//
// `timer(5n, 10n)` fires at 5n, 15n, 25n, 35n ... (§5.10.3.3: start_time then
// every period). The listed observation times are the midpoints between
// firings:
//
//   t = 0     no firing yet                       hits = 0
//   t = 10n   fired once (5n)                     hits = 1
//   t = 20n   fired twice (5n, 15n)               hits = 2
//   t = 30n   fired three times (5n, 15n, 25n)    hits = 3
//
// oracle ($abstime >= 5n) + ($abstime >= 15n) + ($abstime >= 25n), which is the
// same partition written from the clock instead of from the counter. Because
// the oracle is a function of `$abstime` and not of the position in the `//!
// time` list, it is the right want at EVERY timepoint the simulator reports,
// not only at the four listed ones — which matters, see below.
//
// WHY NOT EXACT EVERYWHERE. An earlier draft asserted this to 0.0 and
// justified it with "the observations are the midpoints between firings, so no
// check is evaluated in the same instant as a trigger and the delivery order
// inside one timepoint never matters". That reasoning is false, and it is
// false because of §5.10.3.3 itself: "The analog simulator places a time point
// within time_tol of an event", and with `time_tol` unspecified "the default
// time point is at, or just beyond, the time of the event". So a conforming
// simulator DOES report analog points at (or just past) 5n, 15n and 25n — the
// `//! time` list is a floor on the reported points, not a ceiling — and this
// analog block, including the check, is evaluated there.
//
// At a point placed exactly AT 5n the value of `hits` is genuinely unsettled:
// §7.3.6.1 schedules the digital statement "at the nearest digital time tick to
// the time of the analog event", here tick 5, and §7.3.6.5 makes the analog
// read take "the digital value calculated for the greatest digital time tick
// which is less than or equal to the analog time" — also tick 5. Whether the
// increment at tick 5 precedes or follows this evaluation is a delta-cycle
// ordering the LRM does not fix, and this row's tests/fixtures/ch07_mixed_signal/m01_SPEC.md at 8b1514d4 defers exactly that to
// M02. At a point placed just BEYOND 5n the increment has certainly happened
// and the oracle is exact again.
//
// So the check admits two counts: the oracle above, or the same partition with
// `>` for `>=`, which differs from it only AT a firing instant and only by that
// firing, undelivered yet. Everywhere else it is exact. (It was a CHECKEQ band
// of 1.0, which also admitted one delivery too many, and could not see its want
// moved by 0.1%: `benchmark -- --perturb`.) It keeps every discriminator the
// paragraph below claims — a tool that never delivers reads 0 against a want of
// 2 at t = 20n and 3 at t = 30n, a tool that latches one delivery reads 1
// against 3 at t = 30n, and a tool that delivers on every analog timestep runs
// away immediately. Drop the `>` arm when M02 settles same-instant delivery
// ordering.
//
// COUNTING, NOT SAMPLING, ON PURPOSE. §5.10.4 says an event "is not made to
// occur by changing the index"; §7.3.6.1 adds, for the analog-variable form of
// the same idea, "An event occurs whenever a value is assigned to the variable,
// regardless of whether the variable changes value or not". A counter is the
// only readout that distinguishes three deliveries from one, so a tool that
// delivered the event once and latched it reads 1 at t = 30n, and a tool that
// delivered it on every analog timestep reads far more than 3.
//
// `hits` is written ONLY by the discrete context (the `initial` and the
// `always`) and read only by the analog one, so §7.2.2's both-contexts rule is
// satisfied and Table 7-1's `integer` row is what carries the value back.
//
// WHAT FAILS TODAY. `error[E0205]: unsupported module item: found `always``.
// `lib/frontend/parser.zig:1265` refuses `always` outside a digital run and
// outside a connect module, so the digital half of §5.10.4 has no
// implementation. The analog half — declaring the event and triggering it from
// an analog event statement — already works
// (`tests/fixtures/annex_a_syntax/17_named_event_trigger.va`).
//
// CITE WITHDRAWN AFTER REVIEW. This file used to also carry `//! lrm 7.3.5`.
// §7.3.5 is *Detecting continuous events in a discrete context* and its content
// is Syntax 7-3's `analog_event_functions` alternative — `always @(cross(...))`.
// This file's digital sensitivity list holds a named event, i.e. Syntax 7-3's
// inherited `hierarchical_event_identifier`, so it exercises none of §7.3.5's
// own rule and the cite was unearned coverage. §7.3.5 is owned in this row by
// `09_cross_event_in_a_digital_always.va`, which is the clause's own `sampler2`.
// The cite comes back here only if this file grows an analog event function in
// the `always`, which would duplicate 09.
//
//! lrm 5.10.4
//! lrm 7.3.6.1
//! lrm 7.3.6.1:1
//! lrm 5.10.3.3
//! lrm 8.4.3.2
//! lrm 8.4.3.2:1
//! lrm 8.4.3.2:1002
//! analysis tran
//! time 0, 10n, 20n, 30n
`timescale 1ns/1ns
`include "check.vh"
module m01_named_event_to_digital(p);
  inout p;
  electrical p;
  event ana_event;
  integer hits;

  initial hits = 0;
  always @(ana_event) hits = hits + 1;

  analog begin
    @(timer(5n, 10n))
      -> ana_event;
    // Exact, but for the analog point §5.10.3.3 places AT a firing instant,
    // where §7.3.6.1 + §7.3.6.5 both land on the same tick and the LRM fixes no
    // order between them: there the firing may be not yet delivered (the `>`
    // count). See WHY NOT EXACT EVERYWHERE above; drop the `>` arm when M02
    // settles the ordering.
    `CHECKI("an analog-triggered named event is delivered once per firing",
            (hits == ($abstime >= 5n) + ($abstime >= 15n) + ($abstime >= 25n)) ||
            (hits == ($abstime > 5n) + ($abstime > 15n) + ($abstime > 25n)), 1);
    I(p) <+ 1m * hits;
  end
endmodule
