// §7.2.3: "a port whose connections are both analog is an analog port". Both
// ports here carry a continuous discipline, so both are read by the potential
// access function regardless of direction — `input` does not make a net
// unreadable from the other side, nor `output` unprobeable.
//
// The body is a potential source on the OUTPUT port, whose branch equation is
// V(driven) - V(sense) = 0 (§5.4.2.2; §1.3.1.2 associated reference
// directions). `sense` is biased to 0.7 V by the testbench; `driven` is left
// free and `//! solve` hands it to the Newton loop, so the second check reads
// the solved value of the output port, not a number the runner wrote in:
//
//     V(driven) = V(sense) = 0.7       V(driven) - V(sense) = 0
//
// RECONCILER, 2026-10-08. An earlier revision biased BOTH ports (driven = 0.2,
// sense = 0.7) and asserted their difference, -0.49999999999999994. A potential
// source between `driven` and ground in parallel with the testbench's 0.2 V
// drive has no solution, so that digit described a point no conforming
// simulator reaches; §5.4.2.2's equation makes the difference 0 at every
// solution. The `//! lrm 4.2` cite went with that digit.
//
// The first check is CHECKX: a `//! bias` value is written into the unknown
// vector verbatim and no arithmetic stands between it and the probe. The second
// allows 1e-12 for the solve.
//
//! lrm 7.2.3
//! bias V(sense) = 0.7
//! solve
//! checks 2
`include "check.vh"
module ch7_analog_port(input electrical sense, output electrical driven);
  analog begin
    `CHECKX("the input analog port is readable", V(sense), 0.7);
    `CHECK("the output analog port is driven to the input's potential, V(driven) - V(sense)",
           V(driven) - V(sense), 0.0, 1e-12);
    V(driven) <+ V(sense);
  end
endmodule
