// §7.8.5.1: "For N-output gates (buf, not) The input will be named in, and
// the outputs reading from left to right will be named out1, out2, out3, and
// so forth." §7.8.5 split: "One module instance is instantiated for each such
// port ... SigName__InstName__PortName", whose purpose is that "Parameters of
// auto-inserted connect instances can be set on an instance-by-instance basis
// with the use of the defparam statement".
//
// THE DESIGN. `buf b1(a, c, x)`: out1 is `a`, out2 is `c`, in is the reg `x`.
// `not n1(d, z)`: out1 is `d`, in is the reg `z`. a, c and d are electrical;
// §3.9 gives every primitive terminal the `default_discipline in force,
// ddiscrete, so each of the three outputs is a mixed OUTPUT port, which the
// d2a (discrete input, continuous output) bridges (§7.6 Example 1: "a mixed
// output port whose upper connection is compatible with discipline electrical
// and whose lower connection is compatible with ddiscrete"). Split gives one
// bridge per port, named
//
//     a__b1__out1    c__b1__out2    d__n1__out1
//
// and the three defparams give them vh = 0.75, 0.25 and 0.5.
//
// DERIVATION. The bridge drives V(el) <+ vh when its discrete side is 1 and 0
// otherwise. x = 1, so buf drives 1 on both outputs (IEEE 1364-2005 §7.3
// Table 7-3); z = 0, so not drives 1 (Table 7-4). So
//     V(a) = 0.75,  V(c) = 0.25,  V(d) = 0.5.
// Bridges named from the wrong output (out1 and out2 swapped) give V(a) =
// 0.25 and V(c) = 0.75; a misspelled name is E0907; a gate left on the
// analog node drives no bridge and every V reads 0. Checked at 10n and 20n,
// after the time-zero activity: 3 checks x 2 points.
//
//! lrm 7.8.5.1
//! lrm 7.8.5
//! lrm 7.8.4
//! lrm 3.9
//! solve
//! analysis tran
//! time 10n, 20n
//! checks 6
`timescale 1ns/1ns
`include "check.vh"

connectmodule b5_pno_d2a(cm, el);
  input cm;
  output el;
  ddiscrete cm;
  electrical el;
  parameter real vh = 1.0;
  analog V(el) <+ (cm === 1'b1) ? vh : 0.0;
endmodule

`default_discipline ddiscrete
module b5_prim_connect_noutput_gate;
  electrical a, c, d;
  reg x, z;

  buf b1(a, c, x);
  not n1(d, z);

  defparam a__b1__out1.vh = 0.75;
  defparam c__b1__out2.vh = 0.25;
  defparam d__n1__out1.vh = 0.5;

  initial begin x = 1'b1; z = 1'b0; end

  analog begin
    `CHECK("buf b1 out1 drives a through a__b1__out1", V(a), 0.75, 1e-12);
    `CHECK("buf b1 out2 drives c through c__b1__out2", V(c), 0.25, 1e-12);
    `CHECK("not n1 out1 drives d through d__n1__out1", V(d), 0.5, 1e-12);
  end
endmodule
`default_discipline

connectrules b5_pno_rules;
  connect b5_pno_d2a split;
endconnectrules
