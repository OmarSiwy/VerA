// §7.3.1 and specification/Vague_Decisions.md VD-113: a `reg` the analog
// context assigns holds every bit IEEE 1364-2005 gives it, and the analog
// context computes the right-hand side of the assignment as IEEE 1364
// sizes it (§5.4.1, §5.5.1-§5.5.3, Table 5-22), so for the same statement
// over the same operand values it computes the bits the digital engine
// computes. That identity is what this fixture asserts; no digits are
// written because the reference is the digital engine's own evaluation.
//
// THE DESIGN. A mixed module (its `initial` block waits). The digital
// process computes d1..d24 from x, y, y2, sx (300-bit `reg`s it owns) and
// the parameters K and R; the analog block computes a1..a24 from the same
// statements. The analog side reads every digital `reg` through its
// `Model` words. Each statement's check is three: every bit equal (a wide
// `==`, itself a 1-bit result in a 300-bit context), bits 30..0, and the top
// 31 bits. The table covers every operator class Table 5-22 sizes:
//   d1 = x + y  (+)
//   d2 = y - x  (- wrapping below zero)
//   d3 = x * y2  (* cut to the width)
//   d4 = x / y2  (/ unsigned)
//   d5 = x % y2  (% unsigned)
//   d6 = -x  (unary -)
//   d7 = ~x ^ y  (~ and ^)
//   d8 = x << 13  (<<)
//   d9 = x >> 13  (>>)
//   d10 = sx >>> 13  (>>> of a signed reg)
//   d11 = sx / y2  (/ with an unsigned operand is unsigned)
//   d12 = sx / K  (/ of two signed operands)
//   d13 = sx % K  (% of two signed operands)
//   d14 = K + x  (a signed integer zero-extended in an unsigned context)
//   d15 = K * 3  (a signed context sign-extends)
//   d16 = x ** 3  (**)
//   d17 = (x < y) + (x > y) * 2 + (sx < K) * 4 + (x == x) * 8  (comparisons)
//   d18 = x == y ? y : x + 1  (?:)
//   d19 = x >> K  (a shift count is unsigned)
//   d20 = x[299:268] * y[15:0]  (selects in the context)
//   d21 = !x + &y + |x + (^x) * 8  (! and the reductions)
//   d22 = (x && y) || 0  (&& and ||)
//   d23 = y + R  (a real operand makes the expression real; rounded back)
//   d24 = R * 1e15  (a real right-hand side)
// Two time points (0 and 1n), three checks per statement: checks 144.
// 300 bits is past `wide_kernels.zw_native_max` (128): the analog side
// computes on 32-bit limbs.
//
//! lrm 7.3.1
//! inherited IEEE 1364-2005 5.4.1
//! inherited IEEE 1364-2005 5.5.2
//! analysis tran
//! time 0, 1n
//! checks 144
`timescale 1ns/1ns
`include "check.vh"
module ch7_wide_reg_matches_digital_300(p);
  inout p; electrical p;
  parameter integer K = -5;
  parameter real R = 2.5;
  reg [299:0] x, y, y2;
  reg signed [299:0] sx;
  reg [299:0] d1, d2, d3, d4, d5, d6, d7, d8, d9, d10, d11, d12, d13, d14, d15, d16, d17, d18, d19, d20, d21, d22, d23, d24;
  reg [299:0] a1, a2, a3, a4, a5, a6, a7, a8, a9, a10, a11, a12, a13, a14, a15, a16, a17, a18, a19, a20, a21, a22, a23, a24;
  reg [39:0] eq;
  initial begin
    x = 300'he5ad2ba9053876d287a58b071497d9217e00061f82cf7ad61ff583ee7b65b3f9d6f99029742;
    y = 300'h30007;
    y2 = 300'h2a597c2a6c6cf6946fe30f9277fa246c6723e8;
    sx = 300'h982ddbaa9543f103b87a1b160822378acea92329bce5e42430654eb3c766d7aec1a1f3a0a33;
    d1 = x + y;
    d2 = y - x;
    d3 = x * y2;
    d4 = x / y2;
    d5 = x % y2;
    d6 = -x;
    d7 = ~x ^ y;
    d8 = x << 13;
    d9 = x >> 13;
    d10 = sx >>> 13;
    d11 = sx / y2;
    d12 = sx / K;
    d13 = sx % K;
    d14 = K + x;
    d15 = K * 3;
    d16 = x ** 3;
    d17 = (x < y) + (x > y) * 2 + (sx < K) * 4 + (x == x) * 8;
    d18 = x == y ? y : x + 1;
    d19 = x >> K;
    d20 = x[299:268] * y[15:0];
    d21 = !x + &y + |x + (^x) * 8;
    d22 = (x && y) || 0;
    d23 = y + R;
    d24 = R * 1e15;
    #1 x = x;
  end
  analog begin
    a1 = x + y;
    eq = a1 == d1;
    `CHECKI("d1 every bit", eq[0], 1);
    `CHECKEQ("d1 bits 30..0", a1[30:0], d1[30:0], 0);
    `CHECKEQ("d1 top 31 bits", a1[299:269], d1[299:269], 0);
    a2 = y - x;
    eq = a2 == d2;
    `CHECKI("d2 every bit", eq[0], 1);
    `CHECKEQ("d2 bits 30..0", a2[30:0], d2[30:0], 0);
    `CHECKEQ("d2 top 31 bits", a2[299:269], d2[299:269], 0);
    a3 = x * y2;
    eq = a3 == d3;
    `CHECKI("d3 every bit", eq[0], 1);
    `CHECKEQ("d3 bits 30..0", a3[30:0], d3[30:0], 0);
    `CHECKEQ("d3 top 31 bits", a3[299:269], d3[299:269], 0);
    a4 = x / y2;
    eq = a4 == d4;
    `CHECKI("d4 every bit", eq[0], 1);
    `CHECKEQ("d4 bits 30..0", a4[30:0], d4[30:0], 0);
    `CHECKEQ("d4 top 31 bits", a4[299:269], d4[299:269], 0);
    a5 = x % y2;
    eq = a5 == d5;
    `CHECKI("d5 every bit", eq[0], 1);
    `CHECKEQ("d5 bits 30..0", a5[30:0], d5[30:0], 0);
    `CHECKEQ("d5 top 31 bits", a5[299:269], d5[299:269], 0);
    a6 = -x;
    eq = a6 == d6;
    `CHECKI("d6 every bit", eq[0], 1);
    `CHECKEQ("d6 bits 30..0", a6[30:0], d6[30:0], 0);
    `CHECKEQ("d6 top 31 bits", a6[299:269], d6[299:269], 0);
    a7 = ~x ^ y;
    eq = a7 == d7;
    `CHECKI("d7 every bit", eq[0], 1);
    `CHECKEQ("d7 bits 30..0", a7[30:0], d7[30:0], 0);
    `CHECKEQ("d7 top 31 bits", a7[299:269], d7[299:269], 0);
    a8 = x << 13;
    eq = a8 == d8;
    `CHECKI("d8 every bit", eq[0], 1);
    `CHECKEQ("d8 bits 30..0", a8[30:0], d8[30:0], 0);
    `CHECKEQ("d8 top 31 bits", a8[299:269], d8[299:269], 0);
    a9 = x >> 13;
    eq = a9 == d9;
    `CHECKI("d9 every bit", eq[0], 1);
    `CHECKEQ("d9 bits 30..0", a9[30:0], d9[30:0], 0);
    `CHECKEQ("d9 top 31 bits", a9[299:269], d9[299:269], 0);
    a10 = sx >>> 13;
    eq = a10 == d10;
    `CHECKI("d10 every bit", eq[0], 1);
    `CHECKEQ("d10 bits 30..0", a10[30:0], d10[30:0], 0);
    `CHECKEQ("d10 top 31 bits", a10[299:269], d10[299:269], 0);
    a11 = sx / y2;
    eq = a11 == d11;
    `CHECKI("d11 every bit", eq[0], 1);
    `CHECKEQ("d11 bits 30..0", a11[30:0], d11[30:0], 0);
    `CHECKEQ("d11 top 31 bits", a11[299:269], d11[299:269], 0);
    a12 = sx / K;
    eq = a12 == d12;
    `CHECKI("d12 every bit", eq[0], 1);
    `CHECKEQ("d12 bits 30..0", a12[30:0], d12[30:0], 0);
    `CHECKEQ("d12 top 31 bits", a12[299:269], d12[299:269], 0);
    a13 = sx % K;
    eq = a13 == d13;
    `CHECKI("d13 every bit", eq[0], 1);
    `CHECKEQ("d13 bits 30..0", a13[30:0], d13[30:0], 0);
    `CHECKEQ("d13 top 31 bits", a13[299:269], d13[299:269], 0);
    a14 = K + x;
    eq = a14 == d14;
    `CHECKI("d14 every bit", eq[0], 1);
    `CHECKEQ("d14 bits 30..0", a14[30:0], d14[30:0], 0);
    `CHECKEQ("d14 top 31 bits", a14[299:269], d14[299:269], 0);
    a15 = K * 3;
    eq = a15 == d15;
    `CHECKI("d15 every bit", eq[0], 1);
    `CHECKEQ("d15 bits 30..0", a15[30:0], d15[30:0], 0);
    `CHECKEQ("d15 top 31 bits", a15[299:269], d15[299:269], 0);
    a16 = x ** 3;
    eq = a16 == d16;
    `CHECKI("d16 every bit", eq[0], 1);
    `CHECKEQ("d16 bits 30..0", a16[30:0], d16[30:0], 0);
    `CHECKEQ("d16 top 31 bits", a16[299:269], d16[299:269], 0);
    a17 = (x < y) + (x > y) * 2 + (sx < K) * 4 + (x == x) * 8;
    eq = a17 == d17;
    `CHECKI("d17 every bit", eq[0], 1);
    `CHECKEQ("d17 bits 30..0", a17[30:0], d17[30:0], 0);
    `CHECKEQ("d17 top 31 bits", a17[299:269], d17[299:269], 0);
    a18 = x == y ? y : x + 1;
    eq = a18 == d18;
    `CHECKI("d18 every bit", eq[0], 1);
    `CHECKEQ("d18 bits 30..0", a18[30:0], d18[30:0], 0);
    `CHECKEQ("d18 top 31 bits", a18[299:269], d18[299:269], 0);
    a19 = x >> K;
    eq = a19 == d19;
    `CHECKI("d19 every bit", eq[0], 1);
    `CHECKEQ("d19 bits 30..0", a19[30:0], d19[30:0], 0);
    `CHECKEQ("d19 top 31 bits", a19[299:269], d19[299:269], 0);
    a20 = x[299:268] * y[15:0];
    eq = a20 == d20;
    `CHECKI("d20 every bit", eq[0], 1);
    `CHECKEQ("d20 bits 30..0", a20[30:0], d20[30:0], 0);
    `CHECKEQ("d20 top 31 bits", a20[299:269], d20[299:269], 0);
    a21 = !x + &y + |x + (^x) * 8;
    eq = a21 == d21;
    `CHECKI("d21 every bit", eq[0], 1);
    `CHECKEQ("d21 bits 30..0", a21[30:0], d21[30:0], 0);
    `CHECKEQ("d21 top 31 bits", a21[299:269], d21[299:269], 0);
    a22 = (x && y) || 0;
    eq = a22 == d22;
    `CHECKI("d22 every bit", eq[0], 1);
    `CHECKEQ("d22 bits 30..0", a22[30:0], d22[30:0], 0);
    `CHECKEQ("d22 top 31 bits", a22[299:269], d22[299:269], 0);
    a23 = y + R;
    eq = a23 == d23;
    `CHECKI("d23 every bit", eq[0], 1);
    `CHECKEQ("d23 bits 30..0", a23[30:0], d23[30:0], 0);
    `CHECKEQ("d23 top 31 bits", a23[299:269], d23[299:269], 0);
    a24 = R * 1e15;
    eq = a24 == d24;
    `CHECKI("d24 every bit", eq[0], 1);
    `CHECKEQ("d24 bits 30..0", a24[30:0], d24[30:0], 0);
    `CHECKEQ("d24 top 31 bits", a24[299:269], d24[299:269], 0);
    I(p) <+ V(p);
  end
endmodule
