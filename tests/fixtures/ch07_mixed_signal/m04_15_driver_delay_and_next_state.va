// §9.23 Supplementary Connectmodule Driver Access System
// Functions, verbatim:
//
//   "These driver access functions are provided for access to digital events
//    which have been scheduled onto a driver but might not have matured by the
//    current simulation time.
//
//    These functions can be used to create analog waveforms which cross a
//    specified threshold at the same time the digital event matures, thus
//    providing accurate registration of analog and digital representations of a
//    signal."
//
// §9.23.1 $driver_delay:
//
//   "$driver_delay returns the delay, from current simulation time, after which
//    the pending state or strength becomes active. If there is no pending value
//    on a signal, it returns the value minus one (-1.0). ... The returned delay
//    value is a real number, which is defined by the `timescale for that module
//    where the call has been made. The fractional part arises from the
//    possibility of a driver being updated by an A2D event off the digital
//    timeticks."
//
// §9.23.2 $driver_next_state:
//
//   "$driver_next_state returns the pending state of the driver, if there is
//    one. If there is no pending state, it returns the current state."
//
// THREE SEPARATE OBLIGATIONS, and this file asserts each of them against the
// case that distinguishes it from the lazy answer:
//
//   1. $driver_delay COUNTS DOWN. It is "from current simulation time", not the
//      delay the assignment was written with — so the same pending event reads
//      15 at t=35 and 5 at t=45. A tool that returned the scheduled delay
//      verbatim prints 20 on both lines.
//   2. The no-pending sentinel is -1.0 and it is a REAL. Not 0, which would be
//      indistinguishable from an event maturing this instant.
//   3. $driver_next_state FALLS BACK to the current state when nothing is
//      pending, rather than returning x or z. Lines 1 and 4 are that fallback;
//      lines 2 and 3 are the pending value, which differs from the current
//      state and therefore cannot be produced by aliasing the two functions.
//
// tests/fixtures/ch09_system_tasks/111_driver_delay_connectmodule_rejected.va
// already pins the call site (an ordinary module may not call this). Nothing
// pins what it RETURNS, because nothing in the suite has a connect module on a
// real net with a scheduled driver behind it. This file is that design.
//
//! lrm 9.23
//! lrm 9.23.1
//! lrm 9.23.2
//! lrm 9.22.3
//! analysis tran
//! time 0, 60n
//! checks 4
//! xfail the §7.8 connect module is inserted (elaborate/insert.zig), but its digital half, which makes the §9.22 calls, is a child's discrete process in a design that needs the event kernel, and the flatten refuses it (E0920); nothing runs a connect module's digital half
//
// HAND DERIVATION — one ordinary driver on the mixed net, so §9.22.1's
// "arbitrarily numbered from 0 to N-1" leaves index 0 as the only legal index
// and the answers below are order-independent.
//
//   t=0   o = 1'b0    a blocking assignment: the driver's current state is 0
//                     immediately and there is nothing pending.
//   t=30  o <= #20 1'b1   schedules the value 1 onto the driver, maturing at
//                     t=50. From t=30 to t=50 the driver has a pending value.
//   t=50  the pending value matures; the driver's current state becomes 1.
//
//   Samples (timescale of the CALLING module is 1ns/1ns, so one tick is 1.0):
//     t=25  state 0, nothing pending
//             $driver_delay      = -1.0
//             $driver_next_state = current state = 1'b0
//     t=35  state 0, pending 1 at t=50
//             $driver_delay      = 50 - 35 = 15.0
//             $driver_next_state = 1'b1
//     t=45  state 0, same pending event
//             $driver_delay      = 50 - 45 = 5.0
//             $driver_next_state = 1'b1
//     t=55  state 1, nothing pending
//             $driver_delay      = -1.0
//             $driver_next_state = current state = 1'b1
//
//   $driver_state is asserted alongside on every line because the pair
//   (state, next_state) = (0, 1) at t=35 and t=45 is what makes lines 2 and 3
//   an assertion about a PENDING value rather than about the settled one. Each
//   line is ONE CHECKI over all three values, so one line is one sample. Every
//   want is an integer or an integer-valued real (-1.0, 15.0, 5.0 are ticks at
//   `timescale 1ns/1ns`), so the comparisons are exact.
//
// HOW THIS FILE ASSERTS. Each sample is a check.vh CHECKI from a digital
// `initial`, and `//! checks 4` makes the count exact: a tool that never runs
// one of the asserting processes (in a connect module it did not insert, say)
// FAILs on the count rather than passing on silence.
// CHECKI is a $strobe, which prints at the END of its time step (IEEE 1364
// §17.1), so each `$finish` is one tick after the last sample — a same-tick
// `$finish` would end the run before that strobe. The transient runs to 60 ns
// so the digital half reaches it. This file used to assert through
// `$display` and a `.expected.txt` transcript, which the `.va` harness never
// reads (tests/harness.zig `fixtureExt`: a golden is honoured for `.v` only), so
// it asserted nothing. How `%b` spells a 32-bit integer is a digital display
// rule and is no longer claimed here.

`timescale 1ns/1ns
`include "disciplines.vams"
`include "check.vh"

connectrules m04_dd_rules;
  connect m04_dd_c2e merged input ddiscrete, output electrical;
endconnectrules

connectmodule m04_dd_c2e(d, a);
  input d;
  output a;
  ddiscrete d;
  electrical a;

  reg out;
  assign d = out;

  initial begin
    out = 1'b0;
    #25 `CHECKI("no_pending_value_is_minus_one",
                ($driver_state(d, 0) == 0) && ($driver_delay(d, 0) == -1.0)
                && ($driver_next_state(d, 0) == 0), 1);
    #10 `CHECKI("delay_is_from_now",
                ($driver_state(d, 0) == 0) && ($driver_delay(d, 0) == 15.0)
                && ($driver_next_state(d, 0) == 1), 1);
    #10 `CHECKI("delay_counts_down",
                ($driver_state(d, 0) == 0) && ($driver_delay(d, 0) == 5.0)
                && ($driver_next_state(d, 0) == 1), 1);
    #10 `CHECKI("after_maturity_next_state_is_the_current_state",
                ($driver_state(d, 0) == 1) && ($driver_delay(d, 0) == -1.0)
                && ($driver_next_state(d, 0) == 1), 1);
    #1 $finish(0);
  end

  analog V(a) <+ 0.0;
endmodule

module m04_dd_drv(o);
  output o;
  ddiscrete o;
  reg o;
  initial begin
    o = 1'b0;
    #30 o <= #20 1'b1;   // a value scheduled onto the driver, maturing at t=50
  end
endmodule

module m04_dd_load(a);
  inout a;
  electrical a;
  electrical g;
  ground g;
  analog I(a, g) <+ V(a, g) / 1.0e3;
endmodule

module m04_dd_top;
  electrical net;

  m04_dd_drv  dr(.o(net));
  m04_dd_load ld(.a(net));
endmodule
