// A.6.2 `initial_construct ::= initial statement`: the statement needs no
// timing control. IEEE 1364-2005 §9.9.1 (via VAMS §1.1): "The initial
// construct shall execute only once"; §7.2.2 puts its assignments in the
// discrete context. So an untimed `initial` block whose body is not a constant
// (a system task, a write computed from a variable) is a digital process, and
// it runs exactly as the same body behind `#0` does.
//
// #57: VerA ran `initial #0 begin ... end` on the mixed-signal kernel and
// refused the untimed copy with E0433, as if a zero delay made the block legal.
//
// DERIVATION, `timescale 1ns/1ns`. Each block runs once at time 0:
// k = 2, then state = k + 1 = 3; k0 = 2, then state0 = k0 + 1 = 3. Both are
// integers, so 3 is exact and the checks are CHECKI's. They are read from
// t = 1n on, after both blocks have run; at t = 0 each check states the
// literal against itself, because whether the analog solve at 0 sees a
// time-0 digital write is a clause-8 ordering question this file does not ask
// (ch08_scheduling/analog_digital_initial_order.va is the constant-shape
// file for that instant).
//
// The constant-shape neighbour, folded with no kernel, is
// digital_initial_accepted.va.
//
//! lrm A.6.2
//! lrm 7.2.2
//! inherited IEEE 1364-2005 9.9.1
//! analysis tran
//! time 0, 1n, 2n
`timescale 1ns/1ns
`include "check.vh"
module ch7_initial_untimed_process_runs(p);
  inout p; electrical p;
  integer k, state, k0, state0;
  initial begin
    $display("an untimed initial block runs");
    k = 2;
    state = k + 1;
  end
  initial #0 begin
    $display("an initial block behind #0 runs");
    k0 = 2;
    state0 = k0 + 1;
  end
  analog begin
    `CHECKI("an untimed initial block runs as a digital process", ($abstime > 0.5n) ? state : 3, 3);
    `CHECKI("the same body behind #0 gives the same value", ($abstime > 0.5n) ? state0 : 3, 3);
    I(p) <+ V(p);
  end
endmodule
