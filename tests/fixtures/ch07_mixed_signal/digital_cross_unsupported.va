// §7.3.6.1 analog event appearing in a digital event control: an `always` block
// waits on `cross()`, and the statements under it "shall be scheduled in the
// digital domain at the nearest digital time tick to the time of the analog
// event".
//
// VerA's CEILING, named by E0437. This file used to cite C.7 ("No digital
// behavior or events are supported in Verilog-A") as conformance; that is a rule
// of the Verilog-A subset, and the source is legal Verilog-AMS. What is missing
// is the A2D half of the kernel: a monitor that watches the analog event and
// posts the digital process at the rounded tick. The positive row for the same
// clause is m01_09_cross_event_in_a_digital_always.va.
//
//! lrm 7.3.5
//! lrm 7.3.6.1
//! reject E0437
module ch7_digital_cross(p);
  inout p; electrical p; integer d;
  always @(cross(V(p), +1)) d = 1;
endmodule
