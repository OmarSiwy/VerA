// §7.3.6.1 analog event appearing in a digital event control: an `always` block
// waits on `cross()`, and the statements under it "shall be scheduled in the
// digital domain at the nearest digital time tick to the time of the analog
// event".
//
// C.7 removes the digital half from this dialect — "No digital behavior or
// events are supported in Verilog-A" — so the `always` block is an unsupported
// module item and the rejection is conformance, not debt. Nothing in a
// Verilog-A tool has a digital time tick for the event to be scheduled onto.
//
//! lrm 7.3.5
//! lrm 7.3.6.1
//! lrm C.7
//! reject E0205
module ch7_digital_cross(p);
  inout p; electrical p; integer d;
  always @(cross(V(p), +1)) d = 1;
endmodule
