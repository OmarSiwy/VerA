// §5.10.3.1: time_tol and expr_tol "represent the maximum allowable error
// between the true crossing point and when the event triggers"; "both
// tolerances shall be satisfied at the crossing". §7.3.5 puts cross() in a
// digital event control, where the mixed coordinator cuts each analog step
// that jumps a crossing back toward it.
//
// A time_tol of 1e-30 s cannot be met near 3.3 ns: one ulp of 3.3e-9 s is
// 2^-81 = 4.1e-25 s, so no two representable times lie closer than that
// around the step. The tightest box VerA can give is the pair of adjacent
// floats that holds the step, and it delivers the event from there
// (specification/Vague_Decisions.md §7). Before #35 that pair was a fixed
// point: the -1 -> 3 step puts the secant's crossing a quarter of the way
// in, which rounds back onto the lower float, so each step re-solved there,
// lost the crossing and advanced nothing, and the run hung.
//
// DERIVATION: V(vo) is -1 V before 3.3 ns and 3 V from it, so V(vo) rises
// through zero once, at 3.3 ns, and nowhere falls. The event fires once:
// n = 1 from the next declared point on (4 ns), 0 before the crossing.
// `//! solve` makes the testbench solve the netlist, so V(vo) is the
// source's value; without it every probe reads the default 0 V and no
// crossing exists (the testbench's documented default, as in m02_17).
//
//! lrm 5.10.3.1
//! analysis tran
//! solve
//! time 0, 2n, 4n, 6n, 8n
`timescale 1ns/1ns
`include "check.vh"
module cross_time_tol_below_time_resolution(vo);
  inout vo; electrical vo;
  integer n;
  initial n = 0;
  always @(cross(V(vo), +1, 1e-30)) n = n + 1;
  analog begin
    V(vo) <+ ($abstime >= 3.3n) ? 3.0 : -1.0;
    `CHECKI("one rising crossing, delivered once", ($abstime >= 4n) ? n : (($abstime < 3.3n) ? n + 1 : 1), 1);
  end
endmodule
