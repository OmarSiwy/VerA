// §7.3.7 function calls, first sentence: "Digital functions cannot be called
// from within the analog context." The call on the last line is that violation:
// `digital_scale` is declared `function` (not `analog function`), so it is a
// digital function, and its only caller is the analog block.
//
// The rule is MASKED here, not exercised, and the mask is VerA's ceiling rather
// than C.7's subset rule: a non-analog `function` is a digital subprogram, its
// body is digital procedural code, and VerA has no discrete kernel to run one, so
// the declaration dies as an unsupported module item (E0205) before any caller is
// analysed. The domain-crossing check therefore never fires. The other direction
// is no longer masked — analog_function_from_digital_rejected.va reaches E0430
// now — and cross_domain_function_unsupported.va is still masked, by the same
// digital `function` plus an `always` block.
//
//! lrm 7.3.7
//! lrm C.7
//! reject E0205
module ch7_digital_function_from_analog(p);
  inout p; electrical p;
  function real digital_scale;
    input real value;
    digital_scale = 2.0 * value;
  endfunction
  analog I(p) <+ digital_scale(V(p));
endmodule
