// §7.3.1 Table 7-1, the `bit` row: a discrete bit grouping read from a
// continuous context becomes an INTEGER, and "if the bus width is less than 31
// bits, the higher bits of the integer are set to zero (0)". The sign bit (bit
// 31) "is always set to zero" and "the lowest bit of the bit grouping is mapped
// to the zeroth bit of the integer".
//
// So an 8-bit grouping of all ones reads as +255, not -1: 8'hff = 2^8 - 1 =
// 255, and bits 8 through 31 of the integer are the zeros Table 7-1 requires. A
// tool that sign-extended the bus reads -1 here; one that dropped the grouping
// reads 0. This is the LEGAL half of the width boundary — the illegal half is
// discrete_bus_over31_rejected.va, and the two must not agree on a verdict.
//
// The driver is the LRM's own idiom: §7.3.2's `converter` example assigns its
// discrete net from an `initial` block and reads it from `analog`. §7.2.2
// permits it — `r` is assigned in the discrete context only, and the continuous
// context merely READS it.
//
//! lrm 7.3.1
// WHY THIS IS STILL XFAIL, AND WHAT BLOCKS IT. `reg [7:0] r;` and `initial r =
// 8'hff;` now parse and are recorded — the declaration becomes an integer, which
// is Table 7-1's own mapping — and nothing about the arithmetic below is
// missing. What blocks the file is the SUITE: four green fixtures pin `//! reject
// E0205` on the identical construct, a constant assignment in a digital
// `initial` block. Accepting this file necessarily fails all four. See the xfail
// line for the list; re-verdicting them is an owner decision about whether annex
// C binds VerA, and not something an implementation change can settle.
//
//! xfail blocked by a contradiction inside the suite, not by a missing capability: `reg [7:0] r` and `initial r = 8'hff` parse and are recorded now, but annex_c_analog_subset/13_digital_initial_rejected.va, ch07_mixed_signal/digital_initial_unsupported.va, ch07_mixed_signal/discrete_real_from_analog_unsupported.va and ch08_scheduling/analog_digital_initial_order_unsupported.va are all green and all pin `reject E0205` on a constant assignment in an `initial` block — three of them arguing that the refusal IS conformance under C.7/C.9 — so no implementation satisfies this fixture and those four at once
`include "check.vh"
module ch7_discrete_bus_narrow(p);
  inout p; electrical p;
  reg [7:0] r;
  initial r = 8'hff;
  analog begin
    `CHECKI("an 8-bit grouping is zero-extended into the integer, not sign-extended", r, 255);
    I(p) <+ V(p);
  end
endmodule
