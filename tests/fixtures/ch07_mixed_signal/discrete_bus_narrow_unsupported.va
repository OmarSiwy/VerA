// §7.3.1 Table 7-1, the `bit` row: a discrete bit grouping read from a
// continuous context becomes an INTEGER, and "if the bus width is less than 31
// bits, the higher bits of the integer are set to zero (0)". The sign bit (bit
// 31) "is always set to zero" and "the lowest bit of the bit grouping is mapped
// to the zeroth bit of the integer".
//
// So an 8-bit grouping of all ones reads as +255, not -1: 8'hff = 2^8 - 1 =
// 255, and bits 8 through 31 of the integer are the zeros Table 7-1 requires. A
// tool that sign-extended the bus reads -1 here; one that dropped the grouping
// reads 0. This is the LEGAL half of the width boundary — the illegal half is
// discrete_bus_over31_rejected.va, and the two must not agree on a verdict.
//
// The driver is the LRM's own idiom: §7.3.2's `converter` example assigns its
// discrete net from an `initial` block and reads it from `analog`. §7.2.2
// permits it — `r` is assigned in the discrete context only, and the continuous
// context merely READS it.
//
//! lrm 7.3.1
//! xfail VerA implements no discrete context: `reg [7:0] r` is E0205 (unsupported module item) and so is the `initial` block, so nothing ever holds the grouping Table 7-1 maps
`include "check.vh"
module ch7_discrete_bus_narrow(p);
  inout p; electrical p;
  reg [7:0] r;
  initial r = 8'hff;
  analog begin
    `CHECKI("an 8-bit grouping is zero-extended into the integer, not sign-extended", r, 255);
    I(p) <+ V(p);
  end
endmodule
