// §7.3.1 Table 7-1, the `bit` row: "Discrete bit and bit groupings (buses
// and part selects) are accessed in the continuous context as integer
// numbers. ... The lowest bit of the bit grouping is mapped to the zeroth
// bit of the integer. ... Access of discrete bit groupings with greater than
// 31 bits is illegal." A 31-bit or narrower select is legal anywhere in a
// wide `reg`, here one the digital kernel owns and changes.
//
// THE DESIGN. A mixed module (its `initial` block waits): the 72-bit `r` is
// digital-owned, 72'hA5_1234_5678_9ABC_DEF0 from time 0 and
// 72'h3C_8765_4321_0FED_CBA9 from 5 ns. Read in hex digits from the right,
// the first is DEF0 (bits 15..0), 9ABC (31..16), 5678 (47..32), 1234
// (63..48), A5 (71..64); the second CBA9, 0FED, 4321, 8765, 3C.
//
// DERIVATION (python3 for the shifts, `(v >> lo) & (2**w - 1)`):
//                 before 5 ns          from 5 ns
//   r[71:64]      0xA5 = 165           0x3C = 60          (bits above 63)
//   r[70:40]      621950038            1015506243         (31 bits, spans 63/64)
//   r[47:32]      0x5678 = 22136       0x4321 = 17185     (wholly in 32..63)
//   r[33:3]       324508638            570276213          (31 bits, spans 31/32)
// The change is placed on a declared point, so the solutions are at 0, 5n
// and 10n whatever extra point a tool takes for the D2A (the solve at 5n
// sees the tick's final value, §8.4.3.2), four checks each: checks 12.
// A tool that held the `reg` as a 32-bit integer reads 0 for the first and
// third rows and the low bits only for the others.
//
//! lrm 7.3.1
//! analysis tran
//! time 0, 5n, 10n
//! checks 12
`timescale 1ns/1ns
`include "check.vh"
module m02_wide_reg_part_select_above_31(p);
  inout p; electrical p;
  reg [71:0] r;
  initial begin
    r = 72'hA5_1234_5678_9ABC_DEF0;
    #5 r = 72'h3C_8765_4321_0FED_CBA9;
  end
  analog begin
    `CHECKI("r[71:64], bits above 63", r[71:64], ($abstime < 5n) ? 165 : 60);
    `CHECKI("r[70:40] spans bits 63 and 64", r[70:40], ($abstime < 5n) ? 621950038 : 1015506243);
    `CHECKI("r[47:32] lies wholly in bits 32 to 63", r[47:32], ($abstime < 5n) ? 22136 : 17185);
    `CHECKI("r[33:3] spans bits 31 and 32", r[33:3], ($abstime < 5n) ? 324508638 : 570276213);
    I(p) <+ V(p);
  end
endmodule
