// §7.7.2 discipline resolution connect statement: "the discipline identifiers
// before the resolveto keyword are the list of compatible disciplines and the
// discipline identifier after is the discipline to be used".
//
// THIS FIXTURE'S VERDICT WAS INVERTED — it pinned `reject E0201` on the
// enclosing `connectrules` from C.9/C.16; see connectrules_accepted.va for why
// that argument does not reach the conclusion for a Verilog-AMS compiler.
//
// WHAT IS ASSERTED. That the §7.7.2 FORM is accepted over LIBRARY disciplines:
// `electrical` and `thermal` are annex D's (disciplines.vams, in the shipped
// prelude), so the statement survives elaboration's name check (E0916 when an
// identifier here names no declared discipline) without this file declaring
// anything of its own. `V(p)` at the pinned bias is the whole-file-compiled
// verdict, as everywhere else in this folder.
//
// WHAT IS NOT CLAIMED. The statement DECIDES nothing here: no net in this
// design is undeclared interconnect with more than one candidate discipline,
// so annex F.2.1 step 4.b's third bullet — the consumer of a resolution list —
// never reaches it. The semantics are pinned where the topology exists to
// exercise them: annex_f_resolution/resolveto_resolution.va (a two-candidate
// net resolved by its matching statement, observed through the resolved
// discipline's own access function) and exclude_resolution.va (the `exclude`
// arm, E0917). §7.4.4.3's coercion of a DECLARED interconnect discipline by
// `resolveto` is not implemented and has no fixture — resolution runs on
// undeclared nets only.
//
// The want is the bias read back, exact in binary, so `CHECKX` is the honest
// macro.
//
//! lrm 7.7.2
//! bias V(p) = 0.75
`include "check.vh"
module ch7_host(p);
  inout p; electrical p;
  analog begin
    `CHECKX("the §7.7.2 resolveto statement is accepted over annex D disciplines", V(p), 0.75);
    I(p) <+ V(p);
  end
endmodule
connectrules ch7_resolution;
  connect electrical, thermal resolveto electrical;
endconnectrules
