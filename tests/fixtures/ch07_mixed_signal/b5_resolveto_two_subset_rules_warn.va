// §7.7.2.1: "When there is no exact fit, then the resolved discipline would
// be based on the subset of the rules specified. If there is more than one
// subset matching a set of disciplines, the simulator shall give a warning
// message and apply the first subset rule that satisfies the current
// scenario."
//
// The clause's own Example 2, transcribed with prefixed names:
//
//     connect x,y,a resolveto y;
//     connect x,y,a resolveto a;
//     connect x,y,b resolveto b;
//     "disciplines x,y would resolve to discipline y with a warning."
//     "disciplines y,b would resolve to b."
//
// NET s_xy. Its child segments are x and y, so the candidate list is {x, y}.
// No rule lists exactly {x, y}; all three rules list a superset of it, so
// more than one subset rule matches: the LRM wants a warning and the first
// subset rule, y.
//
// NET s_yb. Candidates {y, b}: no exact rule, and only the third rule's list
// contains both, so b with no tie. Not a warning case; it is here because
// the example states it, and so that the subset fallback is seen choosing a
// discipline (b) that is the LAST rule's, not merely the first's.
//
// HOW IT IS OBSERVED (connect_rule_exact_then_subset_resolution.va's trick).
// Each discipline binds its own potential nature with its own access function;
// by §3.6.2.1 `YV(s_xy)` compiles only if s_xy resolved to y, `BV(s_yb)` only
// if s_yb resolved to b. Units "V" on every potential and one shared flow
// nature make the four disciplines compatible (§3.11.1), as §7.7.2 requires.
//
// The wants are the biases read back, exact in binary. The `//! warn` line
// names VerA's wording for a subset tie; the LRM fixes that a warning is
// issued, not its text.
//
//! lrm 7.7.2.1
//! lrm 7.7.2.1:2
//! lrm 7.7.2.1:1002
//! lrm 7.7.2
//! warn multiple subset resolution rules apply
//! bias s_xy = 0.75, s_yb = 0.25
`include "check.vh"
nature b5_rs_x_pot; units = "V"; access = XV; abstol = 1u; endnature
nature b5_rs_y_pot; units = "V"; access = YV; abstol = 1u; endnature
nature b5_rs_a_pot; units = "V"; access = AV; abstol = 1u; endnature
nature b5_rs_b_pot; units = "V"; access = BV; abstol = 1u; endnature
nature b5_rs_flow;  units = "A"; access = RSI; abstol = 1p; endnature
discipline b5_rs_x; potential b5_rs_x_pot; flow b5_rs_flow; domain continuous; enddiscipline
discipline b5_rs_y; potential b5_rs_y_pot; flow b5_rs_flow; domain continuous; enddiscipline
discipline b5_rs_a; potential b5_rs_a_pot; flow b5_rs_flow; domain continuous; enddiscipline
discipline b5_rs_b; potential b5_rs_b_pot; flow b5_rs_flow; domain continuous; enddiscipline

connectrules b5_rs_rules;
  connect b5_rs_x, b5_rs_y, b5_rs_a resolveto b5_rs_y;
  connect b5_rs_x, b5_rs_y, b5_rs_a resolveto b5_rs_a;
  connect b5_rs_x, b5_rs_y, b5_rs_b resolveto b5_rs_b;
endconnectrules

module b5_rs_x_leaf(p); inout p; b5_rs_x p; endmodule
module b5_rs_y_leaf(p); inout p; b5_rs_y p; endmodule
module b5_rs_b_leaf(p); inout p; b5_rs_b p; endmodule

module b5_resolveto_two_subset_rules_warn(s_xy, s_yb);
  inout s_xy, s_yb;
  b5_rs_x_leaf l1(s_xy);
  b5_rs_y_leaf l2(s_xy);
  b5_rs_y_leaf l3(s_yb);
  b5_rs_b_leaf l4(s_yb);
  analog begin
    `CHECKX("§7.7.2.1 three subset rules for {x, y}: warn and use the first, y", YV(s_xy), 0.75);
    `CHECKX("§7.7.2.1 one subset rule for {y, b}: b", BV(s_yb), 0.25);
    RSI(s_xy) <+ YV(s_xy);
    RSI(s_yb) <+ BV(s_yb);
  end
endmodule
