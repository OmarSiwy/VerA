// §7.3.6.4 "Analog variables that are only assigned values within analog event
// statements can be used in the expressions that drive continuous assigns, both
// when the target of the continuous assign is a wreal or a traditional Verilog
// wire type (wire, trireg, wor, wand, etc.)." §7.4.2 adds that "the real-value
// nets shall obey the rules imposed by 3.7".
//
// The WREAL half (the wire half is analog_event_variable_drives_continuous_
// assign.va). This file used to be `continuous_assign_unsupported.va`, which
// demanded E0205 on Annex C.4/C.7 grounds — the Verilog-A SUBSET's rules. VerA
// targets Verilog-AMS, where the clause above makes the construct legal, so the
// refusal is withdrawn and the claim is stated positively here.
//
// DERIVATION. At the initial step `level` becomes 0.75 inside an analog event
// statement, so it is exactly the variable the clause permits on the right of
// an `assign`. The wreal `lvl` has that single driver and reads 0.75 (Table 7-1
// real row, "no conversion"; 0.75 is exact). Checked at 10n and 20n only, for
// the same reason as the wire half: at t = 0 the A2D event has not yet reached
// the digital kernel.
//
//! lrm 7.3.6.4
//! lrm 7.4.2
//! analysis tran
//! time 0, 10n, 20n
//! print none
//! xfail the mixed-signal runner's digital half fails with E1100 "undeclared digital variable" on `assign lvl = level`: an analog variable is not visible to the digital engine, where §7.3.6.4 lets an event-assigned one drive a continuous assign (the same gap as analog_event_variable_drives_continuous_assign.va)
`timescale 1ns/1ns
`include "check.vh"
module ch7_analog_event_variable_drives_wreal_assign(out);
  inout out;
  electrical out;
  real level;
  wreal lvl;
  assign lvl = level;

  analog begin
    @(initial_step) level = 0.75;
    if ($abstime > 5n)
      `CHECKX("§7.3.6.4 an event-assigned analog variable drives a wreal continuous assign", lvl, 0.75);
    V(out) <+ lvl;
  end
endmodule
