// §7.3.5, Syntax 7-3 admits an `analog_variable_lvalue` as a digital
// event_expression, and §7.3.6.1 gives it its meaning: "one can also use
// analog variables that are only assigned values in analog event statements in
// a digital event control statement. An event occurs whenever a value is
// assigned to the variable, regardless of whether the variable changes value or
// not."
//
// The legal neighbour of m01_13_same_value_analog_assignment_fires.va: the
// same two timer fires (5n and 15n, the body guarded by $abstime < 20n), but
// each assigns a NEW value, smpl + 1.0 (1.0, then 2.0). Every assignment is an
// event under either reading of "changes value", so n = 2 after both reach
// the digital kernel. This isolates m01_13's claim: if this file passes and
// m01_13 reads 1, the missing event is the same-value one alone.
//
// n is pinned at 22n and later, one declared point clear of the last fire.
//
//! lrm 7.3.5
//! lrm 7.3.6.1
//! lrm 7.3.6.1:1001
//! analysis tran
//! time 0, 6n, 12n, 16n, 22n, 30n
`timescale 1ns/1ns
`include "check.vh"
module m01_changed_analog_assignment_fires(out);
  inout out;
  electrical out;
  real smpl;
  integer n;

  initial n = 0;

  always @(smpl) n = n + 1;

  analog begin
    @(timer(5n, 10n)) if ($abstime < 20n) smpl = smpl + 1.0;
    `CHECKI("every assignment of a new value to smpl is a digital event",
            ($abstime > 20n) ? n : 2, 2);
    V(out) <+ smpl;
  end
endmodule
