// §7.4.4.1 basic discipline resolution: "At each level of the hierarchy where
// continuous and discrete meet for an undeclared net that net segment is
// declared continuous." The clause's own worked example says it twice — "NetC
// resolves to electrical based on continuous (electrical) winning over discrete
// (cmos2)".
//
// `shared` is undeclared and meets a discrete discipline (child1) and a
// continuous one (child2). THE COMPILE IS THE TEST: if resolution picked the
// discrete candidate, `shared` has no potential nature, `V` is not one of its
// access functions, and the module is refused with E0501 — which is what
// happened while `resolveDiscipline` kept the first declared segment and the
// discrete child is instantiated first. The assertion below then only has to
// read the net back to prove it is a solver unknown a continuous access
// function reaches; the harness pins its value, so the digit is the harness's
// and the claim is the access.
//
// Ordering is load-bearing and deliberate: child1 (discrete) is instantiated
// BEFORE child2 (continuous), so a first-wins resolution cannot pass by luck.
//
// Once `shared` resolves continuous, child1's port is mixed (§7.8.4: "one of
// the connections to the port is digital and the other is analog"), and §6.5.7
// lets it join the net only "provided the appropriate connect statements
// exist". `ch7441_bridge` is that statement's module (inout/inout, Table 7-2);
// without it the file is E0927 (`reject_mixed_port_no_connect_statement.va`).
// The bridge sits between child1 and `shared` and adds no current, so the
// resolution and the asserted access are unchanged.
//
//! lrm 7.4.4.1
//! lrm 6.5.7
//! lrm 7.4.4
//! lrm 7.4.4:1
//! lrm 7.4.4.1:1000
//! lrm F.2.1
//! lrm F.2.1:4
//! lrm F.2.1:6
//! bias V(shared) = 0.5
`include "check.vh"
discipline ch7441_discrete;
  domain discrete;
enddiscipline
module ch7441_discrete_child(port);
  inout port; ch7441_discrete port;
endmodule
module ch7441_electrical_child(port);
  inout port; electrical port;
endmodule
connectmodule ch7441_bridge(a, d);
  inout a; electrical a;
  inout d; ch7441_discrete d;
endmodule
connectrules ch7441_rules;
  connect ch7441_bridge;
endconnectrules
module ch7441_parent;
  // `shared` is undeclared; it meets discrete (child1) and electrical (child2)
  // at this level. Resolution must make it electrical.
  ch7441_discrete_child child1(shared);
  ch7441_electrical_child child2(shared);
  analog begin
    `CHECKX("undeclared net where continuous meets discrete resolves to continuous", V(shared), 0.5);
    I(shared) <+ V(shared);
  end
endmodule
