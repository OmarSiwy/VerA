// §7.8.6 supply sensitive connect module examples: a `connectmodule` that
// bridges a discrete port to a continuous one by scaling against a supply
// reached through a hierarchical name.
//
// C.9 settles the verdict for a Verilog-A compiler: "Clause 7 only applies to
// Verilog-AMS HDL", and C.16 lists `connectmodule` among the keywords "not used
// by Verilog-A". The module below keeps the refusal about the connectmodule
// rather than about an empty source file. (A hierarchical reference is refused
// on its own account too — see hierarchy_unsupported.va — but the keyword is
// what this file pins.)
//
//! lrm 7.8.6
//! lrm C.9
//! lrm C.16
//! reject E0201
//! reject connectmodule
module ch7_host(p);
  inout p; electrical p;
  analog I(p) <+ V(p);
endmodule
connectmodule ch7_supply_sensitive(cm, electrical_out);
  input cm; output electrical_out;
  ddiscrete cm; electrical electrical_out;
  analog V(electrical_out) <+ V($root.global_supply.vdd) * transition(cm == 1);
endmodule
