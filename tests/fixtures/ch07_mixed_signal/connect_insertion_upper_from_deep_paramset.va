// §7.8.4: "Driver-receiver segregation and connect module insertion is a
// post elaboration operation. It depends on a complete hierarchical
// examination of each signal in the design." §6.9.3, of discipline
// resolution: "It should also occur after the paramset selection as the
// choice for a particular module instantiation may affect the disciplines
// of the connected nets." §6.4.2: a paramset is selected from those whose
// parameter ranges admit the instance's values.
//
// THE DESIGN. top's undeclared `shared` connects mid's port `p` and
// echild's electrical port. mid's two children are instances of the
// paramset name `cup_sel`, two levels below top. `cup_sel` has two
// paramsets: k in [0:1) selects `cup_dleaf` (a cup_d port), k in [1:2)
// selects `cup_aleaf` (an electrical port). mid passes k = 0 to both.
//
// DERIVATION, basic resolution (§7.4.4.1, Annex F.2.1 step 4):
//   §6.4.2: k = 0 is admitted only by the first paramset: both children
//     are cup_dleaf.
//   mid.p: its child nets are l1.port and l2.port, both cup_d: digital.
//   top.shared: children mid.p (cup_d) and e.port (electrical): analog.
//   Mixed ports: mid's port in top only.
//   §7.8.3.2 split: one instance per mixed port, in top: N = 1.
// The bridge loads `shared` with 1 kohm, top drives 1 mA: V = 1.0.
//   A tool that selected cup_aleaf makes mid.p electrical and inserts none
//   (`shared` has no conductance); one that placed bridges on the two leaf
//   ports reads 0.5; one that cannot read a paramset below the planned
//   level refuses (E0929).
//
//! lrm 7.8.4
//! lrm 6.4.2
//! lrm 6.9.3
//! lrm 6.9.3:1
//! lrm F.2.1
//! solve
//! checks 1
`include "check.vh"
discipline cup_d; domain discrete; enddiscipline
connectmodule cup_bridge(a, d);
  inout a; electrical a;
  inout d; cup_d d;
  analog I(a) <+ V(a) / 1000.0;
endmodule
connectrules cup_rules;
  connect cup_bridge split;
endconnectrules
module cup_dleaf(port); inout port; cup_d port; parameter integer k = 0; endmodule
module cup_aleaf(port); inout port; electrical port; parameter integer k = 0; endmodule
paramset cup_sel cup_dleaf;
  parameter integer k = 0 from [0:1);
  .k = k;
endparamset
paramset cup_sel cup_aleaf;
  parameter integer k = 1 from [1:2);
  .k = k;
endparamset
module cup_echild(port); inout port; electrical port; endmodule
module cup_mid(p);
  inout p;
  cup_sel #(.k(0)) l1(p);
  cup_sel #(.k(0)) l2(p);
endmodule
module cup_top;
  cup_mid m(shared);
  cup_echild e(shared);
  analog begin
    I(shared) <+ -1.0e-3;
    `CHECK("one bridge, on mid's port in top: V = 1 mA * 1 kohm", V(shared), 1.0, 1e-12);
  end
endmodule
