// The invalid neighbour of a2d_example_undriven_dnet_reads_z.va: the same
// undriven `wire dnet`, compared against 1'bz with ordinary `==` instead of
// `===`. §7.3.2 admits x and z digits in the analog context only as
// "binary, octal and hexadecimal numeric constants which can contain x and
// z as digits" used with the case equality operators and case statements;
// with `==` the comparison could never test z, so the z constant is refused
// (E0130). The `===` form beside it compiles, reads the z and runs.
//! lrm 7.3.2
//! reject-only E0130
//! neighbour a2d_example_undriven_dnet_reads_z.va
`timescale 1ns/1ns
`include "disciplines.vams"
module a2d_eq_undriven(dnet, anet);
   input dnet;
   output anet;
   wire dnet;
   ddiscrete dnet;
   electrical anet;
   real avar;

   analog begin
      if (dnet == 1'bz)
         avar = 2.5;
      else
         avar = 0;
      V(anet) <+ avar;
   end
endmodule
