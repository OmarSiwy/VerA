// §7.7 connect specification statements. A `connectrules` block names the
// connect modules a mixed-signal elaborator may auto-insert at a
// discrete/continuous port boundary (§7.7.1).
//
// C.9 settles the verdict for a Verilog-A compiler: "Clause 7 only applies to
// Verilog-AMS HDL", and C.16 lists `connect`, `connectrules` and
// `endconnectrules` among the keywords "not used by Verilog-A". Refusing this
// is conformance, not debt — but the refusal has to be ABOUT the construct. A
// module is present below so the file cannot instead be refused for containing
// no module at all, which would say nothing about connect specifications.
//
//! lrm 7.7
//! lrm C.9
//! lrm C.16
//! lrm 7.7.1
//! reject E0201
//! reject connectrules
module ch7_host(p);
  inout p; electrical p;
  analog I(p) <+ V(p);
endmodule
connectrules ch7_rules;
  connect ch7_a2d;
endconnectrules
