// §7.3.2 accessing X and Z bits in a continuous context. The chapter's own
// `converter` example annotates this exact line as illegal:
//
//     var1 = 1'bx;          // error
//
// and the rule above it says why: "it is an error if these operands return x or
// z bit values when solved". An x has no real or integer value to assign, so
// the assignment below is an error in Verilog-AMS HDL as well as in Verilog-A —
// this rejection is conformance in both dialects, not a subset limitation.
// C.3 narrows it further for this one: "support for x and z values is limited
// in the analog block to the mixed signal context".
//
//! lrm 7.3.2
//! lrm C.3
//! reject E0130
module ch7_x_literal(p);
  inout p; electrical p; integer state;
  analog begin state = 1'bx; I(p) <+ state; end
endmodule
