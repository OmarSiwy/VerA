// §7.3.5, second and third sentences: "In Verilog-AMS HDL, monitored continuous
// events can be detected in a discrete context. THE ARGUMENTS TO THESE EVENTS
// ARE IN THE CONTINUOUS CONTEXT."
//
// §7.3.7, first sentence: "Digital functions cannot be called from within the
// analog context."
//
// Together: a `cross()` written in an `always` event control is a digital
// statement, but the expression it monitors is not — it is in the continuous
// context, and a digital function called inside it is called from the analog
// context. `m01_90_digital_function_from_analog_rejected.va` pins §7.3.7 for a
// call inside an `analog` block; this is the other place the LRM puts the
// continuous context, and the one a compiler that decides context by the
// ENCLOSING BLOCK gets wrong.
//
// WHAT THIS PINS THAT NOTHING ELSE DOES. Before 2026-09-24 VerA accepted this
// module: the discrete-context scan walked the `cross()` arguments as digital
// expressions, so `dbl(...)` was an ordinary digital call and the mixed-signal
// kernel evaluated it. The mirror-image argument — the same scan refusing an
// ANALOG function inside the arguments (E0430) — is a separate question and
// is not what this fixture states.
//
// THE FUNCTION IS DELIBERATELY INNOCENT: `dbl` doubles a real, touches nothing
// else, and the call is well-typed, so the only rule it can break is where it
// is called from. The monitored expression `dbl(V(in)) - 2.5` is otherwise the
// clause's own `sampler2` shape (`cross(V(clk) - 2.5, 1)`), and direction 1 is
// an integer, so §5.10.3.1's argument rules (E0517) have nothing to say.
//
//! lrm 7.3.5
//! lrm 7.3.7
//! lrm 7.3.5:1000
//! lrm 7.3.7:1000
//! reject-only E0436
//! neighbour event_bounds_mixed_legal.va
`timescale 1ns/1ns
`include "disciplines.vams"
module ch7_dfunc_in_cross(in, out);
  input in;
  output out;
  electrical in;
  reg out;

  function real dbl(input real x);
    begin
      dbl = 2.0 * x;
    end
  endfunction

  initial out = 1'b0;

  always @(cross(dbl(V(in)) - 2.5, 1))
    out = 1'b1;
endmodule
