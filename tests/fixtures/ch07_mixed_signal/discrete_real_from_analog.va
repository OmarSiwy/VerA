// §7.3.1 Table 7-1, the `real` row: a real owned by the discrete context and
// read from a continuous one is read as a real number, WITH NO CONVERSION. That
// last clause is the whole content of the row, and it is what the assertion
// pins — 1.25 is exact in binary, so a tool that routed the value through an
// integer reads 1, and one that dropped the discrete owner reads §3.2's 0.
//
// §7.2.2 makes the reading legal — `digital_real` is assigned in the discrete
// context ONLY, by the `initial` block, and the analog block merely reads it, so
// there is no both-contexts conflict (both_contexts_assignment_rejected.va is
// the file that has one).
//
// THIS FILE USED TO DEMAND E0205, arguing that C.7 ("No digital behavior or
// events are supported in Verilog-A") deleted the `initial` block and with it the
// discrete owner the real would need, and that C.9 put clause 7 out of reach
// entirely. Both are rules of the Verilog-A SUBSET. VerA targets Verilog-AMS, so
// the file was demanding a diagnostic a conforming AMS compiler must not emit and
// only a subset-only compiler could pass — the inversion
// digital_initial_accepted.va and discrete_discipline.va both had. The subset
// rules are re-scoped, not deleted: they are what a `--std=verilog-a` gate would
// consult, and this compiler has no such gate.
//
// No digital kernel is needed to reach Table 7-1's row, and that is §7.2.2's own
// doing: "the domain of a variable is that of the context from which its value is
// assigned" gives `digital_real` to the discrete context from the SOURCE, the
// block runs once before the analysis, and its constant therefore stands for the
// whole analysis. An `initial` body that is not a constant assignment runs on
// the mixed-signal kernel instead (initial_untimed_process_runs.va).
//
//! lrm 7.3.1
//! lrm 7.2.2
//! lrm C.7
//! lrm C.9
`include "check.vh"
module ch7_discrete_real_from_analog(p);
  inout p; electrical p; real digital_real;
  initial digital_real = 1.25;
  analog begin
    `CHECKX("a discrete-owned real is read from the continuous context with no conversion", digital_real, 1.25);
    I(p) <+ digital_real;
  end
endmodule
