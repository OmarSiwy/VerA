// §7.8.6 supply sensitive connect modules: the supply a connect module
// measures against is passed in as a connect-statement parameter (§7.7.3),
// here a hierarchical name to the supply node as a STRING value — which is how
// §7.8.6's own examples thread `vdd` down ("the supply voltage ... provided as
// a parameter"), and the shape that distinguishes this file from
// connect_parameter_accepted.va's numeric override.
//
// THIS FIXTURE'S VERDICT WAS INVERTED — it pinned `reject E0201` on the
// enclosing `connectrules` from C.9/C.16; see connectrules_accepted.va for why
// that argument does not reach the conclusion for a Verilog-AMS compiler.
//
// WHAT IS ASSERTED. That a §7.7.3 string-valued named override in a connect
// statement is accepted, against a real connect module declaring the string
// parameter (§3.4.1 gives parameters string type). `V(p)` at the pinned bias
// is the whole-file-compiled verdict.
//
// WHAT IS NOT CLAIMED. Supply sensitivity itself. That needs the insertion
// phase to place the bridge and a discrete driver to switch it —
// supply_hierarchical_connectmodule.va's header walks the same boundary from
// the connectmodule side, and its `$root`-prefixed probe is the piece of
// §7.8.6 that IS asserted somewhere. Here the override is parsed and never
// applied (no insertion, no consumer — ConnectInsertion in
// lib/frontend/ast.zig), and `$root.supply.vdd` is text inside a string, not
// a resolved path.
//
// The want is the bias read back, exact in binary, so `CHECKX` is the honest
// macro.
//
//! lrm 7.8.6
//! lrm 7.7.3
//! bias V(p) = 0.75
`include "check.vh"
connectmodule ch7_a2d(a, d);
  input a; output d; electrical a;
  parameter string vddname = "vdd";
endmodule
module ch7_host(p);
  inout p; electrical p;
  analog begin
    `CHECKX("a §7.7.3 string override naming the supply is accepted", V(p), 0.75);
    I(p) <+ V(p);
  end
endmodule
connectrules ch7_supply;
  connect ch7_a2d #(.vddname("$root.supply.vdd"));
endconnectrules
