// §6.5.7: "Ports of both analog and digital discipline may be connected to a
// net provided the appropriate connect statements exist (see 7.7)." §7.8.4:
// "A connection shall be selected for a port only if one of the connections
// to the port is digital and the other is analog. In this case, the port shall
// match one (and only one) connect statement."
//
// `basic_resolution_continuous_beats_discrete.va` without its `connectrules` block: `shared` is undeclared and
// resolves continuous (§7.4.4.1), so child1's discrete port is mixed and no
// connect statement matches it. A port is mixed by the disciplines of its two
// connections, not by whether anything crosses (Vague_Decisions VD-007), so
// the empty bodies change nothing. Zero matches break "one (and only one)" as
// two do (E0922).
//
// Legal neighbour: `basic_resolution_continuous_beats_discrete.va`, the same design plus one connect
// statement, compiles and reads `shared` as a continuous node.
//
//! lrm 7.8.4
//! lrm 7.8.4:2
//! lrm 6.5.7
//! reject-only E0927
//! reject port `port` of `child1`
//! neighbour basic_resolution_continuous_beats_discrete.va
`include "check.vh"
discipline ch7441r_discrete;
  domain discrete;
enddiscipline
module ch7441r_discrete_child(port);
  inout port; ch7441r_discrete port;
endmodule
module ch7441r_electrical_child(port);
  inout port; electrical port;
endmodule
module ch7441r_parent;
  ch7441r_discrete_child child1(shared);
  ch7441r_electrical_child child2(shared);
  analog I(shared) <+ V(shared);
endmodule
