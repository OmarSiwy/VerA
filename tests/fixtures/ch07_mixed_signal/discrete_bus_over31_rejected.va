// §7.3.1 Table 7-1, the `bit` row, last sentence: "Access of discrete bit
// groupings with greater than 31 bits is illegal." This is the only prohibition
// in that row — the mapping rules above it make 8 and 31 bits legal (see
// discrete_bus_narrow_unsupported.va and discrete_bus_31_unsupported.va, which
// must RUN) — so a diagnostic here has to be about the WIDTH and not about
// vector syntax, or the boundary is untested in both directions.
//
// 32 bits is one over the limit, and it is the width that makes the rule
// necessary: bit 31 of a 32-bit grouping has nowhere to go, because Table 7-1
// also requires the integer's sign bit to be zero.
//
// VerA now reports the WIDTH, at E0222, which is the whole point of the file.
// It also still reports the `reg` itself (E0205 — it implements no discrete
// context, so the two legal-width siblings are refused too), and that is
// exactly why the pinned substring here is the RULE and not a code: what tells
// this file apart from those two is the presence of the width diagnostic, not
// the fact that something was rejected.
//
//! lrm 7.3.1
//! reject bit grouping wider than 31 bits
module ch7_discrete_bus_over31(p);
  inout p; electrical p;
  reg [31:0] r;
  initial r = 32'h00000001;
  analog I(p) <+ r;
endmodule
