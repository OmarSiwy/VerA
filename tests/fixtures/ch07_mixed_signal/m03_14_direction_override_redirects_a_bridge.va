// §7.7.1 connect_port_overrides, the DIRECTION form:
//
//     connect_port_overrides ::= ...
//       | output discipline_identifier , input discipline_identifier
//
// "It is also possible to override the port directions of the connect module,
// which allows a module to be used both as a unidirectional and bidirectional
// connect module ... the specified directions are used to define the type of
// connect module."
//
// THE MODULE. `m03_a2d` is declared in §7.6 Example 2's shape: continuous
// `el` is the INPUT, discrete `cm` the OUTPUT. Example 2 says such a module
// "can bridge a mixed output port whose upper connection is compatible with
// discipline ddiscrete and whose lower connection is compatible with
// electrical, or a mixed input port whose upper connection is compatible with
// discipline electrical and whose lower connection is compatible with
// ddiscrete". The port below is neither: it is an OUTPUT port whose LOWER
// connection is `ddiscrete` and whose upper connection is `electrical` — Example
// 1's `d2a` case. As declared, `m03_a2d` does not match it and nothing would
// be inserted.
//
// THE OVERRIDE. The statement
//     connect m03_a2d #(.rin(1500.0)) output electrical, input ddiscrete;
// re-directs the continuous side to OUTPUT and the discrete side to INPUT (each
// override discipline names its side by domain, §7.8: "When two disciplines
// are specified in a connect statement, one shall be discrete and the other
// continuous"), which is the d2a type, so `u1.q` now matches it — and it is the
// only connect statement, so the match is unique (§7.8.4). The disciplines are
// the module's own, so §7.7.1's compatibility requirement holds trivially.
//
// DERIVATION. One inserted instance (merged, the §7.8.3 default; there is one
// port anyway) with rin = 1500 from §7.7.3's parameter list. Its analog block
// is a load to ground (§7.8.2 Figure 7-7's model). Top: 1 kohm shunt, 1 mA
// source. KCL at `b`:
//
//     V/1000 - 1e-3 + V/1500 = 0
//     V * (3 + 2)/3000 = 1e-3
//     V(b) = 0.6
//
// Separating answers: a direction override that is parsed and ignored leaves
// `m03_a2d` in the a2d role, which does not match an output port, so nothing
// is inserted and V(b) = 1.0. An override applied but the parameter list
// dropped reads 1e-3/(1/1000 + 1/1000) = 0.5.
//
// This half used to share m03_07_discipline_and_direction_overrides.va with an
// inout/inout statement, which §3.11.1 made match this port as well; see that
// file's header for why the two cannot share one connectrules.
//
//! lrm 7.7.1
//! lrm 7.7.3
//! lrm 7.6
//! lrm 7.8.4
//! lrm 7.7.1:2
//! lrm 7.7.3:1000
//! solve
`include "check.vh"

connectmodule m03_a2d(el, cm);
  input el;
  output cm;
  electrical el;
  ddiscrete cm;
  reg cm;
  parameter real rin = 1000.0 from (0.0:inf);
  analog I(el) <+ V(el) / rin;
  initial cm = 1'b0;
endmodule

module m03_dout(q);
  output q;
  ddiscrete q;
  // No process and no `reg`: §7.8.4 selects on the two connections'
  // disciplines and the port DIRECTION, so the declaration alone makes this a
  // mixed output port. (A `reg q` here would be a second variable on the one
  // digital segment the bridge's own `reg cm` sits on, which the flatten, which
  // joins a port to its actual, cannot hold apart.)
endmodule

module m03_top;
  electrical b;

  m03_dout u1(b);

  analog begin
    I(b) <+ V(b) / 1000.0;
    I(b) <+ -1.0e-3;
    `CHECK("§7.7.1 direction override: the a2d re-directed output/input bridges an output port, rin=1.5k",
           V(b), 0.6, 1e-12);
  end
endmodule

connectrules m03_rules;
  connect m03_a2d #(.rin(1500.0)) output electrical, input ddiscrete;
endconnectrules
