// §9.22, paragraphs 2-4, verbatim:
//
//   "Access to individual drivers and net resolution is necessary for accurate
//    implementation of connect modules (see 7.5). A driver of a signal is a
//    process which assigns a value to the signal, or a connection of the signal
//    to an output port of a module instance or simulation primitive.
//
//    The driver access functions described here only access drivers found in
//    ordinary modules and not to those found in connect modules. Driver access
//    functions can only be called from connect modules."
//
// and §9.22.1:
//
//   "$driver_count returns an integer representing the number of drivers
//    associated with the signal in question. ... The drivers are arbitrarily
//    numbered from 0 to N-1, where N is the total number of ordinary drivers
//    contributing to the signal value."
//
// TWO SENTENCES THAT PULL IN OPPOSITE DIRECTIONS, AND THAT IS THE POINT. The
// call site must be a connect module, and the connect module's OWN driver must
// not be counted. §9.22.6 forces the collision to be real rather than
// hypothetical: the connect module drives its digital port ("assign d = out;"),
// so at the netlist level `d` genuinely has three drivers here. The clause says
// the answer is two.
//
// tests/fixtures/ch09_system_tasks/31_driver_access.va already pins the
// call-site half from the refusing side (an ordinary module may not call these).
// Nothing pins the counting half, because nothing in the suite has ever had a
// connect module INSERTED on a real net. This file is that design.
//
// WHY THE ASSERTION IS A COUNT AND NOT A VOLTAGE. Everything below is decided by
// the elaborated topology: two ordinary output-port connections on the mixed
// net, one connect-module driver, one ordinary receiver. No number here depends
// on the analog solve, on the 1 kohm load, or on when a threshold is crossed —
// so the fixture cannot be made to pass or fail by tightening a tolerance.
//
//! lrm 9.22
//! lrm 9.22.1
//! lrm 7.8.4
//! lrm 9.22.1:1000
//! lrm 9.22:1000
//! analysis tran
//! time 0, 50n
//! checks 2
//
// WHY THE CONNECT STATEMENT IS `inout ddiscrete, inout electrical`. The
// derivation below needs ordinary INPUT ports (receivers) and OUTPUT ports
// (drivers) on ONE digital segment of an electrical net. Read with its own
// directions (`input d`, `output a`), the connect module is §7.6 Example 1's
// d2a, which "can bridge a mixed input port whose upper connection is
// compatible with discipline ddiscrete and whose lower connection is
// compatible with electrical, or a mixed output port whose upper connection is
// compatible with discipline electrical and whose lower connection is
// compatible with ddiscrete". The output ports here match; an input port under
// an electrical upper connection does not, and §7.8.4 has every mixed port
// "match one (and only one) connect statement". Figure 7-9 is the same case:
// under `merged` the ttl inputs and outputs of one electrical signal still get
// two connect modules (bidir and d2a), because §7.8.3.1 groups ports only
// "provided the module is the same". So an earlier draft of this file, which
// kept the d2a directions and assumed one segment, was wrong, and
// lib/ir/elaborate/insert.zig's matching was right. §7.7.1's direction
// override "allows a module to be used both as a unidirectional and
// bidirectional connect module"; with it the statement is Example 3's bidir,
// which "can bridge any mixed port", and `merged` gives every ddiscrete port on
// `net` one instance and one segment.
//
// HAND DERIVATION
//   `net` in m04_dc_top is `electrical`, so it has an analog segment; the three
//   digital modules put ddiscrete ports on it, so it is a MIXED signal (§7.8.4:
//   "signals which have an analog discipline in one or more of the contexts ...
//   and a digital discipline in one or more of the contexts"). The connect
//   statement matches, connect_mode is `merged`, and §7.8.4's fourth insertion
//   rule puts ONE m04_dc_c2e instance between `net` and all three ddiscrete
//   ports.
//
//   Drivers of the digital segment, by §9.22's definition:
//     hi.o   -> a connection of the signal to an output port  -> driver 1
//     lo.o   -> a connection of the signal to an output port  -> driver 2
//     ear.i  -> an INPUT port; a receiver, not a driver       -> not counted
//     the connect module's own `assign d = out;`              -> EXCLUDED by
//                                                                §9.22 para 3
//   so $driver_count(d) == 2.
//
//   The count is a property of elaboration, so it is the same at t=1 and t=40,
//   after every driver has changed value twice. The second sample exists to
//   pin that: an implementation that recomputed the count from "drivers that
//   have assigned something recently" would read 0 at t=1 or would drift.
//
// HOW THIS FILE ASSERTS. Each sample is a check.vh CHECKI from a digital
// `initial`, and `//! checks 2` makes the count exact: a tool that never runs
// one of the asserting processes (in a connect module it did not insert, say)
// FAILs on the count rather than passing on silence.
// CHECKI is a $strobe, which prints at the END of its time step (IEEE 1364
// §17.1), so each `$finish` is one tick after the last sample — a same-tick
// `$finish` would end the run before that strobe. The transient runs to 50 ns
// so the digital half reaches it. This file used to assert through
// `$display` and a `.expected.txt` transcript, which the `.va` harness never
// reads (tests/harness.zig `fixtureExt`: a golden is honoured for `.v` only), so
// it asserted nothing. How `%b` spells a 32-bit integer is a digital display
// rule and is no longer claimed here.

`timescale 1ns/1ns
`include "disciplines.vams"
`include "check.vh"

connectrules m04_dc_rules;
  connect m04_dc_c2e merged inout ddiscrete, inout electrical;
endconnectrules

// §9.22.7's connect module, reduced to the one query this file is about.
connectmodule m04_dc_c2e(d, a);
  input d;
  output a;
  ddiscrete d;
  electrical a;

  reg out;
  // §9.22.6: "the digital port will be used to read the driver values as well
  // as to set the receiver value". This IS a driver of `d`, and it is the one
  // §9.22 paragraph 3 says $driver_count must not see.
  assign d = out;

  initial begin
    out = 1'b0;
    #1;
    `CHECKI("connect_module_driver_is_not_counted", $driver_count(d), 2);
    #39;
    `CHECKI("count_is_elaboration_time_not_activity", $driver_count(d), 2);
    #1 $finish(0);
  end

  analog V(a) <+ 0.0;
endmodule

// Two ordinary drivers, one ordinary receiver.
module m04_dc_drv(o);
  output o;
  ddiscrete o;
  reg o;
  initial begin
    o = 1'b0;
    #10 o = 1'b1;
    #10 o = 1'b0;
  end
endmodule

module m04_dc_ear(i);
  input i;
  ddiscrete i;
endmodule

module m04_dc_load(a);
  inout a;
  electrical a;
  electrical g;
  ground g;
  analog I(a, g) <+ V(a, g) / 1.0e3;
endmodule

module m04_dc_top;
  electrical net;

  m04_dc_drv  hi(.o(net));
  m04_dc_drv  lo(.o(net));
  m04_dc_ear  ear(.i(net));
  m04_dc_load ld(.a(net));
endmodule
