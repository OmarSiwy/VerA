// §7.8.5.1 names the ports of the N-input and N-output gates, the MOS and
// pass switches and the pull sources "for the purpose of naming the connect
// modules", but not those of the enable gates (bufif0, bufif1, notif0,
// notif1). The clause's rule is that "built-in digital primitives ports will
// be provided with predictable names", so VerA names them as it names the
// N-input gates, left to right in IEEE 1364-2005 A.3.1's terminal order
// `( output_terminal , input_terminal , enable_terminal )`: out, in, enable
// (specification/Vague_Decisions.md VD-115). THIS FILE TESTS THAT CHOICE: the
// identifiers below are VerA's, not the LRM's.
//
// THE DESIGN. `bufif1 e1(a, x, en)` has its output on the electrical `a`, a
// mixed OUTPUT port the d2a bridges (§7.6 Example 1). `notif0 e2(y, z, b)` has
// its enable on the electrical `b`, a mixed INPUT port the a2d bridges (§7.6
// Example 2). Split names (§7.8.5): `a__e1__out` and `b__e2__enable`.
//
// DERIVATION. x = 1, en = 1: bufif1 passes x (IEEE 1364-2005 §7.4 Table 7-5),
// so the d2a sees 1 and drives V(a) = vh, which the defparam sets to 0.6.
// The a2d drives its discrete side to 0 at time zero, so e2's enable is 0;
// notif0 is on at enable 0 and drives ~z = ~0 = 1 on y (Table 7-6), and
// `always @(y) yr = y` copies it into a reg the analog block reads. The a2d
// loads b with I(el) <+ V(el)/1000 and the module drives 1 mA into b, so
// V(b) = 1 mA * 1 kohm = 1.0 (no bridge leaves b with no load: no solution).
// A tool that names the enable gate's ports otherwise finds no bridge for
// `a__e1__out` (E0907); one that leaves the gates on the analog nets reads
// V(a) = 0 and yr = x. Checked at 10n and 20n: 3 checks x 2 points.
//
//! lrm 7.8.5.1
//! lrm 7.8.5
//! lrm 7.8.4
//! lrm 3.9
//! solve
//! analysis tran
//! time 10n, 20n
//! checks 6
`timescale 1ns/1ns
`include "check.vh"

connectmodule b5_pen_d2a(cm, el);
  input cm;
  output el;
  ddiscrete cm;
  electrical el;
  parameter real vh = 1.0;
  analog V(el) <+ (cm === 1'b1) ? vh : 0.0;
endmodule

connectmodule b5_pen_a2d(el, cm);
  input el;
  output cm;
  electrical el;
  ddiscrete cm;
  reg cm;
  analog I(el) <+ V(el) / 1000.0;
  initial cm = 1'b0;
endmodule

`default_discipline ddiscrete
module b5_prim_connect_enable_gate;
  electrical a, b;
  wire y;
  reg x, en, z, yr;

  bufif1 e1(a, x, en);
  notif0 e2(y, z, b);

  defparam a__e1__out.vh = 0.6;

  always @(y) yr = y;
  initial begin x = 1'b1; en = 1'b1; z = 1'b0; end

  analog begin
    I(b) <+ -1.0e-3;
    `CHECK("bufif1 e1's out drives a through a__e1__out", V(a), 0.6, 1e-12);
    `CHECK("b__e2__enable's a2d loads b with 1 kohm: V = 1 mA * 1 kohm", V(b), 1.0, 1e-12);
    `CHECKI("notif0 e2's enable reads b__e2__enable's 0: y = ~z = 1", yr, 1);
  end
endmodule
`default_discipline

connectrules b5_pen_rules;
  connect b5_pen_d2a split;
  connect b5_pen_a2d split;
endconnectrules
