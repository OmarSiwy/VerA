// §7.8.5.1: "For single port primitives (pullup, pulldown) the port will be
// named out." A pull source "shall place a logic value 1 [0] on the nets
// connected in its terminal list" (IEEE 1364-2005 §7.8): its terminal is an
// A.3.3 `output_terminal`, so on an electrical net it is a mixed OUTPUT port,
// which the d2a bridges (§7.6 Example 1).
//
// THE DESIGN. `pullup p1(a)` and `pulldown p0(c)`, a and c electrical. Split
// names (§7.8.5): `a__p1__out` and `c__p0__out`. The bridge drives
// V(el) <+ vh at 1, vl at 0 and 0.5 at x or z (§7.3.2's `===`); the
// defparams give a__p1__out vh = 0.8 and c__p0__out vl = 0.15.
//
// DERIVATION. The pullup places 1 and the pulldown 0, each at pull strength,
// the only drivers of their segments: V(a) = vh = 0.8, V(c) = vl = 0.15. A
// bridge whose segment no pull reached reads z and drives 0.5; a pull left on
// the analog node has no bridge to take the defparam (E0907). Checked at 10n
// and 20n: 2 checks x 2 points.
//
//! lrm 7.8.5.1
//! lrm 7.8.5
//! lrm 7.8.4
//! lrm 3.9
//! solve
//! analysis tran
//! time 10n, 20n
//! checks 4
`timescale 1ns/1ns
`include "check.vh"

connectmodule b5_ppl_d2a(cm, el);
  input cm;
  output el;
  ddiscrete cm;
  electrical el;
  parameter real vh = 1.0;
  parameter real vl = 0.0;
  analog V(el) <+ (cm === 1'b1) ? vh : (cm === 1'b0) ? vl : 0.5;
endmodule

`default_discipline ddiscrete
module b5_prim_connect_pull;
  electrical a, c;

  pullup p1(a);
  pulldown p0(c);

  defparam a__p1__out.vh = 0.8;
  defparam c__p0__out.vl = 0.15;

  analog begin
    `CHECK("pullup p1 places 1 on a__p1__out", V(a), 0.8, 1e-12);
    `CHECK("pulldown p0 places 0 on c__p0__out", V(c), 0.15, 1e-12);
  end
endmodule
`default_discipline

connectrules b5_ppl_rules;
  connect b5_ppl_d2a split;
endconnectrules
