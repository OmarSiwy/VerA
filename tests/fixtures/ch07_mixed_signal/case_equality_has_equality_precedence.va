// §7.3.2: "The case equality and case inequality operators have the same
// precedence as the equality operator."
//
// IEEE 1364-2005 Table 5-4 puts `==`, `!=`, `===` and `!==` in one row, so
// every chain below groups left to right. The operands are chosen so that
// grouping the other way — giving `===` or `!==` a different precedence than
// `==` — changes the answer:
//
//   a = 2'b10   b = 2'b10   c = 1'b1
//
//   a === b == c   left: (1) == 1 = 1    === tighter: a === (b == c)
//                                            b == c sizes c to 2'b01, so
//                                            10 == 01 is 0; a === 0 is 0
//   a !== b == c   left: (0) == 1 = 0    !== tighter: a !== 0 is 1
//   a == b === c   left: (1) === 1 = 1   === tighter: a == 0 is 0
//
// The first two catch `===`/`!==` binding tighter on the right; the third
// catches `===` binding tighter where it is the right-hand operator. All three
// agree only when the precedence is equal and the chain associates left. The
// widths matter: `b == c` compares 2'b10 with the zero-extended 2'b01, and
// that is what makes the alternative grouping a different value.
//
// `a`, `b` and `c` are assigned by an initial block (the discrete context) and
// read in the analog block. §7.3.2 supports four-state values in the analog
// context and Table 7-1 carries them in; every bit here is two-state, so
// `===`/`!==` agree with `==`/`!=` and no x enters the result.
//
//! lrm 7.3.2
//! lrm 7.3.2:1001
//! bias V(p) = 0.0
//! lrm 4.2.6:1000
`include "check.vh"
module ch7_case_equality_precedence(p);
  inout p; electrical p;
  reg [1:0] a, b;
  reg c;

  initial begin
    a = 2'b10;
    b = 2'b10;
    c = 1'b1;
  end

  analog begin
    `CHECKI("=== groups with ==", a === b == c, 1);
    `CHECKI("!== groups with ==", a !== b == c, 0);
    `CHECKI("=== does not bind tighter than ==", a == b === c, 1);
    I(p) <+ V(p);
  end
endmodule
