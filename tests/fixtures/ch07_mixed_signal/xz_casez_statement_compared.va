// §7.3.2 lists "the case, casex, and casez statements" among the features that
// carry four-state values into the analog context. IEEE 1364 §9.5.1 (which
// §7.3.2's NOTE defers to) gives casez its meaning: z bits (and `?`) in either
// the case expression or a case item are don't-care conditions; x is not.
//
// This file used to be `xz_casez_statement_unsupported.va`, a `//! reject
// E0130` that its own header called an implementation boundary rather than
// conformance. casez now lowers, so the claim is stated positively. A digital
// driver replaces the undriven `input d`.
//
// DERIVATION, `timescale 1ns/1ns`.
//
//   r1: casez (d) 1'b0: 1.0, default 0.0 — only a z SUBJECT is a don't-care:
//     [0, 20n) d = 1 -> 0.0;  [20n, 40n) d = x -> 0.0  (x vs 0 differ);
//     [40n, 60n) d = z -> 1.0;  [60n, ..) d = 0 -> 1.0
//   r2: casez (d) 1'bz: 1.0, default 0.0 — a z LABEL matches every d -> 1.0
//
// A tool running casez as casex reads r1 = 1.0 at 30n; one running it as
// `case` reads r1 = 0.0 at 50n and r2 = 0.0 at 10n.
//
//! lrm 7.3.2
//! lrm 7.3.2:1
//! analysis tran
//! time 0, 10n, 30n, 50n, 70n
`timescale 1ns/1ns
`include "check.vh"
module ch7_xz_casez_statement(p);
  inout p; electrical p; reg d; real r1, r2;
  initial begin
    d = 1'b1;
    #20 d = 1'bx;
    #20 d = 1'bz;
    #20 d = 1'b0;
  end
  analog begin
    casez (d)
      1'b0: r1 = 1.0;
      default: r1 = 0.0;
    endcase
    casez (d)
      1'bz: r2 = 1.0;
      default: r2 = 0.0;
    endcase
    `CHECKEQ("casez: a z subject bit is a don't-care, an x one is not", r1, ($abstime < 40n) ? 0.0 : 1.0, 0.0);
    `CHECKX("casez: a z label bit is a don't-care", r2, 1.0);
    I(p) <+ V(p) + r1 + r2;
  end
endmodule
