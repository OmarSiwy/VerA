// §8.5.1: "An explicit zero delay (#0) requires that the process be suspended
// and added as an inactive event for the current time so that the process is
// resumed in the next simulation cycle in the current time." Region 3b:
// "Analog macro-process events shall be processed after all active, explicit
// D2A events, inactive events and non blocking assign update events are
// processed." §8.5 (introduction): an analog block "is implicitly sensitive to
// all digital variable references that are not guarded by event control
// statements", and an implicit D2A event "directly cause[s] an analog
// macro-process event".
//
// DERIVATION, `timescale 1ns/1ns`. At tick 10 the initial block writes d = 2
// (region 1), suspends on #0 into region 2, and resumes in the next cycle of
// the same tick to write d = 3. The unguarded read of d makes both writes
// implicit D2A events, and each creates a macro-process event in region 3b,
// which is processed only after regions 1 and 2 are empty, so the 10n solve
// reads d = 3; the intermediate 2 is never an analog value. The run's values:
//
//   t = 0, 5n     d = 1
//   t = 10n, 12n  d = 3        (2 is visible to no analog solve)
//
// A tool that solved the macro-process as soon as d changed in region 1 reads
// 2 at the 10n solve. The explicit (event-controlled) half of the same tick,
// where region 1b DOES see 2, is m02_15_explicit_d2a_per_delta_cycle.va.
//
//! lrm 8.5.1
//! lrm 8.5.1:2
//! lrm 8.5.1:4
//! lrm 8.5.1:1001
//! lrm 8.5
//! lrm 8.5.3.7
//! analysis tran
//! time 0, 5n, 10n, 12n
`timescale 1ns/1ns
`include "check.vh"
module m02_zero_delay_settles_before_the_macro_process(out);
  inout out;
  electrical out;
  integer d;

  initial begin
    d = 1;
    #10 d = 2;
    #0 d = 3;
  end

  analog begin
    `CHECKI("the analog solve at tick 10 sees d after the #0 cycle", d, ($abstime >= 10n) ? 3 : 1);
    V(out) <+ d;
  end
endmodule
