// §7.6 connect module descriptions: a `connectmodule` is the bridge whose "port
// disciplines define the default type of disciplines which shall be bridged".
//
// THIS FIXTURE'S VERDICT WAS INVERTED, AND THE INVERSION IS THE POINT. It used
// to pin `reject E0201` and argue from annex C — "Clause 7 only applies to
// Verilog-AMS HDL" (C.9) and `connectmodule` is on C.16's list of keywords "not
// used by Verilog-A" — concluding that refusing it "is conformance, not debt".
// Both quotes are real and neither supports the conclusion for THIS compiler.
// Annex C describes the Verilog-A SUBSET: C.9's sentence says clause 7 binds a
// Verilog-AMS implementation, and C.16's list is what a subset leaves out. A
// compiler that implements Verilog-AMS is bound by clause 7, and A.1.2 gives it
// no way to refuse the keyword —
//
//     module_declaration ::= { attribute_instance } module_keyword
//         module_identifier [ module_parameter_port_list ] list_of_ports ;
//         { module_item } endmodule
//     module_keyword ::= module | macromodule | connectmodule
//
// — `connectmodule` is the third alternative of the production `module` is the
// first alternative of, and the terminator is the same `endmodule` (annex B
// reserves `endconnectrules` and no `endconnectmodule`).
//
// There was also a second, decisive reason to move: the old expectation
// CONTRADICTED ch09_system_tasks/38_driver_update_connectmodule.va, which needs
// the same keyword ACCEPTED so that §9.22.4's `always @(driver_update d)` has
// the one context §9.22 paragraph 3 permits it in. No implementation could
// satisfy both files at once, so one of them was wrong about the LRM — and the
// annex C argument is the one with no clause behind it.
//
// WHAT IS ASSERTED. Acceptance is the requirement, so the verdict has to be a
// value that exists only if the whole file compiled, elaborated and ran — and it
// has to come from the ORDINARY module, because a connect module is never a
// device on its own (below). `V(p)` at the pinned bias is that value.
//
// THE CONNECT MODULE IS DELIBERATELY FIRST IN THE FILE, and that ordering is a
// second requirement rather than tidiness. §7.6 makes a connect module the thing
// the INSERTION PHASE puts on a mixed net — "the disciplines of mixed nets are
// determined prior to the connect module insertion phase" — so it is a bridge the
// tool instantiates, never a design root a user asked to elaborate. Nothing in
// this file instantiates `ch7_a2d`, and nothing instantiates `ch7_host` either,
// so a compiler that picked "the first module nothing instantiates" as the device
// would elaborate the BRIDGE: one continuous port, no analog block, and the
// assertion below would never run. This verdict is therefore also the statement
// that a connect module is excluded from that choice.
//
//! lrm 7.6
//! lrm C.9
//! lrm C.16
//! lrm 7.5
//! bias V(p) = 0.75
`include "check.vh"
connectmodule ch7_a2d(a, d);
  input a; output d; electrical a;
endmodule

module ch7_host(p);
  inout p; electrical p;
  analog begin
    `CHECK("the §7.6 connectmodule is accepted and is not the elaborated device",
           V(p), 0.75, 1e-15);
    I(p) <+ V(p);
  end
endmodule
