// §7.9: "If the signal has both analog and digital segments in its hierarchy,
// it is a mixed signal. ... All the analog segments of a mixed signal are
// representations of a single analog node. Each of the non-contiguous digital
// segments of a signal shall be represented internally as a separate digital
// signal, with its own state."
//
// THE DESIGN. One electrical signal `a` in the top module, and two child
// ports on it, `u1.din` and `u2.din`, both ddiscrete inputs: two digital
// segments that touch only through the analog node. `connect b5_sss_a2d
// split;` gives each port its own bridge (§7.8.3.2, §7.8.4 "one connect
// module instance per port"), named by §7.8.5 split as a__u1__din and
// a__u2__din (m03_05 pins those names).
//
// Each bridge drives its discrete side with its `level` parameter. The
// defparam sets u1's bridge to 1; u2's keeps the default 0. So at the same
// instant one segment of `a` holds 1 and the other 0. Each receiver reads
// its port in the analog context (§7.3.1, Table 7-1: a one-bit discrete net
// reads as the integer 0 or 1), at the dc point after the time-zero digital
// activity has settled (§8.4.2, m02_01):
//
//   u1.din = 1   (segment a__u1__din)
//   u2.din = 0   (segment a__u2__din)
//
// A tool that kept the two segments as one digital signal has two drivers
// of opposite value on it and reads the same thing (x, or one of them) in
// both receivers, so at least one check fails.
//
// The node itself is one (the first sentence quoted): 1 kohm shunt, 1 mA,
// and the two split bridges' 1 kohm loads give
//     V/1000 * 3 = 1e-3   =>   V(a) = 1/3 = 0.3333333333333333 (python3)
//
//! lrm 7.9
//! lrm 7.9:1
//! lrm 7.9:1001
//! lrm 7.8.3.2
//! lrm 7.8.5
//! lrm 7.8.5.1:1001
//! solve
`include "check.vh"

connectmodule b5_sss_a2d(el, cm);
  input el;
  output cm;
  electrical el;
  ddiscrete cm;
  reg cm;
  parameter real rin = 1000.0 from (0.0:inf);
  parameter integer level = 0 from [0:1];
  analog I(el) <+ V(el) / rin;
  initial cm = level;
endmodule

module b5_sss_din_hi(din);
  input din;
  ddiscrete din;
  analog
    `CHECKI("§7.9 segment a__u1__din holds its own state, 1", din, 1);
endmodule

module b5_sss_din_lo(din);
  input din;
  ddiscrete din;
  analog
    `CHECKI("§7.9 segment a__u2__din holds its own state, 0, at the same time", din, 0);
endmodule

module b5_split_segments_keep_own_state;
  electrical a;

  b5_sss_din_hi u1(a);
  b5_sss_din_lo u2(a);

  defparam a__u1__din.level = 1;

  analog begin
    I(a) <+ V(a) / 1000.0;
    I(a) <+ -1.0e-3;
    `CHECK("§7.9 the analog segments are one node: shunt and two split loads, V = 1/3",
           V(a), 0.3333333333333333, 1e-12);
  end
endmodule

connectrules b5_sss_rules;
  connect b5_sss_a2d split;
endconnectrules
