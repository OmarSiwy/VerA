// §5.10.3.3: after enable returns nonzero, timer runs "as if it had never
// been disabled". The absolute grid is 1,3,5,7 ns. Initially disabled,
// enabled at 2, disabled at 4 and re-enabled at 6: only 3 and 7 ns deliver.
// Re-enable at the off-grid instants 2 and 6 must neither fire immediately
// nor restart the period there. Three final checks give checks = 3.
// Positive 1 ps tolerance permits the exact deadline; one digital tick is
// the comparison tolerance. Constant-invalid time_tol is covered by a10_12.
//! lrm 5.10.3.3
//! analysis tran
//! time 0, 8n
//! checks 3
`timescale 1ns/1ps
`include "check.vh"
module timer_runtime_enable(p);
  inout p; electrical p;
  event ev;
  integer en, hits;
  real first, last;
  initial begin
    en = 0; hits = 0; first = -1; last = -1;
    #2 en = 1;
    #2 en = 0;
    #2 en = 1;
  end
  always @(ev) begin
    hits = hits + 1;
    if (hits == 1) first = $realtime;
    last = $realtime;
  end
  analog begin
    @(timer(1n, 2n, 1p, en)) -> ev;
    @(final_step) begin
      `CHECKI("disabled grid events are suppressed", hits, 2);
      `CHECK("first enable resumes the existing grid in ns", first, 3, 0.001);
      `CHECK("second enable resumes the existing grid in ns", last, 7, 0.001);
    end
    I(p) <+ 0;
  end
endmodule
