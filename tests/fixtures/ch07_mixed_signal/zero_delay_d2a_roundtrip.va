// §8.4.3.3, the zero-delay inverter of Figure 8-3 and the worked timing of
// Figure 8-4. The normative sentence: "Consequently an A2D event that results in
// a D2A event being scheduled with zero (0) delay, shall have its effect
// propagated back to the analog kernel with zero (0) delay."
//
// And the clause's own numbers, verbatim: "If A detects a positive crossing as a
// result of a transient solution at time 5.2e-9, the digital kernel shall report a
// rising edge at A at time 5.0e-9 and falling edge at B at time 5.0e-9, but the
// analog kernel shall see the transition at B begin at time 5.2e-9".
//
// So this fixture is that example, with the same 1ns/1ns timescale and the same
// 5.2 ns crossing, and it asserts all three of those times.
//
// DERIVATION. V(vi) is the same 0.1 V/ns ramp as 04: 0.52 V is 0.02 V above the
// 5 ns sample and 0.02/0.1 = 0.2, so the crossing is at 5.2 ns and round(5.2) = 5.
//
//     tick_a = 5      the A2D edge, quantized (§8.4.3.3 first paragraph)
//     tick_b = 5      the inverter is ZERO delay, so its output edge is at the
//                     SAME digital tick - not tick 6, and not a delta later in
//                     any sense the digital kernel can report
//     ana_b  = 5.2e-9 the D2A wake-up returns to the analog kernel at the analog
//                     crossing time, NOT at the 5.0 ns the digital kernel used
//
// ana_b is the whole point of the clause and the one number a tool gets wrong if
// it "helpfully" snaps the returned D2A to the digital grid: that tool reads
// 5.0e-9 and loses 0.2 ns of analog time, which is time going BACKWARDS relative
// to the 5.2 ns solution the analog kernel already accepted (§8.4.4: "time never
// goes backwards"). A tool that instead defers the D2A to the next analog step
// reads something later than 5.2e-9 and fails the same check from the other side.
//
// The `@(b_dig)` in the analog block is §8.5's explicit D2A event — "Explicit D2A
// events are created when a digital event occurs to which an analog block is
// explicitly sensitive" — so this file also exercises region 1b as a wake-up
// source, which 08 pins for value ordering.
//
// b_dig is given 1 by the §8.4.1 time-zero `initial` AND by the inverter's own
// time-zero evaluation of a_dig = 0, so its pre-crossing value is 1 under either
// resolution of the IEEE 1364 §11 time-zero start order; there is no race for the
// assertion to depend on.
//
// SHAPE OF THE CHECKS, as in 04 and 07: every want is the literal 1. Each got is
// bounded at every point of the run and pinned only at declared points clear of
// the 5.2 ns crossing: the pre-crossing value at <= 5 ns, the post-crossing value
// at >= 6 ns. At the point a conforming simulator inserts within 1p of 5.2 ns
// (§5.10.3.1) nothing is pinned, because which side of the A2D that strobe
// falls on is not the clause's business. Figure 8-4's claim survives in full
// through ana_b: `@(b_dig)` stamps the D2A's analog time once, and that stamp is
// what is read at 6, 8 and 10 ns, to within the cross()'s own 1p time_tol
// (§5.10.3.1's box, as in 04).
//
//! lrm 7.3.6.1:1002
//! lrm 8.4.3.3
//! lrm 8.4.3.3:1
//! lrm 8.4.4
//! lrm 8.5
//! lrm 8.4.3.3:2
//! lrm 8.4.3.3:3
//! lrm 8.4.3.3:4
//! analysis tran
//! time 0, 5n, 6n, 8n, 10n
//! wave V(vi) = 0, 0.5, 0.6, 0.8, 1.0
`timescale 1ns/1ns
`include "check.vh"
module m02_zero_delay_d2a_roundtrip(vi, vo);
  inout vi, vo; electrical vi, vo;
  reg     a_dig, b_dig;
  integer tick_a, tick_b;
  real    ana_b;
  // §3.2: an integer assigned in a DIGITAL context defaults to x, not 0 — only
  // analog-context assignment defaults to zero. Every name seeded here is
  // written from an `always`, so without the seed `n = n + 1` evaluates x + 1 = x
  // forever and the guarded arms below compare x against 0.
  initial begin a_dig = 1'b0; b_dig = 1'b1; tick_a = 0; tick_b = 0; end
  always @(cross(V(vi) - 0.52, +1, 1p, 1u)) begin a_dig = 1'b1; tick_a = $time; end
  always @(a_dig) begin b_dig = ~a_dig; tick_b = $time; end   // the zero delay inverter
  analog begin
    @(b_dig) ana_b = $abstime;
    `CHECKI("the A2D edge at A is reported at digital tick 5",
            (tick_a == 0 || tick_a == 5)
            && (($abstime <= 5n) ? (tick_a == 0) : 1)
            && (($abstime >= 6n) ? (tick_a == 5) : 1), 1);
    `CHECKI("the zero-delay inverter output at B is reported at the SAME tick",
            (tick_b == 0 || tick_b == 5)
            && (($abstime <= 5n) ? (tick_b == 0) : 1)
            && (($abstime >= 6n) ? (tick_b == 5) : 1), 1);
    `CHECKI("but the D2A returns to the analog kernel at 5.2 ns, not at the tick",
            (($abstime <= 5n) ? (ana_b == 0.0) : 1)
            && (($abstime >= 6n) ? (abs(ana_b - 5.2n) <= 1p) : 1), 1);
    `CHECKI("and B has fallen",
            (($abstime <= 5n) ? (b_dig == 1) : 1)
            && (($abstime >= 6n) ? (b_dig == 0) : 1), 1);
    V(vo) <+ b_dig ? 1.0 : 0.0;
  end
endmodule
