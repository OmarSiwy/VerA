// Verilog-AMS LRM 2.4 §9.22.2, verbatim:
//
//   "driver_state returns the current value contribution of a specific driver
//    to the state of the signal. ... driver_index is an integer value between 0
//    and N-1, where N is the total number of drivers contributing to the signal
//    value. The state value is returned as 0, 1, x, or z."
//
// and §9.22.1, the sentence that decides HOW this can be asserted:
//
//   "The drivers are arbitrarily numbered from 0 to N-1."
//
// ARBITRARILY. So `$driver_state(d, 0)` has no required answer — a fixture that
// pinned index 0 to 1'b1 would be pinning one tool's elaboration order, not the
// LRM. What IS required is the MULTISET: every ordinary driver appears exactly
// once somewhere in 0..N-1, with its own current value, and no driver appears
// twice. A histogram over the whole index range is the strongest claim that is
// order-independent, and it is the shape §9.22.6's own example uses:
//
//     for ( i = 0; i < $driver_count(d); i=i+1)
//       if ( $driver_state(d,i) == 1 )
//         num_ones = num_ones + 1;
//       else
//         num_zeros = num_zeros + 1;
//
// This file extends that loop to four buckets instead of two, because §9.22.2
// names four possible returns and the LRM example's else-branch silently files
// x and z under "zeros".
//
// FOUR DRIVERS, FOUR DISTINCT STATES, which is the only arrangement in which
// the histogram determines each driver's contribution uniquely. Three of the
// four are also the states an implementation is most likely to lose: a driver
// holding z contributes nothing to a resolved wire value, so a tool that built
// the list from "drivers that affect the result" drops it and reports N = 3.
//
//! lrm 9.22.1
//! lrm 9.22.2
//! timescale 1ns/1ns
//
// HAND DERIVATION
//   Four ordinary modules drive the mixed net `net`, each holding one constant:
//     one  -> 1'b1      zero -> 1'b0      unk -> 1'bx      hiz -> 1'bz
//   The connect module's own `assign d = out;` driver is excluded (§9.22 para 3,
//   pinned by 10_driver_count_excludes_connectmodule.va), so
//     $driver_count(d) == 4
//   and the loop over 0..3 finds each state exactly once:
//     ones = 1, zeros = 1, xs = 1, zs = 1
//
//   At t=30 `unk` changes from 1'bx to 1'b1 and `hiz` from 1'bz to 1'b0. The
//   count is unchanged (still four ordinary drivers) but the histogram moves to
//     ones = 2, zeros = 2, xs = 0, zs = 0
//   which is the "CURRENT value contribution" half of §9.22.2: the indexed
//   query tracks the driver, it is not a snapshot taken at elaboration.
//
//   Samples are at t=1 and t=40, both clear of the t=30 assignments, so no
//   intra-timestep ordering is asserted.
//
// THE WIDTH OF THE INTEGER COLUMNS. `n`, `ones`, `zeros`, `xs` and `zs` are
// `integer`s; §3.2 gives an integer the range -2**31 .. 2**31-1, i.e. 32 bits.
// %b is the only integer conversion `src/sim/digital.zig` implements; §9.4.3
// Table 9-22 gives %b no width modifier, and IEEE Std 1364 makes the printed
// field width of %b the SIZE OF THE EXPRESSION, not the number of significant
// digits. So every one of those columns is exactly 32 binary digits,
// zero-padded on the left:
//
//   decimal 0 -> 00000000000000000000000000000000
//   decimal 1 -> 00000000000000000000000000000001
//   decimal 2 -> 00000000000000000000000000000010
//   decimal 4 -> 00000000000000000000000000000100
//
// `ok=%b` is the result of an `==`, self-determined at ONE bit, so it stays a
// single digit.
//
// CORRECTED AFTER REVIEW. These columns previously held the minimum-width
// strings "100", "1", "10", "0". VerA's %b is width-exact, and its own passing
// regression in `src/sim/digital.zig` prints
// `integer 11111111111111111111111111111111` for a 32-bit integer, so the old
// transcript failed a conforming implementation and could only be made to pass
// by making %b non-conformant.

`timescale 1ns/1ns
`include "disciplines.vams"

connectrules m04_ds_rules;
  connect m04_ds_c2e merged input ddiscrete, output electrical;
endconnectrules

connectmodule m04_ds_c2e(d, a);
  input d;
  output a;
  ddiscrete d;
  electrical a;

  reg out;
  integer i, n, ones, zeros, xs, zs;

  assign d = out;

  task histogram;
    begin
      n = $driver_count(d);
      ones = 0; zeros = 0; xs = 0; zs = 0;
      for (i = 0; i < n; i = i + 1) begin
        if ($driver_state(d, i) === 1'b1)      ones  = ones  + 1;
        else if ($driver_state(d, i) === 1'b0) zeros = zeros + 1;
        else if ($driver_state(d, i) === 1'bx) xs    = xs    + 1;
        else                                   zs    = zs    + 1;
      end
    end
  endtask

  initial begin
    out = 1'b0;
    #1;
    histogram;
    $display("four_ordinary_drivers got=%b ok=%b", n, n == 4);
    $display("initial_states ones=%b zeros=%b xs=%b zs=%b", ones, zeros, xs, zs);
    #39;
    histogram;
    $display("count_unchanged_after_transitions got=%b ok=%b", n, n == 4);
    $display("states_track_their_drivers ones=%b zeros=%b xs=%b zs=%b",
             ones, zeros, xs, zs);
    $finish(0);
  end

  analog V(a) <+ 0.0;
endmodule

module m04_ds_hold(o);
  parameter integer sel = 0;   // 0 -> 1, 1 -> 0, 2 -> x, 3 -> z
  output o;
  ddiscrete o;
  reg o;
  initial begin
    case (sel)
      0: o = 1'b1;
      1: o = 1'b0;
      2: o = 1'bx;
      default: o = 1'bz;
    endcase
    #30;
    // x and z resolve to known values; 1 and 0 stay put.
    if (sel == 2) o = 1'b1;
    if (sel == 3) o = 1'b0;
  end
endmodule

module m04_ds_load(a);
  inout a;
  electrical a;
  electrical g;
  ground g;
  analog I(a, g) <+ V(a, g) / 1.0e3;
endmodule

module m04_ds_top;
  electrical net;

  m04_ds_hold #(.sel(0)) one (.o(net));
  m04_ds_hold #(.sel(1)) zero(.o(net));
  m04_ds_hold #(.sel(2)) unk (.o(net));
  m04_ds_hold #(.sel(3)) hiz (.o(net));
  m04_ds_load            ld  (.a(net));
endmodule
