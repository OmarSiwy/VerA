// §9.22.3, verbatim:
//
//   "driver_state returns the current value contribution of a specific driver
//    to the state of the signal. ... driver_index is an integer value between 0
//    and N-1, where N is the total number of drivers contributing to the signal
//    value. The state value is returned as 0, 1, x, or z."
//
// and §9.22.1, the sentence that decides HOW this can be asserted:
//
//   "The drivers are arbitrarily numbered from 0 to N-1."
//
// ARBITRARILY. So `$driver_state(d, 0)` has no required answer — a fixture that
// pinned index 0 to 1'b1 would be pinning one tool's elaboration order, not the
// LRM. What IS required is the MULTISET: every ordinary driver appears exactly
// once somewhere in 0..N-1, with its own current value, and no driver appears
// twice. A histogram over the whole index range is the strongest claim that is
// order-independent, and it is the shape §9.22.7's own example uses:
//
//     for ( i = 0; i < $driver_count(d); i=i+1)
//       if ( $driver_state(d,i) == 1 )
//         num_ones = num_ones + 1;
//       else
//         num_zeros = num_zeros + 1;
//
// This file extends that loop to four buckets instead of two, because §9.22.3
// names four possible returns and the LRM example's else-branch silently files
// x and z under "zeros".
//
// FOUR DRIVERS, FOUR DISTINCT STATES, which is the only arrangement in which
// the histogram determines each driver's contribution uniquely. Three of the
// four are also the states an implementation is most likely to lose: a driver
// holding z contributes nothing to a resolved wire value, so a tool that built
// the list from "drivers that affect the result" drops it and reports N = 3.
//
//! lrm 9.22.1
//! lrm 9.22.3
//! analysis tran
//! time 0, 50n
//! checks 10
//! xfail the analog parse refuses the connect module's `task` (E0205: tasks are a digital-parse item), and past it the digital engine implements none of the §9.22 driver-access functions and a mixed module's digital half declares no parameter for m04_ds_hold's `case (sel)` to read
//
// HAND DERIVATION
//   Four ordinary modules drive the mixed net `net`, each holding one constant:
//     one  -> 1'b1      zero -> 1'b0      unk -> 1'bx      hiz -> 1'bz
//   The connect module's own `assign d = out;` driver is excluded (§9.22 para 3,
//   pinned by 10_driver_count_excludes_connectmodule.va), so
//     $driver_count(d) == 4
//   and the loop over 0..3 finds each state exactly once:
//     ones = 1, zeros = 1, xs = 1, zs = 1
//
//   At t=30 `unk` changes from 1'bx to 1'b1 and `hiz` from 1'bz to 1'b0. The
//   count is unchanged (still four ordinary drivers) but the histogram moves to
//     ones = 2, zeros = 2, xs = 0, zs = 0
//   which is the "CURRENT value contribution" half of §9.22.3: the indexed
//   query tracks the driver, it is not a snapshot taken at elaboration.
//
//   Samples are at t=1 and t=40, both clear of the t=30 assignments, so no
//   intra-timestep ordering is asserted.
//
// HOW THIS FILE ASSERTS. Each sample is a check.vh CHECKI from a digital
// `initial`, and `//! checks 10` makes the count exact: a tool that never runs
// one of the asserting processes (in a connect module it did not insert, say)
// FAILs on the count rather than passing on silence.
// CHECKI is a $strobe, which prints at the END of its time step (IEEE 1364
// §17.1), so each `$finish` is one tick after the last sample — a same-tick
// `$finish` would end the run before that strobe. The transient runs to 50 ns
// so the digital half reaches it. This file used to assert through
// `$display` and a `.expected.txt` transcript, which the `.va` harness never
// reads (tests/harness.zig `fixtureExt`: a golden is honoured for `.v` only), so
// it asserted nothing. How `%b` spells a 32-bit integer is a digital display
// rule and is no longer claimed here.

`timescale 1ns/1ns
`include "disciplines.vams"
`include "check.vh"

connectrules m04_ds_rules;
  connect m04_ds_c2e merged input ddiscrete, output electrical;
endconnectrules

connectmodule m04_ds_c2e(d, a);
  input d;
  output a;
  ddiscrete d;
  electrical a;

  reg out;
  integer i, n, ones, zeros, xs, zs;

  assign d = out;

  task histogram;
    begin
      n = $driver_count(d);
      ones = 0; zeros = 0; xs = 0; zs = 0;
      for (i = 0; i < n; i = i + 1) begin
        if ($driver_state(d, i) === 1'b1)      ones  = ones  + 1;
        else if ($driver_state(d, i) === 1'b0) zeros = zeros + 1;
        else if ($driver_state(d, i) === 1'bx) xs    = xs    + 1;
        else                                   zs    = zs    + 1;
      end
    end
  endtask

  initial begin
    out = 1'b0;
    #1;
    histogram;
    `CHECKI("four_ordinary_drivers", n, 4);
    `CHECKI("initial_states ones", ones, 1);
    `CHECKI("initial_states zeros", zeros, 1);
    `CHECKI("initial_states xs", xs, 1);
    `CHECKI("initial_states zs", zs, 1);
    #39;
    histogram;
    `CHECKI("count_unchanged_after_transitions", n, 4);
    `CHECKI("states_track_their_drivers ones", ones, 2);
    `CHECKI("states_track_their_drivers zeros", zeros, 2);
    `CHECKI("states_track_their_drivers xs", xs, 0);
    `CHECKI("states_track_their_drivers zs", zs, 0);
    #1 $finish(0);
  end

  analog V(a) <+ 0.0;
endmodule

module m04_ds_hold(o);
  parameter integer sel = 0;   // 0 -> 1, 1 -> 0, 2 -> x, 3 -> z
  output o;
  ddiscrete o;
  reg o;
  initial begin
    case (sel)
      0: o = 1'b1;
      1: o = 1'b0;
      2: o = 1'bx;
      default: o = 1'bz;
    endcase
    #30;
    // x and z resolve to known values; 1 and 0 stay put.
    if (sel == 2) o = 1'b1;
    if (sel == 3) o = 1'b0;
  end
endmodule

module m04_ds_load(a);
  inout a;
  electrical a;
  electrical g;
  ground g;
  analog I(a, g) <+ V(a, g) / 1.0e3;
endmodule

module m04_ds_top;
  electrical net;

  m04_ds_hold #(.sel(0)) one (.o(net));
  m04_ds_hold #(.sel(1)) zero(.o(net));
  m04_ds_hold #(.sel(2)) unk (.o(net));
  m04_ds_hold #(.sel(3)) hiz (.o(net));
  m04_ds_load            ld  (.a(net));
endmodule
