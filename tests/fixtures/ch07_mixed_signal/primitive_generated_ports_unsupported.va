// annex C: gate primitives and `defparam` are outside Verilog-A.
//! lrm 7.8.5.1
//! lrm C.9
//! reject E0205
//! reject defparam
// EXPECT: error -- built-in primitive ports have specified auto-connector names.
module ch7_primitive_generated_ports(a, b, y);
  input a, b; output y; wire a, b, y;
  and gate_instance(y, a, b);
  defparam y__gate_instance__in1.threshold = 0.5;
endmodule
