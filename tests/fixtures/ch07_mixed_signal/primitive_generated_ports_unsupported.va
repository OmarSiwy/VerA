// §7.8.5.1 port names for Verilog built-in primitives: a built-in gate has no
// declared port names, so the LRM fixes them for the connect modules an
// elaborator auto-inserts. "For N-input gates (and, nand, nor, or, xnor, xor)
// the output will be named out, and the inputs reading from left to right will
// be in1, in2, in3, and so forth" — hence the `a__gate_instance__in1` below,
// the §7.8.5 generated instance name reached by a hierarchical `defparam`.
//
// The three fields are fixed by §7.8.5 case 2 (split): SigName__InstName__Port-
// Name, "where InstName and PortName are the local instance name of the port
// and its instance respectively" — so SigName is the signal AT that port, not
// the instance's output. In `and gate_instance(y, a, b)` the leftmost terminal
// is the output, named `out` and carrying signal `y`; port `in1` carries signal
// `a`. The name is therefore `a__gate_instance__in1`. `y__gate_instance__in1`
// pairs the output's signal with an input's port name and is a name the scheme
// cannot generate — which would matter, since the identifier text is the only
// thing this fixture records.
//
// Only the N-input family is written here. The other five families (N-output
// gates, 3- and 4-port MOS switches, bidirectional pass switches, single-port
// primitives) would be the same test with a different identifier, because the
// convention lives entirely in identifier TEXT that no parser interprets — the
// same reason connect_generated_split_name was deleted. They are recorded in
// COVERAGE.md, not written as fixtures.
//
// The verdict rests on the GATE and on nothing else. `and gate_instance(...)` is
// A.3 primitive_gate_instance, a production VerA does not have and whose meaning
// is a discrete-time one — E0205 — and there is no auto-insertion to name in the
// first place (C.9: "Clause 7 only applies to Verilog-AMS HDL").
//
// This file used to ALSO pin `//! reject defparam`, on the ground that a
// `defparam` is not an analog module item either. That ground is gone: §6.3.1
// defines the parameter_override, A.1.4 makes it a module_or_generate_item, and
// annex_a_syntax/12_defparam.va requires a conforming compiler to ACCEPT one. So
// the line was removed rather than left asserting a rejection that no longer
// happens for that reason. The defparam's own verdict is pinned where it is the
// only construct in the file — ch07_mixed_signal/connect_generated_defparam_-
// unsupported.va, E0907, the path names no parameter of the design. Here the
// parse stops at the gate before elaboration ever sees it.
//
//! lrm 7.8.5.1
//! lrm 7.8.5
//! lrm C.9
//! reject E0205
module ch7_primitive_generated_ports(a, b, y);
  input a, b; output y; wire a, b, y;
  and gate_instance(y, a, b);
  defparam a__gate_instance__in1.threshold = 0.5;
endmodule
