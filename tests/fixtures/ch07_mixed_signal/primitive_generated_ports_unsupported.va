// §7.8.5.1 port names for Verilog built-in primitives: a built-in gate has no
// declared port names, so the LRM fixes them for the connect modules an
// elaborator auto-inserts. "For N-input gates (and, nand, nor, or, xnor, xor)
// the output will be named out, and the inputs reading from left to right will
// be in1, in2, in3, and so forth" — hence the `a__gate_instance__in1` below,
// the §7.8.5 generated instance name reached by a hierarchical `defparam`.
//
// The three fields are fixed by §7.8.5 case 2 (split): SigName__InstName__Port-
// Name, "where InstName and PortName are the local instance name of the port
// and its instance respectively" — so SigName is the signal AT that port, not
// the instance's output. In `and gate_instance(y, a, b)` the leftmost terminal
// is the output, named `out` and carrying signal `y`; port `in1` carries signal
// `a`. The name is therefore `a__gate_instance__in1`. `y__gate_instance__in1`
// pairs the output's signal with an input's port name and is a name the scheme
// cannot generate — which would matter, since the identifier text is the only
// thing this fixture records.
//
// Only the N-input family is written here. The other five families (N-output
// gates, 3- and 4-port MOS switches, bidirectional pass switches, single-port
// primitives) would be the same test with a different identifier, because the
// convention lives entirely in identifier TEXT that no parser interprets — the
// same reason connect_generated_split_name was deleted. They are recorded in
// tests/fixtures/ch07_mixed_signal/COVERAGE.md at 8b1514d4, not written as fixtures.
//
// THE VERDICT RESTS ON THE GENERATED NAME. `a__gate_instance__in1` names no
// parameter of the elaborated design — E0907 — because nothing here is
// mixed: `a`, `b` and `y` have no discipline and there is no `connectrules`,
// so §7.8.4 selects no connection and inserts nothing to bear the name. The
// `defparam` reaches elaboration, elaboration walks the instance tree, and the
// §7.8.5 name is not in it.
//
// THIS FILE HAS NOW TWICE OUTLIVED THE REASON IT WAS RED, and both times the
// line moved rather than the claim. It used to pin `//! reject defparam`, on
// the ground that a `defparam` is not an analog module item; §6.3.1 defines the
// parameter_override, A.1.4 makes it a module_or_generate_item, and
// annex_a_syntax/12_defparam.va requires a conforming compiler to ACCEPT one,
// so that line went. It then pinned `//! reject E0205` at the GATE, on the
// ground that `and gate_instance(...)` is a production VerA does not have. That
// ground is gone on the same terms: A.1.4 makes `gate_instantiation` a
// module_or_generate_item too, §1.1 makes 1364's primitives part of the
// language, and annex_a_syntax/56_gate_instantiation_unsupported.va requires
// the line to be accepted. The gate is now read and left unmodelled out loud
// (W0252), which is a warning and not a refusal.
//
// What is left is the rule the file was always about, and it is a stronger pin
// than either of the two it replaced: §7.8.5.1's identifier text is the only
// thing this fixture records, and E0907 is the diagnostic that says the text
// resolves to nothing. `y__gate_instance__in1` — the name the scheme cannot
// generate — would get the same E0907 today, so the verdict no longer tells the
// two identifiers apart. The positive half, where a gate's port IS mixed and
// `a__g1__in1` is the inserted bridge a defparam retunes, is
// b5_gate_generated_connect_name_defparam.va.
//
//! lrm 7.8.5.1
//! lrm 7.8.5
//! lrm C.9
//! reject-only E0907
//! neighbour ../annex_a_syntax/12_defparam.va
//! neighbour ../annex_a_syntax/56_gate_instantiation_unsupported.va
module ch7_primitive_generated_ports(a, b, y);
  input a, b; output y; wire a, b, y;
  and gate_instance(y, a, b);
  defparam a__gate_instance__in1.threshold = 0.5;
endmodule
