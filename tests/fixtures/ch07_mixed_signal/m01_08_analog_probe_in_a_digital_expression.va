// §7.3.3: "All continuous nets can be probed from a discrete context using
// access functions. All probes which are legal in a continuous context of a
// module are also legal in the discrete context of a module." The clause's own
// example is `sampler`, an `always @(posedge clk) out = V(in);`, and this file
// is that example with a driven clock and a shaped input.
//
// §7.3.6.3 says which analog value the digital read gets: "The expression shall
// be evaluated using the analog value calculated for the time corresponding to
// a real promotion of the digital time at which the expression is evaluated."
//
// `out` is a `real` and not the LRM's `reg`. §7.3.3 is explicit that this is the
// faithful reader — "Because the discrete domain can fully represent all
// continuous types, a continuous variable is fully visible when it is read in a
// discrete context" — and a `reg out` would fold the answer through an integer
// conversion that belongs to Table 7-1's row, not to this clause.
//
// DERIVATION, `timescale 1ns/1ns`. clk is 0 at t = 0 and toggles every 10 ns,
// so its POSITIVE edges are at 10n and 30n and its negative edge is at 20n.
// V(in) is held flat across each positive edge and made to move between them,
// so the answer does not depend on how the harness interpolates the driving
// wave, while an edge picked at the wrong polarity still lands on a different
// number:
//
//   //! time  0     5n    15n   25n   35n
//   //! wave  1.0   1.0   1.0   3.0   3.0        (linear between listed points)
//
//   t = 0     no edge yet                    out = 0.0   (§3.2 default)
//   t = 5n    no edge yet                    out = 0.0
//   edge at 10n, promoted to 10.0e-9, V(in) = 1.0 (flat over [0, 15n])
//   t = 15n                                  out = 1.0
//   t = 25n   the 20n edge is NEGATIVE       out = 1.0
//   edge at 30n, promoted to 30.0e-9, V(in) = 3.0 (flat over [25n, 35n])
//   t = 35n                                  out = 3.0
//
// oracle ($abstime >= 30n) ? 3.0 : ($abstime >= 10n) ? 1.0 : 0.0.
//
// The 20 ns negative edge is the discriminator, and it is placed on the RAMP
// between the two flats on purpose: V(in) there is 2.0, so a tool that sampled
// on both edges reads 2.0 at t = 25n and a tool that sampled on negedge only
// reads 2.0 at t = 25n and t = 35n. Neither can pass by accident.
//
// This runs through the mixed runner: the discrete processes execute
// and the analog assertions observe sampled values on the listed grid.
//
//! lrm 7.3.3
//! lrm 7.3.6.3
//! lrm 7.3.6.3:1
//! lrm 7.3
//! lrm 7.3:1000
//! lrm 7.3.3:1000
//! analysis tran
//! time 0, 5n, 15n, 25n, 35n
//! wave V(in) = 1.0, 1.0, 1.0, 3.0, 3.0
`timescale 1ns/1ns
`include "check.vh"
module m01_probe_from_digital(in, aout);
  inout in, aout;
  electrical in, aout;
  reg clk;
  real out;

  initial begin
    clk = 1'b0;
    #10 clk = 1'b1;
    #10 clk = 1'b0;
    #10 clk = 1'b1;
  end

  always @(posedge clk)
    out = V(in);

  analog begin
    `CHECKEQ("a digital process reads V(in) at the promoted digital time", out, ($abstime >= 30n) ? 3.0 : ($abstime >= 10n) ? 1.0 : 0.0, 0.0);
    V(aout) <+ out;
  end
endmodule
