// §6.3.4: an instance parameter override updates dependent defaults. The
// sampler instance overrides base to 0.2. On the 0.1 V/ns ramp, delta = 0.4 V gives events
// at initialization, 4 ns and 8 ns, while threshold = 0.6 V crosses at 6 ns.
// The parameters delta, threshold, ttol and etol appear only in event arguments.
// The first absdelta time permits etol/slope plus half a 1 fs digital tick;
// the crossing permits ttol plus that rounding error. Four assertions result.
//! lrm 5.10.3.4
//! lrm 5.10.3.1
//! lrm 6.3.4
//! lrm 6.3.3
//! lrm 6.3.3:1
//! lrm 6.3.4:1000
//! analysis tran
//! time 0, 10n
//! wave V(p) = 0.0, 1.0
//! checks 4
`timescale 1ns/1fs
`include "check.vh"
module sampler(p);
  inout p; electrical p;
  parameter real base = pow(2.0, -3.0);
  parameter real delta = 2.0 * base;
  parameter threshold = 3.0 * base;
  parameter real ttol = 1p;
  localparam real etol = 1u;
  parameter real analog_only = 7.0;
  integer n_delta, n_cross;
  real first_delta, crossed;
  initial begin n_delta = 0; n_cross = 0; first_delta = -1; crossed = -1; end
  always @(absdelta(V(p), delta, ttol, etol)) begin
    n_delta = n_delta + 1;
    if (n_delta == 2) first_delta = $realtime;
  end
  always @(cross(V(p) - threshold, +1, ttol, etol)) begin
    n_cross = n_cross + 1;
    crossed = $realtime;
  end
  analog begin
    @(final_step) begin
      `CHECKI("delta count uses the effective parameter", n_delta, 3);
      `CHECK("delta time uses the effective parameter in ns", first_delta, 4.0, 1.05e-5);
      `CHECKI("the parameterized crossing occurs once", n_cross, 1);
      `CHECK("cross time uses the effective threshold in ns", crossed, 6.0, 0.001001);
    end
    I(p) <+ 0.0;
  end
endmodule

module mixed_event_parameters(p); inout p; electrical p; sampler #(.base(0.2)) u(p); endmodule
