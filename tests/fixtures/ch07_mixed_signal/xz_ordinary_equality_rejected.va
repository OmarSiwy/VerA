// §7.3.2 accessing X and Z bits of a discrete net in a continuous context.
//
// The ORDINARY equality operator is what makes it an error. §7.3.2 lists the
// four features that may carry x and z through the analog context — `===`,
// `!==`, the case/casex/casez statements, and x/z numeric constants — and `==`
// is not among them: it returns x when an operand is x, and "it is an error if
// these operands return x or z bit values when solved".
//
// This is x_case_equality_input_net.va with ONE token changed: the clause's
// `a2d` child tests `dnet == 1'bx` instead of `dnet === 1'bx`. That file
// compiles and runs; this one does not, so the operator is the whole difference.
// VerA refuses the x literal outside a `===`/`!==`/case comparison — E0130,
// "x/z digit in a number literal" — which is where the operator decides it.
//
//! lrm 7.3.2
//! lrm 7.3.2:2
//! lrm C.3
//! reject-only E0130
//! neighbour x_case_equality_input_net.va
`timescale 1ns/1ns
`include "disciplines.vams"
module ch7_xz_ordinary_equality(p);
  inout p; electrical p;
  reg d;
  electrical a;
  initial begin
    d = 1'b1;
    #20 d = 1'bx;
  end
  a2d_eq u(d, a);
  analog I(p) <+ V(p);
endmodule

module a2d_eq(dnet, anet);
   input dnet;
   output anet;
   wire dnet;
   ddiscrete dnet;
   electrical anet;
   real avar;

   analog begin
      if (dnet == 1'bx)
         avar = 1;
      else
         avar = 0;
      V(anet) <+ avar;
   end
endmodule
