// The legal neighbour of b5_gate_port_names_not_for_instantiation_rejected.va.
//
// A.3.1: `n_input_gate_instance ::= [ name_of_gate_instance ]
// ( output_terminal , input_terminal { , input_terminal } )`. A gate's
// terminals are connected by position; IEEE 1364-2005 §7.2 (inherited, §1.1):
// "The first terminal in the terminal list shall be an output and the other
// terminals shall be inputs."
//
// This file and the rejected one differ in one thing, the terminal list of
// `g1`: here by position, there by the names §7.8.5.1 invents for connect
// module naming (out, in1, in2).
//
// DERIVATION. b = 1 from tick 0; a = 0 from tick 0, 1 from tick 5. So
// y = a & b is 0 until tick 5 and 1 after. `always @(y) yr = y;` copies the
// net into a reg the analog block reads (§7.3.6.5, as
// ch06_hierarchy/generate_block_gate.va does). The always block is waiting
// long before the tick-5 edge, so the time-zero start order (IEEE 1364 §11)
// does not matter. Checked at the points after tick 5, 10n and 20n: yr = 1.
//
//! lrm A.3.1
//! lrm 1.1
//! analysis tran
//! time 10n, 20n
`timescale 1ns/1ns
`include "check.vh"
module b5_gate_ordered_terminals(p);
  inout p;
  electrical p;
  reg a, b, yr;
  wire y;

  and g1(y, a, b);

  always @(y) yr = y;
  initial begin
    a = 1'b0;
    b = 1'b1;
    #5 a = 1'b1;
  end

  analog begin
    if ($abstime > 6n)
      `CHECKI("and g1(y, a, b) with a = b = 1 drives y = 1", yr, 1);
    I(p) <+ V(p);
  end
endmodule
