// §7.2.2 contexts: "A given variable can be assigned values only in one context
// or the other, but not in both. The domain of a variable is that of the
// context from which its value is assigned", refined two paragraphs later into
// "It shall be an error to assign to a given variable in both contexts."
//
// `sampled` below is assigned by a statement in an `initial` block — the
// discrete context — and by a statement in the `analog` block — the continuous
// one. Both are statements, not declaration assignments: §7.2.2's own source
// note flags that a module-level declaration assignment is read as context-free
// by one paragraph and as an out-of-block discrete assignment by the other, so
// provoking the rule that way would test the ambiguity instead of the rule.
//
// The rule is now EXERCISED rather than masked. VerA still cannot EXECUTE the
// `initial` block and still says so (E0205, at the keyword), but it parses the
// body and judges it, so the conflict is reported at the analog assignment that
// causes it. Reaching it needed no digital engine: the clause decides a
// variable's domain from WHERE ITS ASSIGNMENT IS WRITTEN, not from anything that
// happens at run time, so both contexts' target sets are readable off the
// source.
//
//! lrm 7.2.2
//! lrm C.7
//! reject assigned in both contexts
module ch7_both_contexts(p);
  inout p; electrical p;
  real sampled;
  initial sampled = 1.25;
  analog begin
    sampled = V(p);
    I(p) <+ sampled;
  end
endmodule
