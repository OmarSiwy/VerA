// §7.6: "The port disciplines define the default type of disciplines which
// shall be bridged by the connect module. The directional qualifiers of the
// discrete port determine the default scenarios where the module can be
// instantiated. The following combinations of directional qualifiers are
// supported for the continuous and discrete disciplines of a connect module:"
//
//   Table 7-2    continuous   discrete
//                input        output
//                output       input
//                inout        inout
//
// §7.5 says what the pair is FOR: "The continuous and discrete disciplines of
// the ports of the connect modules and their directions are used to determine
// the circumstances in which the module can be automatically inserted."
//
// `ch7_both_in` declares its continuous port `el` an `input` AND its discrete
// port `dg` an `input` — a pair Table 7-2 does not list. Read against §7.6's
// three worked examples, it can bridge nothing: a d2a (discrete input,
// continuous output) faces a signal flowing digital-to-analog, an a2d the
// other way, a bidir either; two inputs have no side to drive. The `connect`
// statement designates it a connect module (§7.8 "Each connect statement
// designates a module to be a connect module"), and there is no scenario it
// could be inserted in, so the statement is refused.
//
// §7.7.1's direction overrides could have supplied a Table 7-2 pair ("the
// specified directions are used to define the type of connect module"), which
// is why the check reads the pair AFTER the overrides; this statement gives
// none. The positive twins are every `m03_` fixture, whose connect modules are
// the Table 7-2 pairs and are inserted and run.
//
// WHAT THIS PINS THAT NOTHING ELSE DOES. Before 2026-09-24 VerA accepted this
// source and the rule silently never matched any port.
//
//! lrm 7.6
//! lrm 7.5
//! reject-only E0982
`include "disciplines.vams"
connectmodule ch7_both_in(el, dg);
  input el;
  input dg;
  electrical el;
  ddiscrete dg;
  analog I(el) <+ V(el) / 1k;
endmodule

module ch7_dir_host(p);
  inout p;
  electrical p;
  analog I(p) <+ V(p) / 1k;
endmodule

connectrules ch7_dir_rules;
  connect ch7_both_in;
endconnectrules
