// §7.7.1 connect_port_overrides, the DISCIPLINE form:
//
//     connect_insertion ::= connect connectmodule_identifier [ connect_mode ]
//         [ parameter_value_assignment ] [ connect_port_overrides ] ;
//     connect_port_overrides ::=
//         discipline_identifier , discipline_identifier
//       | input discipline_identifier , output discipline_identifier
//       | output discipline_identifier , input discipline_identifier
//       | inout discipline_identifier , inout discipline_identifier
//
// "Connect modules can be reused for different, but compatible disciplines by
// specifying different discipline combinations in which the connect module can
// be used ... where the specified disciplines shall be compatible for both the
// continuous and discrete disciplines of the given connect module."
//
// ONE connect module, `m03_bidir`, is declared inout/inout over
// (electrical, ddiscrete). The child's port has discipline `m03_cmos_io`, a
// natureless discrete discipline, which §3.11.1's Natureless Discipline Rule
// makes compatible with `ddiscrete` ("a natureless discipline is compatible with
// all other disciplines of the same domain") and therefore a legal override
// target under §7.7.1's compatibility requirement.
//
// NET `a`. `u1.dio` is an INOUT port of discipline m03_cmos_io. The statement
//     connect m03_bidir merged inout electrical, inout m03_cmos_io;
// keeps the declared directions and re-types the discrete side. §7.6 Example 3:
// an inout/inout bridge "can bridge any mixed port whose one connection is
// compatible with discipline ddiscrete and whose connection is compatible with
// electrical". One merged instance, rio at its declared default of 4000. Top:
// 1 kohm shunt, 1 mA source.
//
//     V/1000 - 1e-3 + V/4000 = 0
//     V * 1.25e-3 = 1e-3
//     V(a) = 0.8
//
// WHAT THE NUMBER DOES AND DOES NOT SEPARATE. Nothing inserted reads 1.0. But
// the override does not change WHICH port matches: m03_cmos_io is compatible
// with ddiscrete by the same §3.11.1 rule that makes it a legal override, so the
// un-overridden statement would bridge `u1.dio` too. This row therefore pins
// that a statement carrying a discipline override is accepted and still
// inserts; the override's own effect is not observable with natureless discrete
// disciplines, and no number here claims it is.
//
// WHERE THE DIRECTION HALF WENT. This file used to carry a second net, `b`,
// bridged by `connect m03_bidir merged #(.rio(1500.0)) input electrical, output
// m03_cmos_in;`, and claimed the two distinct discrete disciplines kept each
// statement matching one port. They did not: m03_cmos_in and m03_cmos_io are
// both natureless discrete, so §3.11.1 makes them compatible, and the
// inout/inout statement above bridges "any mixed port" — including `u2.din`.
// `u2.din` then matched two statements, which §7.8.4 forbids ("the port shall
// match one (and only one) connect statement"; E0922, the error
// m03_13_reject_ambiguous_connect_statements.va pins). A conforming tool refused
// the file. The direction override moved to
// m03_14_direction_override_redirects_a_bridge.va, alone in its connectrules.
//
//! lrm 7.7.1
//! lrm 7.6
//! lrm 3.11.1
//! lrm 7.8.4
//! lrm 7.7.1:2
//! solve
`include "check.vh"

discipline m03_cmos_io;
  domain discrete;
enddiscipline

connectmodule m03_bidir(el, cm);
  inout el;
  inout cm;
  electrical el;
  ddiscrete cm;
  reg cm;
  parameter real rio = 4000.0 from (0.0:inf);
  analog I(el) <+ V(el) / rio;
  initial cm = 1'b0;
endmodule

module m03_bio(dio);
  inout dio;
  m03_cmos_io dio;
  // No digital process here: the port is a receiver by its DISCIPLINE alone
  // (§7.8.4 selects on the two connections' disciplines and the port
  // direction).
endmodule

module m03_top;
  electrical a;

  m03_bio u1(a);

  analog begin
    I(a) <+ V(a) / 1000.0;
    I(a) <+ -1.0e-3;
    `CHECK("§7.7.1 discipline override: inout/inout m03_bidir bridges m03_cmos_io, rio=4k",
           V(a), 0.8, 1e-12);
  end
endmodule

connectrules m03_rules;
  connect m03_bidir merged inout electrical, inout m03_cmos_io;
endconnectrules
