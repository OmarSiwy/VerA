// §7.8, third paragraph: "Each connect statement designates a module to be a
// connect module. WHEN TWO DISCIPLINES ARE SPECIFIED IN A CONNECT STATEMENT, ONE
// SHALL BE DISCRETE AND THE OTHER CONTINUOUS."
//
// That is what makes a connect statement a BRIDGE specification rather than a
// discipline alias. §7.7.1's compatibility requirement is a separate and weaker
// check — "the specified disciplines shall be compatible for both the continuous
// and discrete disciplines of the given connect module" — and it is satisfied
// here by the continuous side while the discrete side is violated: `m03_elec2`
// is a continuous discipline being written into the slot that `m03_cm`'s
// `ddiscrete` port occupies, and §3.11.1's Domain Incompatibility Rule
// ("disciplines with different domain attributes are incompatible") makes it
// incompatible with that port's discipline too.
//
// §7.7.2's `resolveto` form is the one that legitimately names two disciplines of
// the SAME domain — "connect electrical18 electrical32 resolveto exclude;" is the
// clause's own example of two continuous disciplines in one connect statement —
// so the two connectrules_item forms cannot be collapsed, and an implementation
// that accepted this line would have no way to tell them apart.
//
// THE PAIR OF REJECT FIXTURES IN THIS ROW IS DELIBERATELY SMALLER THAN THE
// POSITIVE SET: a refusal is not coverage of insertion. These two pin the only
// two errors §7.8 states outright about the selection step itself.
//
// NOTE ON THE EXPECTATION TEXT: the code is E0923, allocated for exactly this
// rule. It must not be an incidental parse error: `m03_elec2` is a legally
// declared discipline and the statement is grammatical, so the refusal has to
// come from §7.8's domain requirement and nothing else — and E0923 is raised
// only by that requirement (elaborate/resolve.zig `checkConnectRules`).
//
//! lrm 7.8
//! lrm 7.8:2
//! lrm 7.7.1
//! lrm 3.11.1
//! reject-only E0923

discipline m03_elec2;
  potential Voltage;
  flow Current;
enddiscipline

connectmodule m03_cm(el, cm);
  input el;
  output cm;
  electrical el;
  ddiscrete cm;
  reg cm;
  analog I(el) <+ V(el) / 1000.0;
  initial cm = 1'b0;
endmodule

module m03_top;
  electrical a;
  analog I(a) <+ V(a) / 1000.0;
endmodule

connectrules m03_rules;
  // Both `electrical` and `m03_elec2` are continuous. Neither side is discrete.
  connect m03_cm electrical, m03_elec2;
endconnectrules
