// §7.8.4: "Driver-receiver segregation and connect module insertion is a
// post elaboration operation. It depends on a complete hierarchical
// examination of each signal in the design", and "The connect module for a
// port shall be instantiated in the context of the ports upper connection."
// §6.2.2: `name_of_module_instance ::= module_instance_identifier [ range ]`,
// an array of instances. IEEE 1364-2005 §12.1.2 gives a module array the
// rules §7.1.6 gives a gate array: a port expression as wide as the
// single-instance port connects to that port of every instance.
//
// THE DESIGN. top's undeclared `shared` connects mid's port `p` and
// echild's electrical port. mid's only children are the instance array
// `l[1:0]` of a digital leaf, each element on `p`.
//
// DERIVATION, basic resolution (§7.4.4.1, Annex F.2.1 step 4):
//   mid.p: its child nets are l[1].port and l[0].port, both cua_d: digital.
//   top.shared: children mid.p (cua_d) and e.port (electrical): analog.
//   Mixed ports: mid's port in top only; inside mid every connection is
//     cua_d.
//   §7.8.3.2 split: one instance per mixed port, in top: N = 1.
// The bridge loads `shared` with 1 kohm, top drives 1 mA: V = 1.0.
//   A tool that placed bridges on the two array elements' ports reads 0.5;
//   one that cannot read the array refuses (E0929).
//
//! lrm 7.8.4
//! lrm 7.8.4:5
//! lrm 6.2.2
//! lrm F.2.1
//! inherited IEEE 1364-2005 12.1.2
//! solve
//! checks 1
`include "check.vh"
discipline cua_d; domain discrete; enddiscipline
connectmodule cua_bridge(a, d);
  inout a; electrical a;
  inout d; cua_d d;
  analog I(a) <+ V(a) / 1000.0;
endmodule
connectrules cua_rules;
  connect cua_bridge split;
endconnectrules
module cua_leaf(port); inout port; cua_d port; endmodule
module cua_echild(port); inout port; electrical port; endmodule
module cua_mid(p);
  inout p;
  cua_leaf l[1:0](p);
endmodule
module cua_top;
  cua_mid m(shared);
  cua_echild e(shared);
  analog begin
    I(shared) <+ -1.0e-3;
    `CHECK("one bridge, on mid's port in top: V = 1 mA * 1 kohm", V(shared), 1.0, 1e-12);
  end
endmodule
