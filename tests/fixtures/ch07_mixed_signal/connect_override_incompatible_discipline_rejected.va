// §7.7.1, the discipline-override form of a connect insertion statement:
//
//   "Connect modules can be reused for different, but compatible disciplines
//   by specifying different discipline combinations in which the connect module
//   can be used. The form is
//       connect connect_module_identifier connect_attributes
//               discipline_identifier , discipline_identifier ;
//   where THE SPECIFIED DISCIPLINES SHALL BE COMPATIBLE for both the continuous
//   and discrete disciplines of the given connect module."
//
// Compatibility is §3.11.1's. Annex D's `magnetic` binds
// `Magneto_Motive_Force` as its potential nature; the connect module's
// continuous port is `electrical`, whose potential is `Voltage`. The two natures
// are not the same, not derived from a common base, and do not agree on `units`
// ("A*turn" against "V"), so §3.11.1's Potential Incompatibility Rule makes the
// disciplines incompatible and `magnetic` cannot stand in for the port's
// `electrical`.
//
// The discrete override, `ddiscrete`, IS the module's own discrete discipline,
// and the two overrides are one continuous and one discrete (§7.8's E0923 has
// nothing to say), so the continuous side is the only thing wrong.
//
// The positive twin is `m03_07_discipline_and_direction_overrides.va`, whose
// override names a discipline compatible with the port and is inserted.
//
// WHY THIS NEEDED A FIX. The compatibility was judged only while inserting into
// a module whose ports reached the rule; this design has no mixed port, so the
// statement was accepted. It is now judged once per statement.
//
//! lrm 7.7.1
//! lrm 7.7.1:1
//! lrm 3.11.1
//! lrm 3.11.1:1
//! lrm 7.7.1:2
//! reject-only cannot stand for
//! neighbour m03_07_discipline_and_direction_overrides.va
`include "disciplines.vams"
connectmodule ch7_ovr_a2d(el, dg);
  input el;
  output dg;
  electrical el;
  ddiscrete dg;
  reg dg;
  initial dg = 1'b0;
  always @(cross(V(el) - 0.5, 1)) dg = 1'b1;
endmodule

module ch7_ovr_host(p);
  inout p;
  electrical p;
  analog I(p) <+ V(p) / 1k;
endmodule

connectrules ch7_ovr_rules;
  connect ch7_ovr_a2d input magnetic, output ddiscrete;
endconnectrules
