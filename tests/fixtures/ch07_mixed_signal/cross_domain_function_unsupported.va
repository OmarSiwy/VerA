// §7.3.6.3 analog primary appearing in a digital expression: "an analog primary
// (variable, potential, or flow) whose value is calculated in the continuous
// domain appears in an expression which is in the digital context; thus the
// analog primary is evaluated in the digital domain." The probe `V(p)` below
// sits in the argument list of a call made from an `always` block, which §7.2.2
// puts in the discrete context — so the analog value crosses, the call does
// not.
//
// This file used to claim "§7.3.7 forbids it, whichever way the call is read".
// That was wrong in both readings, and the correction is the point of the file:
// §7.3.7 forbids a digital function called from the ANALOG context and an
// analog function called from the DIGITAL context, and `probe` is a digital
// function (`function`, not `analog function`) called from a digital context.
// Both ends are digital, so §7.3.7 is satisfied, and §7.3.6.3 makes the analog
// argument legal. The whole module item is legal Verilog-AMS HDL. Its two
// genuine §7.3.7 violations are elsewhere:
// digital_function_from_analog_unsupported.va and
// analog_function_from_digital_unsupported.va, one per sentence.
//
// C.7 is what refuses it here: "No digital behavior or events are supported in
// Verilog-A", so both the `always` block and the non-analog `function` are
// outside the subset and the module item dies at E0205 ("unsupported module
// item"). Conformance for this dialect — and §7.3.6.3's interpolation rule,
// like everything else behind the digital keyword, is never reached.
//
//! lrm 7.3.6.3
//! lrm 7.3.7
//! lrm C.7
//! reject E0205
module ch7_cross_domain_function(p);
  inout p; electrical p; real sampled;
  function real probe;
    input real x;
    probe = x;
  endfunction
  always @(p) sampled = probe(V(p));
endmodule
