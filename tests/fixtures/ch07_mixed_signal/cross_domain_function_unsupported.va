// §7.3.6.3 analog primary appearing in a digital expression: "an analog primary
// (variable, potential, or flow) whose value is calculated in the continuous
// domain appears in an expression which is in the digital context; thus the
// analog primary is evaluated in the digital domain." The probe `V(p)` below
// sits in the argument list of a call made from an `always` block, which §7.2.2
// puts in the discrete context — so the analog value crosses, the call does
// not.
//
// This file used to claim "§7.3.7 forbids it, whichever way the call is read".
// That was wrong in both readings, and the correction is the point of the file:
// §7.3.7 forbids a digital function called from the ANALOG context and an
// analog function called from the DIGITAL context, and `probe` is a digital
// function (`function`, not `analog function`) called from a digital context.
// Both ends are digital, so §7.3.7 is satisfied, and §7.3.6.3 makes the analog
// argument legal. The whole module item is legal Verilog-AMS HDL. Its two
// genuine §7.3.7 violations are elsewhere:
// digital_function_from_analog_unsupported.va and
// analog_function_from_digital_rejected.va, one per sentence — and the second of
// those reaches its own diagnostic now.
//
// WHAT REFUSES IT IS VerA'S CEILING, and not C.7's subset rule. `always` parses
// now (A.1.4); the refusal is E0437: the block re-runs on §8.5's event queue and
// reads an analog probe at a promoted digital time, and VerA runs neither beside
// a device yet. §7.3.6.3's interpolation rule is therefore still never reached;
// its positive row is m01_08_analog_probe_in_a_digital_expression.va.
//
//! lrm 7.3.6.3
//! lrm 7.3.7
//! reject E0437
module ch7_cross_domain_function(p);
  inout p; electrical p; real sampled;
  function real probe;
    input real x;
    probe = x;
  endfunction
  always @(p) sampled = probe(V(p));
endmodule
