// §7.8.5.1: "For 3 port MOS switches (nmos, pmos, rnmos, rpmos) the ports
// reading from left to right will be named source, drain, gate. For 4 port
// MOS switches (cmos, rcmos) the ports reading from left to right will be
// named source, drain, ngate, pgate." Left to right is IEEE 1364-2005
// A.3.1's terminal order, `( output_terminal , input_terminal ,
// enable_terminal )` and `( output_terminal , input_terminal ,
// ncontrol_terminal , pcontrol_terminal )`, so `source` is the switch's
// OUTPUT and `drain` its data input: a mixed `source` is a mixed output port
// and a mixed `gate`/`ngate` a mixed input port (§7.8.4's matching reads the
// terminal's direction as a port's).
//
// THE DESIGN. `nmos m1(a, x, g1)`: source on the electrical `a` (d2a),
// gate on the electrical `g1` (a2d). `cmos c1(c, x, g2, p)`: source on the
// electrical `c` (d2a), ngate on the electrical `g2` (a2d), pgate the reg `p`.
// Split names (§7.8.5): a__m1__source, g1__m1__gate, c__c1__source,
// g2__c1__ngate.
//
// DERIVATION. Each a2d loads its node with I(el) <+ V(el)/1000 and the
// module drives 1 mA into g1 and g2, so V(g1) = V(g2) = 1.0. Each a2d drives
// its discrete side to 1 at time zero, so m1's
// gate and c1's ngate are 1. nmos conducts at gate 1 and passes its data x =
// 1 (IEEE 1364-2005 §7.5 Table 7-7); cmos conducts through its n-type half at
// ngate 1 and passes x = 1 (pgate p = 1 turns the p-type half off, §7.6). So
// both d2a bridges see 1 and drive V(el) <+ vh: the defparams make V(a) =
// 0.7 and V(c) = 0.3. A switch whose gate read the analog node (no a2d) would
// see no 0 or 1 there and pass L/H/x, not a 1; one whose source stayed on
// the analog node drives no bridge and V reads 0; with `source` and `drain`
// swapped a's bridge would be `a__m1__drain` and the defparam would name
// nothing (E0907). Checked at 10n and 20n: 4 checks x 2 points.
//
//! lrm 7.8.5.1
//! lrm 7.8.5
//! lrm 7.8.4
//! lrm 3.9
//! solve
//! analysis tran
//! time 10n, 20n
//! checks 8
`timescale 1ns/1ns
`include "check.vh"

connectmodule b5_pms_d2a(cm, el);
  input cm;
  output el;
  ddiscrete cm;
  electrical el;
  parameter real vh = 1.0;
  analog V(el) <+ (cm === 1'b1) ? vh : 0.0;
endmodule

connectmodule b5_pms_a2d(el, cm);
  input el;
  output cm;
  electrical el;
  ddiscrete cm;
  reg cm;
  analog I(el) <+ V(el) / 1000.0;
  initial cm = 1'b1;
endmodule

`default_discipline ddiscrete
module b5_prim_connect_mos_switch;
  electrical a, c, g1, g2;
  reg x, p;

  nmos m1(a, x, g1);
  cmos c1(c, x, g2, p);

  defparam a__m1__source.vh = 0.7;
  defparam c__c1__source.vh = 0.3;

  initial begin x = 1'b1; p = 1'b1; end

  analog begin
    I(g1) <+ -1.0e-3;
    I(g2) <+ -1.0e-3;
    `CHECK("g1__m1__gate's a2d loads g1: V = 1 mA * 1 kohm", V(g1), 1.0, 1e-12);
    `CHECK("g2__c1__ngate's a2d loads g2: V = 1 mA * 1 kohm", V(g2), 1.0, 1e-12);
    `CHECK("nmos m1: gate from g1__m1__gate = 1 passes x = 1 to a__m1__source", V(a), 0.7, 1e-12);
    `CHECK("cmos c1: ngate from g2__c1__ngate = 1 passes x = 1 to c__c1__source", V(c), 0.3, 1e-12);
  end
endmodule
`default_discipline

connectrules b5_pms_rules;
  connect b5_pms_d2a split;
  connect b5_pms_a2d split;
endconnectrules
