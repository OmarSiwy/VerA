// §5.2.1 an `analog initial` block runs on the first evaluation only, and a
// variable keeps its value from one evaluation to the next (§3.2), so what
// it assigns is what every later evaluation reads. Here the variables are
// `reg`s wider than 32 bits that the analog context assigns, which hold
// every bit IEEE 1364-2005 gives them (specification/Vague_Decisions.md
// VD-113): one 72 bits wide (`wide_kernels.zig` computes it as one native
// integer) and one 300 bits wide (as 32-bit limbs), each kept whole between
// evaluations.
//
// DERIVATION.
//   acc = 72'hA5_0000_0000_0000_0003   acc[71:64] = 0xA5 = 165, acc[1:0] = 3
//   big = (300'h1 << 299) | 300'h5    2**299 + 5: big[299] = 1, big[2:0] = 5
//   q = big / 3   2**299 = 2 (mod 3), so big = 1 (mod 3) and
//                 q = (2**299 + 4) / 3 = (2**299 - 2) / 3 + 2. (2**299 - 2)/3
//                 = 2 * (2**298 - 1) / 3 has its odd bits 1..297 set; adding
//                 2 clears bit 1 and sets bit 2.
//                 q[30:0]    bits 2, 3, 5, 7, ..., 29 = 0x2AAAAAAC = 715827884
//                 q[298:268] bits 269, 271, ..., 297 = 0x2AAAAAAA = 715827882
// The checks run at every evaluation the operating point takes; each
// prints one line per accepted solution: checks 6. A tool that kept only
// 32 bits of a held `reg` reads 0 for the high selects.
//
//! lrm 7.3.1
//! lrm 5.2.1
//! inherited IEEE 1364-2005 5.1.5
//! checks 6
`include "check.vh"
module ch7_wide_reg_held_across_evaluations(p);
  inout p; electrical p;
  reg [71:0] acc;
  reg [299:0] big;
  reg [299:0] q;
  analog initial begin
    acc = 72'hA5_0000_0000_0000_0003;
    big = (300'h1 << 299) | 300'h5;
  end
  analog begin
    q = big / 3;
    `CHECKI("acc[71:64] held", acc[71:64], 165);
    `CHECKI("acc[1:0] held", acc[1:0], 3);
    `CHECKI("big[299] held", big[299], 1);
    `CHECKI("big[2:0] held", big[2:0], 5);
    `CHECKI("big / 3: q[30:0]", q[30:0], 715827884);
    `CHECKI("big / 3: q[298:268]", q[298:268], 715827882);
    I(p) <+ V(p);
  end
endmodule
