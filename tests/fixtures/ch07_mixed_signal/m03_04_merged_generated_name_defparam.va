// §7.8.5 instance names for auto-inserted instances: "Parameters of auto-inserted
// connect instances can be set on an instance-by-instance basis with the use of
// the defparam statement. This requires predictable instance names for the
// auto-inserted modules." For the merged case the clause fixes the spelling:
//
//     "In the merged case, one or more ports have a given discipline at their
//      bottom connection, call it BottomDiscipline, and a common signal, call it
//      SigName, of another discipline at their top connection. A single connect
//      module, call it ModuleName, is placed between the top signal and the
//      bottom signals. In this case, the instance name of the connect module is
//      derived from the signal name, module name, and the bottom discipline:
//          SigName__ModuleName__BottomDiscipline"
//
// "NOTE—The __ between the elements of these generated instance names is a
// double underscore."
//
// HERE the signal is `a`, the module selected by the connect statement is
// `m03_a2d`, and the bottom (formal, lower) connection of both bridged ports has
// discipline `ddiscrete`. The generated instance name is therefore exactly
//
//     a__m03_a2d__ddiscrete
//
// and §6.3.1's parameter_override reaches into it from the enclosing module —
// which is where §7.8.4 put the instance ("The connect module for a port shall
// be instantiated in the context of the port's upper connection", and the upper
// connection of both ports is `m03_top.a`), so the path is a bare local name.
//
// THE NAME IS TESTED BY ITS EFFECT, not by being echoed. A defparam onto a name
// nothing declares is an error (§6.3.1 puts the target "in any module instance
// throughout the design"), so getting the spelling wrong cannot silently pass;
// and a defparam onto the RIGHT name changes a number this fixture reads back.
// That is the only way a generated identifier becomes observable from source.
//
// DERIVATION. `merged` (the default, §7.8.3) puts one a2d between `a` and the
// two ddiscrete ports. The defparam raises that one instance's rin from its
// declared 1000 to 2000. Top module: 1 kohm shunt, 1 mA source. KCL at `a`:
//
//     V/1000 - 1e-3 + V/2000 = 0
//     V * 1.5e-3 = 1e-3
//     V(a) = 2/3 = 0.66666666666666663 (nearest double)
//
// Separating answers: defparam silently ignored -> 0.5; two instances inserted
// and only one reachable by this name -> 1e-3/(1/1000+1/2000+1/1000) = 0.4;
// nothing inserted -> the defparam is an error and the fixture fails to compile.
//
//! lrm 7.8.5
//! lrm 6.3.1
//! lrm 7.8.4
//! lrm 7.8.3
//! solve
//! xfail VerA performs no §7.8 insertion, so the §7.8.5 generated name does not exist and the defparam names nothing (E0907)
`include "check.vh"

connectmodule m03_a2d(el, cm);
  input el;
  output cm;
  electrical el;
  ddiscrete cm;
  reg cm;
  parameter real rin = 1000.0 from (0.0:inf);
  analog I(el) <+ V(el) / rin;
  initial cm = 1'b0;
endmodule

module m03_din(din);
  input din;
  ddiscrete din;
  // No digital process here: the port is a receiver by its DISCIPLINE alone
  // (§7.8.4 selects on the two connections' disciplines and the port
  // direction). An unread `reg seen` process only made the file stop at E0205
  // before it could reach its own assertion.
endmodule

module m03_top;
  electrical a;

  m03_din u1(a);
  m03_din u2(a);

  // §7.8.5 merged: SigName__ModuleName__BottomDiscipline.
  defparam a__m03_a2d__ddiscrete.rin = 2000.0;

  analog begin
    I(a) <+ V(a) / 1000.0;
    I(a) <+ -1.0e-3;
    `CHECK("defparam through the §7.8.5 merged generated name a__m03_a2d__ddiscrete sets rin=2k",
           V(a), 0.66666666666666663, 1e-12);
  end
endmodule

connectrules m03_rules;
  connect m03_a2d;
endconnectrules
