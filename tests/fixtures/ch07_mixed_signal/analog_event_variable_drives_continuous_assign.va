// §7.3.6.4 "Analog variables that are only assigned values within analog event
// statements can be used in the expressions that drive continuous assigns, both
// when the target of the continuous assign is a wreal or a traditional Verilog
// wire type (wire, trireg, wor, wand, etc.)."
//
// The positive half, on the traditional-`wire` target (the wreal target is
// continuous_assign_unsupported.va, which rejects it on Annex C grounds).
// `level` is an analog variable written ONLY inside an analog event statement,
// `@(initial_step)`, so it is exactly the variable the clause permits on the
// right of an `assign`.
//
// DERIVATION. At the initial step `level` becomes 0.75. The continuous assign
// drives `hi = (level > 0.5)`, a 1-bit comparison result of 1 (§4.2.5). The
// analog block reads the discrete wire back through §7.3.1 Table 7-1, where a
// 1-bit 1 reads as the integer 1, and contributes it as a potential.
//
// The check is made at t = 10n and 20n only. At t = 0 the digital side has not
// yet seen the analog event (the assignment is an A2D event scheduled at the
// time the analog event fires, §7.3.6), and which value the analog block reads
// in that same instant is a scheduling question this fixture does not ask.
// By 10n the digital kernel has long since propagated it.
//
//! lrm 7.3.6.4
//! analysis tran
//! time 0, 10n, 20n
//! print none
//! xfail the mixed-signal runner's digital half fails with E1100 "undeclared digital variable" on `assign hi = (level > 0.5)`: an analog variable is not visible to the digital engine, where §7.3.6.4 lets an event-assigned one drive a continuous assign
`timescale 1ns/1ns
`include "check.vh"
module ch7_analog_event_variable_drives_continuous_assign(out);
  inout out;
  electrical out;
  real level;
  wire hi;
  assign hi = (level > 0.5);

  analog begin
    @(initial_step) level = 0.75;
    if ($abstime > 5n)
      `CHECKI("§7.3.6.4 an event-assigned analog variable drives a continuous assign", hi, 1);
    V(out) <+ hi;
  end
endmodule
