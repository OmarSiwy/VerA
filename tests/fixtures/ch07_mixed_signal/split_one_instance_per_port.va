// §7.8.3.2 split: "If more than one input port is connected at a net of a
// signal, using split forces there to be one connect module for each port which
// converts between the net discipline and the port discipline. In this way, the
// net connecting to the ports is segmented by the insertion of one connect
// module for each port."
//
// §7.8.4 states the same as an insertion rule: after the merged clause, "All
// other ports shall have an instance of the selected connect module, i.e., one
// connect module instance per port."
//
// Identical design to 01_merged_is_the_default_one_instance.va — the ONLY
// difference in the whole file is the word `split` in the connect statement.
// That is deliberate: the two files together are the test, because a compiler
// that ignores connect_mode entirely passes one of them by accident and must
// fail the other.
//
// DERIVATION. Same ladder as 01. KCL at node `a`, 1 kohm shunt, 1 mA source,
// N inserted a2d bridges of rin = 1 kohm each:
//
//     V/1000 - 1e-3 + N*V/1000 = 0   =>   V = 1/(N+1)
//
// `split` with two ddiscrete input ports on one electrical signal gives N = 2:
//
//     V(a) = 1/3 = 0.33333333333333331 (nearest double)
//
// A compiler that merged anyway reads 0.5; one that inserted nothing reads 1.0.
// Both are far outside the tolerance.
//
//! lrm 7.8.3.2
//! lrm 7.8.3.2:1001
//! lrm 7.8.4
//! lrm 7.8.4:7
//! lrm 7.8.2
//! lrm 7.7.4
//! lrm 7.7.4:1000
//! lrm 7.8.3
//! lrm 7.8.3:1
//! lrm 7.8.4:4
//! lrm 7.6
//! lrm 7.6:1001
//! solve
`include "check.vh"

connectmodule m03_a2d(el, cm);
  input el;
  output cm;
  electrical el;
  ddiscrete cm;
  reg cm;
  parameter real rin = 1000.0 from (0.0:inf);
  analog I(el) <+ V(el) / rin;
  initial cm = 1'b0;
endmodule

module m03_din(din);
  input din;
  ddiscrete din;
  // No digital process here: the port is a receiver by its DISCIPLINE alone
  // (§7.8.4 selects on the two connections' disciplines and the port
  // direction). An unread `reg seen` process only made the file stop at E0205
  // before it could reach its own assertion.
endmodule

module m03_top;
  electrical a;

  m03_din u1(a);
  m03_din u2(a);

  analog begin
    I(a) <+ V(a) / 1000.0;
    I(a) <+ -1.0e-3;
    `CHECK("split inserts one a2d PER PORT: two ports, two 1k loads, V = 1/(2+1)",
           V(a), 0.33333333333333331, 1e-12);
  end
endmodule

connectrules m03_rules;
  connect m03_a2d split;
endconnectrules
