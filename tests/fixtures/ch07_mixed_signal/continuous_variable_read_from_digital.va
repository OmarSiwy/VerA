// §7.3.3, last paragraph (repeated in §7.3.6.3): "Continuous variables can be
// accessed for reading from any discrete context in the same module where
// these variables are declared. ... If the current time in the continuous and
// discrete kernels differ, interpolation is used to determine the value to be
// used in the discrete context for the continuous variable unless the value of
// the continuous variable was last assigned in an analog event statement. In
// this case, the value used in the digital context is exactly the same as the
// last value assigned to the continuous variable."
//
// m01_08 reads a PROBE from digital code; this file reads two continuous
// VARIABLES, one of each kind the sentence distinguishes:
//
//   x  assigned on every analog evaluation: x = V(in)
//   h  assigned only in an analog event statement: @(timer(10n, 100n)) h = V(in)
//
// DERIVATION, `timescale 1ns/1ns`. V(in) is the ramp 0.1 V/ns (the `//! wave`
// is linear between listed points, and every listed point is on the line).
// The timer fires once inside the run, at 10n (the next fire, 110n, is past
// the end), so h = V(in)(10n) = 1.0 from 10n on. A digital edge at tick 15
// copies both: rx = x, rh = h.
//
//   rx: §7.3.6.3 evaluates the read "for the time corresponding to a real
//       promotion of the digital time", 15.0e-9, where V(in) = 1.5. Whether
//       the analog kernel solved at 15n or the value is interpolated between
//       two solves around it, a linear ramp gives 1.5 either way. A tool that
//       handed the digital side its last solved value instead (the 10n point)
//       reads 1.0.
//   rh: "exactly the same as the last value assigned": 1.0. Interpolating h
//       between its value before and after a later solve, or re-reading
//       V(in), gives something else (1.5 at the edge).
//
// The values are pinned at t = 18n and 25n, after the edge; earlier points
// assert the literal against itself (the copies happen at 15n). Two checks
// per point at every point the runner solves.
//
// No refusal here: the sentence's invalid form, a read from a module other
// than the declaring one, is refused when the digital half runs (E1100), and
// `//! reject` pins compile-time diagnostics only. The clause's compile-time
// refusal is probe_of_a_discrete_net_in_digital_rejected.va.
//
//! lrm 7.3.3
//! lrm 7.3.3:1001
//! lrm 7.3.6.3
//! analysis tran
//! time 0, 10n, 18n, 25n
//! wave V(in) = 0.0, 1.0, 1.8, 2.5
`timescale 1ns/1ns
`include "check.vh"
module m01_continuous_variable_read_from_digital(in, aout);
  inout in, aout;
  electrical in, aout;
  reg clk;
  real x, h, rx, rh;

  initial begin
    clk = 1'b0;
    #15 clk = 1'b1;
  end

  always @(posedge clk) begin
    rx = x;
    rh = h;
  end

  analog begin
    x = V(in);
    @(timer(10n, 100n)) h = V(in);
    `CHECK("a free continuous variable reads its value at the promoted digital time", ($abstime > 16n) ? rx : 1.5, 1.5, 1e-9);
    `CHECK("an event-assigned variable reads exactly its last assignment", ($abstime > 16n) ? rh : 1.0, 1.0, 1e-12);
    V(aout) <+ rx + rh;
  end
endmodule
