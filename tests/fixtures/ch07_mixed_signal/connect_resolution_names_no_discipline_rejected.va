// §7.7.2, Syntax 7-7:
//
//     connect_resolution ::= connect discipline_identifier { , discipline_identifier }
//                            resolveto discipline_identifier_or_exclude ;
//
// "The discipline resolution connect statement specifies a single discipline
// to use during the discipline resolution process when multiple nets with
// compatible disciplines are part of the same mixed net." Every name in it is a
// discipline_identifier. `ch7_no_such_discipline` below is declared nowhere,
// here or in Annex D's disciplines.vams, so no net can carry it and the
// statement has nothing to match. The accepted form over declared disciplines
// is resolution_connect_accepted.va.
//
//! lrm 7.7.2
//! lrm 7.7.2:1000
//! reject-only E0916
//! neighbour resolution_connect_accepted.va
`include "disciplines.vams"
module ch7_resolution_host(p);
  inout p; electrical p;
  analog I(p) <+ V(p);
endmodule
connectrules ch7_bad_resolution;
  connect electrical, ch7_no_such_discipline resolveto electrical;
endconnectrules
