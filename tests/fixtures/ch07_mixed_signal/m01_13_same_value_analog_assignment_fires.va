// §7.3.5, Syntax 7-3 admits an `analog_variable_lvalue` as a digital
// event_expression, and §7.3.6.1 gives it its meaning: "one can also use
// analog variables that are only assigned values in analog event statements in
// a digital event control statement. An event occurs whenever a value is
// assigned to the variable, regardless of whether the variable changes value or
// not."
//
// DERIVATION, `timescale 1ns/1ns`. The timer fires at 5n, 15n, 25n, ...
// (start 5n, period 10n); the body assigns only while $abstime < 20n, so
// exactly two assignments happen, and both store the SAME value, 1.0. The
// always block counts events on `smpl`, so after both have reached the
// digital kernel n = 2.
//
// The second assignment changes nothing (1.0 -> 1.0); "regardless of whether
// the variable changes value" makes it an event anyway. A tool that detected
// value CHANGES (IEEE 1364 §9.7.2's rule for an ordinary variable) counts only
// the 0.0 -> 1.0 at 5n and reads n = 1. The legal neighbour that assigns a new
// value each time, and so passes either reading, is
// m01_14_changed_analog_assignment_fires.va. The refusal, `@(smpl)` over a
// variable the analog block assigns outside any event statement, is
// free_variable_in_digital_event_control_rejected.va (E0484).
//
// The declared points sit off the fire times (a fixed-grid point exactly on
// 15n is where a timer's start + k*period can round past it), so each fire runs
// at the first point after it. n is pinned at 22n and later, one point clear
// of the last fire; earlier points assert the literal against itself.
//
//! lrm 7.3.5
//! lrm 7.3.6.1
//! lrm 7.3.6.1:1001
//! analysis tran
//! time 0, 6n, 12n, 16n, 22n, 30n
`timescale 1ns/1ns
`include "check.vh"
module m01_same_value_analog_assignment_fires(out);
  inout out;
  electrical out;
  real smpl;
  integer n;

  initial n = 0;

  always @(smpl) n = n + 1;

  analog begin
    @(timer(5n, 10n)) if ($abstime < 20n) smpl = 1.0;
    `CHECKI("every assignment of smpl is a digital event, changed or not",
            ($abstime > 20n) ? n : 2, 2);
    V(out) <+ smpl;
  end
endmodule
