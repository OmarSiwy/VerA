// §7.3.4 Syntax 7-2 gives `analog_event_expression ::= ... | posedge expression
// | negedge expression | ...`, and the clause's own example is a `posedge` of a
// digital `wire` inside an `analog` block. §7.3.6.2 fixes WHEN the guarded
// statement runs: "When it is determined the event has occurred in the digital
// domain, the statements under the event control shall be executed in the
// analog domain at the time corresponding to a real promotion of the digital
// time (e.g., 27ns to 27.0e-9)."
//
// This file is §7.3.4's `sampler3` with the `cross` half of its `or` dropped —
// that half is already green as `tests/fixtures/ch05_analog_behavior/
// event_cross_*.va`, and keeping it here would let a tool pass on the analog
// event alone.
//
// THE RAMP IS THE CLOCK. Sampling a constant would only show THAT the event
// fired, never WHEN. V(in) is walked linearly so that V(in) = $abstime / 10n
// volts, which turns the sampled value into a readout of the promotion rule:
//
//   //! time  0     5n    10n   20n
//   //! wave  0.0   0.5   1.0   2.0
//
//   t = 0     clk1 = 1'b0, no edge yet          vout = 0.0  (§3.2 default)
//   t = 5n    still 0                           vout = 0.0
//   t = 10n   clk1 0 -> 1; promoted to 10.0e-9  vout = V(in)(10n) = 1.0
//   t = 20n   clk1 1 -> 0, a negedge            vout = 1.0; vfall = V(in)(20n) = 2.0
//
// oracles ($abstime >= 10n) ? 1.0 : 0.0 and ($abstime >= 20n) ? 2.0 : 0.0,
// exact in binary at every point.
//
// Every plausible mistake changes a digit. Executing at the NEXT analog point
// instead of the promoted digital one reads 2.0; executing at the previous one
// reads 0.5; missing the edge entirely leaves 0.0 for the whole run. The clock
// also falls at 20n, so a `posedge` control that fired on any transition would
// overwrite vout with V(in)(20n) = 2.0 and fail the posedge check there; a tool
// that fired on ANY change would still read 1.0 at 10n, which is what fixture
// 05 separates out.
//
// THE NEGEDGE HALF OF THE SAME SENTENCE is the second control: `@(negedge
// clk1)` fires only on the 20n fall and samples V(in) = 2.0. A tool that
// ignores or refuses negedge leaves vfall at 0.0 for the whole run; one that
// delivers it at the wrong promoted time reads a different ramp value.
//
// WHAT USED TO FAIL (green since ch07 steps 5/7). `error[E0704]: posedge/negedge is digital-only`, whose own
// note cites §5.10.1. The token parses — that much was fixed — but lowering
// refuses it on a Verilog-A subset rule (annex C.7) that Verilog-AMS does not
// have. Before that, `error[E0209]: expected an expression: found `#`` on the
// clock stimulus.
//
//! lrm 7.3.4
//! lrm 7.3.4:1001
//! lrm 7.3.6.2
//! lrm 7.3.6.2:1
//! lrm 5.10.5
//! lrm 5.10.5:1000
//! lrm 7.3.4:1000
//! analysis tran
//! time 0, 5n, 10n, 20n
//! wave V(in) = 0.0, 0.5, 1.0, 2.0
`timescale 1ns/1ns
`include "check.vh"
module m01_posedge_sampler(in, out);
  inout in, out;
  electrical in, out;
  reg clk1;
  real vout, vfall;

  initial begin
    clk1 = 1'b0;
    #10 clk1 = 1'b1;
    #10 clk1 = 1'b0;
  end

  analog begin
    @(posedge clk1)
      vout = V(in);
    @(negedge clk1)
      vfall = V(in);
    `CHECKEQ("posedge at digital tick 10 samples the analog ramp at 10.0e-9", vout, ($abstime >= 10n) ? 1.0 : 0.0, 0.0);
    `CHECKEQ("negedge at digital tick 20 samples the analog ramp at 20.0e-9", vfall, ($abstime >= 20n) ? 2.0 : 0.0, 0.0);
    V(out) <+ vout;
  end
endmodule
