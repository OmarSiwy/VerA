// §7.4 "Additionally, some of the nets can have undeclared discipline(s).
// Discipline resolution assigns disciplines and domains to those nets whose
// discipline is undeclared. This is done ... (2) to ensure that the nets of all
// mixed signals and continuous signals have a known discipline and domain. The
// assignments are based on: discipline declarations, `default_discipline
// directives (see 3.8), and the hierarchical connectivity of the design."
//
// §7.4.4 "Once discipline declarations have been applied, if any mixed-signal
// or continuous-signal nets don't have a discipline and domain assigned
// additional resolution is needed. ... For the entire design, undeclared nets
// shall be resolved at each level of the hierarchy where continuous (analog) has
// precedence over discrete (digital)."
//
// The positive case of both: an interconnect with NO discipline declaration and
// no `default_discipline in force, whose only connections are two `electrical`
// ports. Hierarchical connectivity is the only source of a discipline, and it
// yields `electrical` — so the net is a continuous node and KCL holds on it.
// (35/36 in ch10_directives are the clause's only other cites, and pin that a
// reset default leaves an undeclared net with NOTHING to resolve from.)
//
// DERIVATION. `mid` is implicitly declared by its use in two port connections
// (an implicit net, IEEE 1364 §4.5, which Verilog-AMS inherits). u1 is a 1 kohm resistor p -> mid, u2 a 3 kohm resistor
// mid -> n. V(p) = 1.0, V(n) = 0.0, `//! solve` leaves mid to the device:
//
//   V(mid) = 1.0 * 3k / (1k + 3k) = 0.75
//
// read through u2's port `a`, which is bound to `mid` (§3.13.3 hierarchical
// net reference). A net left without a continuous discipline would not be a
// node at all and the divider would not form.
//
//! lrm 7.4
//! lrm 7.4.1
//! lrm 7.4.1:1001
//! lrm 7.4.4
//! lrm 7.4.4:1
//! lrm 7.4.5
//! lrm 7.4.5:1
//! bias V(p) = 1.0, V(n) = 0.0
//! solve
`include "check.vh"
module ch7_undeclared_interconnect_resolves_continuous(p, n);
  inout p, n;
  electrical p, n;
  ch7_uirc_res #(.r(1k)) u1(p, mid);
  ch7_uirc_res #(.r(3k)) u2(mid, n);
  analog begin
    `CHECK("§7.4 an undeclared interconnect between electrical ports is a continuous node",
           V(u2.a), 0.75, 1e-12);
  end
endmodule

module ch7_uirc_res(a, b);
  inout a, b;
  electrical a, b;
  parameter real r = 1k;
  analog I(a, b) <+ V(a, b) / r;
endmodule
