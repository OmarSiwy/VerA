// §7.3.1 Table 7-1, the `bit` row, at the exact boundary: 31 bits is the widest
// grouping that may be accessed from a continuous context ("access of discrete
// bit groupings with greater than 31 bits is illegal"), and for it Table 7-1
// fixes one more thing — "the sign bit (bit 31) of the integer is always set to
// zero (0)".
//
// A 31-bit grouping of all ones is therefore +2147483647 (= 2^31 - 1), the
// largest value the mapping can produce. A tool that let the top bit of a
// 31-bit bus land on the integer's sign bit would read -1; one that treated 31
// bits as over the limit would not compile this at all. Both are wrong, and
// they are told apart from each other and from the >31 prohibition by the
// verdict of this file against discrete_bus_over31_rejected.va.
//
// The driver is the LRM's own idiom: §7.3.2's `converter` example assigns its
// discrete net from an `initial` block and reads it from `analog`. §7.2.2
// permits it — `r` is assigned in the discrete context only, and the continuous
// context merely READS it.
//
//! lrm 7.3.1
// Blocked for exactly the reason discrete_bus_narrow_unsupported.va is, and by
// the same four fixtures — the §7.3.1 width test already works (E0222 fires only
// above 31, so this 31-bit declaration is accepted as legal), and the `initial`
// block now parses; what cannot happen is the file COMPILING, because four green
// fixtures require a constant assignment in an `initial` block to be refused.
//
//! xfail blocked by a contradiction inside the suite, not by a missing capability: `reg [30:0] r` is accepted as a legal width and `initial r = 31'h7fffffff` parses, but annex_c_analog_subset/13_digital_initial_rejected.va, ch07_mixed_signal/digital_initial_unsupported.va, ch07_mixed_signal/discrete_real_from_analog_unsupported.va and ch08_scheduling/analog_digital_initial_order_unsupported.va are all green and all pin `reject E0205` on a constant assignment in an `initial` block, so no implementation satisfies this fixture and those four at once
`include "check.vh"
module ch7_discrete_bus_31(p);
  inout p; electrical p;
  reg [30:0] r;
  initial r = 31'h7fffffff;
  analog begin
    `CHECKI("31 bits is the widest legal grouping and bit 31 of the integer stays zero", r, 2147483647);
    I(p) <+ V(p);
  end
endmodule
