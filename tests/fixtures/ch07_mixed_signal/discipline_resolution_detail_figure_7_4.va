// §7.4.4.2 detail discipline resolution on its own example, Figure 7-4:
// "In this mode continuous disciplines propagate up and then back down to
// meet discrete disciplines. Discrete disciplines do not propagate up the
// hierarchy. This can result in more connect modules being inserted lower
// down into discrete sections of the design hierarchy for added accuracy."
// The clause's results for this design: "Continuous up: NetC resolves to
// electrical ... NetD resolves to electrical ... Continuous down: NetA
// resolves to electrical ... NetB resolves to electrical", and "The
// specified resolveto connect statements are ignored in this mode unless
// coercion (see 7.8.1) is used." VerA's mode option is
// `--discipline-resolution=detail` (F.2.2: "shall be controlled by a
// simulator option"), here the fixture directive of the same name.
//
// The figure's nets in this file: NetD = top's `netd`, NetA = digital_blk's
// `out`, NetB = twoblks' `out`, NetC = mix's `out`. (The figure prints the
// resolveto lists without commas; A.1.8 separates them with commas.)
//
// Derivation by F.2.2. Step 4 (depth-first): NetB's children are cmos3 and
// cmos4, all digital, so NetB is digital and the first resolveto makes it
// cmos3; NetA's are cmos1, cmos2 and NetB's cmos3, so cmos1 by the second;
// NetC's are cmos2 and electrical: "If any of the connections are analog,
// the net shall be considered analog", electrical; NetD's are NetA (digital)
// and NetC (analog), electrical. Step 5 (top-down) re-decides the nets step
// 4 made digital: NetA's parent NetD is analog, so NetA is analog and takes
// its parent's electrical; then NetB's parent NetA is analog, electrical.
//
// What a host can observe is where §7.8 puts the connect modules: "A
// connection shall be selected for a port only if one of the connections to
// the port is digital and the other is analog", "instantiated in the context
// of the ports upper connection". With NetA and NetB electrical, every
// mixed port is a leaf's: blk1 (cmos1) and blk2 (cmos2) on NetA, blk3
// (cmos3) and blk4 (cmos4) on NetB, blk2 (cmos2) on NetC. Merged (§7.8.3,
// the default) shares one instance only between ports of one signal, one
// connect module and one bottom discipline (§7.8.5's
// SigName__ModuleName__BottomDiscipline), and these five differ by level or
// by discipline: five instances of `f74_d2a`. (cmos1..cmos4 are natureless
// discrete disciplines, which §3.11.1 makes mutually compatible, so the one
// statement matches every port; each port is an output, so the d2a shape
// of §7.6 Example 1, discrete input and electrical output, is the match.)
//
// Each instance loads its electrical side with 1 kohm, and `ablk` drives
// the node with 1 mA: 1e-3 = N * V / 1000, V = 1/N = 0.2 for N = 5. Basic
// mode puts two bridges on the same design (NetA stays cmos1, so the bridge
// for it sits at digital_blk's port in top), V = 0.5:
// discipline_resolution_basic_figure_7_3.va.
//
//! lrm 7.4.4
//! lrm 7.4.4:2
//! lrm 7.4.4.2
//! lrm F.2.2
//! lrm F.2.2:8
//! discipline-resolution detail
//! solve
//! checks 1
`include "check.vh"
discipline cmos1; domain discrete; enddiscipline
discipline cmos2; domain discrete; enddiscipline
discipline cmos3; domain discrete; enddiscipline
discipline cmos4; domain discrete; enddiscipline
connectmodule f74_d2a(d, a);
  input d; cmos1 d;
  output a; electrical a;
  analog I(a) <+ V(a) / 1000.0;
endmodule
connectrules f74_rules;
  connect cmos3, cmos4 resolveto cmos3;
  connect cmos1, cmos2, cmos3 resolveto cmos1;
  connect f74_d2a;
endconnectrules
module blk1(out); output out; cmos1 out; endmodule
module blk2(out); output out; cmos2 out; endmodule
module blk3(out); output out; cmos3 out; endmodule
module blk4(out); output out; cmos4 out; endmodule
module ablk(out);
  output out; electrical out;
  analog begin
    I(out) <+ -1.0e-3;
    `CHECK("five connect modules load the node: V = 1 mA * 1 kohm / 5", V(out), 0.2, 1e-12);
  end
endmodule
module twoblks(out);
  output out;
  blk3 b3(out);
  blk4 b4(out);
endmodule
module digital_blk(out);
  output out;
  blk1 b1(out);
  blk2 b2(out);
  twoblks t(out);
endmodule
module mix(out);
  output out;
  blk2 b(out);
  ablk a(out);
endmodule
module top;
  digital_blk d(netd);
  mix m(netd);
endmodule
