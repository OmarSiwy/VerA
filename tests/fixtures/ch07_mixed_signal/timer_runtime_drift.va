// §5.10.3.3 periodic deadlines are 2 us + k*1 ms. Over [0,4.096 s], k is
// 0..4095: 4096 events, first at 0.002 ms and last at 4095.002 ms. The mixed
// host must insert these points. Three final checks give checks = 3.
// The 1 ns digital precision is 1e-6 ms; these are bounded time assertions,
// not a demand that binary64 representations equal decimal event times.
// This valid periodic schedule has no invalid form; bounds are tested by a10_12.
//! lrm 5.10.3.3
//! analysis tran
//! time 0, 4.096
//! checks 3
`timescale 1ms/1ns
`include "check.vh"
module timer_runtime_drift(p);
  inout p; electrical p;
  event ev;
  integer hits;
  real first, last;
  initial begin hits = 0; first = -1; last = -1; end
  always @(ev) begin
    hits = hits + 1;
    if (hits == 1) first = $realtime;
    last = $realtime;
  end
  analog begin
    @(timer(2u, 1m)) -> ev;
    @(final_step) begin
      `CHECKI("all counted periodic events reach the digital host", hits, 4096);
      `CHECK("first deadline in ms", first, 0.002, 1.01e-6);
      `CHECK("last deadline in ms", last, 4095.002, 1.01e-6);
    end
    I(p) <+ 0;
  end
endmodule
