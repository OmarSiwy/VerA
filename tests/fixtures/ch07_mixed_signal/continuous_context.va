// §7.2.2 contexts: "Assignment statements which appear within an analog block
// or analog initial block are considered to be in the continuous (analog)
// context." So `x` is a continuous variable — it is recomputed from the probe
// every time the analog block is evaluated, not left at the 0 §3.2 initialises
// every real variable to: "Real variables are initialized to zero (0) at the
// start of a simulation." (That sentence is in §3.2 Integer and real data
// types. It is not in §3.4, which is Parameters.)
//
// Biased at V(p) = 1.25 (exact in binary), the assignment must leave x at 1.25;
// a dropped or hoisted-away analog assignment leaves 0.
//
//! lrm 7.2.2
//! lrm 7.2.2:1001
//! lrm 3.2
//! bias V(p) = 1.25
`include "check.vh"
module ch7_continuous(p);
  inout p; electrical p; real x;
  analog begin
    x = V(p);
    `CHECKX("a continuous-context assignment takes the probe's value at the solve", x, 1.25);
    I(p) <+ x;
  end
endmodule
