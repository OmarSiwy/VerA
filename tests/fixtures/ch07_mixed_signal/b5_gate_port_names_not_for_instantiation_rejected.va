// §7.8.5.1: "In the case of built-in digital primitives, however, IEEE Std
// 1364 Verilog does not define port names. In order to support the unique
// naming of auto inserted connect modules and the ability to override the
// parameters of those connect modules, built-in digital primitives ports will
// be provided with predictable names. These names are only for the purpose of
// naming the connect modules and do not define actual port names. These port
// names may not be used to instantiate or to do access of these primitives."
//
// For an N-input gate the names are `out` and `in1`, `in2`, ... (the clause's
// first bullet). This file uses them to INSTANTIATE: `and g1(.out(y),
// .in1(a), .in2(b))`, a named port connection on a gate. The sentence forbids
// it, and A.3.1 agrees: `n_input_gate_instance` takes only an ordered list of
// output_terminal and input_terminal expressions, so there is no production
// for `.name(expr)` there. The refusal is the parser's, at the `.` where a
// terminal expression must start (E0209).
//
// The legal neighbour is the same module with `and g1(y, a, b);`, which
// compiles and runs.
//
//! lrm 7.8.5.1
//! lrm 7.8.5.1:1
//! lrm A.3.1
//! reject-only E0209
//! neighbour b5_gate_ordered_terminals.va
`timescale 1ns/1ns
`include "check.vh"
module b5_gate_port_names_not_for_instantiation_rejected(p);
  inout p;
  electrical p;
  reg a, b, yr;
  wire y;

  and g1(.out(y), .in1(a), .in2(b));

  always @(y) yr = y;
  initial begin
    a = 1'b0;
    b = 1'b1;
    #5 a = 1'b1;
  end

  analog begin
    if ($abstime > 6n)
      `CHECKI("and g1(y, a, b) with a = b = 1 drives y = 1", yr, 1);
    I(p) <+ V(p);
  end
endmodule
