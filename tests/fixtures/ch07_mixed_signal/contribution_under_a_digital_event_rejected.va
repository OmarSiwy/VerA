// §7.3.4 Syntax 7-2 is the grammar of a digital event detected in the analog
// context, and it fixes what may stand under the event control:
//
//   analog_event_control_statement ::= analog_event_control analog_event_statement
//   analog_event_statement ::=
//           { attribute_instance } analog_loop_statement
//         | { attribute_instance } analog_case_statement
//         | { attribute_instance } analog_conditional_statement
//         | { attribute_instance } analog_procedural_assignment
//         | { attribute_instance } analog_event_seq_block
//         | { attribute_instance } analog_system_task_enable
//         | { attribute_instance } disable_statement
//         | { attribute_instance } event_trigger
//         | { attribute_instance } ;
//
// There is no `contribution_statement` in that list. §7.3.6.2 then says what
// the statements under a digital event control are for: "When it is determined
// the event has occurred in the digital domain, the statements under the event
// control shall be executed in the analog domain at the time corresponding to a
// real promotion of the digital time" — an instant, and a contribution is not an
// instantaneous act: it states the branch's value at every solution.
//
// So `@(posedge clk) I(p) <+ 1m;` is outside the grammar for exactly the reason
// the `cross()` form is (§5.10, E0406), and the event being DIGITAL changes
// nothing: Syntax 7-2 is one production for `posedge expression`,
// `cross(...)` and `timer(...)` alike. The legal way to write the intent is the
// clause's own `sampler3`/§7.3.6.2 shape — assign a variable under the event
// and contribute it outside — and that is `m01_04_posedge_in_an_analog_event_control.va`,
// which runs and asserts the sampled value.
//
// Everything else is legal: `clk` rises at tick 10 from a delayed `initial`
// write, so the module is mixed and `posedge clk` is an explicit D2A term
// (§8.5), not the E0704 a non-digital edge would get.
//
//! lrm 7.3.4
//! lrm 7.3.6.2
//! reject-only E0406
//! neighbour m01_04_posedge_in_an_analog_event_control.va
`timescale 1ns/1ns
`include "disciplines.vams"
module ch7_contrib_under_posedge(p);
  inout p;
  electrical p;
  reg clk;

  initial begin
    clk = 1'b0;
    #10 clk = 1'b1;
  end

  analog begin
    @(posedge clk)
      I(p) <+ 1m;
    I(p) <+ V(p) / 1k;
  end
endmodule
