//! reject E0130
// EXPECT: error -- 7.3.2 permits explicit Z testing with case inequality.
module ch7_z_case_inequality(p, d);
  inout p; electrical p; input d; wire d; real result;
  analog begin
    result = (d !== 1'bz) ? 1.0 : 0.0;
    I(p) <+ result;
  end
endmodule
