// §7.3.2 makes case inequality (`!==`) over a four-state digital net the way an analog block
// tests for a z bit: "if (dnet === 1'b1) ... else if (dnet === 1'bx)". Two
// independent annex C rules delete that from Verilog-A, and both apply to the
// line below:
//
//   C.5: "The case equality operators (===, !==) are not supported in
//        Verilog-A."
//   C.3: from 2.6, "support for x and z values is limited in the analog block
//        to the mixed signal context, as defined in 7.3.2".
//
// So the verdict is reject and it is conformance, not debt. The pin is E0130
// (the literal) rather than E0323 (the operator, whose lrm field is C.5)
// because the lexer wins the race: `1'bz` is refused before the parser has an
// operator to check, and E0323 never appears in the output. case_equality.va is
// where `===` is pinned as E0323 on its own, with no x/z literal to mask it.
//
//! lrm 7.3.2
//! lrm C.3
//! lrm C.5
//! reject E0130
module ch7_z_case_inequality(p, d);
  inout p; electrical p; input d; wire d; real result;
  analog begin
    result = (d !== 1'bz) ? 1.0 : 0.0;
    I(p) <+ result;
  end
endmodule
