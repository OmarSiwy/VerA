// §7.7.3 parameter passing attribute: "an attribute method can be used with
// the connect statement to specify parameter values to pass into the
// Verilog-AMS HDL connect module and override the default values", spelled
// `connect a2d_035u #(.tt(3.5n), .vcc(3.3));`.
//
// THIS FIXTURE'S VERDICT WAS INVERTED — it pinned `reject E0201` on the
// enclosing `connectrules` from C.9/C.16; see connectrules_accepted.va for why
// that argument does not reach the conclusion for a Verilog-AMS compiler.
//
// WHAT IS ASSERTED. That §7.7.3's parameter list is accepted in its A.1.8
// grammar slot — `[ parameter_value_assignment ]` after the optional mode —
// and that it is the SAME production an instance's `#(...)` is (A.4.1), parsed
// by the same code, named override and all. The connect module is real and
// declares the parameter being overridden. `V(p)` at the pinned bias is the
// whole-file-compiled verdict.
//
// WHAT IS NOT CLAIMED. The override is never APPLIED: §7.7.3's values
// parameterize the instance the insertion phase (§7.8) would create, VerA does
// no insertion, and the parsed list has no consumer — ConnectInsertion in
// lib/frontend/ast.zig says so. For the same reason the parameter NAME is not
// judged against the connect module's declarations (an unapplied override of a
// misspelled parameter configures the same nothing); E0907 owns that check the
// day an insertion phase instantiates the module.
//
// The want is the bias read back, exact in binary, so `CHECKX` is the honest
// macro.
//
//! lrm 7.7.3
//! bias V(p) = 0.75
`include "check.vh"
connectmodule ch7_a2d(a, d);
  input a; output d; electrical a;
  parameter real threshold = 2.5;
endmodule
module ch7_host(p);
  inout p; electrical p;
  analog begin
    `CHECKX("the §7.7.3 parameter list on a connect statement is accepted", V(p), 0.75);
    I(p) <+ V(p);
  end
endmodule
connectrules ch7_parameters;
  connect ch7_a2d #(.threshold(0.5));
endconnectrules
