// §7.4.3 connection of continuous-time disciplines: "Ports of continuous-time
// disciplines ... shall obey the rules imposed in 3.11. It shall be an error to
// connect incompatible continuous disciplines together."
//
// §3.11 gives the form the violation can take inside one module, with no
// hierarchy and no elaborator: "if an access function has two nets as
// arguments, they must be compatible". Two disciplines are compatible only when
// their natures are, and compatibility of natures is the Self Rule — a nature
// is compatible with itself. ch7_inc_a and ch7_inc_b share no nature at all:
// different units, different abstols, different access functions. So the
// two-net access `V(p, q)` below spans incompatible disciplines and is the
// error §7.4.3 names.
//
// This is the negative of compatible_disciplines.va, which is the same shape
// built on two disciplines that DO name the same natures and must run green.
// The pair is what makes the compatibility rule falsifiable in both directions.
//
//! lrm 7.4.3
//! lrm 3.11
//! reject incompatible discipline
//! xfail VerA has no discipline-compatibility diagnostic; it lowers `V(p, q)` across unrelated natures without complaint
nature ch7_inc_potential;
  units = "V";
  access = V;
  abstol = 1u;
endnature
nature ch7_inc_flow;
  units = "A";
  access = I;
  abstol = 1p;
endnature
nature ch7_inc_other_potential;
  units = "Wb";
  access = Phi;
  abstol = 1n;
endnature
nature ch7_inc_other_flow;
  units = "A_turn";
  access = MMF;
  abstol = 1p;
endnature
discipline ch7_inc_a;
  potential ch7_inc_potential;
  flow ch7_inc_flow;
enddiscipline
discipline ch7_inc_b;
  potential ch7_inc_other_potential;
  flow ch7_inc_other_flow;
enddiscipline
module ch7_incompatible(p);
  inout p; ch7_inc_a p;
  ch7_inc_b q;
  analog I(p) <+ 0.001 * V(p, q);
endmodule
