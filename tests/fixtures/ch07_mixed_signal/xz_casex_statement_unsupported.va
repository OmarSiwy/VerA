// The frontend preserves this legal four-state casex statement.
// Execution is still unavailable in the analog backend; E0130 records that
// implementation boundary, not full-AMS conformance.
//! lrm 7.3.2
//! lrm C.7
//! reject E0130
module ch7_xz_casex_statement(p, d);
  inout p; electrical p; input d; wire d; real result;
  analog begin
    casex (d)
      1'bx: result = 1.0;
      default: result = 0.0;
    endcase
    I(p) <+ result;
  end
endmodule
