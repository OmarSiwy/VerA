// §7.4: "Discipline resolution assigns disciplines and domains to those nets
// whose discipline is undeclared. This is done to (1) control auto-insertion
// of connect modules, according to the rules embodied in connect statements
// ... Once all net segments of every mixed signal has been resolved,
// insertion of connect modules shall be performed."
//
// THE DESIGN. `n` is an undeclared interconnect (an implicit net, IEEE 1364
// §4.5) in the top module. Its two child segments are `u1.din` (ddiscrete,
// input) and `u2.p` (electrical). The discrete child is instantiated first,
// so a first-arrival resolution cannot pass by luck.
//
// RESOLUTION. §7.4.4.1 basic mode: "At each level of the hierarchy where
// continuous and discrete meet for an undeclared net that net segment is
// declared continuous" (F.2.1 step 4.a: not all children digital, so analog;
// 4.b: the one continuous candidate, electrical). F.2.2's detail mode gives
// the same answer here ("If any of the connections are analog, the net shall
// be considered analog"), so the file does not depend on the mode.
//
// INSERTION, after resolution. `u1.din` is then an input port whose upper
// connection is electrical and lower connection ddiscrete: a mixed port.
// §7.6 Example 2's a2d shape (`electrical` input, `ddiscrete` output) "can
// bridge a mixed input port whose upper connection is compatible with
// electrical and whose lower connection is compatible with ddiscrete", so
// `connect b5_rpi_a2d;` selects it (§7.8.4) and exactly one instance is
// inserted. `u2.p` joins electrical to electrical and gets nothing.
//
// DERIVATION (m03_01's load-count method, §7.8.2 Figure 7-7). u2 holds a
// 1 kohm shunt and a 1 mA source; the bridge loads the node with rin = 1 kohm:
//
//     V/1000 - 1e-3 + N*V/1000 = 0   =>   V = 1/(N+1)
//
//   N = 1 (resolved, then inserted)          -> V = 0.5
//   N = 0 (insertion judged before n had a discipline, or never) -> V = 1.0
//
//! lrm 7.4
//! lrm 7.4:1
//! lrm 7.4.4.1
//! lrm 7.8.4
//! lrm F.2.1
//! solve
`include "check.vh"

connectmodule b5_rpi_a2d(el, cm);
  input el;
  output cm;
  electrical el;
  ddiscrete cm;
  reg cm;
  parameter real rin = 1000.0 from (0.0:inf);
  analog I(el) <+ V(el) / rin;
  initial cm = 1'b0;
endmodule

module b5_rpi_din(din);
  input din;
  ddiscrete din;
endmodule

module b5_rpi_load(p);
  inout p;
  electrical p;
  analog begin
    I(p) <+ V(p) / 1000.0;
    I(p) <+ -1.0e-3;
  end
endmodule

module b5_rpi_top;
  b5_rpi_din  u1(n);
  b5_rpi_load u2(n);
  analog
    `CHECK("§7.4 n resolves electrical, then one a2d is inserted at u1.din: V = 1/(1+1)",
           V(u2.p), 0.5, 1e-12);
endmodule

connectrules b5_rpi_rules;
  connect b5_rpi_a2d;
endconnectrules
