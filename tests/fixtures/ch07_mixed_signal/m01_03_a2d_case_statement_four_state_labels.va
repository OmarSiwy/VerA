// §7.3.2, the third of the four x/z features: "the case, casex, and casez
// statements". The clause writes this out itself — "A case statement could also
// have been used as an alternative to the above if-else-if statement to perform
// the 4-state logic value comparisons" — and prints the arms as `1'b1:`,
// `1'bx:`, `1'b0:` and `1'bz:`.
//
// So this file is 02 restated as the clause's second example. Both must pass,
// and both must produce the SAME numbers, because the clause says the two forms
// are alternatives for one another. That is the point of writing it twice: a
// `case` in a continuous context is IEEE 1364 §9.5 case equality, not the
// `==` an analog tool would reach for, and the only way to see the difference
// is to run the x and z arms.
//
// DERIVATION. Identical to 02 and repeated here so this file stands alone,
// `timescale 1ns/1ns`:
//
//   t = 0, 10n   dnet = 1'b1   arm 1'b1   avar = 5.0
//   t = 30n      dnet = 1'bx   arm 1'bx   avar = avar, still 5.0
//   t = 50n      dnet = 1'bz   arm 1'bz   avar = 2.5
//
// oracle ($abstime < 40n) ? 5.0 : 2.5.
//
// The DEFAULT arm is deliberately absent. §7.3.2's example has none either, and
// its absence is load-bearing: with all four states covered there is no arm for
// a tool to fall into when it mishandles x or z, so a miss leaves avar at
// whatever it held and the z point (2.5 vs 5.0) catches it.
//
// WHAT FAILS TODAY: only the x arm. The §7.3.2 comparison itself is green —
// `xz_four_state_input_compared.va` asserts it with a value on every arm — and
// the run reads 5.0 at t = 0, 10n and 2.5 from 40n. At 20n and 30n it reads
// 0.0: `avar = avar` reads the variable at the start of THIS evaluation, and
// VerA keeps an analog variable across evaluations only when an event
// statement writes it (lib/ir/lower/param.zig `scanHeld`). §3.2 initializes a
// real "at the start of a simulation", not at every evaluation, so the hold
// is the clause's and VerA's retention is the gap.
//
//! lrm 7.3.2
//! xfail §3.2 retention — VerA holds an analog variable across evaluations only when an event statement writes it (param.zig scanHeld), so the x arm's `avar = avar` reads 0.0, not the held 5.0; the §7.3.2 comparison is green in xz_four_state_input_compared.va
//! analysis tran
//! time 0, 10n, 30n, 50n
`timescale 1ns/1ns
`include "check.vh"
module m01_a2d_case_statement(anet);
  inout anet;
  electrical anet;
  reg dnet;
  real avar;

  initial begin
    dnet = 1'b1;
    #20 dnet = 1'bx;
    #20 dnet = 1'bz;
  end

  analog begin
    case (dnet)
      1'b1: avar = 5;
      1'bx: avar = avar; // hold value
      1'b0: avar = 0;
      1'bz: avar = 2.5;  // high impedance - float value
    endcase

    `CHECKEQ("a case over four-state labels agrees with the === chain", avar, ($abstime < 40n) ? 5.0 : 2.5, 0.0);
    V(anet) <+ avar;
  end
endmodule
