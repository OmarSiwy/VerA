// §7.3.6.1: "Besides using analog event functions, one can also use analog
// variables that are only assigned values in analog event statements in a
// digital event control statement. An event occurs whenever a value is
// assigned to the variable, regardless of whether the variable changes value
// or not." §8.5.1: "Note that A2D events must be analog event controlled
// statements (e.g., @cross, @timer)."
//
// `smpl` here is assigned on every analog evaluation, `smpl = V(in)`, outside
// any event statement. It is not a variable "only assigned values in analog
// event statements", so `always @(smpl)` waits on an A2D event no analog event
// statement produces: the variable moves with the solution as the probe it
// copies does, which §8.5.1 refuses for `@(V(in))` (E0484).
//
// DERIVATION OF THE VERDICT. The module breaks only that rule: reading `smpl`
// in a digital expression is legal (§7.3.3,
// m01_12_continuous_variable_read_from_digital.va), and the legal neighbour,
// the same `always @(smpl)` over a variable assigned only under
// `@(timer(...))`, is m01_13_same_value_analog_assignment_fires.va.
//
//! lrm 7.3.6.1
//! lrm 8.5.1
//! lrm 8.5.1:7
//! reject-only E0484
//! neighbour m01_12_continuous_variable_read_from_digital.va
//! neighbour m01_13_same_value_analog_assignment_fires.va
`timescale 1ns/1ns
`include "disciplines.vams"
module free_variable_in_digital_event_control(in);
  inout in;
  electrical in;
  real smpl;
  integer n;

  initial n = 0;

  always @(smpl) n = n + 1;

  analog begin
    smpl = V(in);
    V(in) <+ 0.0;
  end
endmodule
