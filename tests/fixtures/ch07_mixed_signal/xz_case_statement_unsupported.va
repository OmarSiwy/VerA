// §7.3.2, the plain `case` form: "A case statement could also have been used as
// an alternative to the above if-else-if statement to perform the 4-state logic
// value comparisons", and the LRM's own example labels its arms `1'bx:` and
// `1'bz:`. So the statement below is LEGAL Verilog-AMS HDL — unlike casex and
// casez, which C.7 names and deletes, `case` itself survives into Verilog-A;
// what removes this file is the x/z literals in the case items.
//
// C.3, from 2.6: "support for x and z values is limited in the analog block to
// the mixed signal context, as defined in 7.3.2". A Verilog-A compiler has no
// mixed signal context (C.9: "Clause 7 only applies to Verilog-AMS HDL"), so
// the four-state labels have no value to compare against and the rejection is
// conformance, not debt.
//
// The pin is E0130, the literal, because that is where a Verilog-A tool lands:
// the labels are refused one token at a time and there is no separate
// four-state-case-label diagnostic to want. This is the statement form of the
// rule x_literal_unsupported.va pins for a plain assignment.
//
//! lrm 7.3.2
//! lrm C.3
//! lrm C.9
//! reject E0130
module ch7_xz_case_statement(p, d);
  inout p; electrical p; input d; wire d; real result;
  analog begin
    case (d)
      1'bx: result = 1.0;
      1'bz: result = 2.0;
      default: result = 0.0;
    endcase
    I(p) <+ result;
  end
endmodule
