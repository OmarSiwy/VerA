// §5.10.3.1: "If enable argument is specified and it is zero, then cross() is
// inactive, meaning that it does not generate an event at threshold crossings
// and does not act to control the timestep. Thus, there are two ways to
// disable the cross function, either by specifying enable as 0, or giving a
// value other than –1, 0, or 1 to dir." §5.10.3.2 says the same of above()'s
// enable.
//
// §7.3.5 puts these functions in a digital event control, where the mixed
// coordinator monitors them. DERIVATION: V(vi) ramps 0 -> 1 V over 0..10 ns,
// so V(vi) - 0.5 rises through zero once, at 5 ns, and nowhere falls.
//
//   @(cross(V(vi) - 0.5, 1, 1p, 1u, 1))   enabled, rising: one event    n_on  = 1
//   @(cross(V(vi) - 0.5, 1, 1p, 1u, 0))   enable 0: inactive            n_off = 0
//   @(cross(V(vi) - 0.5, 200))            dir 200: "does not generate
//                                         an event"                     n_dir = 0
//   @(above(V(vi) - 0.5, 1p, 1u, 0))      enable 0: inactive            n_abv = 0
//
// Checked from 6 ns on, after the only crossing. The enabled control is what
// shows the crossing is really there: n_on = 1 proves a monitor sees it, so
// each 0 is the argument's doing, not an absent event.
//
//! lrm 5.10.3.1
//! lrm 5.10.3.2
//! analysis tran
//! time 0, 2n, 4n, 6n, 8n, 10n
//! wave V(vi) = 0, 0.2, 0.4, 0.6, 0.8, 1.0
`timescale 1ns/1ns
`include "check.vh"
module cross_enable_and_dir(vi, vo);
  inout vi, vo; electrical vi, vo;
  integer n_on, n_off, n_dir, n_abv;
  initial begin n_on = 0; n_off = 0; n_dir = 0; n_abv = 0; end
  always @(cross(V(vi) - 0.5, 1, 1p, 1u, 1)) n_on = n_on + 1;
  always @(cross(V(vi) - 0.5, 1, 1p, 1u, 0)) n_off = n_off + 1;
  always @(cross(V(vi) - 0.5, 200)) n_dir = n_dir + 1;
  always @(above(V(vi) - 0.5, 1p, 1u, 0)) n_abv = n_abv + 1;
  analog begin
    `CHECKI("an enabled rising cross fires once", ($abstime >= 6n) ? n_on : 1, 1);
    `CHECKI("enable 0 makes cross inactive", n_off, 0);
    `CHECKI("dir 200 generates no event", n_dir, 0);
    `CHECKI("enable 0 makes above inactive", n_abv, 0);
    V(vo) <+ 0.0;
  end
endmodule
