// §8.3.1: "simulators combine constitutive relationships with Kirchhoff's Laws
// in nodal analysis to form a system of differential-algebraic equations of
// the form f(v, t) = dq(v, t)/dt + i(v, t) = 0 ... f( ) is a vector containing
// the total flow out of each node". §8.4.3: "Analog processes that share
// conservative nodes are 'solved' jointly and can be viewed as a 'macro'
// process", and §8.4.3.2: "When an analog macro process is evaluated, the
// analog engine finds a potential 'solution' at a future time ... If it is
// woken up prior to acceptance time by an event that disturbs its current
// solution, it will cancel its own 'wake up' event, accept at the wake-up
// time, recalculate its solution". So a node that only current contributions
// set is a KFL row of the mixed macro process, solved at every point the
// mixed scheduler accepts, the D2A-forced ones included.
//
// DERIVATION. Node `a` has two flows out of it and nothing else (`//! solve`
// leaves it free; without that line the testbench ties every unnamed unknown
// to 0 V, docs/using/testbenches.md):
//
//     I(a) <+ -1 mA * (1 + b)      a source pushing (1 + b) mA into a
//     I(a) <+ V(a) / 1 kohm        a conductance to ground
//
// KFL at a: -1e-3 * (1 + b) + V(a) / 1000 = 0, so V(a) = 1 + b volts.
// `b` is a reg the analog block reads (§7.3.6.5, Table 7-1: 1'b0 -> 0,
// 1'b1 -> 1). It is 0 from time zero and 1 from 5 ns, so
//
//     t = 0, the DC point (§8.4.2)          b = 0   V(a) = 1.0
//     t = 5n, the implicit D2A point        b = 1   V(a) = 2.0
//     t = 10n, 20n                          b = 1   V(a) = 2.0
//
// The 5 ns point is not declared: §8.4.3.2's wake-up on a disturbing event
// puts it there, and §7.3.6.5 has its solve see every tick at or before it,
// so it reads b = 1. The oracle is written against `$abstime`, not against
// `b`, so a solve that read a stale b, or one that skipped the point, fails.
// That is four points, hence `//! checks 4`.
//
// WHY THIS FIXTURE EXISTS (#29). A probe of this circuit without `//! solve`
// read V(a) = 0 with res[a] = -1e-3 on the mixed path and was reported as a
// mixed-runner solve bug. It is the testbench's default netlist: the pure
// analog runner reads the same 0 V for the same source, and with `//! solve`
// both read 1.0. This fixture pins the KFL value on the mixed path, at a
// declared point and at a D2A-inserted one.
//
// The linear system is solved in one Newton step; 1e-12 V is rounding.
//
//! lrm 8.3.1
//! lrm 8.4.3
//! lrm 8.4.3:1
//! lrm 8.4.3.2
//! lrm 7.3.6.5
//! analysis tran
//! time 0, 10n, 20n
//! solve
//! checks 4
`timescale 1ns/1ns
`include "check.vh"
module m02_kcl_node_solved_at_every_mixed_point;
  electrical a;
  reg b;

  initial begin
    b = 1'b0;
    #5 b = 1'b1;
  end

  analog begin
    I(a) <+ -1.0e-3 * (1 + b);
    I(a) <+ V(a) / 1000.0;
    `CHECK("KFL at a: V(a) = 1 + b, b rising at 5n", V(a), ($abstime < 5n) ? 1.0 : 2.0, 1e-12);
  end
endmodule
