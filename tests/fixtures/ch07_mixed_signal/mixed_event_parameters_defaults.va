// §5.10.3.4's electrical_sampler uses real parameters for absdelta's
// delta and tolerances. §6.3.4 keeps defaults dependent on earlier parameters.
// V(p) rises 0.1 V/ns. base = 2**(-3) = 0.125 gives delta = 0.25 V: initialization and
// the 2.5, 5, 7.5 ns thresholds fire; the final remaining 0.25 V is not MORE
// than delta. threshold = 3*base = 0.375 V crosses at 3.75 ns (§5.10.3.1).
// delta, threshold and both tolerances are read only in monitored events.
// Four final assertions give checks = 4. This valid parameter form has no
// invalid counterpart; negative controls have event_bounds_absdelta_* rejects.
//! lrm 5.10.3.4
//! lrm 5.10.3.1
//! lrm 6.3.4
//! analysis tran
//! time 0, 10n
//! wave V(p) = 0.0, 1.0
//! checks 4
`timescale 1ns/1fs
`include "check.vh"
module mixed_event_parameters(p);
  inout p; electrical p;
  parameter real base = pow(2.0, -3.0);
  parameter real delta = 2.0 * base;
  parameter threshold = 3.0 * base;
  parameter real ttol = 1p;
  localparam real etol = 1u;
  parameter real analog_only = 7.0;
  integer n_delta, n_cross;
  real first_delta, crossed;
  initial begin n_delta = 0; n_cross = 0; first_delta = -1; crossed = -1; end
  always @(absdelta(V(p), delta, ttol, etol)) begin
    n_delta = n_delta + 1;
    if (n_delta == 2) first_delta = $realtime;
  end
  always @(cross(V(p) - threshold, +1, ttol, etol)) begin
    n_cross = n_cross + 1;
    crossed = $realtime;
  end
  analog begin
    @(final_step) begin
      `CHECKI("delta count uses the effective parameter", n_delta, 4);
      `CHECK("delta time uses the effective parameter in ns", first_delta, 2.5, 1.05e-5);
      `CHECKI("the parameterized crossing occurs once", n_cross, 1);
      `CHECK("cross time uses the effective threshold in ns", crossed, 3.75, 0.001001);
    end
    I(p) <+ 0.0;
  end
endmodule
