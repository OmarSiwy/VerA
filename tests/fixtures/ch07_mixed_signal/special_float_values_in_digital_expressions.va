// §7.3.2.1 "Floating point arithmetic can produce special values representing
// plus and minus infinity and Not-a-Number (NaN) to represent a bad value.
// While use of these special numbers in digital expressions is not an error, it
// is illegal to assign these values to a branch through contribution in the
// analog context."
//
// The permitted half. inf_contribution.va, nan_contribution_rejected.va and
// neg_inf_contribution_rejected.va pin the illegal half; this file produces
// infinities in DIGITAL expressions — an `initial` block's assignment, which is
// the discrete context by §7.2.2 — and requires them to be ordinary values.
//
// DERIVATION. 1.0e308 * 1.0e308 overflows binary64 (max ~1.797e308), and IEEE
// 754 round-to-nearest turns the overflow into +inf; its negation is -inf.
// The analog block reads the two digital variables (§7.3.1, Table 7-1 lets the
// continuous context read a discrete real) and compares them with the LARGEST
// finite double, 1.7976931348623157e308, where IEEE 754 orders
// -inf < every finite < +inf:
//
//   pinf >  1.7976931348623157e308   -> 1
//   ninf < -1.7976931348623157e308   -> 1
//
// Only a true infinity passes: a result saturated to the largest finite value
// compares equal, not greater.
//
// Nothing special reaches a branch: the contribution is V(p, n) alone, so the
// module is legal on both halves of the clause.
//
//! lrm 7.3.2.1
//! lrm 7.3.2.1:1
//! lrm 7.2.2
//! bias V(p) = 0.5
`include "check.vh"
module ch7_special_float_values_in_digital_expressions(p, n);
  inout p, n;
  electrical p, n;
  real pinf, ninf;
  initial pinf = 1.0e308 * 1.0e308;
  initial ninf = -(1.0e308 * 1.0e308);
  analog begin
    `CHECKI("§7.3.2.1 +inf from a digital expression is a usable value", pinf > 1.7976931348623157e308, 1);
    `CHECKI("§7.3.2.1 -inf from a digital expression is a usable value", ninf < -1.7976931348623157e308, 1);
    I(p, n) <+ V(p, n);
  end
endmodule
