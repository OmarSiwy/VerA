// §7.3.2: "Accessing digital net and digital binary constant operands are
// supported within analog context expressions." A two-state binary constant
// is such an operand, so `1'b1` and `4'b1010` format in an analog block.
// The invalid neighbour is reject_display_x_operand_analog.va: the same call
// with `1'bx`, an operand that returns an x bit (E0130).
//
// By hand, %b with no field width prints the operand's bits: "1" for 1'b1
// and "1010" for 4'b1010. The text is formatted into
// a string with $sformat (§9.5.3, the same conversions) so the check can
// compare it; a $display of the same arguments prints the same text.
//! lrm 7.3.2
//! lrm 9.5.3
//! checks 2
`include "check.vh"
module display_binary_operand_analog(p);
  inout p; electrical p;
  string a, b;
  analog begin
    $sformat(a, "%b", 1'b1);
    $sformat(b, "%b", 4'b1010);
    `CHECKI("a binary constant formats in an analog block", a == "1", 1);
    `CHECKI("all four of its bits", b == "1010", 1);
    I(p) <+ V(p);
  end
endmodule
