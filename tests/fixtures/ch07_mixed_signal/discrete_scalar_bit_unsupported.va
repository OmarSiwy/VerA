// §7.3.1 Table 7-1, the `bit` row, scalar case: a discrete bit read from a
// continuous context becomes an integer, 0 or 1. Reading it takes no access
// function — the whole point of the row is that a digital net appears in an
// analog expression as a number — so `I(p) <+ d;` below is the LEGAL
// Verilog-AMS HDL form of that read, not a mistake.
//
// C.9 removes it: "Clause 7 only applies to Verilog-AMS HDL". With no
// mixed-signal read, what is left of §4.4 is the ordinary rule that a net is a
// point in a conservative system and not a number, so it must be read through
// an access function — V(d) or I(d) — and a bare `d` in an expression has no
// value. That is where a Verilog-A compiler must land, and E0315 is the code
// that says it. Conformance, not debt.
//
//! lrm 7.3.1
//! lrm 4.4
//! lrm C.9
//! reject E0315
module ch7_discrete_scalar_bit(p, d);
  inout p; electrical p; input d; wire d;
  analog I(p) <+ d;
endmodule
