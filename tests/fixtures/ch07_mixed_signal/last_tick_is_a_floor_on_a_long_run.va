// §7.3.6.5: "The expression shall be evaluated using the digital value
// calculated for the greatest digital time tick which is less than or equal to
// the analog time when the expression is evaluated."
//
// "Less than or equal" is a floor, and a floor does not stop being one when
// the run is long. `m01_11_digital_primary_uses_the_last_tick.va` checks the
// rule at tens of nanoseconds; this checks it at 0.6 s, where 6e8 ticks of
// 1 ns make a tolerance scaled by the tick count wider than half a tick.
//
// DERIVATION, `timescale 1ns/1ns`, so tick k is at k ns:
//
//   tick 0            code = 4'd1
//   tick 600000001    code = 4'd5      (0.600000001 s)
//
//   t = 0.6000000006 s  = 600000000.6 ticks: the greatest tick <= t is
//                         600000000, which precedes the change   -> 1
//   t = 0.600000001 s   = tick 600000001 exactly                  -> 5
//
// oracle ($abstime >= 0.600000001) ? 5 : 1. A tool that rounds t to the
// NEAREST tick reads tick 600000001 at the first point, 5 instead of 1: the
// analog kernel sees the digital future.
//
//! lrm 7.3.6.5
//! lrm 7.3.6.5:1
//! analysis tran
//! time 0.6000000006, 0.600000001
`timescale 1ns/1ns
`include "check.vh"
module last_tick_floor(p);
  inout p;
  electrical p;
  reg [3:0] code;

  initial begin
    code = 4'd1;
    #600000001 code = 4'd5;
  end

  analog begin
    `CHECKEQ("the greatest tick <= t, not the nearest", code, ($abstime >= 0.600000001) ? 5 : 1, 0.0);
    I(p) <+ 1m * code;
  end
endmodule
