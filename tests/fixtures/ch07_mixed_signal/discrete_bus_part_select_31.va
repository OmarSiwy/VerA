// §7.3.1 Table 7-1, the `bit` row: "Access of discrete bit groupings with
// greater than 31 bits is illegal." The limit is on the grouping ACCESSED,
// not on the declaration, so a 31-bit part-select of a wider `reg` is legal
// (ROADMAP §5.3, AMS 7.3.1: VerA used to refuse the declaration itself).
// Each select maps by the same rule as a whole grouping: bit 0 of the
// selection is bit 0 of the integer, and bit 31 of the integer is zero.
//
// IEEE 1364-2005 §4.2.1 fixes which bits a select names: the right-hand bound
// of the declared range is the LSB in either direction.
//
// DERIVATION. Both registers hold the low 32 bits 0x9234_5678 (the analog
// context holds a `reg` as its 32-bit §3.2 integer; the 0xAB above bit 31 of
// the 40-bit literal is not read by any select here).
//   r[30:0]  bits 30..0 of 0x92345678            = 0x12345678 = 305419896
//   r[31:1]  bits 31..1: 0x92345678 >> 1         = 0x491A2B3C = 1226451772
//   r[7:4]   bits 7..4: 0x7                      = 7
//   r[3]     bit 3 of 0x8                        = 1
//   q[9:39]  q is [0:39], so q[39] is bit 0 and q[9] is bit 30: the same
//            31 bits as r[30:0]                  = 305419896
// A tool that counted from the left bound of `q` would read bits 39..9 of a
// 40-bit value instead; one that sign-extended bit 31 into r[31:1] would read
// a negative number.
//
// Invalid neighbours: discrete_bus_part_select_32_rejected.va (a 32-bit
// select, E0222) and discrete_bus_over31_rejected.va (the whole 32-bit reg).
//
//! lrm 7.3.1
//! inherited IEEE 1364-2005 4.2.1
//! checks 5
`include "check.vh"
module ch7_discrete_bus_part_select_31(p);
  inout p; electrical p;
  reg [39:0] r;
  reg [0:39] q;
  initial begin
    r = 40'hab_9234_5678;
    q = 40'hab_9234_5678;
  end
  analog begin
    `CHECKI("r[30:0] is a legal 31-bit grouping of a 40-bit reg", r[30:0], 305419896);
    `CHECKI("r[31:1] maps bit 31 of the reg to bit 30, never the sign", r[31:1], 1226451772);
    `CHECKI("r[7:4]", r[7:4], 7);
    `CHECKI("r[3]", r[3], 1);
    `CHECKI("q[9:39] of an ascending range: q[39] is the LSB", q[9:39], 305419896);
    I(p) <+ V(p);
  end
endmodule
