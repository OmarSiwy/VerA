// 7.8.4:1002: an ordinary digital high drives a 2 V/1 kohm analog source.
// A 100 ohm load reduces the shared node to 2/11 V, below the bridge's
// 0.5 V receive threshold. The ordinary receiver must therefore see zero
// while the ordinary driver remains one. Direct driver-to-receiver
// propagation would produce the opposite receiver result.
//! lrm 7.8.4:1002
//! analysis tran
//! time 0, 10n
//! solve
//! checks 3
`timescale 1ns/1ps
`include "check.vh"
connectmodule loaded_state_bridge(d, a);
  inout d; ddiscrete d;
  inout a; electrical a;
  reg drive, receive;
  initial begin drive = 0; receive = 0; end
  assign d = receive;
  always @(driver_update d) drive = $driver_state(d, 0);
  always @(absdelta(V(a), 0.0)) receive = V(a) > 0.5;
  analog I(a) <+ (V(a) - ((drive === 1'b1) ? 2.0 : 0.0))/1000.0;
endmodule
module loaded_state_driver(o);
  output o; ddiscrete o; reg o;
  initial begin
    #0 o = 1'b1;
    #9 `CHECKI("the ordinary driver's value remains high", o, 1);
  end
endmodule
module loaded_state_receiver(i);
  input i; ddiscrete i;
  initial #9 `CHECKI("receiver is determined by the loaded analog node", i, 0);
endmodule
module receiver_reads_loaded_analog_state;
  electrical node;
  loaded_state_driver source(node);
  loaded_state_receiver receiver(node);
  analog begin
    I(node) <+ V(node)/100.0;
    @(final_step) begin
      `CHECK("ordinary driver contributes to the loaded analog state", V(node), 0.18181818181818182, 1e-12);
    end
  end
endmodule
connectrules loaded_state_rules;
  connect loaded_state_bridge merged;
endconnectrules
