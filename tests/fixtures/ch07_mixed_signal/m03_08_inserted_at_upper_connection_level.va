// §7.8.4, the second of the four insertion rules: "The connect module for a port
// shall be instantiated in the context of the port's upper connection."
//
// §7.8.1 says the same thing about the sweep: "Auto-insertion of connect modules
// is done hierarchically. The connect modules are inserted based on the net
// disciplines and ports at each level of the hierarchy." And §7.8.4 defines the
// two ends of a port: "The segment in the instantiated module is called the lower
// or formal connection and the segment in the instantiating module is the upper
// or actual connection."
//
// THE HIERARCHY. Three levels:
//
//     m03_top        electrical a          -- instantiates mid
//       m03_mid      electrical n (port)   -- instantiates leaf
//         m03_leaf   ddiscrete  d (port)
//
// Only ONE port is mixed: `m03_leaf`'s `d`. Its lower connection is the leaf's
// `ddiscrete d`; its upper connection is `m03_mid`'s `electrical n`. The rule
// therefore places the bridge inside `m03_mid`, NOT inside `m03_top` — the port
// from `m03_top` into `m03_mid` is electrical on both ends and is not mixed at
// all, so nothing is inserted at the top level.
//
// HOW THE LEVEL IS OBSERVED. By the path a §6.3.1 defparam must take. §7.8.5's
// merged name is SigName__ModuleName__BottomDiscipline; the signal at the upper
// connection is `m03_mid`'s `n`, so the instance is
//
//     n__m03_a2d__ddiscrete
//
// and from `m03_top` it is reached as `mid.n__m03_a2d__ddiscrete`. Two things
// about that path are assertions rather than notation:
//   - the leading `mid.` — a compiler that inserted at the top would have to be
//     reached as a bare local name, and this defparam would name nothing;
//   - `n` and not `a` — SigName is the upper-connection signal in the context the
//     bridge lands in, which at that level is spelled `n`.
// A defparam whose target does not exist is an error (§6.3.1 places the target
// "in any module instance throughout the design"), so a wrong level or a wrong
// SigName cannot pass silently.
//
// DERIVATION. One bridge, rin raised from 1000 to 3000 by the defparam. The
// analog signal is ONE node across `top.a` and `mid.n` (§7.8.2: "there shall
// never be more than one analog node representing a signal"), so the top's 1 kohm
// shunt and 1 mA source see the bridge's load directly:
//
//     V/1000 - 1e-3 + V/3000 = 0
//     V * 4/3000 = 1e-3
//     V(a) = 0.75
//
// Separating answers: defparam applied but rin left at 1000 -> 0.5; nothing
// inserted -> the defparam target does not exist and the file must not compile.
//
//! lrm 7.8.4
//! lrm 7.8.1
//! lrm 7.8.5
//! lrm 7.8.2
//! lrm 6.3.1
//! solve
//! xfail VerA performs no §7.8 insertion, so no bridge is placed in `mid` and the defparam target does not exist (E0907)
`include "check.vh"

connectmodule m03_a2d(el, cm);
  input el;
  output cm;
  electrical el;
  ddiscrete cm;
  reg cm;
  parameter real rin = 1000.0 from (0.0:inf);
  analog I(el) <+ V(el) / rin;
  initial cm = 1'b0;
endmodule

module m03_leaf(d);
  input d;
  ddiscrete d;
  // No digital process here: the port is a receiver by its DISCIPLINE alone
  // (§7.8.4 selects on the two connections' disciplines and the port
  // direction). An unread `reg seen` process only made the file stop at E0205
  // before it could reach its own assertion.
endmodule

// The only mixed port in the design is inside THIS module, so this is where
// §7.8.4 requires the bridge to land.
module m03_mid(n);
  inout n;
  electrical n;
  m03_leaf lf(n);
endmodule

module m03_top;
  electrical a;

  m03_mid mid(a);

  // One level down, named for `mid`'s own signal `n` — both facts are the test.
  defparam mid.n__m03_a2d__ddiscrete.rin = 3000.0;

  analog begin
    I(a) <+ V(a) / 1000.0;
    I(a) <+ -1.0e-3;
    `CHECK("the bridge lands in mid (the port's upper connection), named for mid's signal n",
           V(a), 0.75, 1e-12);
  end
endmodule

connectrules m03_rules;
  connect m03_a2d;
endconnectrules
