// §7.8.5.1: "The following naming conventions shall be used when generating
// connect module instance names that are connected to built-in digital
// primitives. For N-input gates (and, nand, nor, or, xnor, xor) the output
// will be named out, and the inputs reading from left to right will be named
// in1, in2, in3, and so forth."
//
// §7.8.5 split: "One module instance is instantiated for each such port. In
// this case, the instance name of the connect module is
// SigName__InstName__PortName". §7.8.5's stated purpose: "Parameters of
// auto-inserted connect instances can be set on an instance-by-instance basis
// with the use of the defparam statement. This requires predictable instance
// names for the auto-inserted modules."
//
// THE DESIGN. `and g1(y, a, b)`: the leftmost terminal is the output (out,
// signal y), then in1 (signal a) and in2 (signal b). `a` is electrical; y and
// b are discipline-less wires. §3.9: "For digital primitives the domain is
// discrete and thus the discipline is set via the default_discipline
// directive", so `default_discipline ddiscrete gives every gate terminal,
// and the undeclared y and b, the discipline ddiscrete (E0960's legal side,
// ch03_data_types/digital_primitive_on_mixed_net_rejected.va).
//
// So g1's in1 is a mixed INPUT port, upper electrical (a), lower ddiscrete:
// §7.6 Example 2's a2d shape, which `connect b5_ggn_a2d split;` selects
// (§7.8.4). y and b are digital on both sides and get nothing. One split
// instance, named
//
//     SigName__InstName__PortName = a__g1__in1
//
// and `defparam a__g1__in1.rin = 3000.0` retunes its load.
//
// DERIVATION. 1 kohm shunt and 1 mA into `a`, one bridge of rin = 3 kohm:
//     V/1000 + V/3000 = 1e-3   =>   V(a) = 3/4 = 0.75   (python3: 0.75)
// The defparam ignored (rin = 1 kohm) reads 0.5; nothing inserted means the
// defparam names nothing (E0907) and the file must not compile; a name built
// from the wrong field (`y__g1__in1`, `a__g1__a`) is likewise E0907.
//
//! lrm 7.8.5.1
//! lrm 7.8.5.1:2
//! lrm 7.8.5
//! lrm 3.9
//! lrm 6.3.1
//! solve
//! xfail an analog compile keeps no gate (W0252) and insertion walks module instances only, so no a2d is inserted at g1's in1 and a__g1__in1 is E0907
`include "check.vh"

connectmodule b5_ggn_a2d(el, cm);
  input el;
  output cm;
  electrical el;
  ddiscrete cm;
  reg cm;
  parameter real rin = 1000.0 from (0.0:inf);
  analog I(el) <+ V(el) / rin;
  initial cm = 1'b0;
endmodule

`default_discipline ddiscrete
module b5_gate_generated_connect_name_defparam;
  electrical a;
  wire y, b;

  and g1(y, a, b);

  // §7.8.5 split name for the bridge at g1's port in1.
  defparam a__g1__in1.rin = 3000.0;

  analog begin
    I(a) <+ V(a) / 1000.0;
    I(a) <+ -1.0e-3;
    `CHECK("split a2d at and g1's in1 is a__g1__in1; defparam rin = 3k gives V = 0.75",
           V(a), 0.75, 1e-12);
  end
endmodule
`default_discipline

connectrules b5_ggn_rules;
  connect b5_ggn_a2d split;
endconnectrules
