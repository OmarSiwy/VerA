// A continuous assignment into a net of a DISCRETE discipline, the positive
// half of the rule E0438 pins on a variable.
//
// §3.6.2.2 declares `discipline ddiscrete; domain discrete; enddiscipline`, and
// Syntax 3-6 makes `ddiscrete [3:0] code;` a NET declaration ("ddiscrete
// [10:1] connector1;" is the clause's own example). A discipline decides the
// net's DOMAIN, not whether it is a net. IEEE 1364-2005 §6.1 (part of VAMS by
// §1.1): "Continuous assignments shall drive values onto nets", and A.6.1's
// `net_assignment ::= net_lvalue = expression`. §7.2 says who may drive it:
// "only digital blocks and primitives can drive a discrete net", and §7.3
// "Write operations of nets and variables are only allowed from the context of
// their domain" — a continuous assignment is the discrete context (§7.2.2), and
// both nets here are of the discrete domain. So the source is legal.
//
// VerA used to refuse it with E0438 ("drives a net, not a variable"): lowering
// counted only UNDISCIPLINED nets as nets. The domain check §7.3 does make — a
// CONTINUOUS net written by `assign` — is E0435, pinned by
// continuous_net_continuously_assigned_rejected.va.
//
// DERIVATION. `b` is 4'b1100 = 8 + 4 = 12, driven onto `code`. §7.3.1 Table
// 7-1's bit row reads a discrete bit grouping in the continuous context as the
// integer whose bit 0 is the grouping's lowest bit, so `code` reads 12 (a
// reversed mapping reads 4'b0011 = 3). `hi` is driven from the part-select
// `code[2]`, which is 1 (0 reversed), so the scalar ddiscrete net reads 1.
//
// WHAT FAILS TODAY. The compiler accepts it (`vera --lint` exits 0; the
// lowering side is pinned by lib/ir/lower/test.zig, "an assign target is judged
// by declaration kind, then by domain"). The mixed runner's digital half does
// not: src/sim/digital/root.zig skips every net with `discipline != .none` as
// "§7.2.1 continuous", the same discipline-for-domain mistake, so `code` is
// never minted and the `assign` fails with "undeclared digital variable".
//
//! lrm 3.6.2.2
//! lrm 7.2
//! lrm 7.3
//! lrm 7.3.1
//! lrm A.6.1
//! xfail the digital runner treats every disciplined net as continuous, so a ddiscrete net is never minted (src/sim/digital/root.zig)
`include "check.vh"
module ch7_ddiscrete_net_continuously_assigned(p);
  inout p;
  electrical p;
  reg [3:0] b;
  ddiscrete [3:0] code;
  ddiscrete hi;

  assign code = b;
  assign hi = code[2];
  initial b = 4'b1100;

  analog begin
    `CHECKI("Table 7-1: a ddiscrete bus assigned 4'b1100 reads as the integer 12", code, 12);
    `CHECKI("a scalar ddiscrete net assigned code[2] reads 1", hi, 1);
    I(p) <+ V(p);
  end
endmodule
