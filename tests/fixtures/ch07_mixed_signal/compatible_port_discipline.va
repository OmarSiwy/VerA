// §7.4.3 "Ports of continuous-time disciplines ... shall obey the rules imposed
// in 3.11", and those rules ACCEPT as well as refuse. §3.11.1's worked example
// rules on this pair by name: "electrical and sig_flow_v are compatible
// disciplines because the nature for potential is same for both disciplines
// and the nature for flow does not exist in sig_flow_v" (the Non-Existent
// Binding Rule: "A nature is compatible with a non-existent discipline
// binding").
//
// Annex D declares that shape as `voltage`: potential Voltage and no flow,
// where `electrical` is potential Voltage, flow Current. So the child's port
// `a`, declared voltage, may be connected to the parent's electrical `p`, and
// the child reads the joined net through the potential access both
// disciplines share.
//
// This is the positive half of incompatible_port_discipline_rejected.va: a
// port-binding check that refused every pair of DIFFERENT disciplines would
// pass that file and fail this one.
//
// The second child is the SELF RULE's own instance: an electrical port on the
// parent's electrical net, which is legal for no reason other than "A
// discipline is compatible with itself." Together the two children exercise
// both accepted shapes — the same discipline and a different compatible one.
//
// The value: `p` is biased to 0.75 V; the child's `a` is the same signal
// (§6.2.2, a port connection joins the two), so V(a) reads 0.75.
//
//! lrm 7.4.3
//! lrm 3.11
//! lrm 3.11.1
//! lrm 1.3.4
//! lrm 1.3.4:2
//! lrm 3.11.1:1
//! lrm 7.4.3:1
//! bias V(p) = 0.75, V(n) = 0.0
`include "check.vh"
module ch07_compatible_port_child(a);
    input a;
    voltage a;
    analog `CHECKX("the voltage port reads the electrical net it is joined to", V(a), 0.75);
endmodule

module ch07_compatible_port_same(b);
    input b;
    electrical b;
    analog `CHECKX("an electrical port joins an electrical net: a discipline is compatible with itself", V(b), 0.75);
endmodule

module ch07_compatible_port_discipline(p, n);
    inout p, n;
    electrical p, n;
    ch07_compatible_port_child u(p);
    ch07_compatible_port_same u2(p);
    analog I(p, n) <+ V(p, n) * 1.0e-3;
endmodule
