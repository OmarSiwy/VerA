// §7.3.1 Table 7-1: an integer is read in a continuous context as an integer
// number, and the value it gates is chosen by §4.2.12 — "If expression1
// evaluates to true (any value other than zero (0)), then expression2 is
// evaluated and used as the result."
//
// `digital_value` is given its value in the analog block, so §7.2.2 makes it a
// continuous variable: an analog-only tool has no discrete context to assign it
// from, and §7.2.2 leaves an unassigned variable's domain — and so its value —
// undefined, which is nothing an assertion may lean on.
//
// 2 is deliberately not 1: the true arm is selected by "any value other than
// zero", not by equality with one. With V(p) biased to 0.7 the two arms are
// 0.7 and 0.0, so picking the wrong one is visible.
//
// Both checks are CHECKX. The selected arm is a `//! bias` value the runner
// wrote into the unknown vector verbatim, and a ternary selects an operand
// rather than computing one, so the result is bit-identical to the literal in
// either arm. A 1e-15 window on 0.7 would have been nine ulp of slack
// (ulp(0.7) = 1.1102230246251565e-16) where the answer is exact.
//
//! lrm 7.3.1
//! lrm 4.2.12
//! lrm 4.2.12:1
//! bias V(p) = 0.7
`include "check.vh"
module ch7_read_integer(p);
  inout p; electrical p; integer digital_value;
  analog begin
    digital_value = 2;
    `CHECKX("a nonzero integer condition selects the true arm", digital_value ? V(p) : 0.0, 0.7);
    `CHECKX("a zero integer condition selects the false arm", (digital_value - 2) ? V(p) : 0.0, 0.0);
    I(p) <+ digital_value ? V(p) : 0.0;
  end
endmodule
