// §9.22.5 driver_update, verbatim and in full:
//
//   "The status of drivers for a given signal can be monitored with the event
//    detection keyword driver_update. It can be used in conjunction with the
//    event detection operator @ to detect updates to any of the drivers of the
//    signal.
//
//      always @(driver_update clock)
//        statement;
//
//    causes the statement to execute any time a driver of the signal clock is
//    updated. Here, an update is defined as the addition of a new pending value
//    to the driver. This is true whether or not there is a change in the
//    resolved value of the signal."
//
// THE LAST SENTENCE IS THE WHOLE ROW. Every other event in this language fires
// on a CHANGE: `@(net)` fires when the net's value differs, `cross()` fires when
// a crossing happens, `@(posedge x)` fires on a transition. `driver_update` is
// the one that does not. It fires on the ASSIGNMENT, and the clause spells out
// the case that distinguishes the two — re-driving a driver with the value it
// already holds, so that the resolved signal cannot have moved.
//
// tests/fixtures/ch09_system_tasks/38_driver_update_connectmodule.va says so
// itself: "how often it fires depends on how many drivers the elaborated
// netlist puts on `d` — a property of the instantiating design, not of this
// source. Counting firings here would pin the harness, not the LRM." That file
// therefore asserts only acceptance. THIS file is the instantiating design it
// was missing, so the count becomes a property of the LRM again.
//
// WHY THE COUNT IS UNAMBIGUOUS. Every driver assignment below is at a distinct
// time, at least 10 ticks from its neighbours, and every sample is taken 5
// ticks after the last assignment that could affect it. So no ordering within a
// timestep, no delta-cycle count and no simultaneity is being asserted — only
// "one assignment to a driver produces exactly one firing".
//
//! lrm 9.22.5
//! lrm 9.22.6
//! lrm 9.22.3
//! lrm 9.22.3:1000
//! lrm 9.22.5:1000
//! analysis tran
//! time 0, 60n
//! checks 8
//
// WHOSE DRIVERS ARE WATCHED — settled 2026-09-24 by the user
// (docs/ROADMAP.md §7 item 1): `driver_update` does NOT fire for the connect
// module's OWN driver of the signal, the `assign d = out;` below. The reading
// is §9.22.6's separation of the two kinds of driver: with that assignment
// "the digital port of the connect module will drive the receivers with a
// value determined in the connect module", which "may potentially be
// different from the value of the drivers of the connect module digital
// port". The connect module's driver feeds the RECEIVERS; "the drivers of the
// connect module digital port" are the ordinary modules' drivers, and those
// are the drivers §9.22 ¶3's access functions — and so `driver_update` — see
// (the same exclusion 10_driver_count_excludes_connectmodule.va pins for
// `$driver_count`). So the `out = 1'b0` at t=0 is not an update of `d`.
// `src/sim/digital/driver.zig` `cm_driver_updates = false` is this decision.
//
// HAND DERIVATION — two ordinary drivers on the mixed net, `a` and `b`.
//
//   t=0   out := 1'b0  the connect module's own driver: NOT counted (above)
//   t=10  a := 1'b1   a moves x -> 1   : update #1
//   t=20  b := 1'b1   b moves x -> 1   : update #2
//   t=30  a := 1'b1   a ALREADY HOLDS 1, and b holds 1 too, so nothing about
//                     the signal's resolved value can differ before and after.
//                     §9.22.5 sentence 4 makes it   : update #3
//   t=50  a := 1'b0   a moves 1 -> 0                : update #4
//
//   Samples and their expected counts:
//     t=15  updates = 1   ones = 1   driver states: one 1, one x
//     t=25  updates = 2   ones = 2   driver states: two 1s
//     t=35  updates = 3   ones = 2   driver states: two 1s   <- IDENTICAL to t=25
//     t=55  updates = 4   ones = 1   driver states: one 1, one 0
//
//   The t=25 / t=35 pair is the assertion: the update counter must differ
//   (2 -> 3) while the driver-state histogram must not (ones = 2 at both). A
//   tool that implemented driver_update as "@(the resolved net)" reads 2 at
//   both.
//
//   The ones histogram is checked rather than an indexed state because
//   §9.22.1 numbers the drivers arbitrarily (see m04_11_driver_state_histogram.va).
//
// HOW THIS FILE ASSERTS. Each sample is two check.vh CHECKIs from a digital
// `initial`, and `//! checks 8` makes the count exact: a tool that never runs
// the connect module's process FAILs on the count rather than passing on
// silence. CHECKI is a $strobe, which prints at the END of its time step
// (IEEE 1364 §17.1), so `$finish` is one tick after the last sample. This file
// used to assert through `$display` of `%b` columns and carried no `//!
// analysis`/`time`/`checks` lines, so the `.va` harness reported that it
// asserted nothing; how `%b` spells a 32-bit integer is a digital display rule
// and is no longer claimed here.

`timescale 1ns/1ns
`include "disciplines.vams"
`include "check.vh"

connectrules m04_du_rules;
  connect m04_du_c2e merged input ddiscrete, output electrical;
endconnectrules

connectmodule m04_du_c2e(d, a);
  input d;
  output a;
  ddiscrete d;
  electrical a;

  reg out;
  integer updates, i, ones;

  assign d = out;

  always @(driver_update d)
    updates = updates + 1;

  task ones_now;
    begin
      ones = 0;
      for (i = 0; i < $driver_count(d); i = i + 1)
        if ($driver_state(d, i) === 1'b1) ones = ones + 1;
    end
  endtask

  initial begin
    out = 1'b0;
    updates = 0;
    #15 ones_now;
    `CHECKI("first_driver_assignment updates", updates, 1);
    `CHECKI("first_driver_assignment ones", ones, 1);
    #10 ones_now;
    `CHECKI("second_driver_assignment updates", updates, 2);
    `CHECKI("second_driver_assignment ones", ones, 2);
    #10 ones_now;
    `CHECKI("redriving_the_same_value_still_updates updates", updates, 3);
    `CHECKI("redriving_the_same_value_still_updates ones", ones, 2);
    #20 ones_now;
    `CHECKI("real_transition_updates updates", updates, 4);
    `CHECKI("real_transition_updates ones", ones, 1);
    #1 $finish(0);
  end

  analog V(a) <+ 0.0;
endmodule

module m04_du_drv_a(o);
  output o;
  ddiscrete o;
  reg o;
  initial begin
    #10 o = 1'b1;
    #20 o = 1'b1;   // §9.22.5: an update, though the value does not change
    #20 o = 1'b0;
  end
endmodule

module m04_du_drv_b(o);
  output o;
  ddiscrete o;
  reg o;
  initial begin
    #20 o = 1'b1;
  end
endmodule

module m04_du_load(a);
  inout a;
  electrical a;
  electrical g;
  ground g;
  analog I(a, g) <+ V(a, g) / 1.0e3;
endmodule

module m04_du_top;
  electrical net;

  m04_du_drv_a a(.o(net));
  m04_du_drv_b b(.o(net));
  m04_du_load  ld(.a(net));
endmodule
