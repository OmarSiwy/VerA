// §7.8.4: "Driver-receiver segregation and connect module insertion is a
// post elaboration operation. It depends on a complete hierarchical
// examination of each signal in the design." Annex F.2.1 step 3: "Apply all
// out-of-context node and signal declarations", before step 4 resolves the
// undeclared nets; §7.6: "The disciplines of mixed nets are determined
// prior to the connect module insertion phase of elaboration."
//
// THE DESIGN. top's undeclared `shared` connects mid's port `p` and
// echild's electrical port. mid's two children are leaves whose port has no
// discipline; mid itself declares them `cuo_d` out of context
// (`cuo_d l1.port;`), one level below top, the level that must place the
// bridge.
//
// DERIVATION, basic resolution (§7.4.4.1, Annex F.2.1):
//   Step 3: l1.port and l2.port are cuo_d.
//   Step 4: mid.p's child nets are both cuo_d: digital. top.shared's
//     children are mid.p (cuo_d) and e.port (electrical): analog.
//   Mixed ports: mid's port in top only.
//   §7.8.3.2 split: one instance per mixed port, in top: N = 1.
// The bridge loads `shared` with 1 kohm, top drives 1 mA: V = 1.0.
//   A tool that placed bridges on the two leaf ports reads 0.5; one that
//   applied the declarations only after planning top refuses (E0929).
//
//! lrm 7.8.4
//! lrm F.2.1
//! lrm 7.6
//! solve
//! checks 1
`include "check.vh"
discipline cuo_d; domain discrete; enddiscipline
connectmodule cuo_bridge(a, d);
  inout a; electrical a;
  inout d; cuo_d d;
  analog I(a) <+ V(a) / 1000.0;
endmodule
connectrules cuo_rules;
  connect cuo_bridge split;
endconnectrules
module cuo_uleaf(port); inout port; endmodule
module cuo_echild(port); inout port; electrical port; endmodule
module cuo_mid(p);
  inout p;
  cuo_uleaf l1(p);
  cuo_uleaf l2(p);
  cuo_d l1.port;
  cuo_d l2.port;
endmodule
module cuo_top;
  cuo_mid m(shared);
  cuo_echild e(shared);
  analog begin
    I(shared) <+ -1.0e-3;
    `CHECK("one bridge, on mid's port in top: V = 1 mA * 1 kohm", V(shared), 1.0, 1e-12);
  end
endmodule
