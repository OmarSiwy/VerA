// §7.6 connect module descriptions: a `connectmodule` is the bridge whose "port
// disciplines define the default type of disciplines which shall be bridged".
//
// C.9 settles the verdict for a Verilog-A compiler: "Clause 7 only applies to
// Verilog-AMS HDL", and C.16 lists `connectmodule` among the keywords "not used
// by Verilog-A". Refusing this is conformance, not debt — but the refusal has
// to be ABOUT the construct, so a plain module is present and the file cannot
// be refused merely for declaring no module.
//
//! lrm 7.6
//! lrm C.9
//! lrm C.16
//! reject E0201
//! reject connectmodule
module ch7_host(p);
  inout p; electrical p;
  analog I(p) <+ V(p);
endmodule
connectmodule ch7_a2d(a, d);
  input a; output d; electrical a;
endmodule
