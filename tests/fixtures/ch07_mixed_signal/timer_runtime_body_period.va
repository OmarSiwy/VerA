// §5.10.3.3: changes made by a body AFTER delivery retain that event, then
// schedule using the latest absolute grid. Start 0, period 2 ns gives 0 and
// 2 ns. The second event's digital body changes period to 3 ns: the next
// points are 3 and 6, not the stale 4 nor a last-fire-origin 5 ns.
// A side-effect counter executes once per event. Four final assertions give
// checks = 4; the time comparisons allow the 1 ps digital precision.
// This legal state change has no invalid form; negative tolerance is a10_12.
//! lrm 5.10.3.3
//! lrm 5.10.4
//! lrm 7.3.6.1
//! analysis tran
//! time 0, 7n
//! checks 4
`timescale 1ns/1ps
`include "check.vh"
module timer_runtime_body_period(p);
  inout p; electrical p;
  event ev;
  real period, changed, after_change, last;
  integer hits;
  initial begin period = 2n; hits = 0; changed = -1; after_change = -1; last = -1; end
  always @(ev) begin
    hits = hits + 1;
    if (hits == 2) begin changed = $realtime; period = 3n; end
    if (hits == 3) after_change = $realtime;
    last = $realtime;
  end
  analog begin
    @(timer(0, period)) -> ev;
    @(final_step) begin
      `CHECKI("the body executes once for each of four events", hits, 4);
      `CHECK("body change retains the event already delivered in ns", changed, 2, 0.001);
      `CHECK("next event uses the new absolute grid in ns", after_change, 3, 0.001);
      `CHECK("subsequent event stays on the new grid in ns", last, 6, 0.001);
    end
    I(p) <+ 0;
  end
endmodule
