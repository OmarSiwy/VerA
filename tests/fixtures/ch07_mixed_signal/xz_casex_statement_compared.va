// §7.3.2 lists "the case, casex, and casez statements" among the features that
// carry four-state values into the analog context. IEEE 1364 §9.5.1 (which
// §7.3.2's NOTE defers to) gives casex its meaning: x and z bits in either the
// case expression or a case item are don't-care conditions.
//
// This file used to be `xz_casex_statement_unsupported.va`, a `//! reject
// E0130` that its own header called an implementation boundary rather than
// conformance — a limitation pinned as a pass. casex now lowers, so the claim
// is stated positively. A digital driver replaces the undriven `input d`.
//
// DERIVATION, `timescale 1ns/1ns`.
//
//   r1: casex (d) 1'b0: 1.0, default 0.0 — an x or z SUBJECT is a don't-care:
//     [0, 20n) d = 1 -> 0.0;  [20n, 40n) d = x -> 1.0;
//     [40n, 60n) d = z -> 1.0;  [60n, ..) d = 0 -> 1.0
//   r2: casex (d) 1'bx: 1.0, default 0.0 — an x LABEL matches every d -> 1.0
//
// A tool running casex as `case` reads r1 = 0.0 at 30n and 50n, and r2 = 0.0
// at 10n; one running it as casez reads r1 = 0.0 at 30n.
//
//! lrm 7.3.2
//! lrm 7.3.2:1
//! analysis tran
//! time 0, 10n, 30n, 50n, 70n
`timescale 1ns/1ns
`include "check.vh"
module ch7_xz_casex_statement(p);
  inout p; electrical p; reg d; real r1, r2;
  initial begin
    d = 1'b1;
    #20 d = 1'bx;
    #20 d = 1'bz;
    #20 d = 1'b0;
  end
  analog begin
    casex (d)
      1'b0: r1 = 1.0;
      default: r1 = 0.0;
    endcase
    casex (d)
      1'bx: r2 = 1.0;
      default: r2 = 0.0;
    endcase
    `CHECKEQ("casex: an x or z subject bit is a don't-care", r1, ($abstime < 20n) ? 0.0 : 1.0, 0.0);
    `CHECKX("casex: an x label bit is a don't-care", r2, 1.0);
    I(p) <+ V(p) + r1 + r2;
  end
endmodule
