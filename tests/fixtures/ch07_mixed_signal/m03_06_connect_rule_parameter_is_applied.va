// §7.7.3 parameter passing attribute: "An attribute method can be used with the
// connect statement to specify parameter values to pass into the Verilog-AMS HDL
// connect module and override the default values. Any parameters declared in the
// connect module can be specified." The clause prints
//
//     connect a2d_035u #(.tt(3.5n), .vcc(3.3));
//
// and §7.8.3.2 Example 3 restates it as one of the three things a connect
// statement does: "Sets the value of the parameter r to 30k".
//
// tests/fixtures/ch07_mixed_signal/connect_parameter_accepted.va already pins
// that this list PARSES in its A.1.8 grammar slot, and says in its own header
// that the override "is never APPLIED". This fixture is the other half: the
// value must actually reach the inserted instance and change its behavior.
//
// DERIVATION. One ddiscrete input port on electrical signal `a`, `merged` by
// default (§7.8.3), so exactly one m03_a2d is inserted. Its declared default
// rin is 1000; the connect statement overrides it to 2500. Top module: 1 kohm
// shunt, 1 mA source. KCL at `a`:
//
//     V/1000 - 1e-3 + V/2500 = 0
//     V * (2.5 + 1)/2500 = 1e-3
//     V * 1.4e-3 = 1e-3
//     V(a) = 1/1.4 = 5/7 = 0.71428571428571430 (nearest double)
//
// Separating answers: override parsed and dropped (rin stays 1000) -> 0.5;
// nothing inserted -> 1.0. Both far outside the tolerance.
//
// NOT CLAIMED HERE: what happens when a connect statement names a parameter the
// connect module does not declare. §7.7.3 says only "any parameters declared in
// the connect module can be specified", which makes an undeclared name an error
// but does not name the diagnostic; that is left to the implementation and has
// no fixture in this row.
//
//! lrm 7.7.3
//! lrm 7.8.3.2
//! lrm 7.8.4
//! solve
//! xfail VerA parses §7.7.3's parameter list and never applies it — there is no inserted instance to apply it to
`include "check.vh"

connectmodule m03_a2d(el, cm);
  input el;
  output cm;
  electrical el;
  ddiscrete cm;
  reg cm;
  parameter real rin = 1000.0 from (0.0:inf);
  analog I(el) <+ V(el) / rin;
  initial cm = 1'b0;
endmodule

module m03_din(din);
  input din;
  ddiscrete din;
  // No digital process here: the port is a receiver by its DISCIPLINE alone
  // (§7.8.4 selects on the two connections' disciplines and the port
  // direction). An unread `reg seen` process only made the file stop at E0205
  // before it could reach its own assertion.
endmodule

module m03_top;
  electrical a;

  m03_din u1(a);

  analog begin
    I(a) <+ V(a) / 1000.0;
    I(a) <+ -1.0e-3;
    `CHECK("§7.7.3 #(.rin(2500)) on the connect statement reaches the inserted a2d",
           V(a), 0.71428571428571430, 1e-12);
  end
endmodule

connectrules m03_rules;
  connect m03_a2d #(.rin(2500.0));
endconnectrules
