// §7.3.1 and specification/Vague_Decisions.md VD-116: a `reg` the analog
// context assigns holds every bit IEEE 1364-2005 gives it, and the analog
// context computes the right-hand side of the assignment as IEEE 1364
// sizes it (§5.4.1, §5.5.1-§5.5.3, Table 5-22), so for the same statement
// over the same operand values it computes the bits the digital engine
// computes. That identity is what this fixture asserts; no digits are
// written because the reference is the digital engine's own evaluation.
//
// THE DESIGN. A mixed module (its `initial` block waits). The digital
// process computes d1..d8 from x and y2 (65600-bit `reg`s it owns) and
// nothing else; the analog block computes a1..a8 from the same
// statements. The analog side reads every digital `reg` through its
// `Model` words. Each statement's check is three: every bit equal (a wide
// `==`, itself a 1-bit result in a 65600-bit context), bits 30..0, and the top
// 31 bits. The table covers the operators whose limb algorithms differ:
//   d1 = x + y2  (+)
//   d2 = y2 - x  (- wrapping below zero)
//   d3 = x * y2  (* cut to the width)
//   d4 = x / y2  (/ unsigned)
//   d5 = x % y2  (% unsigned)
//   d6 = x << 1000  (<<)
//   d7 = x >> 999  (>>)
//   d8 = (x < y2) + (x > y2) * 2 + (x == x) * 4  (comparisons)
// Two time points (0 and 1n), three checks per statement: checks 48.
// 65600 bits is past `wide_kernels.zw_native_max` (128): the analog side
// computes on 32-bit limbs.
// 65600 bits is past Zig's widest integer (u65535) and the IEEE 1364-2005
// §4.3.1 minimum (2^16 bits) every implementation must allow.
//
//! lrm 7.3.1
//! inherited IEEE 1364-2005 5.4.1
//! inherited IEEE 1364-2005 5.5.2
//! analysis tran
//! time 0, 1n
//! checks 48
`timescale 1ns/1ns
`include "check.vh"
module ch7_wide_reg_matches_digital_65600(p);
  inout p; electrical p;
  parameter integer K = -5;
  parameter real R = 2.5;
  reg [65599:0] x, y2;
  reg [65599:0] d1, d2, d3, d4, d5, d6, d7, d8;
  reg [65599:0] a1, a2, a3, a4, a5, a6, a7, a8;
  reg [39:0] eq;
  initial begin
    x = 65600'hc1529c70c7703f8b6771d7413d31d4ccee601ad44aec86d5775604915444447f60d88a139176720869d616a632d72a1ab6c854a3e0ec8a537462dc29da0e7ee2bcc20a52361b05c7c13871dbb6dd04301835a3350bdc9e115aafe493cd7d79ab5f279bd7d4275ccb297795c09e2df9c8e21eaa7c305fd54c017b3544cd3eec3a29700061db47794e893d45ed57bde93f8fd78c924f4cbb36248d19333feff5d9e458eeea3af6589dfdf32aef15a13f776bc679a9dec7b559fcdfa412ec49a7b8e3e9e6a2f78caca9c4ce1c2523d3c5f6b3696f05e26dec26be3100527abf8c2575b98acaa0c8dcb955547fb2fc6e31ab6fa4414ca98154953f62d3e4463120c5eadfe78237d82a4c6ff80a3490e503102befcd242876a357719456733109d2c05f1062ed50311fd69c304c22af111735e7bfcb38680c053764630bad3f4478d57f68609a129f4959fca13b898b4cc753da5b19b86e4a0f8472f13208c9346767c7440743f5f5c3554a5e06f7d269409669d472a886f32646d56bfb9c596e4e78b001b1738310a6df7a0953140a9ae8a684ae2a044a7a66e48005941c98c6ccedfd0b8daacbdf3c5ee7b0be0086e74d9f2ab2dfa21ec9f1306104cb1fb1c719e8da014a143301b1d7a6119347b63b295c4c8c88005afe40ba1994572c0a1d50d4bb46fea7bf502eca3cad708acae18f6341982ea756c479be98bc59e6efa2eb275f9e0102f7a6a0bf6868240bdd741ebeb03f348e54e1488bededc9c5ae9241b35cabeb382994be52ab9be70aa5136eac13356ce3e8f02365e65d448db486b606173ff2669005e236eb51f7de7bb80fab64d9eb8b3a6a5407ec0bb28a6ea0aeb9eb1f94f3464fc583a5da1ad348daf425ad98fedaacc6ef9c587f95e0d612fdc08488d0396c5a1d74b48f174906df9184d4fd93e3507060fc4e467c9ce4ab3420a503b3e696549cb869d121d57d0ddf3b961b3897a71dad7278be9dcedbbc57a8b079f94150372195668873fe97e8a9f54bc9a062baefb211779174822f3963d889899c0eeb385d1471895ae1f210d68a0386ee09f9b6161e6925a2c6ab8247844d04b8ca6e2ffc8cb6adf2cfde63047f725f2f18965a4dc49727be232c2ac3f08fef7e590037da89bbdb1294522110738f03598a3444a15920e7a9e30aa4e50cb919670ac22f6b71d2ac6bff2275e05e093e747588e0f1e395b441d82a8b4afcee96a750f12c7a6a20e11dad984958c83badf809c85bf9b55ee8611312eb14cc8fbf0fddc692269c1471a3510ec4a1b78366ccc16f171fa978987377c9845efac90ef11392b8132898e7a487fb19f8d8067a1749f46ee5cf48b8e31728703099736197b012a788209f41d65992237c2e62a8f00d90c2fbf521af7f20804eac29c81099357300113c6b5b1c6abeed34a9e238f0e9431df1328e6f12eb5355f221d58d0534c6279171bde48d8fbac7d6d1a1e362f80c06119ac1c861f7d12728dfd69668c93a7382b1b0f4c6912fb40306e294ab09375e56c58698a590e79b861374f6a59da8ba61aa68d8a9f0a8f9ddf5dead55992f3c8101f7f480f43d9a88cb680f4da11fae86a249eb28f92f7a633203bffdbee6832036ff5a3f8d5a6ba0b6650efa0bbaaf7e0aef9b72aa97098967eb660af8402dd237a0426dc10af698269b48fc1330d4c8918078446e9cd42ca33274ff41af9e336cdfa5aa4257e1d212d24bdc448b6764c8c85b16164855fa6aa1bdc9e7d14e7a6dda861d7243595bd5fa6ce6abb310560fe96e4c8fa18ecf7b5d61770198b8ecd50c4f3954d60cd067f885aff2726ba3aca12ae5927b7a9d03f119afb9e2d4219205f8f0d73e594ab33921ca2eda0db4d537cd1bd4712ee2c3f75f9268e79f4c9687c9a2295ab8e50191cb489d087701ffe0385e220fa7adbb8b9502679e02e643008b9b28492116c97a6907e183e1b5c4d1d40572eb87425cf9ede168ae3df8dd9a386edfd092738bb6531c219676f44c17a06b4ae7f5d8c43b9d6867e4c96e91da5735b6eba75447face4e6bebc340b03703457291f756d0e212a120a100001d00de2cbae7c0c2c64f6036abe5a29e475307f18dfe010c90170a40bd6a282463b5d73418cca541de874349491b3a0a7b335596692ff110953554c180d1f9335c1412d3e0208189fed44cefadb147d5140eac98ff49c2760f733f29fc9f01abb6c48b90af90262160f5503f277ba346553b7a1a3c43d2166e3e0de4ae0a5639fb57b26b0db9b410b934f139fd683e14d977e8353d98218fe6957c9a9190d6fa3a6d0a90f8391a85083e4fdaa54af54c2485af7c4d4b28e20a2a8dbf73393656b9af6c0acfb3832ad8792aedd23faa893dda1edaabe3f3c4f8e2fad5bb4d9e39bf9341f914db3d991c79c859acd210e39a453a292c2b9edd46d0e11077242a68f19b3d60fba9fef47efc5e056c16a3b3d5fb8cd16aee741b692eab06022dc36f19b1ec3c9a56ff78ee6a2504046ac24a66aba77589a5e34175db2493f3f53faac8cf461f1ad450ccba23ad32df6e32a5b8d1ede7b3122c6b675b8abaf4901e9f277e748fc28e6fb46d13df2952525f27ecbc783719815eeaa3f8dbcce0fc3d269b3ceeb7f14d8564c26267ac678caed6e1c134e0664ad149d673c5c80af73696885cfe3b31dde23366de1cc9758febf4d606ec67356002279b8fed321d0d7213a0d3969678ed78ab326614b4b1c4b0dc2947d970f8dec494016259138fe4854103bf2aec5ffef58f810ef65ae59e717cd028430951f6fc56eefafc222fcb63231e9debe6737aba3b026e835621c966be54081fe5c460fc609bd23dab7ef0cd30b77444f2727b653d6eb4f3c82763d130036fc88d1c2971f42fd36031577cf85a7b8ecd6f5260d6e8116e12aaa473ae37cb4956466ecf7640183bd082220337f92cdee4ecd7387711a9034b897ffdebed19c5aeff4165cfe0a8a304e364b61f016535efa3f98fbcb6cbb0d75bc63314cf632920fe372e1482ff6c80ddc572135a220dde4c2f4dbd6b90e89960e72ce1c4bee66bcacce0922a35a14a8af5af2553fb3d23984e2914776d8633d4c739b1362c38e8a04ba6492e1dd38d0ca567eccf30b2c1fec203d3c51a92ac9332eea85f8e4addea6e58d56da6368ef8b4076332ec67ab3657a54196507d55cec80662600cb35f6f75ec22d3cb15fbcda600a873e891048e71b5bedec085d0935e0d9cc2035e1d80e2f9b38d2fad9c5d7bf8f507eafb83078391740654ffa4f289d877ca7d339233c3bed1a6736767c990693f0a38eb2d1d27cdeaf87cfd856d70d0faef9bbec14cc1bebb7ecb4b33c0fe7b804ad2d172e5975467658ff8ec7bb14a8c718fd9b902f7676d24ac7cb8b146b4bfd4fe4ef2a4c7d649310a77925a4e14141fec7ca4604a39675d848dc20dc72cd1594da4fc9581c4aac91990ad2bad350b75a7afc942b0022585098c447e9beb04e55e4198c4a4d5468346dfe3048668a09fe237352ba21b7f56d35147e4b4f8d110e4392d7005b6ed306dcf245fc5b24dc871300053b1640ed12c9439d26180aabf2f4a4765b065bf690a6b1a19c2ca407a8d80d91d1add8743db9c9d3634863561ee7b14e6062ab63125c3e270a6b7162276f04b2a183c233c9e103e3820a89c76bce654e905593a5345cb283393c2fca46fcf735e3b108b042fcfc9e9ea5bbfdf2bf4e5a62cda930b1e3035fe20598e4590e5a8d15287e6548923aa896ae535b8376ccfd33cec4f163dda3a56041679fa0e539bc1b4a184dba963b9476d37bceebe0e5a354e39252d7c4198ed0415dd92c7fc5737103d069637dd4baaedebd97459acf2913d8058f514aca0e21db2f9584f07f277abea9089240887005b0803023a0fb472660d8c70430c1154a021e95d968c957dc65f918e7fd1c2d8e7efd79491b6d1aa501c22c1f75ea9e52753bcd2a5cc072bb536a3bd402ab907eb02fb6a645b2eb042b0b1b9524b333820d1f7d9d1c6a41d9d52bc75f52bfcd3215948452dab2df424147c4f9901bdcd8d3cb0ca09fd610b5c1329a73922358ddf96603678c7f402184aac85f73716c60d046e997922ff75fef7a4abfddfcb4f4bc74df5d760fd9a48b10ed4025084271e3de3f3c38ae58443c2e05c7bc03e8ec623fb1186bc99da5f7cf81b20e3ed1250e5b1acfe9969c1ead1eacaacc164d4247998049f1645f0ab278a70e6f4146b8daa3063f8d32e36cc973abd1299834407b3bd68df0cfd96648b4876f866e25f86553074a9496687d9463d35c29c43f5d5ed13d039923523d491230236be4d04271ec3fdd20acd566a5e404ab3fa0a6cd6fc9859de1be8112cde02e4e1abb407ef9251a0523575561edf001e476b851d7b25bbba1430027adbd7c2e5595bf666777247158ca8c55bcc0893abf386d28e9205e92d1d259bdc55a28162e969cdcec263356cf55bc6cf8d28177c6ff941a3e49c599be4e80982c1500c7768eb15fd57eb9070fb443016ac78597b0e9b5e55adc460fb659a0f56904c54db77a6d56f19930b9f6455402b3a132fce64ef5c30ef4fd564996b484033ea0a0f5b9f65894ce1a8f705bbe7a24ca17b29fe10b7d8fbbcd16897c5921866c383f7ed131f71d0a5b8198457440984c6cd518a11bbb0e4c33a5926a8fa309c0e86f7b410f0d138a88deb021da6c9f703e6e07ce954c620fb4e321cc6eb6af167e67289441eefa30772ce2739a6bfbf61bba6abcd2a98f5abadc2bf310208bdebc32b81bf581172acaf3d0f799e2b455645209b620fe8ad4569996049f44c93532849f7054f5d8e7146cf8b3b3bd0ee442c0c56752c0758e523cc8ebd905eddfc07efdbf793e7c5defb2b6bfe8a120a9ace945ba038dadb2faa718d39e771a4e0d8f1b0fdc6fd9581b25df468925b74fa9abd46d00ec5ec3b7bad91c13555a4232f8b1e418032d5dd065bc1c6594988c1e968fe4f96cb67e68c13db66e48fdfa4516dda60fa4d6e65c37c59307a0a75c6417c69aad59d2038193187691e76e93a9bb8cf1cd31fcfc501ad94844a33c5acde2424a5db74c25462beefeebdda510815828c0a2c38f3a2ba77b8687683cc6bb7fb751e3a8924d4e687d6fdc1bd64a04d2a30d62c9d1434a753372c31a9052ba1829055a69597d8069b76e0896f8d666d3181d08e1cdec7e579a385c7e6f483710d6486bbc49fe1f2c68a2e6493fbd360686d41c3ec61068c0206d9f40f46b14f7ab0195dc335a6aa1c314c8506181dc26ca920789ae59d15231a41569e0807c3c09fcf646127812b39e09ec5861bd72d000830b9d4f6c880cdec85c3b8de1389ac9260d5b446ae3eac81d5afd0528bd1564cc5894f827ca9d99e094fe99fb5f773cd079be69ace8e72aa19d6e61f73ba711702a22fab0c5db9a3fa9b2dccb9f234835f5ad59ce3b9377024d483bdd23c77459a578ae1926ae5c7bdb726ba05cb0e2807afec2a80979deadade926ca9c94683f98bd822b752ec7445b12b4247be92493dd36282536bcdb83a6c770a04d060c381d9d855448abd889335f86784d9f8bb5579cf296f19284ba9f1095007567baf666458ef6e52a29485de66a84c89f346b83ea6203270b2de709ecb6acb1a02cef7f6ecf2730f5f6b09ca82b788e3a164c4d6003222868f2805f1e94744cf4429ac926da135d9dd7d120a7bbe369a86ebe0b889e78d609d49fa4a1438329888da7aed1c256adad820285952edefa31d211fad717a18b08d23ee047f8d82371c60fda537d993830116867963a4886bb4ec39a2c22d1b8ad2f7ff6f7f83db624696e95493341db3aae89557d3cbc71d8510a6031896eda0fcb46b167793875a89ddc18a25f751078cd821ba9b680dd824548e51dbd337e510a41c35767aaafac3b12f158635d4b76743e26af133d2480d1c0d2b36daaa9dcb9c8e3af4745800caa63f53744ac339718259555c2e007442767c7dea3295b04de2c604e47292ba313979ea0880b1848206892eeb2f62aadba6e59330b1069f2ec4f18cac7678b705a77585b1596574b32cea01b5b8a689ae3d6249cf4bcb99bf104ef1dbea95c242666e4c578585089b1ee3c299b8ab94c84ca72b3f72f5963d2a142c84db0b4b9f986d10f8c7bd6aa6a1c82bbf75245a9b68605cb4f6ba79d6d20640131039bfd637c814d93ea16c1d44af57105868395d94a832511db2f5b8b47b908db0d324b2fd3c295259238d23d9cdac70dd9806d4a3b1b2484c61463733cd6670fa44fc80f0c362026e4cd2865797cf67df62c4800e92158f84ed60863889967106a951f402c924f7e74d2170983c100e6ca40a958962e5a624c93308082b16d21fab9f8ccdf27f65f795f142e13cf1a91b0d527c34fe9f18c26402e631a36e88d3232bc37a73850a1cdc71bab184695e1d57b007ce76e74b7685cc0307267ab637b8b643c1814d67e90a8a5da7bafd58c0e124627f2b58de17fe40623648d379c05972c5be5016179f68de77911c505e14c30304de4a961f1d293977016f03d91a94da384a007cc158b660119cb662f14cd9f9ecc99bcaeed69a1176f089d658392f03851759369c7b670afb8d773255422de22af432c1f5c3acf4ccbd7878b9c8e77f48c67ff5d95ace9be12295e697502a86d36c1a918b267893437b0b7c9aea26c31cbe57b781e9e1232bb5325e92c4b2c26b1ffb5e934fb31bf95e52d1c3deab2316a7c963ea99e69ef414931684c5811d44a0e0b8639d98602ed416a766b7c355acb11ceb798725b2ab5ceb79ec7e5cfb11c2434d76b7fbc17a7afb098696736b3b57f56f8beb9a007d979b96c13bd5580d659934da9a970e945740ccac55a73cbfadc6bbaf5be516a2e1825750c9c2baa1d09629a552898222318a17db917e4304e5c8de5c684a8259c31a9a188d36072368c92a3a615ad4a0019f8db1ef0f13e69a90a97112d54f191816bde511738ed4ec5ad0751d995b62cf7a6f8fc31778c7cac2aaaf8ca52c5af58b93d99fcf63b2bccd574aa29e7d40d23186d8999dbf3894ea8d52788e1dae2d61a784becff7b04d85772fd57f54b76f74580be946f0221e9327a8aae6f59e53ea0fdb2e5e6f0ae2e7d1f02e41ef540185f2d3e61f32ef070a3adc8c16db23b22df59da04b0bb269dd9252f89ac7f707fe93710713585ab9f2eefb91ce22fb90854115bd10fee259c112e69948d17a95c1d5b8cd0a1ee83dbf2586ffd583c24d10e2a0fd8290ac1b0f78c9e59092834f62d55d85343ac1344c36dad2a2abbed82abee392816d451b4baa437a46f18098c1f2368e4f97b6c46d821cba3046d0da2c201de54e13a7902d4a7392b6be34335d70e1062e54c861a76762fe0d1d9c12b3cc78378a058538d478aaecd4b605008a8f2427ed8e707830b20c21251efc14fe995cf87be42ab8b94f5fce0d5221f621734097a8ecc682de090fb93f3fdee56626637b1c9026f2a04f1ceaad2fe2c9d93e6a557af73ce03cce2163b7a0dcb6580e6fb2ad291de03ab75fefc6f2c503b3abdabfbea498bc21b6475bd324c57459f3671d9cbc0506f53109832bb8eba8bec4c273615e4173baf8ae1298d14aa168e13ebf26a7007d82f6fa3c21b8505ed2453ea21ccb5543b580c95c65ca2963c5cea78f41a67ae9cb3d6740e4e20b3ff5722398126bf409789612c7d8d904fea9c32d67d1542ec1ef963a6fce6518c2a94678c362b8224c9fce045562225776ee43659912579d0c1d28a4aa9404d6b444cfdef5761f9ddb45f0daf97b5b491c9e012c9bd301c072956fcefc2b4e08b0fb0cccd0f2e130de54b1f0892917cf5f11bb88bf1cd56dcafef683392b67af6b86bda0fe8dc964d2ba06031b51c5dac6761400cb4aabed01232b1424e7738833fd90382cc47254b332ab26a9fb5a2ed0dc586f7d8633679f00e990c4e093a5842d6545f2c3dce76a74dfbc9f0853754d263ff6756d0d74657ee03b4a0d460d9a64a28ecd1016fb67f35b731653d9208216f36063b011b737fc3876990166e820e95aa9f4f84b9fc9adc81e54a7b5bf8722bf613ca6381f67f6e380121648ce2ecf6eb6a2922f3bfc8e1186652ea34a45d1db02051fbff2083302b032792481aab4db3b090d0e40bf442d34c9ca09f952cf7e81f0e96208eaccec178e3936901484c69cf8213688fe79db0d91cdd9a32b2dae44febe5ad74fe2d06ed9293f3401396a7b95fed3faeb3b986e7fb4fe128db2a234441cff367a553ff3365bb7d4b5fd06087a3d00dc104799b7bac9e73e13e31ab5e73c8bdec99e48c74aca228483d7faa3fe6f4dd2a5b3b6b585956f8472a1e6e9d27a8308d053b4d7a656680ded9f964d1c4a247df3809dc8624fd144ab3c2e5c0299f092ddeb05b4d99460f48ff87bc7c6c10c7b7ce02f68e2da041e5a3731259d1af25a27d3214e70d754625169e175ef25421a3e5b9812f4e1e028587a148f6c1759d2739a8dc21a68b6d40a3d720f896e9f28899128950a5b66c0a0699c8fa858af2ea2303594031a1be29f2a9d86702df7fba3c5a585b86dcbe664eda49cdc244dfa073a6232d5c06454645c449b00f88706408983cc601e00452795fea07fe7f7544052c5ea8f3b1fe1018eb2c4f080b4b21dc24f50e77e3b515d50a207085a38863bccf16918e7a81f1970dba5ec31c5408aa8406ab2bc27d67288121c275747ddf51d8cf8eab0fff478c5130f1cf20df18761a13adf058d96a435ebaaf1272437eefb56cf1e751136cc365354edc24f2b0c7e0bf92ae439a2f5c2b6c24da1f6e1521b62547314c18dd825b9ee74740ec59be7655a2fe7a04fa9ce2e855fb1a05ea84f67ace17e5ef9dc19d635ef0fd7a1dcfe1809f860a3ad6719e4bbb4b2e89f7d804a8a40aa271f61314cf3e393b7c336cb3296a0d65f4b30de74d8847bd38891c1ab13f14709e5ecd6e778ed26fc70e7f71e3b9ff20743e4d174dde5bf57729f2ec81d1fc5b9670b639c76609107a6e6320cb04cafd7d1d024bc9126bbb38fb595ebd19e71f519395b76d06c027a1af50fbcef74a0731647234c8d37520918670d3e0e6aad0d8f5cd00591d202a4f31befa06212a6abaac5a4c0896725f963c6f7ca7c90e2e3c12986a774f677f1b5eca53de16d57a210f43f6c4d3b12021b2783767af46594682aec41a745f72243177e3fe89ada3fc87e38987486e0e42a98f38fa8818739d9af54c1def95584e1e7848687f72bb53fb4409dd61ed53c8bf55c9185d8ac2bea310ef07e33ac13d6f03efb98fd95c98b8c6b1c2c37a31a90120b5b15ff062130c46e5f61626ab50cad8e860f5db33b794f315ce6d74b038e0e21efa984d2534979f6597dd1750f6df27759ec7979f6f8a6c846770acdbfd954922acd36796fb96d8f8fefdd2d8e380ce068208293ba110fe926e8ca1b2b629a7ec5585f54818cfe0b96383231132afa0fcd3995dcec1e3893ae17941496f26245ec08611f7776e1ecd14b6082d40c65de41d2ff98ebec1a25d8dcc0c28bb21edf4ac7e2cc39d61f8b9412a28f607e2de5abb50584fed13e275c1b383e3da667ffc657026ede580b630f821ee5c742bb8ebdb7cd6c7b96d76c52b99eefb2ba37ff29e3e97a5e33913b7ebbfa4e6defc5c98ad33e9869e5d0238f69b90f7bf80a8f4a61d7d9c2dcf7fd66b0627a1810111a69945627fc6cd79d83a30ab39b97c481d430091cf12a687dea933da122b781e254d959df5f58c993b9f07cb431b487438bbdd1b94ee0c62856978d8c1beee7a6afc6c9c2a2b428db2b2f374abd05c58177d3e68f4c3e7d5e617c45a8d57399984caed9de911b7062e80b401f2742835158a74fd80fd8fc9566e2e8515df622e45f9a348dbbaa4c3900b8a29c651640ccd894d53c1795932ec0b89d9e8ea873020d15b4a1c443a3ba204d4184081ffd067cd6ab886fc79b1a57bc5a086af3492f49b01d00f7931713bc350e4ba100a175f1af4a59f446c098ed436371f303bb3116f71db74e8f543093d7458716917e2c50e7c0502a5676b12be43993a0812ab2f7a13e17493307bd872a7b14b0dc11a4a891ed4a8bbe31b94f2409546ffaea758afff08868b2574f6d2504c943ad5892e35677207a79fb2df335cfb235bd25bde7f3ba7d730c9ee080b529986fc7a39cdedc22dc31882ddedb74c01f9db60eb51db021e1b50ded95360a9262f35410a988c39f0dd0d6bfebc91f9b4217c4c1e72cdc5404cadb119f38aec8ad391728be3a20ac8bd89dd9afb0288c3b5118a291590c1e6a9b1047053b2e45a42cd6493cddfdf052118e6c52238ce7f8e6fe10d2a8911f453a33f7aa1c4f9ef7813f54a8b8606a1f4eae333e2ed6f6bcc5198c7806d3d8937f0eb6ec990c2d5528a30fbcb636926bec4716387c8f0433a2f475a7f6a54dbbd010ed0df90a03a0b0c3fa92a0b145cd30285f729e5567924f8b9f4f0940cd2a4dc84a8c98b76a420099fa96b643e432c9e54fadf2010b56f3475585a3870cfb66999489c28f0b55aa6e0a1d658352f247347404502e7edbcae2686b7c3d81ae36c1ec00912d7efe955fa724c437e9d8368c2eedb7d7cd3111b9809696d9e6027ccacc47886963dcc406d5750ce7bdbe120cc470e5957c6fcca8f654d2b4d86ae040ccc26abbcb60dc1fee52462e36e7ca2fe292593f2323ea775a77bc1c16349f56954b2ad7a128861544555c7d8d2870b49b9b6858447d5756582aea72f82b36564a5effe9d9f91ae5b384d490e482b2dcaf13b00b875ecb0f4d00ca7d7456ae4c1375067510d4fe21f5fc70a2e9a5a818353865b1146cbf46aaff6dd0a57ba144e9dd445761655dd8a62867b7c377204462d522d40afe4808ddc4e605d3766627dc3aa983a8b1cd091216397d4dfbdc2577a9ed5b52aa1a6cb1cf0d48217f3a4821ac8d97f636f722afc442db8f72fb98405da7a68ba66710cbbe2ae03e6671f62fb662a02ba83d4a3d1281f699d312e1cf92bbe358dfb54047a9620a1b9a879dc74bdfabbacb260e84ad853ca7fd9bd1a4c1f8cb17d1cb010d517522b74e3328bf4b866292f39a96c09ce7c02aa3b05bd7c17311cddbaddc1497f5dae479b679abb3b15f18008bcf6f39befb0c2542b1cb716adf9b6b39f40b39a1c0e65ab5bc603404e25b36e82d0ee3dafbdc704065b93ce07e7a4f0a2ef19a7be818cbec255f4f11ef7fdd343d627052afaaab1ac884fce0a66e54797ddc0521cb91e94189a79ec13f041448c95b23c7b7582b81688e8b106f8044820ccd5bfd7a4ae50725c805adf428895b5ac1882a36d7f7c5c74a4319c0248410ac5654b3a8604eca2e28f06f1cca58b1d49491e7e9d9a622b3f1c350ba2486aec50310e374c8de949d25c0678ccbe5ede340f2d077156d40b958600e528384539f7d7d3dac73495328c424aa34d6c30526b05d6503be7654b475ac0e9e1d7c0bafd4b6bf45e63efd45abcaeff30f2ff2bb0cd8ff51c05265726ef582bea9f76772eea971c016049c3d2470d1737539a5be65be77940c1c68eeadb1072d65b140b16bdb0fca6a98d5ff00f3485e4d17cca9dd9fe2cc605c4538577a0730a5a80cf2c0b44053bbf6c26fcd781f3ac96e131a33142781bd8412444081399f0446e1379e94f3a41f27f9ea74;
    y2 = 65600'he279f5466c82da28783cbaa7881a3e1664d574acce515e8a3dc7a6164c40bf36dd73439e94de852ce404db7080226a30ac47fe03af5258773bab0e081943aba32fe30ad7210d79679b292caccd781793f5f16b9c9eedc2a6457f885c7b95fa8c9ea1d2e63552fa197511ed7193d84f3580ae2d0239303446d1629054a00516cb1b0a76f8e38db5a74743d2a87566c610fc130192a6719788ee5dd6daf4102151444f1eb95a1a99280a4660db53f2b482a459f1129ec38869499732fa39bc5e02fe8bf27982e42ff7b5f3cab998b622a4e1ea745f3334ba84298a5b0828671b01ad20e0fea47d550d6191b73bd20dfa106019cc83434f65b6a2a758723695a373c62f76e5c68f55c54df60470d875d7d6bef16475d3211b3b6a71ede8f5d35183583f9f82d236025554a710e23c09cdc5ab622c231831c1927c486ba31b1710b3ee8d94ac0c92782063ca1fe5b310d7995101ff730f05ac00c11509852af9350ee9c977deae7444b9216a87db427f040364737c2070cae5dd9c424df8d1b98f79726794a456e842e650a08bbcb9ab582e3645b6703c5c9a592f69b9134842869daae14410373a63372c6f8c569a8f43558d17485f002a285a9c62b569b443c9460e1ad393aa3cc00d6b189dd5f041b3e6c8b079208ba79f4677ac64229496e27032b3a7dea3bc71bf79afe05ef7a5bff71b198c5205818f8fbb1991915297f9ecc7c6c8e5d73e1d2478372fd8d1c83772c4e40ef72900484662700c017bc8fd2e34106bc73ff21f19054e4c3263236562f0f7d71769b6c3deeb8fd6d9f8224d64bbb162b6a1505323806b0bbf160f67a98258a82d9c16af87ce0d9854f246a30f3bdd11f5ed306e6d25cbe85062af09e2bdd4032b6f1559927c4924f2afdceea93d845b2714bbaf4904b098a6c6b71295a0d9033c063321e1077e8f2316a7f07f82f7d5a9086780c765016324b3b49899a7b935a939d008ff24d41da75dce7e5a64bcdc331db85c13480c46d67fc7de3ed03a69208266545c43164c58a47953e0c340834d4a0b8a264007cb8cd9078d29dfa8956bc4f2f9016a09fea3f72a3120eb70280c6853c539515ae01f2672f338a2fecbb253be01cd9b58cf095f30baa6221b2875068db538bfbd5bb3bd6aac64f5b04eb2c3111f1aae462d52445a4dffbc094547ceee288332d6f32f708cdf94552a8f6c59e47b7b73e4f5ea1c9c14aafcba5614083fcd1c614c07646893068cf54135f2b0aa44840b1bd7c0b72bf1753563653d7e7c7760dc811352ae92d6f2c6016691cdc8dcbeb616c40a285df073458a4f2fd5cfb0bc35c480bdeb87b42a2be74b1b33a453a121a6f238b121c67986871fdc389364bbb73dfb51e2024f6e5a85e0bc5ed01c16a6c222f7f66eadb3f1c7e556b03e9531653dc710523447052c1783a2f3aba521cccec9f58204d3473caf3e87be41fb862a897e2734efbfabc089c87d8e75a2a55c52053cf9a5d5ee33732b8d0e4de57a46f15e095b88bffff82ed7ae941c147b028d7fea342c95308b6a1ab99ad7adfdb10ee4ae9daf1b87f146db21528542c36ccbfa9d8c0cf6c2169489ccecd4178333bd3d88cc608a7c64f3573ddd0bf50b91669c1257153b3b5a7c52096751e320150006e6f1d5232efd90571377e1e719a50affce4ca757cbe832bdfb291a8c943a9dbb5c28735c750113491a28e0edbfc0f4d5d2cea12b2c3c974c197a227a344d2c13b282f1ce241c5648ab367a8a779616d77862f0fe7280e5b5c3624b98e05728c0ba2329640a583aefbafdccf383af43a61afb6e9f6839e7e01085c1a7d3b912e66069743edb2e1174778ef9882bfd5e4ba86700d44a81f4053b2fdefce7013514adb70976ff2a0471c914d927721da06f28b429880018f2f114d4eb0e77835bb21f82547ed5699bc48a29f123c376ac6eb74259812a141f06a8e73381c4baccfad56559ca9b633d43fab224f511fc9bc09c56a17736ecc6de6f0453d7fe83594cfad00f7a7edefdc3e404fec2fb3d838b131aa4f39ad889f4381d4b993fe0d41eeb9badd979d3bc6f9bf0ef39c3e6523a276806cc3290887dbbd012531c956eee48197b4b562f4c83c561f9a12c815706675db1cebea3c4e79bbc66370c8793aa7a5510ecda6e5c487318a817496872f0bbe51a32dae9bbc1b13e0e705540db7cf0b22a179c696b73f98a233292a67b6bc6dae0669b94c9cb54834d944eaad62ea3f4b7e50a535da8cd3016d8fd675020094993bdac63e89acc892f8727258dd4b35af93bdb9245d89e04aa558ae71f6e5a3a3501a10ae5e1cfcfbbb53f006e2ea029260bf9bc2b91a0fa84c68c2a17448ca6680be07aea57f2f0bb62ab77407bd23eb5fd20bfa4c5ef5952b5900e83d7d3f1285e68a3b3283d6b8d810e3034836d7ec8e7df0c4ec5daae61e65c15bf945251184932b01f1c6124ede8cad6b71c606831dc5186bf324be042b5ef0a31ed5bb76b0e959189f00764bb1ad8aa5238c429594d0f313146e3464b20b3b6efdd91e1814aca9339e58ed1c1532da116f0d10b03c208c94a56fd64022bb5a8a3a0716a421df69ed8caae1d7348a43696a6f2f1a4b9c46d42551b115b10763a86af3149d7ab1ad48780fb699877c3f9eb2924d649f0d7cc111428c0b1d5e78606ce7f1bf4071a89f173d29d2a205d3c47211702dad744d3596eb5ce8bb726b03d3bd9468a35b02cc65b0a26fd0a90c59efc315ec4ba5dd7dc953feac8f641a095e242dcb3eed09e79ca12908eebbb518c5b2fb2cbed529612e3986dfe0f6e4a93da88cbf9f3f573367ba2bf8f966b158865a90f50580bfd0786206498a30d76aed1fdda990facc87ef7aa023d30ca61f546b91b781c66aa570880f47be3c346a4ace566c5d125eedb616beb222e1e086738439fd9095a6e08aa863fac8900f69a7eada801181978bd2a047b44d38152b15e24313f7f425227d210034ae00d834a8f994ab72dc56b592fd2d45f5409a109df90b2c46ad7f9e950cab473849d9a53947d420c9729a2a91f47d3526d58feb2473b880f0b6f5798dab4837729a290167926f0490106b4c9fffe21eb28ea595563561116375661c6885faf4ecbf25a3675ca02a056e816252cc99e9a37b6a7d8ffdac77fc1aed3e33f027bdf6da5fdde0d529f853bffd9bb204a44a5c5c6146159ded5b9d897026cb901b49b74f68bc36234fbbe6d5ffdd4d0e4be166f21466c0f26eff1cb916a5a85661737c515994f3d714c2ca23427dbb6c3abc1a23ddd5654231b9a446839a536d5ca9da5a711de1efe52b72c7222ac29b5cea5a4003d7dc968ce68ff7dde938d1ecef05324ecd1d2db8db666295d82d5e30841e08c16607022490f1bdc38a4257c1404c54d563390e1e964de649a6b64bb82689c8530e3e3c552c17128a0818d3363ca4ff756bb0b9b55b1089b4b902d5b6285d0ee15e0f2cf4b4efa864241632795d2113f78840402f0d3ec4770acbc3227990595dbf76c2bb51e331bb2102d0e06527483eb26216dc1d89bebae9f9e14c1e8c6b2e104abed2bc95c08e7f3efc8968fb7611c81cde737e213f97d38c62e5bb9d59c3fb5863fcbcd8c27b3570e7ae23b7667ac1034de82268c8a1799b21560e2dbb03aa9b8ade0777d8dc13e72baa17ed1252a224c657f0d904f68576cd2eabd7040c00af09a9258d15b698bccbce6dfa011f4310100b972621bb9153c603c7ccb9f184e164375f9265cfed5ccbeac87fffb366529cb91de398b899265f385b6b580d0ce5a4ec4c3695d71beea08a1732cf24f25a2c991bb7581c0ccb9dd5b0f560cc47abac0217ab885df206309dad4150ddcadefc613e2335cd419a1b276f5b68275fe284e37b7029a8a6351ecc0c4ecfdc60f1be29193469c974dcfe2b7f07d37a4bfe7338d81f5a4530744c956b45460a6d193ac129d5bee76db03a955b399f4fe253a4b9dfb831204ecc9edd4589c8d14bc23b0dd8dc45e74b2ced9403feb72a81c99c6e2cd39db68d9b6d29f3885383c64798a3fac2533906efa28f57b292e43cc13cd90a1a6b7444cbc9e7f5a6f53010336b4922a25ef774c678ded46d2532574372b7cd77bf0eb6d52cba6f6fb0ff733d4972164727384f83b5c1522a549c4effbc57adef105a74e8cb1367f6766ff3daa63d809fba8b9d34f3a600c8e4875e10e2d62247e7b21f2176fac488a022f269e2e10ddaddb42d2f5ffb6ae4bf1c4ff0964b4e894bc5b9993167a78f4e4e74dda985cdcf37746747b6f8833572e1201f96638aa81c3685f02ae9167c1b91b6f8edfac5caba6f8abdb9aec79d0bedf0a52714c1af0345fd45eb2758e4a34292781b76ed64b1140c917f078402bed06b8911fecb913ef1f5b0315bc52e983f6ee153a30143a2e001c4c8d0bd040e4cd224d06d6bab82a7f61e449226fd1e49d73ec6c15388b6f1356204e7080fc92e5e89b3b21de5725488866a6d7d6a03701c323712176e13be2008589e1a09ec203a651294deb7f64141e56ef013efa21637f082d37904784338d300775dcec9d88a75c0ce20c9e060bc11e17aa07d698b5aa4461a061e5c3ed8d1eedbe26c848368506e2d0a82d4e3ef1fcd7c105e509640f47c0642700325114d5132a98ac3d75b370d148c4d87cd48c6d44f73f8839fb66704c675e51792543dc667962967ba79fed73ac2adc5e1eb3e34e3f61f33d1059adcc2eae280957bedc57f97f5886deb96c7db93fb59dc8cec0ee0de8d42243b729c56f97c7b114b2d5c664cf348d776825cd374b92d1ab09931e4caccf8ee217f8c078da057f668f32104b271fd5542f138720445bffeec78d8b928af8deef042aa7b8fa1a6c321b1b8e92849c6a4ee8968df07aa7960a922612e68e85d9c47f20c1bbf1e08c4ec2bbd61b5fd2ef58093622f07e4a79bbf9f174f93315ff82397653cf191cfe298476c8ecb2d51bccff8211f6df555cfd7c3f2dc93ccb0f53e79aca5b936e640fe753569c4646eebfe1ce0531310f98c0db3acc4b4a7a20f8e93c2d217297acb55e1dbd0da97731433100bda7d0d2a83dd230527881d2a231de6e0548586d6e975ce885f4e979a5acca13d445e5d70ca7d23ec8880408c61684f1b80f1d7f6581677d8d6ca77e5d1b27458a2a4e75aa99b187c5dc861408ec47d1cb2374e628fd453ba23176acd4172d8e78b53cf3937ff348686480f6989766530d64c669d63aa4453fcefab9f6e0b68b7aa2d995481506c0542a937246d290db9a3c5b3cb182da3c2f79833411653733bc90b5a48410876429ea699df964fa9f1eece3d095c4e28f78f8250d17d0dc34703154460689022638bacc4d95b5c45702e75e9a30572152c16cbfa9b76eb7b63cdf27343d9dde10ce6072ba437c05e9dfd7764f218851314136f270d89ec2ed804383ef5faa074152820611cc1ebd3cb62ff10c4d036a3567ab5d2564e0dde62cade40a532601afdce9ff869dc9efadf808ff273ad3ea830a090bf22d7304850c58eaab3d0616e5dfff0222aff8a2d579882adeb97a9b908b83429d9bf0b66544d6664f03078b1ed71912fb71f4925b2c28ed0d530eb17a90f31ef2ca92d7925ca2502475964150e7b4c944ed7a61508a05bbc0f09b5314dcedbd9543f8414fdacb0d220720d70dd35554eb9d8b0ee51c0269a7ff2b5e11c87c39bdb9adbdcf399dfb4b4beaffdc14d035fa4f361f5e509b43e856331af5049dce9f69731b8cbf6f41b870210a88d6e41e0ed0a1492fabdf668ebe36fa97832f1f0bd61d06e0d5bbcc027c7dbc16782152646d481a0a4fc35b51cfe323e56b;
    d1 = x + y2;
    d2 = y2 - x;
    d3 = x * y2;
    d4 = x / y2;
    d5 = x % y2;
    d6 = x << 1000;
    d7 = x >> 999;
    d8 = (x < y2) + (x > y2) * 2 + (x == x) * 4;
    #1 x = x;
  end
  analog begin
    a1 = x + y2;
    eq = a1 == d1;
    `CHECKI("d1 every bit", eq[0], 1);
    `CHECKEQ("d1 bits 30..0", a1[30:0], d1[30:0], 0);
    `CHECKEQ("d1 top 31 bits", a1[65599:65569], d1[65599:65569], 0);
    a2 = y2 - x;
    eq = a2 == d2;
    `CHECKI("d2 every bit", eq[0], 1);
    `CHECKEQ("d2 bits 30..0", a2[30:0], d2[30:0], 0);
    `CHECKEQ("d2 top 31 bits", a2[65599:65569], d2[65599:65569], 0);
    a3 = x * y2;
    eq = a3 == d3;
    `CHECKI("d3 every bit", eq[0], 1);
    `CHECKEQ("d3 bits 30..0", a3[30:0], d3[30:0], 0);
    `CHECKEQ("d3 top 31 bits", a3[65599:65569], d3[65599:65569], 0);
    a4 = x / y2;
    eq = a4 == d4;
    `CHECKI("d4 every bit", eq[0], 1);
    `CHECKEQ("d4 bits 30..0", a4[30:0], d4[30:0], 0);
    `CHECKEQ("d4 top 31 bits", a4[65599:65569], d4[65599:65569], 0);
    a5 = x % y2;
    eq = a5 == d5;
    `CHECKI("d5 every bit", eq[0], 1);
    `CHECKEQ("d5 bits 30..0", a5[30:0], d5[30:0], 0);
    `CHECKEQ("d5 top 31 bits", a5[65599:65569], d5[65599:65569], 0);
    a6 = x << 1000;
    eq = a6 == d6;
    `CHECKI("d6 every bit", eq[0], 1);
    `CHECKEQ("d6 bits 30..0", a6[30:0], d6[30:0], 0);
    `CHECKEQ("d6 top 31 bits", a6[65599:65569], d6[65599:65569], 0);
    a7 = x >> 999;
    eq = a7 == d7;
    `CHECKI("d7 every bit", eq[0], 1);
    `CHECKEQ("d7 bits 30..0", a7[30:0], d7[30:0], 0);
    `CHECKEQ("d7 top 31 bits", a7[65599:65569], d7[65599:65569], 0);
    a8 = (x < y2) + (x > y2) * 2 + (x == x) * 4;
    eq = a8 == d8;
    `CHECKI("d8 every bit", eq[0], 1);
    `CHECKEQ("d8 bits 30..0", a8[30:0], d8[30:0], 0);
    `CHECKEQ("d8 top 31 bits", a8[65599:65569], d8[65599:65569], 0);
    I(p) <+ V(p);
  end
endmodule
