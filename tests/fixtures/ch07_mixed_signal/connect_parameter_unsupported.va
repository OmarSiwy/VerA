// §7.7.3 parameter passing attribute: "an attribute method can be used with the
// connect statement to specify parameter values to pass into the Verilog-AMS
// HDL connect module and override the default values", spelled
// `connect a2d_035u #(.tt(3.5n), .vcc(3.3));`.
//
// C.9 settles the verdict for a Verilog-A compiler: "Clause 7 only applies to
// Verilog-AMS HDL", and C.16 lists `connect` and `connectrules` among the
// keywords "not used by Verilog-A". The module below keeps the refusal about
// the connect specification rather than about an empty source file.
//
//! lrm 7.7.3
//! lrm C.9
//! lrm C.16
//! reject E0201
//! reject connectrules
module ch7_host(p);
  inout p; electrical p;
  analog I(p) <+ V(p);
endmodule
connectrules ch7_parameters;
  connect ch7_a2d #(.threshold(0.5));
endconnectrules
