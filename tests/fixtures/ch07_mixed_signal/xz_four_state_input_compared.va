// §7.3.2, verbatim: "Verilog-AMS HDL supports accessing of 4-state logic values
// within the analog context. The x and z states must be translated to
// equivalent analog real or integer values before being used within the analog
// context. The language supports the following specific features, which
// provide a mechanism to perform this conversion: the case equality operator
// (===), the case inequality operator (!==), the case, casex, and casez
// statements, binary, octal and hexadecimal numeric constants which can contain
// x and z as digits."
//
// The clause's own a2d example is m01_02 (the `===` chain) and m01_03 (the
// `case`). Both hold `avar` on the x arm with `avar = avar`, which also tests
// §3.2's variable retention across evaluations. THIS file is the same
// comparison with every arm assigning a value of its own, so it asserts the
// conversion and nothing else.
//
// IEEE 1364 §5.1.8 (which §4.2.6 defers to) defines `===` as a bitwise compare
// of 0, 1, x and z that "shall never result in x": a z is not a 0 and an x is
// not a 1. So the four states are four different values:
//
//   t in [0, 20n)    dnet = 1   -> avar = 5
//   t in [20n, 40n)  dnet = x   -> avar = 1
//   t in [40n, 60n)  dnet = z   -> avar = 2.5
//   t in [60n, ...)  dnet = 0   -> avar = 0
//
// The declared points sit inside each interval; the implicit D2A points a
// conforming kernel adds at 20n, 40n and 60n (§8.4.7) sit at the START of the
// next interval, because the analog solve at t reads the greatest tick <= t
// (§7.3.6.5), and the oracle's half-open intervals say the same.
//
// Every mistake changes a digit. Comparing value bits only reads z as 0 (0 at
// [40n, 60n), not 2.5) and x as 1 (5 at [20n, 40n), not 1). Treating any x or z
// as the §7.3.2 access error ends the run at 20n. The `case` form must agree
// with the `===` chain at every point (IEEE 1364 §9.5: the case items compare
// with `===`), and `!==` is its negation.
//
// `dnet` is read ONLY through these comparisons, so an x or z in it is a value
// here and not "the value of the digital variable being accessed in the analog
// context goes either to x or z", which the same clause makes an error.
//
//! lrm 7.3.2
//! lrm 7.3.2:1
//! analysis tran
//! time 0, 10n, 30n, 50n, 70n
`timescale 1ns/1ns
`include "check.vh"
module xz_four_state_input_compared(anet);
  inout anet;
  electrical anet;
  reg dnet;
  real avar, bvar;

  initial begin
    dnet = 1'b1;
    #20 dnet = 1'bx;
    #20 dnet = 1'bz;
    #20 dnet = 1'b0;
  end

  analog begin
    if (dnet === 1'b1)
      avar = 5;
    else if (dnet === 1'bx)
      avar = 1;
    else if (dnet === 1'b0)
      avar = 0;
    else if (dnet === 1'bz)
      avar = 2.5;
    case (dnet)
      1'b1: bvar = 5;
      1'bx: bvar = 1;
      1'b0: bvar = 0;
      1'bz: bvar = 2.5;
    endcase
    `CHECKEQ("=== tells 1, x, z and 0 apart", avar,
             ($abstime < 20n) ? 5.0 : ($abstime < 40n) ? 1.0 : ($abstime < 60n) ? 2.5 : 0.0, 0.0);
    `CHECKEQ("a case over x/z labels agrees with the === chain", bvar, avar, 0.0);
    `CHECKI("!== is its negation, x against 1'bx included",
            (dnet !== 1'bx) ? 1 : 0, ($abstime >= 20n && $abstime < 40n) ? 0 : 1);
    V(anet) <+ avar;
  end
endmodule
