// §7.4.2: "Ports of discrete-time disciplines (ports where digital signals
// appear at both upper (vpiHiConn) and lower (vpiLoConn) connections) shall
// obey the rules imposed by IEEE Std 1364 Verilog on such connections. IN
// ADDITION, THE REAL-VALUE NETS SHALL OBEY THE RULES IMPOSED BY 3.7."
//
// §3.7, the rule it imports: "Compatible interconnect are nets of type wire,
// tri, and wreal where the IEEE Std 1364 Verilog net resolution is extended for
// wreal. When the two nets connected by a port are of net type wreal and
// wire/tri, the resulting single net will be assigned as wreal. CONNECTION TO
// OTHER NET TYPES WILL RESULT IN AN ERROR."
//
// The port below is a discrete-time port in §7.4.2's sense: the child's lower
// connection `o` is a `wreal` (§3.7, a digital net carrying a real) and the
// parent's upper connection `n` is a `wand` — both digital, neither has a
// continuous discipline. `wand` is not in §3.7's closed list {wire, tri,
// wreal}, and its identity is its wired-AND resolution function, which a merge
// into a wreal would delete. So the connection is the error §3.7 names.
//
// The positive half of the same sentence — a wreal port joined to a `wire`,
// promoted to wreal — is what `analog_event_variable_drives_wreal_assign.va`
// and ch03's wreal fixtures run. `digital/m04_21_reject_wreal_connected_to_wand.v`
// states this rule for the `.v` digital runner; this is the `.va` compile,
// where the two modules are a mixed design VerA elaborates itself.
//
//! lrm 7.4.2
//! lrm 7.4.2:1
//! lrm 7.4.2:2
//! lrm 3.7
//! reject-only E0919
//! neighbour analog_event_variable_drives_wreal_assign.va
`timescale 1ns/1ns
`include "disciplines.vams"
module ch742_wreal_child(o);
  output o;
  wreal o;
  assign o = 2.5;
endmodule

module ch742_wand_parent(p);
  inout p;
  electrical p;
  wand n;
  ch742_wreal_child u(.o(n));
  analog I(p) <+ V(p) / 1k;
endmodule
