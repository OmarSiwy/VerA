// §7.7.4 / §7.8.3 connect_mode: `merged` and `split` say "whether all ports of
// a common discrete discipline and port direction share a connect module or
// have individual connect modules" — a signal-segmentation decision (§7.8.2)
// taken during auto-insertion. §7.7.1's port overrides ride along in the same
// statement: `input electrical, output logic` re-types and re-directs the
// connect module's ports for library reuse.
//
// THIS FIXTURE'S VERDICT WAS INVERTED — it pinned `reject E0201` on the
// enclosing `connectrules` from C.9/C.16; see connectrules_accepted.va for why
// that argument does not reach the conclusion for a Verilog-AMS compiler.
//
// WHAT IS ASSERTED. That every optional slot of A.1.8's connect_insertion
// parses IN ITS GRAMMAR POSITION —
//
//     connect_insertion ::= connect connectmodule_identifier [ connect_mode ]
//         [ parameter_value_assignment ] [ connect_port_overrides ] ;
//     connect_mode ::= merged | split
//
// — with both mode spellings, both directed override shapes the grammar's
// input/output pairing admits, real connect modules (E0915 otherwise) and
// annex D disciplines (`electrical`; `logic` is disciplines.vams' own
// `discipline \logic ;`, so the bare spelling names it). `V(p)` at the pinned
// bias is the whole-file-compiled verdict.
//
// WHAT IS NOT CLAIMED. Segregation itself: merged-vs-split is a difference in
// what the INSERTION phase builds (§7.8.3.1/§7.8.3.2 — one shared instance per
// signal versus one per port), VerA does no insertion, and the parsed mode has
// no consumer — lib/frontend/ast.zig's ConnectInsertion says so in one place
// rather than a fixture implying otherwise. §7.8.3's "default is merged" is
// likewise about a phase that does not run.
//
// The want is the bias read back, exact in binary, so `CHECKX` is the honest
// macro.
//
//! lrm 7.7.4
//! lrm 7.8.3
//! lrm 7.7.1
//! bias V(p) = 0.75
`include "check.vh"
connectmodule ch7_a2d(a, d);
  input a; output d; electrical a;
endmodule
connectmodule ch7_d2a(d, a);
  input d; output a; electrical a;
endmodule
module ch7_host(p);
  inout p; electrical p;
  analog begin
    `CHECKX("both connect_mode spellings and both override shapes are accepted", V(p), 0.75);
    I(p) <+ V(p);
  end
endmodule
connectrules ch7_mode;
  connect ch7_a2d merged input electrical, output logic;
  connect ch7_d2a split input logic, output electrical;
endconnectrules
