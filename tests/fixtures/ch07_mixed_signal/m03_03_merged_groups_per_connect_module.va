// §7.8.3.1 merged, second sentence — the qualifier that stops "merged" from
// meaning "one bridge per net": "This instructs the simulator to try to group
// all ports (whether they are input, output, or inout) and to use just one
// connector module, PROVIDED THE MODULE IS THE SAME." Figure 7-9's prose spells
// out the consequence: "The ttl output ports are merged, but with a different
// connect module; i.e., there is one connector module inserted between the
// electrical signal and all of the ttl output ports."
//
// §7.8.4 is the normative form: ports share an instance only when they are
// "connecting to the same signal (upper connection), SHARING THE SAME CONNECT
// MODULE, and having merged parameter".
//
// WHAT IS ON THE NET. One electrical signal `a` carries three digital ports:
//
//   u1.din, u2.din   ddiscrete INPUT  -> §7.6 Example 2 direction pair -> m03_a2d
//   u3.q             ddiscrete OUTPUT -> §7.6 Example 1 direction pair -> m03_d2a
//
// (Example 2's `a2d` covers "a mixed INPUT port whose upper connection is
// compatible with electrical and whose lower connection is compatible with
// ddiscrete"; Example 1's `d2a` covers "a mixed OUTPUT port whose upper
// connection is compatible with discipline electrical and whose lower connection
// is compatible with ddiscrete". Earlier revisions of this file had the two
// example numbers the wrong way round.)
//
// Both connect statements say merged. The correct result is therefore TWO
// instances, not one and not three: the two inputs merge with each other, the
// output cannot merge with them because the selected module differs.
//
// DERIVATION. m03_a2d loads with rin = 1 kohm (§7.8.2 Figure 7-7). m03_d2a is a
// Thevenin source: vsup * dval behind rout = 2 kohm. u3 holds its output reg at
// 1'b1, so dval = 1 and the d2a injects vsup/rout = 2.0/2000 = 1 mA. With the
// top module's 1 kohm shunt and 1 mA source, KCL at `a`:
//
//     V/1000 - 1e-3 + V/1000 + (V - 2.0)/2000 = 0
//     V * (1/1000 + 1/1000 + 1/2000) = 1e-3 + 2.0/2000
//     V * 2.5e-3 = 2.0e-3
//     V(a) = 2.0e-3 / 2.5e-3 = 0.8
//
// The wrong answers this separates from:
//   one merged instance for the whole net, a2d only -> 1e-3/2e-3     = 0.5
//   one merged instance for the whole net, d2a only -> 2e-3/1.5e-3   = 1.333...
//   three instances (merged ignored)                -> 2e-3/3.5e-3   = 0.57142857...
//   nothing inserted                                -> 1e-3/1e-3     = 1.0
//
// WHY 1'b1 AND NOT 1'b0. This fixture used to hold u3's reg at 1'b0 and claim
// that its number "asserts the inserted bridge SEES the digital state". It did
// not: 0 is also what an `initial` that never ran leaves behind, and `cm` at x
// makes `(cm == 1'b1) ? 1.0 : 0.0` yield 0 as well — all three give 0.4. Driving
// 1'b1 makes the claim real. A bridge that does not see the digital state of the
// port it bridges — because the inserted instance's `initial` never ran, because
// `cm` is x, or because the d2a is wired to nothing — reads 0.4, which is now a
// FAILING value rather than the wanted one.
//
//! lrm 7.8.3.1
//! lrm 7.8.4
//! lrm 7.6
//! solve
//! xfail VerA performs no §7.8 connect-module insertion, so the design solves with neither bridge and reads got=1 want=0.8
`include "check.vh"

connectmodule m03_a2d(el, cm);
  input el;
  output cm;
  electrical el;
  ddiscrete cm;
  reg cm;
  parameter real rin = 1000.0 from (0.0:inf);
  analog I(el) <+ V(el) / rin;
  initial cm = 1'b0;
endmodule

connectmodule m03_d2a(cm, el);
  input cm;
  output el;
  ddiscrete cm;
  electrical el;
  parameter real rout = 2000.0 from (0.0:inf);
  parameter real vsup = 2.0;
  analog I(el) <+ (V(el) - vsup * ((cm == 1'b1) ? 1.0 : 0.0)) / rout;
endmodule

module m03_din(din);
  input din;
  ddiscrete din;
  // No digital process here: the port is a receiver by its DISCIPLINE alone
  // (§7.8.4 selects on the two connections' disciplines and the port
  // direction). An unread `reg seen` process only made the file stop at E0205
  // before it could reach its own assertion.
endmodule

module m03_dout(q);
  output q;
  ddiscrete q;
  reg q;
  initial q = 1'b1;   // 1, not 0: see "WHY 1'b1 AND NOT 1'b0" in the header
endmodule

module m03_top;
  electrical a;

  m03_din  u1(a);
  m03_din  u2(a);
  m03_dout u3(a);

  analog begin
    I(a) <+ V(a) / 1000.0;
    I(a) <+ -1.0e-3;
    `CHECK("merged groups per SELECTED MODULE: 2 inputs share one a2d, the output gets its own d2a driving 1",
           V(a), 0.8, 1e-12);
  end
endmodule

connectrules m03_rules;
  connect m03_a2d merged;
  connect m03_d2a merged;
endconnectrules
