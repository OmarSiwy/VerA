// §7.3.1 Table 7-1, the `bit` row: the listed examples are `reg r1;` and
// `wire w1;`, and the row says "Discrete bit and bit groupings (buses and part
// selects) are accessed in the continuous context as integer numbers."
//
// This is the clause's OWN example, `onebit_dac`, copied out of 7.3.1 with one
// addition: the LRM prints `in` as an unconnected input port, which at the top
// of a design has no driver and therefore no value to assert. A reg written
// once by the discrete context and driven onto the wire through a zero-delay
// `assign` gives the net a value a human can name. (The `assign` is D06's
// machinery; nothing here depends on its delay or strength model, only on the
// value the net settles to.)
//
// THE BUS IS THE HEADLINE ASSERTION, AND IT WAS ADDED AFTER REVIEW. As first
// written this file asserted only `x == 3.0`, which is the FALL-THROUGH arm of
// `if (in == 0)`. Every implementation that reads the wire as anything at all
// nonzero passes that — including one that reads uninitialised storage, one
// that reads x, and one that has not wired the net up at all — so the one thing
// the fixture existed to pin, Table 7-1's `bit` row, was untested. The row does
// not merely say "nonzero"; it states an exact mapping:
//
//   "Discrete bit and bit groupings (buses and part selects) are accessed in
//    the continuous context as integer numbers. The sign bit (bit 31) of the
//    integer is always set to zero (0). The lowest bit of the bit grouping is
//    mapped to the zeroth bit of the integer. The next bit of the bus is mapped
//    to the first bit of the integer and so on. If the bus width is less than
//    31 bits, the higher bits of the integer are set to zero (0)."
//
// So a four-bit discrete NET carrying 4'b1010 has exactly one legal continuous
// reading, and it is 10. 4'b1010 is deliberately not a palindrome: an
// implementation that mapped the bus's HIGHEST bit onto integer bit 0 reads 5,
// one that sign-extended or left the upper bits alone reads something outside
// [0, 15], one that read the net as unwired reads 0 or x. Each of those is a
// different integer from 10 and each fails. That is the claim `x == 3.0` could
// not make on its own.
//
// It has to be a `wire` and not a `reg`: Table 7-1's `bit` row lists both, and
// the reg half is already green (`tests/fixtures/ch07_mixed_signal/
// discrete_bus_31.va`, `discrete_bus_narrow.va`). The net half is what VerA
// refuses, with E0315 below.
//
// DERIVATION. `b` is 4'b1010 = 8 + 2 = 10, driven onto `code`, so `code` reads
// as the integer 10. `in` is `code[1]`, the part-select the same table row
// names, and bit 1 of 4'b1010 is 1 — so `in == 0` is false and the else arm
// runs: x = 3.0, and V(out) <+ 3.0 makes the node a 3 V source. Both numbers
// are exact in binary and neither is the §3.2 default, so a compiler that
// dropped the discrete read entirely (reading 0) takes the `if` arm and lands on
// 0.0 — visibly wrong in every check.
//
// WHAT FAILS TODAY, in the order the compiler reaches it. First
// `error[E0205]: unsupported module item: found `assign`` — a continuous assign
// is gated on `self.digital` (`lib/frontend/parser.zig:966`), which a `.va`
// file never sets. With the driver removed, the read itself is
// `error[E0315]: net must be read through an access function: `in``: VerA
// refuses to read a net by name at all, which is right for a CONTINUOUS net
// (§3.5 makes a discipline's net readable only through V/I) and wrong for a
// DISCRETE one — Table 7-1 exists precisely to say what happens when a `wire`
// appears bare in a continuous expression. The diagnostic cannot tell the two
// apart because VerA has no discrete net.
//
//! lrm 7.3.1
//! lrm 7.3
//! lrm 7.3:1000
//! bias V(out) = 0
`include "check.vh"
module m01_onebit_dac(out);
  inout out;
  electrical out;
  reg [3:0] b;
  wire [3:0] code;
  wire in;
  real x;

  assign code = b;
  assign in = code[1];
  initial b = 4'b1010;

  analog begin
    // The discriminating claim: Table 7-1's exact bit-grouping mapping, on a
    // NET. Reversed bit order reads 5, an unwired net reads 0, anything
    // sign-extended leaves [0, 15].
    `CHECKI("Table 7-1 bit row: a 4-bit discrete net holding 4'b1010 reads as the integer 10", code, 10);
    if (in == 0)
      x = 0.0;
    else
      x = 3.0;
    `CHECKX("a discrete wire at 1 selects the else arm of 7.3.1's own dac", x, 3.0);
    V(out) <+ x;
  end
endmodule
