// §7.3.2 makes case equality (`===`) over a four-state digital net the way an
// analog block tests for an x bit: the clause's `a2d` example writes
// "else if (dnet === 1'bx)", and lists "the case equality operator (===)" and
// "binary ... numeric constants which can contain x and z as digits" among the
// features that carry x and z into the analog context.
//
// This file used to be `x_case_equality_unsupported.va` and demanded E0130 on
// Annex C.3/C.5 grounds — the Verilog-A SUBSET's removal of `===` and of x/z
// outside the mixed-signal context. VerA targets Verilog-AMS, and this module
// IS the mixed-signal context, so the refusal is withdrawn and the claim stated
// positively. (The same clause's `converter` example annotates
// `dnet === 1'bx` "error"; the LRM text in specification/ch7-mixed-signal.html records
// that as an editorial discrepancy against the feature list and the `a2d`
// example, which this file follows.)
//
// The old file read an undriven top-level `input d; wire d;`; a digital driver
// is added so the net has a value sequence a human can name.
//
// DERIVATION, `timescale 1ns/1ns`, IEEE 1364 §5.1.8 `===` (never x):
//
//   [0, 20n)   d = 1   d === 1'bx is 0   result 0.0
//   [20n, 40n) d = x   d === 1'bx is 1   result 1.0
//   [40n, 60n) d = z   d === 1'bx is 0   result 0.0   (z is not x)
//   [60n, ..)  d = 0   d === 1'bx is 0   result 0.0
//
// A tool comparing value bits only reads x as 1 and z as 0, and gets 0.0 at
// 30n; one treating any unknown as x gets 1.0 at 50n.
//
//! lrm 7.3.2
//! lrm C.3
//! lrm 7.3.2:1
//! analysis tran
//! time 0, 10n, 30n, 50n, 70n
`timescale 1ns/1ns
`include "check.vh"
module ch7_x_case_equality(p);
  inout p; electrical p; reg d; real result;
  initial begin
    d = 1'b1;
    #20 d = 1'bx;
    #20 d = 1'bz;
    #20 d = 1'b0;
  end
  analog begin
    result = (d === 1'bx) ? 1.0 : 0.0;
    `CHECKEQ("§7.3.2 === picks out the x state and nothing else", result,
             ($abstime >= 20n && $abstime < 40n) ? 1.0 : 0.0, 0.0);
    I(p) <+ V(p) + result;
  end
endmodule
