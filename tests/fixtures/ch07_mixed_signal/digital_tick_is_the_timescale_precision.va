// §7.3.6: "Verilog-AMS HDL provides synchronization between the continuous
// and discrete domains. Simulation in the discrete domain proceeds in integer
// multiples of the digital tick. This is the smallest value of the second
// argument of the `timescale directive (see 19.8 in IEEE Std 1364 Verilog)."
//
// §8.4.7 states the same assumption from the engine's side: "The digital engine
// has some minimum time granularity and all digital events occur at a time which
// is some integer multiple of that granularity."
//
// So the tick is the PRECISION, not the unit. Under `timescale 1ns/100ps the
// unit is 1 ns and the tick is 100 ps, and a delay of 2.5 (units) is 2.5 ns =
// 25 ticks exactly — representable, so no rounding happens (IEEE 1364 §19.8
// rounds only to the precision). A digital engine that stepped in whole UNITS
// would have to put the write at 2 ns or 3 ns; one that stepped in ticks puts
// it at 2.5 ns.
//
// The observer is the analog block, through §7.3.6.5: a digital primary is read
// at "the greatest digital time tick which is less than or equal to the analog
// time". `code` is 1 from time 0 and 5 from the 2.5 ns write:
//
//   t = 2.4n   greatest tick <= t is 2.4 ns, before the write   -> 1
//   t = 2.5n   the write's own tick                              -> 5
//   t = 2.6n   after it                                          -> 5
//
// oracle ($abstime >= 2.5n) ? 5 : 1. A unit-stepping engine reads 1 at 2.5n
// (write at 3 ns) or 5 at 2.4n (write at 2 ns); both are caught, and neither
// point lands on a whole nanosecond, so no rounding of the observation time can
// rescue the wrong answer.
//
//! lrm 7.3.6
//! lrm 8.4.7
//! lrm 7.3.6.5
//! lrm 7.3.6.5:1
//! lrm 7.3.6:1000
//! analysis tran
//! time 2.4n, 2.5n, 2.6n
`timescale 1ns/100ps
`include "check.vh"
module ch736_tick(p);
  inout p;
  electrical p;
  reg [3:0] code;

  initial begin
    code = 4'd1;
    #2.5 code = 4'd5;
  end

  analog begin
    `CHECKEQ("the digital write lands on its 100 ps tick, 2.5 ns", code, ($abstime >= 2.5n) ? 5 : 1, 0.0);
    I(p) <+ 1m * code;
  end
endmodule
