//! reject expression
// EXPECT: error -- casez is part of full Verilog-AMS mixed-signal conversion.
module ch7_xz_casez_statement(p, d);
  inout p; electrical p; input d; wire d; real result;
  analog begin
    casez (d)
      1'bz: result = 1.0;
      default: result = 0.0;
    endcase
    I(p) <+ result;
  end
endmodule
