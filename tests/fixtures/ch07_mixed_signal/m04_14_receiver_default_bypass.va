// Verilog-AMS LRM 2.4 §9.22.5 Receiver Net Resolution, the DEFAULT half,
// verbatim:
//
//   "By not specifying the receiver value directly in the connect module
//    driver, receiver segregation will be ignored, which is the default case.
//    ...
//    The default is equivalent of assign d_receivers = d_drivers;
//    Where the value passed to the receivers through driver receiver
//    segregation is the value being driven without delay or any impact from
//    analog connections to the net. This is essentially bypassing driver
//    receiver segregation."
//
// So a connect module that does NOT assign its digital port is not a connect
// module that leaves its receivers undefined, or at z, or at the analog
// kernel's opinion of the node: it is one whose receivers read the ordinary
// drivers' resolved value directly, with no delay and with the analog node
// having no say at all. "Without delay" is the part a plausible implementation
// gets wrong — routing the value through the D2A and A2D pair it already built
// gives the right values one or two threshold crossings late.
//
// THIS FILE IS 13_receiver_value_set_by_connectmodule.va WITH ONE LINE DELETED,
// PLUS ONE QUERY ADDED. The driver, the receiver, the load and every receiver
// sample time are identical to 13; only `reg out; assign d = out;` and the
// process that sets it are gone. The three receiver lines are exact complements
// of 13's on lines 2 and 3 and differ on line 1 by x versus 1. That
// relationship is one of the two claims: §9.22.5's two cases are selected by
// the presence of the `assign`, and nothing else in the design distinguishes
// them.
//
// CORRECTED AFTER REVIEW — WHY THE $driver_count LINE IS HERE. As originally
// written this file's whole transcript was `x / 1 / 0`, which is EXACTLY what a
// simulator with no connect-module insertion, no driver-receiver segregation
// and no §9.22.5 handling prints: on a plain digital net the receiver reads the
// driver, and that is the same answer. The file therefore had no independent
// force at all — it was meaningful only when diffed against 13 — while its
// header claimed it stood on its own. That is not repairable by rewording,
// because §9.22.5's default IS the bypass: the default answer and the
// feature-absent answer necessarily coincide.
//
// So the file now also asserts, from INSIDE the connect module, that the
// connect module exists and sees the ordinary driver: §9.22 paragraph 3 —
// "Driver access functions can only be called from connect modules" — and
// §9.22.1's count over ordinary drivers. There is one ordinary driver (`dr.o`),
// one ordinary receiver (`ear.i`, an input port and therefore not a driver),
// and this connect module contributes no driver of its own precisely because
// the `assign d = out;` is absent. So $driver_count(d) == 1. A tool that
// inserted nothing never runs this `initial` block and emits no such line at
// all; a tool that inserted a connect module but counted its own port, or
// counted the receiver, prints ok=0. THAT is the line the three bypass lines
// now hang off, and the pair is what this file claims.
//
//! lrm 9.22.5
//! lrm 9.22.1
//! lrm 7.9
//! timescale 1ns/1ns
//
// HAND DERIVATION — one ordinary driver, one ordinary receiver, no receiver
// assignment in the connect module, so `d_receivers = d_drivers` throughout.
//
//   t=0   the driver's reg is unassigned: 1'bx. One driver, so the resolved
//         driver value is 1'bx.
//   t=1   the connect module reads $driver_count(d) -> 1.
//   t=5   receiver samples -> 1'bx.       (13's twin reads 1 here)
//   t=10  driver := 1'b1.
//   t=20  receiver samples -> 1'b1.       (13's twin reads 0 here)
//   t=30  driver := 1'b0.
//   t=40  receiver samples -> 1'b0.       (13's twin reads 1 here)
//
//   The t=1 query is 4 ticks clear of the first receiver sample, so the two
//   processes never print in the same timestep and no ordering between them is
//   asserted.
//
//   HOW MUCH OF "WITHOUT DELAY" IS ACTUALLY ASSERTED, stated honestly: the
//   sample times are 5, 10 and 10 ticks after the assignments that determine
//   them, so this file excludes any receiver path whose delay is 5 ns or more
//   — which is what a route through the 1 kohm-loaded analog node and back
//   costs, since no crossing has happened by t=20 with this connect module
//   contributing nothing but 0 V. It does NOT exclude a delay of one or two
//   ticks. Sampling adjacent to the assignment would exclude that too, but it
//   would then be asserting intra-timestep delivery order, which is M02's row
//   and which this row's SPEC.md explicitly does not cover. The residual
//   window is disclosed rather than papered over.
//
// The `got=` column is an `integer` printed with %b, which IEEE Std 1364 prints
// at the SIZE OF THE EXPRESSION — 32 digits for §3.2's 32-bit integer (see
// 10_driver_count_excludes_connectmodule.va). `ok=%b` is an `==` result,
// self-determined at one bit.

`timescale 1ns/1ns
`include "disciplines.vams"

connectrules m04_byp_rules;
  connect m04_byp_c2e merged input ddiscrete, output electrical;
endconnectrules

connectmodule m04_byp_c2e(d, a);
  input d;
  output a;
  ddiscrete d;
  electrical a;

  // NO `assign d = ...;`  -> §9.22.5's default, d_receivers = d_drivers.
  // Consequently this connect module contributes no driver of `d`, and the
  // only driver §9.22.1 can count is the ordinary one in m04_byp_drv.

  integer n;
  initial begin
    #1;
    n = $driver_count(d);
    $display("connect_module_is_inserted_and_sees_the_ordinary_driver got=%b ok=%b",
             n, n == 1);
  end

  analog V(a) <+ 0.0;
endmodule

module m04_byp_drv(o);
  output o;
  ddiscrete o;
  reg o;
  initial begin
    #10 o = 1'b1;
    #20 o = 1'b0;
  end
endmodule

module m04_byp_ear(i);
  input i;
  ddiscrete i;
  initial begin
    #5  $display("default_receiver_reads_the_unassigned_driver %b", i);
    #15 $display("default_receiver_reads_a_one_driver %b", i);
    #20 $display("default_receiver_reads_a_zero_driver %b", i);
    $finish(0);
  end
endmodule

module m04_byp_load(a);
  inout a;
  electrical a;
  electrical g;
  ground g;
  analog I(a, g) <+ V(a, g) / 1.0e3;
endmodule

module m04_byp_top;
  electrical net;

  m04_byp_drv  dr(.o(net));
  m04_byp_ear  ear(.i(net));
  m04_byp_load ld(.a(net));
endmodule
