// §7.8.4: "A connection shall be selected for a port only if one of the
// connections to the port is digital and the other is analog", and §3.9:
// "For digital primitives the domain is discrete and thus the discipline is
// set via the default_discipline directive". So `and g1(y, a, b)` with `a`
// electrical and `default_discipline ddiscrete in force has a mixed input
// port, in1 (§7.8.5.1), and the a2d `connect b5_gbd_a2d;` selects is
// inserted on it (§7.6 Example 2's shape): the gate reads the bridge's
// discrete side, not the analog node.
//
// The bridge loads `a` with I(el) <+ V(el)/1000, and the module drives 1 mA
// into `a`: V(a) = 1 mA * 1 kohm = 1.0 (with no bridge `a` has no load and
// no solution). The bridge drives its discrete port `cm` to 1 at time zero. b is a reg set
// to 1, so y = cm & b = 1 & 1 = 1 (IEEE 1364-2005 §7.2 Table 7-1), and
// `always @(y) yr = y;` copies it into a reg the analog block reads
// (§7.3.6.5). Checked at 10n and 20n: V(a) = 1.0 and yr = 1, 2 checks x 2 points.
// A gate left on the analog node itself reads no driven 0 or 1 there, so y
// would be x and yr would not read 1.
//
// The analog-only half, the generated name a defparam reaches, is
// b5_gate_generated_connect_name_defparam.va.
//
//! lrm 7.8.4
//! lrm 7.8.4:1
//! lrm 7.8.5.1
//! lrm 3.9
//! solve
//! analysis tran
//! time 10n, 20n
//! checks 4
`timescale 1ns/1ns
`include "check.vh"

connectmodule b5_gbd_a2d(el, cm);
  input el;
  output cm;
  electrical el;
  ddiscrete cm;
  reg cm;
  analog I(el) <+ V(el) / 1000.0;
  initial cm = 1'b1;
endmodule

`default_discipline ddiscrete
module b5_gate_connect_bridge_drives_gate_input;
  electrical a;
  wire y;
  reg b, yr;

  and g1(y, a, b);

  always @(y) yr = y;
  initial b = 1'b1;

  analog begin
    I(a) <+ -1.0e-3;
    `CHECK("the a2d at g1's in1 loads a with 1 kohm: V = 1 mA * 1 kohm", V(a), 1.0, 1e-12);
    `CHECKI("g1 reads the bridge's cm = 1 at in1: y = 1 & 1", yr, 1);
  end
endmodule
`default_discipline

connectrules b5_gbd_rules;
  connect b5_gbd_a2d;
endconnectrules
