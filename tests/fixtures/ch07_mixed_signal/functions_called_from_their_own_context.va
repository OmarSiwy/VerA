// §7.3.7, in full: "Digital functions cannot be called from within the analog
// context. Analog functions cannot be called from within the digital context."
//
// The clause is written as two prohibitions, and both are pinned elsewhere
// (`m01_90_digital_function_from_analog_rejected.va`, E0436;
// `analog_function_from_digital_rejected.va`, E0430;
// `digital_function_in_cross_arguments_rejected.va`, the continuous context
// §7.3.5 puts inside a digital event control). What they leave standing is the
// permission the prohibitions are carved out of, and §4.7 states it: "Each
// function can be an analog user-defined function or a digital function (as
// defined in IEEE Std 1364 Verilog)". A module may hold BOTH kinds, and each
// is called from its own context. This fixture runs that module and asserts
// each call's value, so a compiler that satisfied §7.3.7 by refusing one kind
// of function outright fails here.
//
// DERIVATION, `timescale 1ns/1ns, bias V(p) = 0.75:
//
//   digital:  `dsq` starts at 0 (the `initial` block's first write), and at
//             tick 10 the digital context calls `dsquare(7)` = 7 * 7 = 49.
//             §7.3.6.5 has the analog block read "the greatest digital time
//             tick which is less than or equal to the analog time", so
//             t = 5n reads 0, and t = 10n and 15n read 49.
//   analog:   `ahalf(V(p))` = 0.75 / 2 = 0.375 at every point — the bias
//             holds the node, so the function sees the same argument each time.
//
// The digital function is integer-valued and the analog one real-valued, so a
// compiler that routed one call through the other kind's machinery gets a
// visibly wrong type as well as a wrong value (49 is exact in both; 0.375 is
// not an integer).
//
//! lrm 7.3.7
//! lrm 4.7
//! lrm 4.7:1000
//! analysis tran
//! time 5n, 10n, 15n
//! bias V(p) = 0.75
`timescale 1ns/1ns
`include "check.vh"
module ch737_both_kinds(p);
  inout p;
  electrical p;
  integer dsq;

  function integer dsquare(input integer x);
    begin
      dsquare = x * x;
    end
  endfunction

  analog function real ahalf;
    input x;
    real x;
    begin
      ahalf = x / 2.0;
    end
  endfunction

  initial begin
    dsq = 0;
    #10 dsq = dsquare(7);
  end

  analog begin
    `CHECKEQ("a digital function called from the digital context", dsq, ($abstime >= 10n) ? 49 : 0, 0.0);
    `CHECKX("an analog function called from the analog context", ahalf(V(p)), 0.375);
    I(p) <+ V(p) / 1k;
  end
endmodule
