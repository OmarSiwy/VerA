// MIX-LOCAL-001, AMS §4.4 physical 76–77 and §6.5.8 physical 165.
// "The access function name shall match the discipline declaration for the
// nets, ports, or branch given in the argument expression list."
// Parent shared and child port are compatible segments of one analog node;
// sharing the node does not replace the child's explicit electrical discipline.
// The only access under test is Va(port) in the child. Generic accesses in
// the parent avoid an incidental accessor mismatch masking this test.
// This is an isolated invalid accessor; the corresponding local control uses
// V(port) and must be legal. E0501 is the existing flat-net mismatch diagnostic;
// acceptance here exposes the lost local declaration, not conformance.
// Direct checking accepts this invalid access; MIX-LOCAL-001 records the gap.
//! lrm 4.4
//! lrm 6.5.8
//! reject E0501
//! xfail MIX-LOCAL-001 accepts parent Va accessor on an explicitly electrical child port
nature local_potential;
  units = "V"; access = Va; abstol = 1u;
endnature
nature local_flow;
  units = "A"; access = Ia; abstol = 1p;
endnature
discipline local_custom;
  potential local_potential; flow local_flow;
enddiscipline
module audit_child_wrong_potential_rejected;
  local_custom shared;
  local_child c(shared);
  analog flow(shared) <+ potential(shared);
endmodule
module local_child(port);
  inout port;
  electrical port;
  real observed;
  analog observed = Va(port);
endmodule
