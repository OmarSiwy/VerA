// §7.2.2 a top whose discrete half needs the event kernel — a suspending
// `initial` (§8.5) — and which also instantiates an ordinary analog child
// (§6.2.2). Both halves are legal together: C.8 makes Clause 6 hierarchy apply
// to Verilog-AMS, and nothing in §7 confines a digital process to a module with
// no instances.
//
// DERIVATION. `timescale 1ns/1ns. q is 0 from time zero and 1 from tick 10.
// §7.3.6.5 the solve at t reads the greatest tick <= t, so
//
//     t = 0, 5 ns   q = 0   the top drives V(a,b) = 0.0
//     t = 15 ns     q = 1   the top drives V(a,b) = 1.0
//
// and the child, a 1 kOhm resistor across the same pair, carries V/1k. Every
// point is 5 ns clear of the edge.
//
// THE DEFECT THIS PINS, AND WHY XFAIL. Elaboration used to build the flattened
// module without the top's `discrete` list whenever the top had a child, so this
// compiled silently with q missing and V(a,b) = 0 at every point. The top's
// discrete half is now carried, which makes the design mixed and hands it to the
// mixed-signal runner — whose digital engine re-elaborates the source from the
// top and walks instance `r1` as a DIGITAL instance, failing on its electrical
// ports (E1100). That is the runner's limitation, and it is loud.
//
//! lrm 7.2.2
//! lrm 6.2.2
//! lrm 7.3.6.5
//! analysis tran
//! time 0, 5n, 15n
//! xfail E1100: the mixed-signal runner's digital engine elaborates the analog child `r1` as a digital instance
`timescale 1ns/1ns
`include "check.vh"
module ch7_mixed_top(a, b);
  inout a, b; electrical a, b;
  reg q;
  initial begin q = 1'b0; #10 q = 1'b1; end
  ch7_mt_res r1(a, b);
  analog begin
    `CHECKI("the top's suspending initial runs with a child present",
            ($abstime < 9n) ? (q == 0) : (q == 1), 1);
    V(a, b) <+ q ? 1.0 : 0.0;
  end
endmodule

module ch7_mt_res(p, n);
  inout p, n; electrical p, n;
  analog I(p, n) <+ V(p, n) / 1k;
endmodule
