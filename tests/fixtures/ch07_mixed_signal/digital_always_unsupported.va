//! lrm 7.2.2
//! lrm C.7
//! reject E0205
// EXPECT: error -- a digital always process needs the digital backend.
module ch7_digital_always;
  reg state;
  always @(state) state = !state;
endmodule
