// §7.2.2 contexts: "assignment statements within an initial or always block"
// are in the discrete (digital) context. The `always` block below is that
// context in its plainest form — one reg, assigned from a digital process and
// from nowhere else — and it is legal Verilog-AMS HDL.
//
// THE REFUSAL IS VerA'S CEILING, and it is not C.7's. `always` is a module item
// of every module (A.1.4) and parses now; the E0205 this file used to pin was the
// grammar refusing it. What refuses it is E0437: an `always` block RE-RUNS on an
// event, so what `state` holds is a function of §8.5's simulation cycle, and VerA
// does not yet run that cycle beside a device.
//
//! lrm 7.2.2
//! reject E0437
module ch7_digital_always;
  reg state;
  always @(state) state = !state;
endmodule
