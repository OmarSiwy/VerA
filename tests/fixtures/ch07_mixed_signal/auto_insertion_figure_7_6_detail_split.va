// §7.8.1 Figure 7-6, Case 1, detail resolution (§7.4.4.2), split: "d2a at
// each of the five cmos1 blocks". §7.8.3: "The connect_mode indicates how
// input, output, or inout ports of the given discipline shall be combined
// for the purpose of inserting connect modules"; split's ports each get an
// instance (§7.8.4: "All other ports shall have an instance of the selected
// connect module, i.e., one connect module instance per port").
//
// The design: every digital module (blk1..blk4 and mix's blk2, here one
// module `blk`) has one output port of discipline cmos1, `ablk`'s port is
// electrical, and NetD (top's `netd`), NetA (digital_blk's `out`), NetB
// (twoblks' `out`) and NetC (mix's `out`) are undeclared: the figure's
// Case 1, "All interconnects are undeclared". Each port is an output whose
// lower connection is cmos1, so the statement's d2a shape matches it when
// its upper connection is electrical (§7.6 Example 1: "a mixed output port
// whose upper connection is compatible with discipline electrical and whose
// lower connection is compatible with ddiscrete").
//
// Each connect module loads its electrical side with 1 kohm and ablk drives
// the node with 1 mA, so the node reads V = 1e-3 * 1000 / N for N
// instances: the count, and so where §7.8 inserted them, is what is asserted.
//
// Derivation (F.2.2): as in auto_insertion_figure_7_6_detail_merged.va, step
// 5 makes NetA and NetB electrical, so the five leaf ports are the mixed
// ones, and split gives each its own instance: N = 5, V = 0.2.
//
//! lrm 7.4.4.2
//! lrm 7.8.3
//! lrm 7.8.3:1
//! lrm F.2.2
//! discipline-resolution detail
//! solve
//! checks 1
`include "check.vh"
discipline cmos1; domain discrete; enddiscipline
connectmodule f76ds_d2a(d, a);
  input d; cmos1 d;
  output a; electrical a;
  analog I(a) <+ V(a) / 1000.0;
endmodule
connectrules f76ds_rules;
  connect f76ds_d2a split input cmos1, output electrical;
endconnectrules
module f76ds_blk(out); output out; cmos1 out; endmodule
module f76ds_ablk(out);
  output out; electrical out;
  analog begin
    I(out) <+ -1.0e-3;
    `CHECK("5 connect modules load the node: V = 1 mA * 1 kohm / 5", V(out), 0.2, 1e-12);
  end
endmodule
module f76ds_twoblks(out);
  output out;
  f76ds_blk b3(out);
  f76ds_blk b4(out);
endmodule
module f76ds_digital_blk(out);
  output out;
  f76ds_blk b1(out);
  f76ds_blk b2(out);
  f76ds_twoblks t(out);
endmodule
module f76ds_mix(out);
  output out;
  f76ds_blk b2(out);
  f76ds_ablk a(out);
endmodule
module f76ds_top;
  f76ds_digital_blk d(netd);
  f76ds_mix m(netd);
endmodule
