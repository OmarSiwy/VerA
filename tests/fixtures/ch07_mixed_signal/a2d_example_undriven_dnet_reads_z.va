// §7.3.2's own example, verbatim but for the check line:
//
//   module a2d(dnet, anet);
//      input dnet;  output anet;  wire dnet;  ddiscrete dnet;
//      electrical anet;  real avar;
//      analog begin
//         if (dnet === 1'b1) avar = 5;
//         else if (dnet === 1'bx) avar = avar; // hold value
//         else if (dnet === 1'b0) avar = 0;
//         else if (dnet === 1'bz) avar = 2.5; // high impedance - float value
//         V(anet) <+ avar;
//      end
//   endmodule
//
// Compiled as the top, nothing drives `dnet`: it is a `wire` input port of a
// top-level module with no driver in the design. IEEE 1364-2005 4.6 (via
// VAMS 1.1): "If no driver is connected to a net, its value shall be
// high-impedance (z)". §7.3.2 lets `===` read that z ("supports accessing of
// 4-state logic values within the analog context ... the case equality
// operator"), so the fourth arm runs: avar = 2.5 and V(anet) = 2.5 at every
// point. A tool that refuses the undriven discrete read (the defect this
// pins: E0315, E0369) compiles nothing; one that reads an undriven net as 0
// gives 0.
// a2d_example_undriven_dnet_equality_rejected.va is the invalid neighbour:
// the same z compared with `==` against 1'bz, which §7.3.2 refuses.
//! lrm 7.3.2
//! analysis tran
//! time 0, 10n
//! checks 2
`timescale 1ns/1ns
`include "disciplines.vams"
`include "check.vh"
module a2d(dnet, anet);
   input dnet;
   output anet;
   wire dnet;
   ddiscrete dnet;
   electrical anet;
   real avar;

   analog begin
      if (dnet === 1'b1)
         avar = 5;
      else if (dnet === 1'bx)
         avar = avar; // hold value
      else if (dnet === 1'b0)
         avar = 0;
      else if (dnet === 1'bz)
         avar = 2.5; // high impedance - float value

      `CHECKX("an undriven dnet is z, so the z arm sets avar", avar, 2.5);
      V(anet) <+ avar;
   end
endmodule
