// §7.2.2: "Module-level variable declaration assignments are considered to be
// context free and do not associate the variable with a particular domain."
//
// `v` has a module-level declaration assignment AND an assignment in the
// analog block. If the declaration assignment associated `v` with the discrete
// domain, the analog assignment would be the clause's error — "It shall be an
// error to assign to a given variable in both contexts" (E0432,
// both_contexts_assignment_rejected.va) — and this module would be refused.
// The context-free reading is what makes it legal, and 0.25 is the value the
// solve reads back.
//
// `kept` is the control: its declaration assignment is the only one it ever
// gets, so the value the analog block reads shows that a declaration
// assignment still initializes the variable. Context freedom is about the
// domain, not about dropping the initial value.
//
// 0.25 is the `bias` value written into the unknown vector verbatim; 1.25 is
// exact in binary. Both are CHECKX.
//
//! lrm 7.2.2
//! lrm 7.2.2:1002
//! bias V(p) = 0.25
`include "check.vh"
module ch7_decl_assignment_context_free(p);
  inout p; electrical p;
  real v = 1.5;      // context free
  real kept = 1.25;  // context free, never assigned elsewhere

  analog begin
    v = V(p);
    `CHECKX("the declaration assignment does not stop the analog context writing v", v, 0.25);
    `CHECKX("the declaration assignment still initializes kept", kept, 1.25);
    I(p) <+ V(p);
  end
endmodule
