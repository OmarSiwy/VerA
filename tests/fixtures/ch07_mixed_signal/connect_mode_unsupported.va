// §7.7.4 / §7.8.3 connect_mode: `merged` and `split` say "whether all ports of a
// common discrete discipline and port direction share a connect module or have
// individual connect modules" — a signal-segmentation decision (§7.8.2) taken
// during auto-insertion.
//
// C.9 settles the verdict for a Verilog-A compiler: "Clause 7 only applies to
// Verilog-AMS HDL", and C.16 lists `connect`, `connectrules`, `merged` and
// `endconnectrules` among the keywords "not used by Verilog-A". Refusing this
// is conformance, not debt. The module below keeps the refusal about the
// connect specification rather than about an empty source file.
//
//! lrm 7.7.4
//! lrm 7.8.3
//! lrm C.9
//! lrm C.16
//! lrm 7.8.3.1
//! reject E0201
//! reject connectrules
module ch7_host(p);
  inout p; electrical p;
  analog I(p) <+ V(p);
endmodule
connectrules ch7_mode;
  connect ch7_a2d merged input electrical, output logic;
  connect ch7_d2a split input logic, output electrical;
endconnectrules
