// §7.2.2: "assignment statements within an initial or always block" are in the
// discrete context, and §6.2.2 instantiation puts a copy of the definition's
// processes in every instance (IEEE 1364 Clause 12, which §6.2 builds on). So
// the `always` below is a clock that runs inside instance `u`, and the child's
// own analog block reads it through §7.3.1 Table 7-1 — the same design as
// m02_06_unit_delay_tick_alignment.va's, one level down.
//
// DERIVATION. `timescale 1ns/1ns. clk is 0 from the time-zero `initial` and
// toggles every 10 ticks: 0 on [0, 10) ns, 1 on [10, 20) ns. §7.3.6.5: the
// analog solve at t reads "the greatest digital time tick which is less than or
// equal to the analog time", so the declared points read
//
//     t = 0, 5 ns   clk = 0   V(p,n) = 0.0
//     t = 15 ns     clk = 1   V(p,n) = 1.0
//
// Each point is at least 5 ns clear of a toggle, so no tick-rounding question
// can decide it.
//
// WHY XFAIL. Elaboration flattens `u` into the top, renaming `clk` to `u.clk`;
// the mixed-signal runner re-elaborates the source and binds each discrete input
// by its top-scope name, so the flattened name reaches nothing. VerA refuses the
// design (E0920) rather than stamp the analog half with clk missing, which is
// what it used to do silently.
//
//! lrm 7.2.2
//! lrm 6.2.2
//! lrm 7.3.6.5
//! analysis tran
//! time 0, 5n, 15n
//! xfail E0920: a flattened child's `always` cannot reach the mixed-signal runner, which binds discrete inputs by top-scope name
`timescale 1ns/1ns
`include "check.vh"
module ch7_child_always(p, n);
  inout p, n; electrical p, n;
  ch7_ca_clocked u(p, n);
endmodule

module ch7_ca_clocked(a, b);
  inout a, b; electrical a, b;
  reg clk;
  initial clk = 1'b0;
  always #10 clk = ~clk;
  analog begin
    `CHECKI("the child's clock is 0 before 10 ns and 1 after",
            ($abstime < 9n) ? (clk == 0) : (clk == 1), 1);
    V(a, b) <+ clk ? 1.0 : 0.0;
  end
endmodule
