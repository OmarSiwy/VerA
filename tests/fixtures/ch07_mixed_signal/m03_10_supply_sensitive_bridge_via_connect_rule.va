// §7.8.6 supply sensitive connect module examples: "When we need to consider the
// time dependent effect of supplies on the switching behavior of connect modules
// then using elaboration time constants is not sufficient ... Using the analog
// node alias system functions (see 9.20), a more generic connect module may be
// written where the supply name is provided via a string parameter. THIS
// PARAMETER MAY BE SET VIA CONNECT RULES."
//
// The clause prints exactly this shape:
//
//     connectmodule logic_to_elect(cm, el);
//       ...
//       electrical vdd;
//       parameter string vddname = "(not_given)"; // Set via the CR
//       analog initial begin
//         if($analog_node_alias(vdd, vddname) == 0)
//           $error("Unable to resolve power supply: %s", vddname);
//       end
//       analog V(el) <+ V(vdd) * transition((cm == 1) ? 1 : 0);
//     endmodule
//     connectrules mixedsignal;
//       connect logic_to_elect #(.vddname("$root.global_supply.vdd"));
//     endconnectrules
//
// tests/fixtures/ch07_mixed_signal/supply_hierarchical_connectmodule.va already
// pins that a `$root`-prefixed path parses as an access-function terminal, and
// says in its own header that "the supply sensitivity itself is still unreached
// ... `ch7_supply_sensitive` is never instantiated". This fixture instantiates
// the design the clause describes and asserts the resulting voltage.
//
// §9.20 fixes what the alias does: "If the hierarchical_reference_string
// references a valid continuous node, then the analog_net_reference will be
// aliased to that hierarchical node and SHALL REFER TO THE SAME CIRCUIT MATRIX
// POSITION." So the bridge's local `vdd` is not a copy of 3.0 V — it is the
// supply node itself, and the current the bridge draws flows back through
// `sup.vdd`.
//
// A Thevenin d2a instead of the clause's ideal `V(el) <+ ...` source, because a
// finite `rout` is what lets the top module's load divide the supply and turn
// "did the alias resolve?" into a number.
//
// WHY THE SUPPLY IS NOT IDEAL. "Shall refer to the same circuit matrix position"
// is a statement about CURRENT, not only about voltage: an alias that copied the
// supply's value into a private node would satisfy every voltage readback and
// still be wrong. An earlier revision of this file wrote `analog V(vdd) <+ 3.0;`
// and then asserted `V($root.m03_top.sup.vdd) == 3.0` — an assertion no
// implementation can fail, because an ideal source holds 3.0 whether or not
// anything is connected to it. It passes at HEAD today with insertion, aliasing
// and the digital kernel all absent. So the supply is now 3.0 V behind
// rs = 100 ohm, and the bridge's pull-up path runs THROUGH the aliased node:
// the current the bridge delivers to `a` is drawn from `sup.vdd` and drops it.
// The supply readback is now a claim about the shared matrix position.
//
// DERIVATION. Two unknowns. `sup` is 3.0 V behind rs = 100. The bridge, with its
// digital half reading 1'b1, connects `el` to the aliased `vdd` through
// rout = 1000. The top module loads `a` with 1 kohm to ground.
//
//     KCL at a:    (V_a - V_vdd)/1000 + V_a/1000       = 0   =>  V_vdd = 2*V_a
//     KCL at vdd:  (V_vdd - 3.0)/100  + (V_vdd - V_a)/1000 = 0
//
//     substitute V_a = V_vdd/2:
//     10*(V_vdd - 3.0) + (V_vdd - V_vdd/2) = 0
//     10.5 * V_vdd = 30
//     V_vdd = 30/10.5 = 20/7 = 2.857142857142857   (nearest double)
//     V_a   = 10/7       = 1.4285714285714286      (nearest double)
//
// Separating answers, each of which is a distinct failure of the clause:
//   alias returns 0 and `vdd` stays a private local node -> nothing drives the
//     bridge, V(a) = 0.0, and sup.vdd sits UNLOADED at exactly 3.0
//     (§9.20: "If the return value is zero (0), then the node referenced by the
//      analog_net_reference shall be treated as a normal continuous node")
//   the alias resolves by VALUE rather than by matrix position -> V(a) = 1.5
//     (3.0 behind 1k into 1k) and sup.vdd again unloaded at 3.0
//   the string parameter never reaches the inserted instance -> vddname is
//     "(not_given)", the alias fails, V(a) = 0.0, sup.vdd = 3.0
//   the digital half reads 0 instead of 1 -> V(a) = 0.0, sup.vdd = 3.0
//   no insertion at all -> node `a` has only the 1 kohm shunt and reads 0.0,
//     sup.vdd = 3.0, and the second assertion's hierarchical path names nothing
//
// Every one of those misses BOTH checks. The 3.0 that used to be the first
// check's want is now precisely the value that marks the feature as absent.
//
// WHY THE DRIVER WRITES AFTER #0. The bridge's `always @(cm)` only sees a
// change of `cm` it is already waiting for, and `initial q = 1'b1` at time 0
// would be a region-1 event beside that always block's first arrival at `@(cm)`
// (and beside `initial lvl = 1'b0`). §8.5.1: region-1 events "can be processed
// in any order", "an essential source of nondeterminism", so a conforming kernel
// could leave lvl at 0 and read "the digital half reads 0". §8.5.1's "explicit
// zero delay (#0)" makes the write an inactive event, after every process is at
// its first event control; the derivation is unchanged.
//
//! lrm 7.8.6
//! lrm 7.8.6:1
//! lrm 9.20
//! lrm 9.20:11
//! lrm 9.20:12
//! lrm 7.7.3
//! lrm 6.7.1
//! lrm 6.5.7
//! lrm 6.5.7:2
//! lrm 6.7.1:1
//! lrm 7.7.3:1000
//! lrm 9.20:6
//! solve
`include "check.vh"

module m03_supply;
  electrical vdd;
  // 3.0 V behind a finite source resistance. The rs is what makes the readback
  // of this node an assertion rather than a tautology — see the header.
  parameter real rs = 100.0 from (0.0:inf);
  analog I(vdd) <+ (V(vdd) - 3.0) / rs;
endmodule

connectmodule m03_d2a_sup(cm, el);
  input cm;
  output el;
  ddiscrete cm;
  electrical el;
  // §9.20: a local continuous node, not a port, aliased by the string below.
  electrical vdd;
  parameter string vddname = "(not_given)";   // set via the connect rule
  parameter real rout = 1000.0 from (0.0:inf);
  integer status;
  reg lvl;

  initial lvl = 1'b0;
  always @(cm) lvl = cm;                      // digital half of the bridge

  analog initial begin
    status = $analog_node_alias(vdd, vddname);
    if (status == 0) $error("Unable to resolve power supply: %s", vddname);
  end
  // The pull-up path is a BRANCH between `el` and the aliased node, not a
  // voltage-controlled source referring to it, so the current the bridge
  // delivers is drawn from the supply. That is what §9.20's "same circuit
  // matrix position" means and what the first assertion below reads back.
  analog begin
    if (lvl == 1'b1) I(el, vdd) <+ V(el, vdd) / rout;
    else             I(el)      <+ V(el)      / rout;
  end
endmodule

module m03_dsrc(q);
  output q;
  ddiscrete q;
  reg q;
  initial #0 q = 1'b1;
endmodule

module m03_top;
  electrical a;

  m03_supply sup();
  m03_dsrc   u1(a);

  analog begin
    I(a) <+ V(a) / 1000.0;
    `CHECK("the bridge's current is drawn from the SUPPLY NODE itself (same matrix position), so 3.0 V behind 100 sags",
           V($root.m03_top.sup.vdd), 2.857142857142857, 1e-12);
    `CHECK("the connect rule's string parameter aliases the bridge's vdd to the real supply: 20/7 behind 1k into 1k",
           V(a), 1.4285714285714286, 1e-12);
  end
endmodule

connectrules m03_rules;
  connect m03_d2a_sup #(.vddname("$root.m03_top.sup.vdd"));
endconnectrules
