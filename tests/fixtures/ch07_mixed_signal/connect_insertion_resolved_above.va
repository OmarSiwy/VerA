// §7.8.4: "A connection shall be selected for a port only if one of the
// connections to the port is digital and the other is analog. In this case,
// the port shall match one (and only one) connect statement", and "The
// connect module for a port shall be instantiated in the context of the
// ports upper connection." §7.6: "The disciplines of mixed nets are
// determined prior to the connect module insertion phase of elaboration."
//
// Basic resolution (§7.4.4.1, F.2.1 step 4): mid's undeclared port `p` has
// one child, leaf's ciu_discrete port, so `p` is ciu_discrete; top's
// undeclared `shared` meets `p` (discrete) and echild's electrical port, so
// continuous wins and `shared` is electrical. The one mixed port is mid's
// (upper `shared` electrical, lower `p` ciu_discrete), and its bridge is
// instantiated in top; leaf's port joins two discrete segments and gets
// none. The bridge's continuous side is decided one level above the port
// that carries the discrete declaration, which is what this file pins.
//
// The bridge loads `shared` with 1 kohm and top drives 1 mA into it, so one
// bridge reads V(shared) = 1e-3 * 1000 = 1.0 (two would read 0.5, none
// leaves the node with no conductance at all).
//
// Invalid neighbour: reject_mixed_port_no_connect_statement.va, a mixed
// port with no statement (E0927).
//
//! lrm 7.8.4
//! lrm 7.8.4:1
//! lrm 7.8.4:5
//! lrm 7.4.4.1
//! solve
//! checks 1
`include "check.vh"
discipline ciu_discrete;
  domain discrete;
enddiscipline
connectmodule ciu_bridge(a, d);
  inout a; electrical a;
  inout d; ciu_discrete d;
  analog I(a) <+ V(a) / 1000.0;
endmodule
connectrules ciu_rules;
  connect ciu_bridge;
endconnectrules
module ciu_leaf(port);
  inout port; ciu_discrete port;
endmodule
module ciu_mid(p);
  inout p;
  ciu_leaf leaf(p);
endmodule
module ciu_echild(port);
  inout port; electrical port;
endmodule
module ciu_top;
  ciu_mid m(shared);
  ciu_echild e(shared);
  analog begin
    I(shared) <+ -1.0e-3;
    `CHECK("one bridge, at mid's port in top, loads shared with 1 kohm", V(shared), 1.0, 1e-12);
  end
endmodule
