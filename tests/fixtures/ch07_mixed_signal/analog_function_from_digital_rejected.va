// §7.3.7 function calls, second sentence: "Analog functions cannot be called
// from within the digital context." The `initial` block below is that
// violation: §7.2.2 puts "assignment statements within an initial or always
// block" in the discrete (digital) context, and this one calls an
// `analog function`.
//
// THE RULE IS NOW EXERCISED, not masked. This file used to pin E0205 and say so:
// C.7 ("No digital behavior or events are supported in Verilog-A") refused the
// `initial` block as an unsupported module item before the call inside it was
// analysed, so the domain-crossing check never fired and the file proved only
// that annex C's subset had been applied. C.7 is a rule of the SUBSET and VerA
// targets Verilog-AMS, so the block is accepted now and the call is reached:
// E0430, the §4.7.3/§7.3.7 calling-context rule, reported AT the call. That is
// the rule this file is named for, and pinning its code is what makes the file
// fail if the check regresses rather than if the dialect gate moves.
//
// The call is not a constant expression, so the block is not the constant
// shape VerA folds (digital_initial_accepted.va) and is a process for the
// mixed-signal kernel (#57). Only E0430 is pinned: the LRM rule is E0430's,
// whatever else a compiler reports about the block, and a compiler with a full
// discrete kernel emits it.
//
// The other sentence of §7.3.7 — no DIGITAL function called from analog — is
// still masked; digital_function_from_analog_unsupported.va records why.
//
// Corrected 2026-10-08 (construct only, the pins are unchanged): the formal
// was `input real value;`, which A.2.6 does not derive for an analog function
// (E0291, a parse error that would have stopped the compile before E0430). It
// is now `input value; real value;`, 4.7.1's spelling.
//
//! lrm 7.3.7
//! lrm 4.7.3
//! lrm 4.7.3:2
//! lrm 7.3.7:1000
//! reject-only E0430
//! neighbour digital_initial_accepted.va
module ch7_analog_function_from_digital;
  real sampled;
  analog function real analog_scale;
    input value;
    real value;
    analog_scale = 2.0 * value;
  endfunction
  initial sampled = analog_scale(1.0);
endmodule
