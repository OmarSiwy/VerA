// §7.3.2, the plain `case` form: "A case statement could also have been used as
// an alternative to the above if-else-if statement to perform the 4-state logic
// value comparisons", and the LRM's own example labels its arms `1'bx:` and
// `1'bz:`.
//
// This file used to be `xz_case_statement_unsupported.va` and demanded E0130
// on Annex C.3/C.9 grounds — a Verilog-A compiler has no mixed-signal context.
// VerA targets Verilog-AMS and this module is that context, so the refusal is
// withdrawn. A digital driver replaces the old undriven `input d; wire d;`.
//
// DERIVATION, `timescale 1ns/1ns`. IEEE 1364 §9.5: a `case` item compares with
// `===`, so x and z labels match only x and z:
//
//   [0, 20n)   d = 1   default   result 0.0
//   [20n, 40n) d = x   1'bx      result 1.0
//   [40n, 60n) d = z   1'bz      result 2.0
//   [60n, ..)  d = 0   default   result 0.0
//
//! lrm 7.3.2
//! lrm C.3
//! lrm 7.3.2:1
//! analysis tran
//! time 0, 10n, 30n, 50n, 70n
`timescale 1ns/1ns
`include "check.vh"
module ch7_xz_case_statement(p);
  inout p; electrical p; reg d; real result;
  initial begin
    d = 1'b1;
    #20 d = 1'bx;
    #20 d = 1'bz;
    #20 d = 1'b0;
  end
  analog begin
    case (d)
      1'bx: result = 1.0;
      1'bz: result = 2.0;
      default: result = 0.0;
    endcase
    `CHECKEQ("§7.3.2 case labels 1'bx and 1'bz match x and z exactly", result,
             ($abstime >= 20n && $abstime < 40n) ? 1.0 : ($abstime >= 40n && $abstime < 60n) ? 2.0 : 0.0, 0.0);
    I(p) <+ V(p) + result;
  end
endmodule
