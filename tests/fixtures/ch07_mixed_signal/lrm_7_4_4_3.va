// MIX-LOCAL-001 corrects this fixture's former claim that a parent's declared
// discipline replaces an explicitly declared child port's accessors.
// §4.4: "The access function name shall match the discipline declaration for
// the nets, ports, or branch given in the argument expression list."
// §6.5.8 permits one analog node to have several locally declared disciplines;
// §7.4 resolves undeclared segments, not every segment sharing that node.
//
// Parent shared remains ch7443_alt with Va/Ia. Child port remains electrical
// with V/I. Both access the same physical unknown through their own declarations.
// The parent's contribution is zero; the child contributes V(port)-0.5.
// KFL gives 0+(V-0.5)=0, hence both probes must read exactly 0.5.
// The undeclared plain net inherits electrical from its child and reads 0.25.
// Four observations are required at the single operating point.
//
// The former child Va/Ia acceptance claim is withdrawn and moves to the
// MIX-LOCAL-001 invalid-access fixtures, where rejection is required instead.
// This correction changes the oracle, not the LRM. A failure after correcting
// the local access names exposes implementation debt rather than invalidating
// the locally declared discipline. See docs/conformance-mixed-signal.md.
//
// The resolveto override half of §7.4.4.3 is untested here. Resolution precedes
// bridge insertion; absence of insertion does not make that half inapplicable.
//
//! lrm 7.4.4.3
//! lrm 4.4
//! lrm 6.5.8
//! checks 4
//! xfail MIX-LOCAL-001 shared-node discipline replaces the child's local declaration and rejects legal V/I accesses
//! bias V(plain) = 0.25
//! solve
//! print none
`include "check.vh"
nature ch7443_pot;
  units = "V";
  access = Va;
  abstol = 1u;
endnature

nature ch7443_flo;
  units = "A";
  access = Ia;
  abstol = 1p;
endnature

discipline ch7443_alt;
  domain continuous;
  potential ch7443_pot;
  flow ch7443_flo;
enddiscipline

module ch7443_top;
  ch7443_alt shared;

  ch7443_alt_child c1(shared);
  ch7443_elec_child c2(plain);

  analog begin
    `CHECKX("the declared discipline governs the declared interconnect", Va(shared), 0.5);
    `CHECKX("an undeclared net is resolved, and reads through its port's discipline", V(plain), 0.25);
    Ia(shared) <+ 0.0;
    I(plain) <+ 0.0;
  end
endmodule

// Both children preserve their explicit electrical port declarations.
module ch7443_alt_child(port);
  inout port;
  electrical port;

  analog begin
    `CHECKX("the electrical child uses its own accessor on the shared node",
            V(port), 0.5);
    I(port) <+ V(port) - 0.5;
  end
endmodule

module ch7443_elec_child(port);
  inout port;
  electrical port;

  analog begin
    `CHECKX("and a child on a resolved net sees the resolved one", V(port), 0.25);
    I(port) <+ V(port) - 0.25;
  end
endmodule
