// §7.3.5: "In Verilog-AMS HDL, monitored continuous events can be detected in a
// discrete context. The arguments to these events are in the continuous
// context. A continuous event in a discrete context is blocking like other
// discrete events." Syntax 7-3 admits `analog_event_functions` into
// `event_expression`, and the clause's example is `sampler2`:
//
//     always @(cross(V(clk) - 2.5, 1))
//        out = in;
//
// §7.3.6.1 adds the delivery rule: "the statements under the event control
// shall be scheduled in the digital domain at the nearest digital time tick to
// the time of the analog event. This event shall not be schedule in the digital
// domain earlier than the last or current digital event".
//
// DERIVATION. V(clk) is walked up and back down across the 2.5 V threshold:
//
//   //! time  0     5n    10n   15n   20n
//   //! wave  0.0   2.0   4.0   2.0   0.0
//
// so V(clk) - 2.5 goes -2.5, -0.5, +1.5, -0.5, -2.5. It has exactly two zero
// crossings, and they are of opposite sign:
//
//   rising  in (5n, 10n)   — linearly at 5n + 5n*(0.5/2.0) = 6.25n
//   falling in (10n, 15n)  — linearly at 10n + 5n*(1.5/2.0) = 13.75n
//
// ARITHMETIC CORRECTED AFTER REVIEW. The falling time read 11.25n here, from
// 5n*0.25. The fraction is not 0.25. On (10n, 15n) the expression runs +1.5 to
// −0.5, a span of 2.0, and zero is reached after 1.5 of that span:
// 1.5/2.0 = 0.75, so 10n + 5n*0.75 = 13.75n. (11.25n would be the answer for a
// segment falling 0.5 into −1.5, which is not this one.) Nothing downstream
// moves: `dir = 1` discards the falling crossing either way, and 13.75n is
// still strictly inside (10n, 15n), so the fixture's want is unchanged. It is
// corrected because a derivation that does not survive being redone is not a
// derivation.
//
// With `dir = 1` only the rising one is an event (§5.10.3.1: "If dir is +1, the
// event and timestep control only occur on rising edge transitions of the
// signal"), so the count is 0 up to and including the 5n observation and 1 from
// the 10n one:
//
//   t = 0, 5n           n = 0
//   t = 10n, 15n, 20n   n = 1
//
// THE WINDOW BETWEEN THEM IS DELIBERATELY NOT ASSERTED, and that is a change
// from the first draft, which wrote the oracle as `($abstime >= 10n) ? 1 : 0`
// and asserted it everywhere. §5.10.3.1 says cross() "controls the timestep to
// accurately resolve the crossing" and that the event "shall occur after the
// threshold crossing, and while the signal remains in the box defined by actual
// crossing and expr_tol and time_tol" — with both tolerances unspecified here,
// "the tool sets them". So a conforming simulator reports analog points at and
// around 6.25n that the `//! time` list does not name, and §7.3.6.1 then places
// the digital statement "at the nearest digital time tick to the time of the
// analog event" — tick 6 for an event at 6.25n, tick 7 for a tool whose
// tolerance box pushes the event past 6.5n. At an analog point anywhere in that
// region, `n` may legitimately read 0 or 1, and the clause supplies no digits
// to write down. The want is therefore `n` itself on the open interval
// (5n, 10n), which asserts nothing there on purpose, and the exact integer
// outside it. This is the §7.3.6.1 rounding window the row's tests/fixtures/ch07_mixed_signal/m01_SPEC.md at 8b1514d4 assigns to
// M02; when M02 pins the placement, replace the middle arm with the digit.
//
// oracle ($abstime <= 5n) ? 0 : ($abstime >= 10n) ? 1 : n.
//
// A counter rather than a sample, because the two things this fixture has to
// separate are both counts, and both are separated OUTSIDE the unasserted
// window: a tool that ignored `dir` fires again at 13.75n and reads 2 at
// t = 15n and t = 20n against a want of 1, and a tool that re-delivered the
// event on every digital tick after the crossing reads far more at the same two
// points. A tool that never delivered reads 0 at t = 10n, 15n and 20n.
//
// `n` is written only by the `always` block, so it is discrete by §7.2.2 and
// comes back to the analog block through Table 7-1's `integer` row. The 1 mA
// scale on the contribution keeps the residual readable and is not asserted.
//
// WHAT USED TO FAIL (green since ch07 steps 5/7). `error[E0205]: unsupported module item: found `always``.
// The event expression itself parses — `tests/fixtures/ch07_mixed_signal/
// digital_cross_unsupported.va` is this shape — but the enclosing block is
// refused as an item, so §7.3.5 has no behavioral coverage anywhere.
//
//! lrm 7.3.5
//! lrm 7.3.5:1001
//! lrm 7.3.6.1
//! lrm 7.3.6.1:2
//! lrm 5.10.3.1
//! lrm 5.10.3.1:5
//! lrm 7.3.5:1000
//! analysis tran
//! time 0, 5n, 10n, 15n, 20n
//! wave V(clk) = 0.0, 2.0, 4.0, 2.0, 0.0
`timescale 1ns/1ns
`include "check.vh"
module m01_cross_to_digital(clk, p);
  inout clk, p;
  electrical clk, p;
  integer n;

  initial n = 0;

  always @(cross(V(clk) - 2.5, 1))
    n = n + 1;

  analog begin
    // The middle arm is `n` itself: on (5n, 10n) the §7.3.6.1 tick-rounding
    // window around the 6.25n crossing makes both 0 and 1 conforming, so no
    // digit is written there. See THE WINDOW BETWEEN THEM above.
    `CHECKEQ("cross(V(clk)-2.5,1) reaches the digital process once, on the rising crossing", n, ($abstime <= 5n) ? 0 : ($abstime >= 10n) ? 1 : n, 0.0);
    I(p) <+ 1m * n;
  end
endmodule
