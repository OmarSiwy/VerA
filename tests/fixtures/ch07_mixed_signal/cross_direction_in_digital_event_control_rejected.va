// §7.3.6.1: "In this case, an analog event, such as cross or timer, appears in
// an @() statement in the digital context." §7.3.5: "The arguments to these
// events are in the continuous context", and Syntax 7-3 derives the term from
// the SAME `analog_event_functions` production as Syntax 7-2's analog event
// control — `cross ( analog_expression [ , analog_expression_or_null ... ] )`.
//
// So a `cross()` in an `always` block is §5.10.3.1's function, not a digital
// look-alike, and §5.10.3.1's rules bind it wherever it is written:
//
//   "The direction indicator ... shall evaluate to integers."
//
// Here the direction is 0.5, which folds and is not an integer. The same
// argument in an `analog` block is E0517 (tests/fixtures/ch05_analog_behavior
// carries that half); this is the digital-context half of one rule.
//
// DERIVATION OF THE VERDICT. 0.5 is not integral, and §5.10.3.1 gives no
// rounding: a direction of 0.5 selects neither the rising (+1) nor the falling
// (-1) crossing and is not the both-directions 0. Everything else in the module
// is legal — the monitored expression is the clause's `V(x) - 5.5` shape and
// the body writes a `reg` — so the only rule the module breaks is the one on
// the direction.
//
// WHAT THIS PINS THAT NOTHING ELSE DOES. Before 2026-09-24 VerA accepted this
// module: §5.10.3.1's checks ran only where an analog block lowered the event,
// and the mixed-signal kernel was handed a direction of 0.5 to interpret.
//
//! lrm 7.3.6.1
//! lrm 7.3.5
//! lrm 5.10.3.1
//! lrm 5.10.3.1:3
//! reject-only direction shall evaluate to an integer
`timescale 1ns/1ns
`include "disciplines.vams"
module ch7_cross_dir_digital(x, n);
  input x;
  output n;
  electrical x;
  reg n;

  initial n = 1'b0;

  always begin
    @(cross(V(x) - 5.5, 0.5))
      n = 1'b1;
  end
endmodule
