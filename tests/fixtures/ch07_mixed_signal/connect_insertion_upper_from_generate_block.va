// §7.8.4: "Driver-receiver segregation and connect module insertion is a
// post elaboration operation. It depends on a complete hierarchical
// examination of each signal in the design", and "The connect module for a
// port shall be instantiated in the context of the ports upper connection."
// §6.9.3: "Discipline resolution can only occur after elaboration of the
// generate constructs once the connections of all nets have been resolved."
// §6.6.2: the conditional generate constructs "select at most one generate
// block ... based on constant expressions evaluated during elaboration."
//
// THE DESIGN. top's undeclared `shared` connects mid's port `p` and
// echild's electrical port. mid instantiates its two digital leaves only
// inside an if-generate on mid's parameter `use_d`, whose default 0 top
// overrides to 1. So whether mid's `p` is digital is decided by a generate
// block one level BELOW the level that must place the bridge (top).
//
// DERIVATION, basic resolution (§7.4.4.1, Annex F.2.1 step 4; no
// `//! discipline-resolution`, so basic):
//   use_d = 1 (top's override), so the block `g` exists.
//   mid.p: its child nets are g.l1.port and g.l2.port, both cub_d
//     (discrete): "Any net whose child nets are all digital shall be
//     considered digital", cub_d.
//   top.shared: children mid.p (cub_d) and e.port (electrical): "any others
//     shall be considered analog", electrical.
//   Mixed ports (one connection analog, the other digital): mid's port in
//     top only. Inside mid both connections of g.l1's and g.l2's ports are
//     cub_d.
//   §7.8.3.2 split: one instance per mixed port, in top: N = 1.
// The bridge loads `shared` with 1 kohm and top drives 1 mA into it:
// V(shared) = 1e-3 * 1000 / N = 1.0.
//   A tool that placed the bridges below, on the two leaf ports, reads 0.5
//   (split); one that evaluated the scheme with mid's default (use_d = 0)
//   finds no child on mid.p and inserts none, leaving `shared` with no
//   conductance; one that cannot read the generate block refuses (E0929).
//
//! lrm 7.8.4
//! lrm 7.8.4:5
//! lrm 6.6.2
//! lrm 6.9.3
//! lrm F.2.1
//! lrm F.2.1:6
//! solve
//! checks 1
`include "check.vh"
discipline cub_d; domain discrete; enddiscipline
connectmodule cub_bridge(a, d);
  inout a; electrical a;
  inout d; cub_d d;
  analog I(a) <+ V(a) / 1000.0;
endmodule
connectrules cub_rules;
  connect cub_bridge split;
endconnectrules
module cub_leaf(port); inout port; cub_d port; endmodule
module cub_echild(port); inout port; electrical port; endmodule
module cub_mid(p);
  inout p;
  parameter integer use_d = 0;
  generate
    if (use_d) begin : g
      cub_leaf l1(p);
      cub_leaf l2(p);
    end
  endgenerate
endmodule
module cub_top;
  cub_mid #(.use_d(1)) m(shared);
  cub_echild e(shared);
  analog begin
    I(shared) <+ -1.0e-3;
    `CHECK("one bridge, on mid's port in top: V = 1 mA * 1 kohm", V(shared), 1.0, 1e-12);
  end
endmodule
