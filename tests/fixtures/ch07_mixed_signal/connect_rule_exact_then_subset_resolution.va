// §7.7.2.1 "When there is an exact match for the set of disciplines specified
// as part of the discipline_list, the resolved discipline would be as per the
// rule specified in the exact match. ... When there is no exact fit, then the
// resolved discipline would be based on the subset of the rules specified. ...
// The resolved discipline need not be one of the disciplines specified in the
// discipline list."
//
// The clause's own Example 1, transcribed:
//
//     connect x,y,a resolveto a;
//     connect x,y resolveto x;
//     "disciplines x,y would resolve to discipline x."        (exact match)
//     "disciplines y,a would resolve to discipline a."        (subset)
//
// m03_13_reject_ambiguous_connect_statements.va is the clause's only other cite
// and is a §7.8.4 rejection; this file is the resolution mechanism itself.
//
// HOW THE RESOLUTION IS OBSERVED — annex_f_resolution/resolveto_resolution.va's
// trick. Each of the three disciplines binds its OWN potential nature with its
// OWN access function (XV, YV, AV). By §3.6.2.1 a net's access functions are
// its discipline's, so `XV(s_xy)` compiles only if s_xy resolved to x, and
// `AV(s_ya)` only if s_ya resolved to a. A tool that picked the superset rule
// for {x, y} (resolving to a) or ignored the subset rule for {y, a} fails to
// build. The three potential natures share units "V" and the flow nature is
// common, so the disciplines are compatible by §3.11.1's Units Value Rule, which
// §7.7.2 requires of the nets a resolution statement joins.
//
// Both interconnects are undeclared and connect only leaves of the listed
// disciplines, so resolution — not a declaration — decides them. The wants are
// the biases read back through the resolved access functions, exact in binary.
//
//! lrm 7.7.2.1
//! lrm 7.7.2
//! lrm 7.4.1
//! lrm 7.4.1:1000
//! lrm 7.7.2:1000
//! lrm A.1.8
//! lrm A.1.8:1000
//! bias s_xy = 0.75, s_ya = 0.25
`include "check.vh"
nature ch7_crr_x_pot; units = "V"; access = XV; abstol = 1u; endnature
nature ch7_crr_y_pot; units = "V"; access = YV; abstol = 1u; endnature
nature ch7_crr_a_pot; units = "V"; access = AV; abstol = 1u; endnature
nature ch7_crr_flow;  units = "A"; access = CRRI; abstol = 1p; endnature
discipline ch7_crr_x; potential ch7_crr_x_pot; flow ch7_crr_flow; domain continuous; enddiscipline
discipline ch7_crr_y; potential ch7_crr_y_pot; flow ch7_crr_flow; domain continuous; enddiscipline
discipline ch7_crr_a; potential ch7_crr_a_pot; flow ch7_crr_flow; domain continuous; enddiscipline

connectrules ch7_crr_rules;
  connect ch7_crr_x, ch7_crr_y, ch7_crr_a resolveto ch7_crr_a;
  connect ch7_crr_x, ch7_crr_y resolveto ch7_crr_x;
endconnectrules

module ch7_crr_x_leaf(p); inout p; ch7_crr_x p; endmodule
module ch7_crr_y_leaf(p); inout p; ch7_crr_y p; endmodule
module ch7_crr_a_leaf(p); inout p; ch7_crr_a p; endmodule

module ch7_connect_rule_exact_then_subset(s_xy, s_ya);
  inout s_xy, s_ya;
  ch7_crr_x_leaf l1(s_xy);
  ch7_crr_y_leaf l2(s_xy);
  ch7_crr_y_leaf l3(s_ya);
  ch7_crr_a_leaf l4(s_ya);
  analog begin
    `CHECKX("§7.7.2.1 {x, y} has an exact rule and resolves to x", XV(s_xy), 0.75);
    `CHECKX("§7.7.2.1 {y, a} has no exact rule; the subset rule resolves it to a", AV(s_ya), 0.25);
    CRRI(s_xy) <+ XV(s_xy);
    CRRI(s_ya) <+ AV(s_ya);
  end
endmodule
