// §7.3.1 Table 7-1 makes r[38:8] of a 40-bit `reg` legal: it is a 31-bit
// grouping. This `reg` is assigned in the analog context, so the analog
// context computes every one of its 40 bits, as IEEE 1364-2005 sizes the
// assignment: §5.4.1 "including the left-hand side of an assignment" puts
// the 40 bits in the context of the right-hand side, §5.5.2 converts each
// context-determined operand to it (sign-extending only a signed context),
// and §5.5.3 cuts the result to the `reg`. A real right-hand side is
// rounded to the nearest integer (IEEE 1364-2005 §4.8.2).
// (specification/Vague_Decisions.md VD-116.)
//
// DERIVATION. Each assignment, its 40-bit value, then the selects
// (`(v >> lo) & (2**w - 1)`):
//   r = 1           1 is a 32-bit signed decimal; context (40, signed):
//                   0x00_0000_0001.        r[38:8] = 0, r[0] = 1
//   r = -1          -1 at 40 bits: forty ones.
//                                          r[39:9] = 2**31 - 1 = 2147483647
//   r = 1 << 35     1 at 40 bits, shifted: 2**35 = 0x08_0000_0000.
//                                          r[38:8] = 2**27 = 134217728
//   r = K + 1       K = 2**31 - 1 (integer, 32-bit signed) at 40 bits plus 1:
//                   2**31, no 32-bit wrap. r[38:8] = 2**23 = 8388608,
//                                          r[31] = 1, r[32] = 0
//   r = 40'hF0_0000_0001 + 40'h10_0000_0000
//                   0x100_0000_0001 cut to 40 bits: 0x00_0000_0001.
//                                          r[39:32] = 0, r[0] = 1
//   r = 1.5e11      150000000000 = 0x22_ECB2_5C00.
//                                          r[39:32] = 0x22 = 34,
//                                          r[31:8] = 0xECB25C = 15512156
//   r = 1 << 35; s = r << 8
//                   s, 48 bits, reads r whole: 2**35 at 48 bits, shifted:
//                   2**43.                 s[47:17] = 2**26 = 67108864
// One check each at the one operating point: checks 12. A tool that held
// the `reg` as its 32-bit integer reads 0 for every select above bit 31 and
// wraps K + 1 to -2**31.
//
//! lrm 7.3.1
//! inherited IEEE 1364-2005 5.4.1
//! inherited IEEE 1364-2005 5.5.3
//! checks 12
`include "check.vh"
module ch7_discrete_bus_part_select_above_31_assigned(p);
  inout p; electrical p;
  parameter integer K = 2147483647;
  reg [39:0] r;
  reg [47:0] s;
  analog begin
    r = 1;
    `CHECKI("r = 1: r[38:8]", r[38:8], 0);
    `CHECKI("r = 1: r[0]", r[0], 1);
    r = -1;
    `CHECKI("r = -1 fills 40 bits: r[39:9]", r[39:9], 2147483647);
    r = 1 << 35;
    `CHECKI("1 << 35 at 40 bits: r[38:8]", r[38:8], 134217728);
    s = r << 8;
    `CHECKI("s = r << 8 reads r whole: s[47:17]", s[47:17], 67108864);
    r = K + 1;
    `CHECKI("K + 1 at 40 bits: r[38:8]", r[38:8], 8388608);
    `CHECKI("K + 1 at 40 bits: r[31]", r[31], 1);
    `CHECKI("K + 1 at 40 bits: r[32]", r[32], 0);
    r = 40'hF0_0000_0001 + 40'h10_0000_0000;
    `CHECKI("the carry out of bit 39 is cut: r[39:32]", r[39:32], 0);
    `CHECKI("the carry out of bit 39 is cut: r[0]", r[0], 1);
    r = 1.5e11;
    `CHECKI("1.5e11 rounded: r[39:32]", r[39:32], 34);
    `CHECKI("1.5e11 rounded: r[31:8]", r[31:8], 15512156);
    I(p) <+ V(p);
  end
endmodule
