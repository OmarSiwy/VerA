// §8.5.3.6: "An explicit D2A event is processed by evaluating the analog block
// that is sensitive to this event. This is so that the values used for the
// digital variables referenced inside the explicitly sensitive event control
// statement in the analog block are the values of those variables after region
// 1 has been processed, not the values of those variables just before region
// 3b is processed." §8.5.1: explicit D2A events (region 1b) are processed
// "after all the active events", BEFORE the inactive events of region 2, and
// "An explicit zero delay (#0) requires that the process be suspended and added
// as an inactive event for the current time so that the process is resumed in
// the next simulation cycle in the current time."
//
// DERIVATION, `timescale 1ns/1ns`. The analog block is explicitly sensitive to
// d through `@(d)`. At tick 10:
//
//   cycle 1, region 1   d = 2 (a change: an explicit D2A event)
//            region 1b  the @(d) body runs and reads d = 2: k = 1, c1 = 2
//            region 2   the #0 resumes the initial block
//   cycle 2, region 1   d = 3 (a second change, a second explicit D2A event)
//            region 1b  the body runs again and reads d = 3: k = 2, c2 = 3
//
// The body is guarded by $abstime > 5n so whatever happens to d at time zero
// (x -> 1, ordered against the DC solve by nothing) is not counted. k, c1 and
// c2 are analog-context integers, which start at 0 (§3.2). After tick 10:
// k = 2, c1 = 2, c2 = 3. A tool that evaluated the explicitly sensitive block
// once with the values "just before region 3b" reads k = 1 and c1 = 3; that is
// the reading the clause names and excludes. The implicit half of the same
// tick, where the solve sees only 3, is
// m02_14_zero_delay_settles_before_the_macro_process.va.
//
//! xfail explicit D2A events across a #0 delta are coalesced: the @(d) body runs once at tick 10 and reads d after region 2 (k = 1, c1 = 3)
//! lrm 8.5.3.6
//! lrm 8.5.1
//! analysis tran
//! time 0, 5n, 10n, 12n
`timescale 1ns/1ns
`include "check.vh"
module m02_explicit_d2a_per_delta_cycle(out);
  inout out;
  electrical out;
  integer d;
  integer k, c1, c2;

  initial begin
    d = 1;
    #10 d = 2;
    #0 d = 3;
  end

  analog begin
    @(d) if ($abstime > 5n) begin
      k = k + 1;
      if (k == 1) c1 = d; else c2 = d;
    end
    `CHECKI("one explicit D2A event per delta cycle", k, ($abstime >= 10n) ? 2 : 0);
    `CHECKI("the first sees d after region 1, before the #0 resumes", c1, ($abstime >= 10n) ? 2 : 0);
    `CHECKI("the second sees the #0 cycle's value", c2, ($abstime >= 10n) ? 3 : 0);
    V(out) <+ d;
  end
endmodule
