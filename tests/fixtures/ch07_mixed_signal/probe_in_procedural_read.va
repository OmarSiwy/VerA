// VAMS §7.3.6.3: "If the analog value is read from the digital context, the
// value used is the analog value calculated for the time corresponding to a
// real promotion of the digital time." A procedural assignment reads it when
// its process runs.
//
// The analog block drives V(a) = 1.0 at every solution (`//! solve`), so at
// 1 ns, between the solutions at 0 and 2 ns, the value read is 1.0 whichever
// way it is interpolated, and 1.0 > 0.5 makes hi = 1. One check, printed by
// the digital $strobe at 1 ns.
//
// The legal neighbour of probe_in_continuous_assign_refused.va: the same
// probe, read here by a procedural statement instead of a continuous
// assignment.
//
//! lrm 7.3.6.3
//! analysis tran
//! time 0, 2n
//! solve
//! checks 1
`timescale 1ns/1ns
`include "check.vh"
module probe_in_procedural_read(a);
  inout a; electrical a;
  reg hi;
  initial begin
    #1 hi = V(a) > 0.5;
    `CHECKI("a procedural read of the probe sees the solution", hi, 1);
  end
  analog V(a) <+ 1.0;
endmodule
