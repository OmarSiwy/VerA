// §5.10.4, the other direction of the same clause. Its example is
//
//     initial #10 -> dig_event;
//     analog begin
//        ...
//        @(dig_event) $display("Event: dig_event detected in analog");
//     end
//
// and §5.10.5 names it as a category: "analog behavior can be made sensitive to
// digital events, including posedge events, negedge events, state change
// events, and named events. In the example above it shows how a digital event
// (dig_event) can be detected within the analog context."
//
// §7.3.6.2 fixes the instant: the guarded statement runs "at the time
// corresponding to a real promotion of the digital time".
//
// DERIVATION, `timescale 1ns/1ns`. The trigger is issued twice, ten
// nanoseconds apart, and the analog side COUNTS rather than samples — §5.10.4's
// named event carries no value, so counting is the only thing there is to
// observe, and it is also the only way to tell two deliveries from one:
//
//   t = 5n    no trigger yet                    n = 0
//   t = 15n   triggered once, at tick 10        n = 1
//   t = 25n   triggered twice, at ticks 10, 20  n = 2
//
// oracle ($abstime >= 10n) + ($abstime >= 20n).
//
// The observation times are offset from the trigger times by half a period so
// that no check is evaluated in the same instant as a delivery; §7.3.6.2 says
// the statement runs AT the promoted time, and whether the analog block's check
// at exactly that instant sees the update is a clause-8 ordering question this
// row does not decide.
//
// `n` is written only by the analog block, so it is a continuous variable by
// §7.2.2 and there is no both-contexts conflict with the `initial` block, which
// writes nothing.
//
// A tool that treated `-> dig_event` as a level rather than an event reads 1 at
// t = 25n (one lasting trigger). One that never delivered reads 0 throughout.
// One that re-delivered on every analog step reads far more than 2.
//
// WHAT USED TO FAIL (green since ch07 steps 5/7). `error[E0209]: expected an expression: found `#`` — the
// `.va` dialect has no `#` delay, so a digital process cannot be made to do
// anything AT a time. With the delay removed, `@(dig_event)` itself lowers
// (the named-event machinery exists), but the trigger can then only happen
// before the analysis, and the fixture's whole claim is about when.
//
//! lrm 5.10.4
//! lrm 5.10.5
//! lrm 7.3.6.2
//! lrm 7.2.2
//! lrm 5.10.5:1000
//! lrm 7.3.4
//! lrm 7.3.4:1000
//! analysis tran
//! time 5n, 15n, 25n
`timescale 1ns/1ns
`include "check.vh"
module m01_named_event_to_analog(p);
  inout p;
  electrical p;
  event dig_event;
  integer n;

  initial begin
    #10 -> dig_event;
    #10 -> dig_event;
  end

  analog begin
    @(dig_event)
      n = n + 1;
    `CHECKEQ("a digital named event is delivered to the analog block once per trigger", n, ($abstime >= 10n) + ($abstime >= 20n), 0.0);
    I(p) <+ 1m * n;
  end
endmodule
