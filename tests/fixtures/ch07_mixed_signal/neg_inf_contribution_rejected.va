// §7.3.2.1 special floating point values: "Floating point arithmetic can
// produce special values representing plus and minus infinity and Not-a-Number
// (NaN) to represent a bad value. While use of these special numbers in digital
// expressions is not an error, it is illegal to assign these values to a branch
// through contribution in the analog context."
//
// The clause names three values; this is the third. inf_contribution.va does
// +inf and nan_contribution_rejected.va does the NaN. Minus infinity gets its
// own file because a compiler may well diagnose one sign and not the other, and
// a single file contributing both would hide that.
//
// `-inf` is not writable as an expression: annex A gives
// `value_range_expression ::= constant_expression | -inf | inf`, and `inf` is
// absent from the A.8.4 `primary` list this chapter reprints as Syntax 7-1. So
// the value is formed by the arithmetic the clause names — -1.0/0.0 is the IEEE
// 754 division of a finite negative by zero, whose result is -inf.
//
//! lrm 7.3.2.1
//! reject contribution of an infinite value
//! xfail VerA does not diagnose an infinite contribution; `I(p) <+ -1.0/0.0` yields only W0650
module ch7_neg_inf_contribution(p);
  inout p; electrical p;
  real bad;
  analog begin
    bad = -1.0/0.0;
    I(p) <+ bad + 0.0*V(p);
  end
endmodule
