// §7.8.1 Figure 7-6 ("Auto-insertion with coercion"), Case 1, basic
// resolution, merged: "d2a at top.mix.blk2 and d2a at top.digital_blk (two
// connect modules)". §7.8.1: "Auto-insertion of connect modules is done
// hierarchically. The connect modules are inserted based on the net
// disciplines and ports at each level of the hierarchy."
//
// The design: every digital module (blk1..blk4 and mix's blk2, here one
// module `blk`) has one output port of discipline cmos1, `ablk`'s port is
// electrical, and NetD (top's `netd`), NetA (digital_blk's `out`), NetB
// (twoblks' `out`) and NetC (mix's `out`) are undeclared: the figure's
// Case 1, "All interconnects are undeclared". Each port is an output whose
// lower connection is cmos1, so the statement's d2a shape matches it when
// its upper connection is electrical (§7.6 Example 1: "a mixed output port
// whose upper connection is compatible with discipline electrical and whose
// lower connection is compatible with ddiscrete").
//
// Each connect module loads its electrical side with 1 kohm and ablk drives
// the node with 1 mA, so the node reads V = 1e-3 * 1000 / N for N
// instances: the count, and so where §7.8 inserted them, is what is asserted.
//
// Derivation (§7.4.4.1, F.2.1): NetB's children are cmos1 only, so NetB is
// cmos1; NetA's likewise; NetC meets cmos1 and electrical, continuous wins,
// electrical; NetD meets NetA (cmos1) and NetC (electrical), electrical. The
// mixed ports (§7.8.4: "one of the connections to the port is digital and
// the other is analog") are digital_blk's (NetD over NetA), bridged in top,
// and mix's blk2 (NetC over cmos1), bridged in mix: N = 2, V = 0.5.
// Detail mode on the same design: auto_insertion_figure_7_6_detail_merged.va.
//
//! lrm 7.8.1
//! lrm 7.4.4.1
//! solve
//! checks 1
`include "check.vh"
discipline cmos1; domain discrete; enddiscipline
connectmodule f76bm_d2a(d, a);
  input d; cmos1 d;
  output a; electrical a;
  analog I(a) <+ V(a) / 1000.0;
endmodule
connectrules f76bm_rules;
  connect f76bm_d2a input cmos1, output electrical;
endconnectrules
module f76bm_blk(out); output out; cmos1 out; endmodule
module f76bm_ablk(out);
  output out; electrical out;
  analog begin
    I(out) <+ -1.0e-3;
    `CHECK("2 connect modules load the node: V = 1 mA * 1 kohm / 2", V(out), 0.5, 1e-12);
  end
endmodule
module f76bm_twoblks(out);
  output out;
  f76bm_blk b3(out);
  f76bm_blk b4(out);
endmodule
module f76bm_digital_blk(out);
  output out;
  f76bm_blk b1(out);
  f76bm_blk b2(out);
  f76bm_twoblks t(out);
endmodule
module f76bm_mix(out);
  output out;
  f76bm_blk b2(out);
  f76bm_ablk a(out);
endmodule
module f76bm_top;
  f76bm_digital_blk d(netd);
  f76bm_mix m(netd);
endmodule
