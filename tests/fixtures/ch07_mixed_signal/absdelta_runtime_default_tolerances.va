// VerA's documented §5.10.3.4 choice: an absent or zero expr_tol is 1e-12
// in the expression's units. This pins the implementation choice, not a
// mandatory numeric tolerance for other simulators. delta = 100 V prevents
// delta events. After rising to 2e-12 V, the 0.5e-12 V reversal at 2 ns is
// ignored; the total 1e-12 V reversal at 3 ns meets the tolerance exactly.
// Both spellings therefore initialize once and fire once on reversal.
// One intermediate and two final assertions give checks = 3.
//! analysis tran
//! time 0, 1n, 2n, 3n, 4n
//! wave V(p) = 0.0, 2p, 1.5p, 1p, 1p
//! checks 3
`timescale 1ns/1ps
`include "check.vh"
module absdelta_runtime_default_tolerances(p);
  inout p; electrical p;
  integer absent, zero;
  initial begin absent = 0; zero = 0; end
  always @(absdelta(V(p), 100.0)) absent = absent + 1;
  always @(absdelta(V(p), 100.0, 0.0, 0.0)) zero = zero + 1;
  analog begin
    if ($abstime == 2n) `CHECKI("default tolerance suppresses the smaller reversal", absent == 1 && zero == 1, 1);
    @(final_step) begin
      `CHECKI("absent tolerance uses the documented 1e-12 boundary", absent, 2);
      `CHECKI("zero tolerance uses the same documented boundary", zero, 2);
    end
    I(p) <+ 0.0;
  end
endmodule
