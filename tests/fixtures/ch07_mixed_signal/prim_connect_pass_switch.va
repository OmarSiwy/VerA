// §7.8.5.1: "For bidirectional pass switches (tran, tranif1, tranif0, rtran,
// rtranif1, rtranif) the ports reading from left to right will be named
// source, drain, gate." A pass switch's two terminals are IEEE 1364-2005
// A.3.3 `inout_terminal`s, so a mixed one is a mixed inout port, which only a
// bidirectional connect module bridges (§7.6 Example 3: "can bridge any mixed
// port"; Table 7-2's inout/inout).
//
// THE DESIGN. `tranif1 t1(a, y, en)`: source on the electrical `a`, drain on
// the wire `y`, gate the reg `en`. `tran t2(w, c)`: source on the wire `w`,
// drain on the electrical `c`. Split names (§7.8.5): `a__t1__source` and
// `c__t2__drain`; the defparams give them vh = 0.4 and 0.9.
//
// DERIVATION. `assign y = dy` and `assign w = dw` drive 1 (dy = dw = 1), and
// en = 1 turns t1 on (IEEE 1364-2005 §7.6). A conducting pass switch joins
// its two nets into one resolution, so each bridge's discrete side, the
// segment now on the switch, reads strong 1. The bridge drives V(el) <+ vh
// at 1 and 0 otherwise: V(a) = 0.4, V(c) = 0.9. A switch left on the analog
// node connects the wires to no bridge and both V read 0; `source` and
// `drain` swapped name `a__t1__drain` and `c__t2__source`, and the defparams
// name nothing (E0907). Checked at 10n and 20n: 2 checks x 2 points.
//
//! lrm 7.8.5.1
//! lrm 7.8.5
//! lrm 7.8.4
//! lrm 3.9
//! solve
//! analysis tran
//! time 10n, 20n
//! checks 4
`timescale 1ns/1ns
`include "check.vh"

connectmodule b5_pps_bidir(cm, el);
  inout cm;
  inout el;
  ddiscrete cm;
  electrical el;
  parameter real vh = 1.0;
  analog V(el) <+ (cm === 1'b1) ? vh : 0.0;
endmodule

`default_discipline ddiscrete
module b5_prim_connect_pass_switch;
  electrical a, c;
  wire y, w;
  reg dy, dw, en;

  assign y = dy;
  assign w = dw;
  tranif1 t1(a, y, en);
  tran t2(w, c);

  defparam a__t1__source.vh = 0.4;
  defparam c__t2__drain.vh = 0.9;

  initial begin dy = 1'b1; dw = 1'b1; en = 1'b1; end

  analog begin
    `CHECK("tranif1 t1 joins y = 1 to a__t1__source", V(a), 0.4, 1e-12);
    `CHECK("tran t2 joins w = 1 to c__t2__drain", V(c), 0.9, 1e-12);
  end
endmodule
`default_discipline

connectrules b5_pps_rules;
  connect b5_pps_bidir split;
endconnectrules
