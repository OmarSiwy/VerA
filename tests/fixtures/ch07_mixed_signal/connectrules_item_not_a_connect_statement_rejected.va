// §7.7 Syntax 7-5, the whole of what a `connectrules` block may hold:
//
//   connectrules_declaration ::=
//           connectrules connectrules_identifier ;
//               { connectrules_item }
//           endconnectrules
//   connectrules_item ::=
//           connect_insertion
//         | connect_resolution
//
// and the clause's prose says the same list in words: "The connect
// specification statements allow the designer to define: specification of
// which connect module is used ..., overrides for the connect module default
// disciplines and port directions, resolution of incompatible disciplines ...
// The two forms of the connect specification statements and their syntaxes
// are detailed in the following subclauses" — 7.7.1 (insertion) and 7.7.2
// (resolution). Both open with the keyword `connect`.
//
// A `connectrules` block is a description of the COMPILATION, not a module
// (A.1.2 lists it beside `module_declaration`, `paramset_declaration` and
// `discipline_declaration`): it declares no nets. So `wire w;` inside it is
// not a connectrules_item, and the parser has to say so where it stands rather
// than accept a declaration that nothing could ever own.
//
// The legal statement after it, `connect ch7_cr_a2d;`, is exactly
// `connectrules_accepted.va`'s, which is the positive twin and runs green.
//
//! lrm 7.7
//! lrm 7.7:1000
//! reject-only expected `connect`
//! neighbour connectrules_accepted.va
`include "disciplines.vams"
connectmodule ch7_cr_a2d(el, dg);
  input el;
  output dg;
  electrical el;
  ddiscrete dg;
  reg dg;
  initial dg = 1'b0;
  always @(cross(V(el) - 0.5, 1)) dg = 1'b1;
endmodule

module ch7_cr_host(p);
  inout p;
  electrical p;
  analog I(p) <+ V(p) / 1k;
endmodule

connectrules ch7_cr_rules;
  wire w;
  connect ch7_cr_a2d;
endconnectrules
