// §7.7.1, the first override form: "Connect modules can be reused for
// different, but compatible disciplines by specifying different discipline
// combinations in which the connect module can be used. The form is
//
//     connect connect_module_identifier connect_attributes
//             discipline_identifier , discipline_identifier ;
//
// where the specified disciplines shall be compatible for both the continuous
// and discrete disciplines of the given connect module."
//
// Syntax 7-6 spells it `connect_port_overrides ::= discipline_identifier ,
// discipline_identifier`: no direction keywords. m03_07 and m03_14 cover the
// direction forms; this file is the plain one, on a connect statement that
// must be accepted and still insert.
//
// THE OVERRIDE. `b5_cpo_a2d` is declared over (electrical in, ddiscrete out).
// The statement names `electrical` (the continuous side, compatible with
// itself) and `b5_cpo_cmos` (a natureless discrete discipline, compatible
// with `ddiscrete` by §3.11.1's Natureless Discipline Rule), so both halves
// of the "shall be compatible" requirement hold. The directions stay the
// module's own, input for the continuous port and output for the discrete
// one: the plain form gives no direction to change.
//
// THE PORT. `u1.din` is an input of discipline `b5_cpo_cmos` on the
// electrical signal `a`: upper electrical, lower b5_cpo_cmos, the a2d shape
// of §7.6 Example 2 with the overridden discrete discipline. One merged
// instance (§7.8.3 default), rin = 1 kohm.
//
// DERIVATION. 1 kohm shunt, 1 mA into `a`, one bridge of 1 kohm:
//     V/1000 - 1e-3 + V/1000 = 0   =>   V(a) = 0.5
// Nothing inserted (the statement refused or ignored) reads 1.0.
//
// WHAT THE NUMBER DOES NOT CLAIM. As m03_07 records, natureless discrete
// disciplines are all compatible with each other, so the un-overridden
// statement would bridge this port too; the override's own effect on which
// port matches is not visible here. The file pins that the plain form is
// accepted with compatible disciplines and the connect module is inserted.
//
//! lrm 7.7.1
//! lrm 7.7.1:1
//! lrm 3.11.1
//! lrm 7.6
//! lrm 7.8.4
//! solve
`include "check.vh"

discipline b5_cpo_cmos;
  domain discrete;
enddiscipline

connectmodule b5_cpo_a2d(el, cm);
  input el;
  output cm;
  electrical el;
  ddiscrete cm;
  reg cm;
  parameter real rin = 1000.0 from (0.0:inf);
  analog I(el) <+ V(el) / rin;
  initial cm = 1'b0;
endmodule

module b5_cpo_din(din);
  input din;
  b5_cpo_cmos din;
endmodule

module b5_cpo_top;
  electrical a;
  b5_cpo_din u1(a);
  analog begin
    I(a) <+ V(a) / 1000.0;
    I(a) <+ -1.0e-3;
    `CHECK("§7.7.1 `connect b5_cpo_a2d electrical, b5_cpo_cmos;` still inserts one a2d",
           V(a), 0.5, 1e-12);
  end
endmodule

connectrules b5_cpo_rules;
  connect b5_cpo_a2d electrical, b5_cpo_cmos;
endconnectrules
