// §7.2.2 contexts: "assignment statements within an initial or always block"
// are in the discrete (digital) context. This is the `initial` half of that
// sentence — the §7.3.2 `converter` example drives its discrete net exactly
// this way — and it is legal Verilog-AMS HDL.
//
// C.7 deletes it from this dialect: "No digital behavior or events are
// supported in Verilog-A". So the block is an unsupported module item (E0205)
// and refusing it is conformance. digital_always_unsupported.va is the other
// half.
//
//! lrm 7.2.2
//! lrm C.7
//! reject E0205
module ch7_digital_initial;
  integer state;
  initial begin state = 1; end
endmodule
