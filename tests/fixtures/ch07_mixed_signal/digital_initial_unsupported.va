//! lrm 7.2.2
//! lrm C.7
//! reject E0205
// EXPECT: error -- a digital initial process needs the digital backend.
module ch7_digital_initial;
  integer state;
  initial begin state = 1; end
endmodule
