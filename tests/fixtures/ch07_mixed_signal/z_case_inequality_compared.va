// §7.3.2 lists "the case inequality operator (!==)" as one of the four features
// Verilog-AMS HDL provides for "accessing of 4-state logic values within the
// analog context". Its `a2d` example uses the positive form on the z bit —
// "else if (dnet === 1'bz) avar = 2.5; // high impedance - float value" — and
// `!==` is that same test negated.
//
// This file used to be `z_case_inequality_unsupported.va` and demanded E0130
// on Annex C.3/C.5 grounds, the Verilog-A SUBSET's rules. VerA targets
// Verilog-AMS and this module is the mixed-signal context, so the refusal is
// withdrawn. A digital driver replaces the old undriven `input d; wire d;`.
//
// DERIVATION, `timescale 1ns/1ns`, IEEE 1364 §5.1.8 (`!==` never x):
//
//   [0, 20n)   d = 1   d !== 1'bz is 1   result 1.0
//   [20n, 40n) d = x   d !== 1'bz is 1   result 1.0   (x is not z)
//   [40n, 60n) d = z   d !== 1'bz is 0   result 0.0
//   [60n, ..)  d = 0   d !== 1'bz is 1   result 1.0   (0 is not z)
//
// Value bits alone read z as 0, so a tool comparing them reads 0.0 at 70n.
//
//! lrm 7.3.2
//! lrm C.3
//! lrm 7.3.2:1
//! analysis tran
//! time 0, 10n, 30n, 50n, 70n
`timescale 1ns/1ns
`include "check.vh"
module ch7_z_case_inequality(p);
  inout p; electrical p; reg d; real result;
  initial begin
    d = 1'b1;
    #20 d = 1'bx;
    #20 d = 1'bz;
    #20 d = 1'b0;
  end
  analog begin
    result = (d !== 1'bz) ? 1.0 : 0.0;
    `CHECKEQ("§7.3.2 !== is false on the z state only", result,
             ($abstime >= 40n && $abstime < 60n) ? 0.0 : 1.0, 0.0);
    I(p) <+ V(p) + result;
  end
endmodule
