// §7.4.4.1 basic discipline resolution: "At each level of the hierarchy where
// continuous and discrete meet for an undeclared net that net segment is
// declared continuous." The clause's own worked example says it twice — "NetC
// resolves to electrical based on continuous (electrical) winning over discrete
// (cmos2)".
//
// `shared` is undeclared and meets a discrete discipline (child1) and a
// continuous one (child2). THE COMPILE IS THE TEST: if resolution picked the
// discrete candidate, `shared` has no potential nature, `V` is not one of its
// access functions, and the module is refused with E0501 — which is what
// happened while `resolveDiscipline` kept the first declared segment and the
// discrete child is instantiated first. The assertion below then only has to
// read the net back to prove it is a solver unknown a continuous access
// function reaches; the harness pins its value, so the digit is the harness's
// and the claim is the access.
//
// Ordering is load-bearing and deliberate: child1 (discrete) is instantiated
// BEFORE child2 (continuous), so a first-wins resolution cannot pass by luck.
//
//! lrm 7.4.4.1
//! bias V(shared) = 0.5
`include "check.vh"
discipline ch7441_discrete;
  domain discrete;
enddiscipline
module ch7441_discrete_child(port);
  inout port; ch7441_discrete port;
endmodule
module ch7441_electrical_child(port);
  inout port; electrical port;
endmodule
module ch7441_parent;
  // `shared` is undeclared; it meets discrete (child1) and electrical (child2)
  // at this level. Resolution must make it electrical.
  ch7441_discrete_child child1(shared);
  ch7441_electrical_child child2(shared);
  analog begin
    `CHECKX("undeclared net where continuous meets discrete resolves to continuous", V(shared), 0.5);
    I(shared) <+ V(shared);
  end
endmodule
