// §7.3.2 "Verilog-AMS HDL supports accessing of 4-state logic values within the
// analog context. ... The language supports the following specific features ...
// the case equality operator ( === ) the case inequality operator ( !== )".
//
// THIS FILE USED TO DEMAND A REJECTION (E0323) on annex C.5, which removes both
// operators from the Verilog-A SUBSET only. §7.3.2 is the full-AMS rule and it
// names them as supported, so a conforming AMS compiler must accept this module:
// the verdict is inverted, as annex_c_analog_subset/10_case_equality_accepted.va
// explains. The x/z halves of §7.3.2 (x/z digits, a four-state net read) are
// still refused, and x_case_equality_unsupported.va and
// z_case_inequality_unsupported.va pin those at E0130.
//
// THE VALUE, by hand. `state` is assigned 2, every bit two-state, so IEEE 1364
// §5.1.8's `===`/`!==` are `==`/`!=`: `state === 1` is 0, `state !== 0` is 1,
// and the if-else chain takes its middle arm, result = 0.5.
//
//! lrm 7.3.2
//! bias V(p) = 0
`include "check.vh"
module ch7_case_equality(p);
  inout p; electrical p; integer state; real result;
  analog begin
    state = 2;
    if (state === 1) result = 1.0;
    else if (state !== 0) result = 0.5;
    else result = 0.0;
    `CHECK("state = 2 takes the (state !== 0) arm", result, 0.5, 0);
    I(p) <+ result + 0.0*V(p);
  end
endmodule
