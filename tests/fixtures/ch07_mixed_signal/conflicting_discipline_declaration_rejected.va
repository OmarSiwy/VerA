// §7.4.4 resolution of mixed signals: "More than one conflicting discipline
// declaration from the same context (in or out of context) for the same
// hierarchical segment of a signal is an error. In this case, conflicting
// simply means an attempt to declare more than one discipline regardless of
// whether the disciplines are compatible or not."
//
// "Regardless of compatibility" is the whole clause, and it is what separates
// this file from incompatible_disciplines_rejected.va. ch7_conf_a and
// ch7_conf_b name the very same potential and flow natures, so they ARE
// compatible by the §3.11 Self Rule — and declaring `w` with both is still an
// error. A tool that only checked compatibility would accept this file, which
// is exactly the mistake the fixture is here to catch.
//
// One module, one net name, two declarations from the same context: no
// hierarchy and no elaborator are needed to provoke it.
//
//! lrm 7.4.4
//! lrm 3.11
//! reject more than one discipline declaration
//! xfail VerA has no redeclaration-of-discipline diagnostic; the second declaration silently overwrites the first
nature ch7_conf_potential;
  units = "V";
  access = V;
  abstol = 1u;
endnature
nature ch7_conf_flow;
  units = "A";
  access = I;
  abstol = 1p;
endnature
discipline ch7_conf_a;
  potential ch7_conf_potential;
  flow ch7_conf_flow;
enddiscipline
discipline ch7_conf_b;
  potential ch7_conf_potential;
  flow ch7_conf_flow;
enddiscipline
module ch7_conflicting(p);
  inout p; ch7_conf_a p;
  ch7_conf_a w;
  ch7_conf_b w;
  analog I(p) <+ 0.001 * V(p, w);
endmodule
