// §10.2 `default_discipline. Syntax 10-1 makes the discipline_identifier
// OPTIONAL:
//
//   default_discipline_directive ::= `default_discipline [ discipline_identifier
//                                    [ qualifier ] ]
//
// so the bare form is legal and ends the region opened by the preceding
// `default_discipline electrical — the directive applies "until either the end
// of the text stream or another `default_discipline directive with the qualifier
// (if applicable) is found".
//
// The reset itself has no numeric consequence HERE, and deliberately so: p and n
// carry explicit `electrical` declarations, and §10.2 only applies the default
// "to all discrete signals WITHOUT a discipline declaration". What that makes
// checkable is the negative — the reset must not retroactively strip the
// disciplines already declared. If it did, p and n would have no nature and no
// potential access function, and the value below would not exist. §1.3.1 fixes
// it at 0.75 - 0.25 = 0.5 V.
//
//! lrm 10.2
//! bias V(p) = 0.75, V(n) = 0.25
`default_discipline electrical
`default_discipline
`include "check.vh"
module ch10_default_discipline_empty_reset(p, n);
  inout p, n; electrical p, n;
  analog begin
    `CHECK("the reset leaves the explicitly declared electrical ports intact", V(p,n), 0.5, 1e-15);
    I(p,n) <+ V(p,n);
  end
endmodule
