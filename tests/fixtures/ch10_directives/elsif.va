// IEEE Std 1364 §19.4 `elsif: the arms are tried in order and exactly ONE is
// compiled. FIRST_CHOICE is not defined and SECOND_CHOICE is, so the `elsif arm
// wins and both the first arm and the `else are deleted. The module contributes
// 2.0*V(p,n).
//
// Each arm asserts its own coefficient against the value the surviving arm must
// produce: 2.0*0.5 = 1.0 at V(p,n) = 0.5. The three coefficients 1.0, 2.0, 3.0
// give three different products, so the digit names which arm compiled.
//
//! lrm 10.1
//! bias V(p) = 0.5
`define SECOND_CHOICE
`include "check.vh"
module ch10_elsif(p, n);
  inout p, n; electrical p, n;
  analog begin
`ifdef FIRST_CHOICE
    I(p,n) <+ V(p,n);
    `CHECKX("FIRST_CHOICE is not defined, this arm must be deleted", 1.0*V(p,n), 1.0);
`elsif SECOND_CHOICE
    I(p,n) <+ 2.0*V(p,n);
    `CHECKX("the elsif arm is the one that compiles", 2.0*V(p,n), 1.0);
`else
    I(p,n) <+ 3.0*V(p,n);
    `CHECKX("the else arm must be deleted once an elsif matched", 3.0*V(p,n), 1.0);
`endif
  end
endmodule
