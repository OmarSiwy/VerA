// IEEE 1364-2005 §19.5 (taken whole by VAMS §10.1): "The filename can be a full
// or relative path name." Neither standard says what a relative name is
// relative to. VerA's reading (specification/Vague_Decisions.md VD-091,
// specification/Vague_Decisions.md): the directory of the file that holds the
// `include first, then each -I directory in order, then the built-in annex D
// headers.
//
// The fixture runner passes -I tests/fixtures -I tests/fixtures/ch10_directives.
// include_dir/vd091_outer.vh includes two names:
//   "vd091_nested_only.vh" exists only in include_dir/, which no -I names, so
//     only the including file's directory can find it: VD091_NESTED = 3.
//   "vd091_inner.vh" exists in include_dir/ (VD091_PICKED 2) and in
//     ch10_directives/ (VD091_PICKED 1, on the -I path). The including file's
//     directory is searched first, so VD091_PICKED = 2.
// A tool that searched only -I would refuse the nested include (E0126 in
// VerA); one that searched -I first would read 1.
//
// Legal-neighbour pair: include_including_dir_is_per_file_rejected.va names
// vd091_nested_only.vh from THIS directory, where it does not exist.
//! lrm 10.1
//! inherited IEEE 1364-2005 19.5
//! nowarn
//! checks 2
`include "check.vh"
`include "include_dir/vd091_outer.vh"
module include_searches_the_including_files_directory(p, n);
  inout p, n; electrical p, n;
  analog begin
    `CHECKI("a nested include is found beside its includer", `VD091_NESTED, 3);
    `CHECKI("the includer's directory comes before -I", `VD091_PICKED, 2);
    I(p, n) <+ V(p, n);
  end
endmodule
