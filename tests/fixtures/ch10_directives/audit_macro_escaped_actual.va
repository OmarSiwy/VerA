// VAMS 10.4 inherits IEEE 1364-2005 19.3.1 (physical pages 380-382):
// each formal is replaced literally by the complete actual expression.
// IEEE 3.7.1 (physical page 44), also VAMS 2.8.1, makes whitespace terminate
// an escaped identifier. The space before ')' below is required: deleting
// it merges ')' into the escaped name instead of substituting the expression.
// AUDIT_ID contributes parentheses but no whitespace after its formal, so
// the actual's lexical boundary must survive expansion. A simple actual is
// the legal control case. Both independent assignments use exactly 7.0.
// The assertion macro sees only plain identifiers, isolating AUDIT_ID.
// KEY-MACRO-001: current actual-argument trimming destroys that boundary.
//! lrm 10.4
//! lrm 2.8.1
//! checks 2
//! xfail KEY-MACRO-001: macro actual trimming loses escaped-identifier terminator
`include "check.vh"
`include "disciplines.vams"
`define AUDIT_ID(ARG) (ARG)
module audit_macro_escaped_actual(p);
  inout p; electrical p;
  real plain, \audit.value , simple_result, escaped_result;
  analog begin
    plain = 7.0;
    \audit.value = 7.0;
    simple_result = `AUDIT_ID(plain);
    escaped_result = `AUDIT_ID(\audit.value );
    `CHECKX("simple actual", simple_result, 7.0);
    `CHECKX("escaped actual", escaped_result, 7.0);
    I(p) <+ V(p);
  end
endmodule
