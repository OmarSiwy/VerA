// §10.4: "The `define and `undef compiler directives are described in IEEE Std
// 1364 Verilog." IEEE 1364-2005 §19.3.1, physical page 350: "All compiler
// directives shall be considered predefined macro names; it shall be illegal
// to redefine a compiler directive as a macro name." Its closing list says it
// again: "a) Text macro names may not be the same as compiler directive
// keywords."
//
// §10.1 Table 10-1 lists `include as a Verilog-AMS compiler directive, so
// `define include ... is illegal source. (The same table lists `__FILE__ and
// `__LINE__, which the rule covers too.) The body is a harmless number so that
// the only thing wrong with this file is the name.
//
// E0143 is VerA's code for this rule.
//
//! lrm 10.4
//! lrm 10.1
//! reject-only E0143
`define include 1
`include "disciplines.vams"
module ch10_directive_name_is_not_a_macro_name(p, n);
  inout p, n; electrical p, n;
  analog I(p, n) <+ V(p, n);
endmodule
