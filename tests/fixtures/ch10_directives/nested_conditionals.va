// IEEE Std 1364 §19.4 conditionals nest, and each `endif closes the nearest
// open `ifdef. OUTER_ON and INNER_ON are both defined, so the inner true arm is
// the only surviving text and the module contributes 6.0*V(p,n).
//
// Each arm asserts its own coefficient against the value the surviving arm must
// produce: 6.0*0.5 = 3.0 at V(p,n) = 0.5. The three coefficients 6.0, 2.0 and
// 1.0 give three different products, so a mis-paired `else or `endif — the
// failure mode nesting has — shows up as a different number, not as silence.
//
//! lrm 10.1
//! bias V(p) = 0.5
`define OUTER_ON
`define INNER_ON
`include "check.vh"
module ch10_nested_conditionals(p, n);
  inout p, n; electrical p, n;
  analog begin
`ifdef OUTER_ON
`ifdef INNER_ON
    I(p,n) <+ 6.0*V(p,n);
    `CHECKX("both guards defined: the inner true arm compiles", 6.0*V(p,n), 3.0);
`else
    I(p,n) <+ 2.0*V(p,n);
    `CHECKX("INNER_ON is defined, this inner else must be deleted", 2.0*V(p,n), 3.0);
`endif
`else
    I(p,n) <+ V(p,n);
    `CHECKX("OUTER_ON is defined, this outer else must be deleted", 1.0*V(p,n), 3.0);
`endif
  end
endmodule
