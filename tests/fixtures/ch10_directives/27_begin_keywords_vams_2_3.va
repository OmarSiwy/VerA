// LRM 10.6 worked example: under a VAMS keyword set sin is reserved (Annex B),
// so using it as a port name "shall result in an error". Pinned on the identifier
// only -- begin_keywords support is landing concurrently and will reword the message.
//! reject sin
// EXPECT: error
// LRM 10.6: under a VAMS keyword set sin is a reserved keyword (Annex B), so a port named sin shall result in an error.
`begin_keywords "VAMS-2.3"
module ch10_begin_keywords_vams_2_3(sin, n);
  inout sin, n; electrical sin, n;
  analog I(sin,n) <+ V(sin,n);
endmodule
`end_keywords
