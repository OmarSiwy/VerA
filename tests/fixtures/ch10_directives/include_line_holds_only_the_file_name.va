// §10.1 Table 10-1 takes `include from IEEE Std 1364 Verilog. IEEE 1364-2005
// §19.5, physical page 356, Syntax 19-6 is
//
//     include_compiler_directive ::= `include "filename"
//
// and the clause adds: "Only white space or a comment may appear on the same
// line as the `include compiler directive." Its own examples include
// `include "fileB" // including fileB, which is the legal trailing form.
//
// Below, an identifier follows the file name on the directive's line. That is
// neither white space nor a comment, so the file is illegal. It used to be
// accepted with the word silently dropped, so a module header written on that
// line vanished without a message.
//
// E0144 is VerA's code for this rule.
//
//! lrm 10.1
//! reject-only E0144
`include "disciplines.vams" stray_word
module ch10_include_line_holds_only_the_file_name(p, n);
  inout p, n; electrical p, n;
  analog I(p, n) <+ V(p, n);
endmodule
