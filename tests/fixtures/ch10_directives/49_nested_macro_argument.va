// §10.4 hands text macros to IEEE Std 1364, whose recursion rule is a property
// of the DEFINITION: a macro whose TEXT refers to itself, directly or through
// another macro, has no fixed point and is refused. `MAX`'s text below refers
// only to its two formals. The nested use sits at the CALL SITE, inside an
// actual argument, and the substitution model 1364 transcribes from the C
// preprocessor expands each actual FULLY before it is substituted — so by the
// time `MAX`'s own text is rescanned, the inner invocation is already the
// ternary it expands to and no name is met twice.
//
// This is not a corner: nested MIN/MAX/clamp is stock in PDK headers
// (`MAX(`MIN(x,hi),lo) is the canonical clamp), and a preprocessor that
// splices the RAW argument text into the body and rescans it while the outer
// name is still on its cycle guard reports "recursive macro expansion" for
// source every mainstream tool accepts. VerA did exactly that — E0118 with the
// chain "MAX -> MAX" — which is why the digit below is written into a
// contribution and not merely echoed.
//
// The value: `MAX(`MAX(1.0,2.0),3.0) -> max(max(1.0,2.0),3.0) = 3.0, exact in
// binary64 (all three operands and every compare are exact). Only the OUTER
// call gives 3.0 from a wrong inner result of 2.0 too — so the second check
// nests the other way, `MAX(3.0,`MAX(1.0,2.0)) with the nested call in the
// SECOND argument, and a tool that mis-slices the argument list on the inner
// commas fails one of the two.
//
// Genuine self-reference in the TEXT is still an error — the reject half of
// this rule lives in the unit suite (E0118 on `define R `R and on a mutually
// recursive pair), so this file only has to pin the accept half.
//
//! lrm 10.4
//! bias V(p) = 0.5
`define MAX(a,b) ((a)>(b)?(a):(b))
`include "check.vh"
module ch10_nested_macro_argument(p, n);
  inout p, n; electrical p, n;
  analog begin
    `CHECKX("a nested `MAX in the first actual argument expands, not E0118",
            `MAX(`MAX(1.0,2.0),3.0), 3.0);
    `CHECKX("and in the second actual argument, across the top-level comma",
            `MAX(3.0,`MAX(1.0,2.0)), 3.0);
    I(p,n) <+ `MAX(`MAX(1.0,2.0),3.0)*V(p,n);
  end
endmodule
