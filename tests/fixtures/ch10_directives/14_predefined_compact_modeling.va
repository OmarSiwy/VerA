// §10.5: `__VAMS_COMPACT_MODELING__` is defined "if and only if all the compact
// modeling extensions are supported by the simulator". Whether it is defined is
// therefore an implementation fact and NOT something this fixture may assert.
// What the LRM does pin is the arm that gets compiled when it is defined: the
// value of ddx().
//
// §4.5.6 worked example (the `vccs` module), verbatim: for vin = V(pin,nin),
//   ddx(vin, V(pin)) is +1, ddx(vin, V(nin)) is -1, ddx(vin, V(pout)) is 0.
// Here the expression is V(p,n) = V(p) - V(n), so d/dV(p) is exactly +1 and
// d/dV(n) is exactly -1. The sign check is the restricting half: a lowering
// that dropped the negation on the reference node passes the first and fails
// the second.
//
// The operating point is nonzero so that a ddx() that merely passed its first
// argument through would report 0.5 rather than 1.
//
//! bias V(p) = 0.75, V(n) = 0.25
`include "check.vh"
module ch10_predefined_compact_modeling(p, n);
  inout p, n; electrical p, n;
  analog begin
    `CHECK("the differentiated expression is nonzero", V(p,n), 0.5, 1e-15);
`ifdef __VAMS_COMPACT_MODELING__
    `CHECKX("ddx(V(p,n), V(p)) is +1", ddx(V(p,n), V(p)), 1.0);
    `CHECKX("ddx(V(p,n), V(n)) is -1", ddx(V(p,n), V(n)), -1.0);
    I(p,n) <+ ddx(V(p,n), V(p));
`else
    `CHECKX("without the extensions the model is the plain resistor", 2.0*V(p,n), 1.0);
    I(p,n) <+ V(p,n);
`endif
  end
endmodule
