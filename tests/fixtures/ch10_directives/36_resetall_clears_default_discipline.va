// §10.2 opens its reset sentence with "In addition to `resetall, ...", which
// makes `resetall the second way — and the only one chapter 10 names — to
// withdraw the default discipline: after it, "discipline resolution will not
// use a default discipline for nets declared after this directive is
// encountered in the text stream".
//
// This is 35 with `resetall in place of the bare `default_discipline. Both
// arms are needed because they are separate mechanisms in any implementation:
// one is the directive resetting itself, the other is the global reset sweeping
// it away with everything else, and a table that is cleared by one is not
// necessarily cleared by the other.
//
// Note what is NOT claimed here. `resetall appears exactly twice in the whole
// LRM — the §10.1 table row and this sentence — and neither says it undefines a
// text macro; the deleted 20_resetall_clears_macro asserted that and a
// conforming tool failed it. §10.5's "shall always be defined" says the
// opposite for the predefined macros, and 28 pins that.
//
// As in 35: with the `default_discipline electrical below still in force this
// module compiles and V(p,n) resolves (01); with `resetall between them it must
// not.
//
// Cites and expectation follow 35 for the same reasons: §10.2 only withdraws
// the default, so §7.4 (discipline resolution) and §3.6.1 (an access function
// comes from a nature, reached through the net's discipline) are the clauses
// that make V(p,n) an error, and E0501 "unknown access function" is the code
// that says so. The bare word "discipline" is not usable as the expectation —
// it occurs inside `default_discipline, which this file contains, so any
// diagnostic quoting the directive would XPASS this xfail without the rule
// being implemented at all.
//
//! lrm 10.2
//! lrm 7.4
//! lrm 3.6.1
//! reject E0501
//! xfail The RULE now fires — `resetall clears the default and VerA rejects this module — but with E0337 "net has no declared discipline" rather than the E0501 guessed above, so the substring does not match. Same open question as 35
`default_discipline electrical
`resetall
module ch10_resetall_clears_default_discipline(p, n);
  inout p, n;
  analog I(p, n) <+ V(p, n);
endmodule
