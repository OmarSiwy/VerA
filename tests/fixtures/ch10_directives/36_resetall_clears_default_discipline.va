// §10.2 opens its reset sentence with "In addition to `resetall, ...", which
// makes `resetall the second way — and the only one chapter 10 names — to
// withdraw the default discipline: after it, "discipline resolution will not
// use a default discipline for nets declared after this directive is
// encountered in the text stream".
//
// This is 35 with `resetall in place of the bare `default_discipline. Both
// arms are needed because they are separate mechanisms in any implementation:
// one is the directive resetting itself, the other is the global reset sweeping
// it away with everything else, and a table that is cleared by one is not
// necessarily cleared by the other.
//
// Note what is NOT claimed here. `resetall appears exactly twice in the whole
// LRM — the §10.1 table row and this sentence — and neither says it undefines a
// text macro; the deleted 20_resetall_clears_macro asserted that and a
// conforming tool failed it. §10.5's "shall always be defined" says the
// opposite for the predefined macros, and 28 pins that.
//
// As in 35: with the `default_discipline electrical below still in force this
// module compiles and V(p,n) resolves (01); with `resetall between them it must
// not. The expectation is a message substring because VerA has no code for an
// undisciplined net yet — any diagnostic about this rule will say "discipline".
//
//! lrm 10.2
//! reject discipline
//! xfail VerA discards `default_discipline and `resetall in the preprocessor and never runs discipline resolution, so it has no default to clear — V() resolves on a bare port regardless
`default_discipline electrical
`resetall
module ch10_resetall_clears_default_discipline(p, n);
  inout p, n;
  analog I(p, n) <+ V(p, n);
endmodule
