// §10.4 a macro text may itself use a macro: OUTER's body names INNER, which is
// expanded in turn when OUTER is used, with OUTER's actual argument carried
// through to INNER's formal.
//
//   `OUTER(x) -> (`INNER(x) + (x)) -> (((x)*(x)) + (x)) = x*x + x
//
// At x = V(p,n) = 0.5 that is 0.25 + 0.5 = 0.75, exactly. Only the inner square
// would give 0.25 and only the outer sum 1.0, so the digit pins that both
// levels ran, in that order.
//
//! lrm 10.4
//! bias V(p) = 0.5
`define INNER(x) ((x)*(x))
`define OUTER(x) (`INNER(x) + (x))
`include "check.vh"
module ch10_nested_macros(p, n);
  inout p, n; electrical p, n;
  analog begin
    `CHECKX("the nested macro in the body is expanded too", `OUTER(V(p,n)), 0.75);
    I(p,n) <+ `OUTER(V(p,n));
  end
endmodule
