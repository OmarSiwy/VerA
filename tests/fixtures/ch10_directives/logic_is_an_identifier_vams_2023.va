// §10.6's third worked example carries a note about the other side of the
// keyword set: "Note that the word "logic" is not a keyword in Verilog-AMS
// 2023, whereas it is a keyword in the IEEE Std 1800 SystemVerilog." §10.6
// makes that exhaustive — under "VAMS-2023" "only the identifiers listed as
// reserved keywords in the Verilog-AMS HDL are considered to be reserved words.
// These identifiers are listed in Annex B" — and logic is not in Annex B.
//
// Every other keyword-set fixture tests the set from the forbidden side: 17 and
// 27 require `sin` to be rejected, 32 requires an unknown specifier to be
// rejected. Nothing required the set not to be OVER-broad, and the compiler
// most likely to be over-broad is the plausible real one — a Verilog-AMS front
// end grown on a SystemVerilog parser, which reserves `logic` and fails this
// file while passing all of §10.6's negatives.
//
// The assertion is that logic DENOTES the variable and nothing else: at
// V(p,n) = 0.75 - 0.25 = 0.5 V (§1.3.1), 2.5 * 0.5 = 1.25, exact in binary
// because both operands are. Legality alone would not be an assertion, and a
// bare `CHECKX on the variable would not tell a declared identifier apart from
// a keyword the parser silently swallowed.
//
// The LRM's example spells the DISCIPLINE `\logic` with an escape; the plain
// identifier is the cheap and unambiguous half of the same note, and does not
// drag §2.7.1 escaped identifiers into a chapter-10 fixture.
//
// WHAT THIS FIXTURE ASSUMES. Annex D.1's disciplines.vams declares
// `discipline \logic;`, and §2.7.1 makes `\logic ` and `logic` the same
// identifier, so on a tool that supplies the standard disciplines implicitly
// the name is already bound at global scope (§3.13.1: natures and disciplines
// "have a global scope"). What is declared below is a module-scope real
// VARIABLE, in a different scope and a different namespace from the global
// discipline, and the LRM's own §10.6 example has both live at once — it
// declares the discipline and then writes plain `logic dnet;`. A tool that
// refuses to let a module-local name shadow a standard discipline would fail
// this file; that is a §3.13.1 name-resolution question the cited note does
// not reach, and the note's actual claim — that the WORD is not reserved — is
// what is under test. Nothing here uses `logic` in net-declaration position,
// where the discipline, not the variable, is what the name would mean.
//
//! lrm 10.6
//! lrm 10.6:1003
//! bias V(p) = 0.75, V(n) = 0.25
`begin_keywords "VAMS-2023"
`include "check.vh"
module ch10_logic_is_an_identifier_vams_2023(p, n);
  inout p, n; electrical p, n;
  real logic;
  analog begin
    logic = 2.5;
    `CHECKX("logic is an ordinary identifier under VAMS-2023", logic*V(p,n), 1.25);
    I(p,n) <+ logic*V(p,n);
  end
endmodule
`end_keywords
