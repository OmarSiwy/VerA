// WHAT THIS PINS. `assert` is not a keyword of Verilog-AMS 2023, so a port, a
// net or a variable may be named `assert` and a compiler must take it. This
// file names a port and a net `assert` and reads the potential across it.
//
// The chain is short and every link is normative:
//
//   §2.8.2 Keywords: "Keywords are predefined simple identifiers which are used
//   to define the language constructs. A Verilog-AMS HDL keyword preceded by an
//   escape character is not interpreted as a keyword. All keywords are defined
//   in lowercase only. Annex B lists all defined Verilog-AMS HDL keywords."
//
//   §10.6: "The version_specifier, "VAMS-2023" specifies that only the
//   identifiers listed as reserved keywords in the Verilog-AMS HDL are
//   considered to be reserved words. These identifiers are listed in Annex B."
//
//   Annex B, opening paragraph: "Keywords are predefined nonescaped identifiers
//   that define Verilog-AMS language constructs. An escaped identifier shall
//   not be treated as a keyword. Verilog-AMS reserves the keywords listed in
//   Table B.1."
//
// The reservation is Table B.1 and nothing else, so the list is CLOSED, and
// `assert` is not in it. It would sit between `asinh` and `assign` if it were;
// it is in neither the 2023 source PDF nor this repository's corrected
// docs/annex-b-keywords.html.
//
// THE LRM MAKES THE SAME POINT ABOUT A WORD OF THE SAME PEDIGREE, in §10.6's
// last worked example: "Note that the word "logic" is not a keyword in
// Verilog-AMS 2023, whereas it is a keyword in the IEEE Std 1800
// SystemVerilog." `assert` is a SystemVerilog word of exactly that shape. The
// standard does not reserve a spelling because 1800 uses it, and a tool that
// reserves one has invented a keyword set rather than read one.
//
// WHY THE `begin_keywords "VAMS-2023" WRAPPER. §10.6: for a module with no
// directive above it, "the set of reserved keywords in effect for this module
// shall be the implementation's default set of reserved keywords." Leaving the
// set unnamed would let the file pass for an implementation whose default is
// 1364-2005 — where `assert` is free for a reason that has nothing to do with
// this claim — and fail for one whose default is VAMS-2.3. Naming the set
// removes both escapes: the file compiles if and only if the VAMS-2023 keyword
// set really is the Annex B list, which is the whole claim.
// 02_begin_keywords_region_survives_the_include_that_opened_it.va makes the
// same argument at length.
//
// WHAT IT REPLACES. tests/fixtures/annex_b_keywords/13_assert_reserved.va
// asserted the opposite — `//! reject assert` against a `real assert;` — and
// justified it by "the 2.4.0 printing (page 395, between `asinh` and `assign`)"
// plus the observation that "Verilog-AMS 2.4 gives it no statement, no system
// function and no production in Annex A". That last sentence is an argument
// AGAINST reserving it, not for: the 2.4 list carried the word as debris from a
// SystemVerilog-influenced draft, the 2023 edition does not carry it, and a
// keyword set built by accumulating every list a standard has ever printed
// drifts from the standard it claims to implement. It is the same shape as
// `net_resolution` in 13_net_resolution_is_an_ordinary_identifier.va.
//
// THE ORACLE. §1.3.1: the branch potential is the difference of the two node
// potentials, 1.25 - 0.25 = 1.0 V, both operands binary-exact, so CHECKX and
// not a tolerance. `assert` is an ordinary net name and the assertion is that
// reading it as one gave the ordinary answer.
//
// STATUS. VerA reserves the spelling under its VAMS-2023 set and refuses the
// port before it ever sees the analog block:
//
//   error[E0208]: expected an identifier: found assert
//     = note: LRM 2.8
//
// which is the compiler contradicting the clause it cites: §2.8.2 is the
// sentence that makes Annex B the whole list, and Annex B does not have this
// word. The reservation is specific to the AMS sets and not to the name's
// syntax — the identical module under `begin_keywords "1364-2005"` compiles
// today — so the defect is one table entry, not a parsing problem.
//
// The harness's own label for this file today is `did not compile: NoModule`
// rather than `CompileFailed`, and that is the location of the check rather than
// a second problem: the reservation is enforced in the PARSER, so the port list
// never becomes a module declaration and elaboration has nothing to select. The
// E0208 above is the diagnostic; `NoModule` is only the phase that gave up.

//! lrm 10.6
//! lrm 2.8.2
//! lrm B
//! bias V(assert) = 1.25, V(n) = 0.25
`begin_keywords "VAMS-2023"
`include "check.vh"
module d10_assert_is_an_ordinary_identifier(assert, n);
  inout assert, n;
  electrical assert, n;

  analog begin
    `CHECKX("`assert` names an ordinary net under the VAMS-2023 keyword set",
            V(assert, n), 1.0);
    I(assert, n) <+ V(assert, n);
  end
endmodule
`end_keywords
