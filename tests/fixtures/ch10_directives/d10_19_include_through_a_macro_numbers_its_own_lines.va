// §10.7: "An `include directive changes the expansions of `__FILE__ and
// `__LINE__ to correspond to the included file. At the end of that file, when
// processing resumes on the input file that contained the `include directive,
// the expansions of `__FILE__ and `__LINE__ revert to the values they had
// before the `include (but `__LINE__ is then incremented by one as processing
// moves to the line after the `include)."
//
// Here the `include is not written in this file: it is the text of the macro
// PROBE, and the use `PROBE is what puts it in the text stream. IEEE 1364
// §19.3.1 makes an expansion part of the text stream like any other text, so
// the clause applies unchanged. d10_19_line_probe.vh's `__LINE__ sits on that
// file's line 3, so probe_line is 3. The `__LINE__ on the line after `PROBE
// is that line's number in this file, 28, counted by hand from the top.
//
// VerA used to read the probe's line through the macro's invocation offset,
// which indexes this file and not the probe, and reported 4.
//
//! lrm 10.7
//! xfail an `include reached through a macro expansion numbers its lines from the invocation site
`include "check.vh"
`define PROBE `include "d10_19_line_probe.vh"
module d10_19_include_through_a_macro_numbers_its_own_lines(p, n);
  inout p, n; electrical p, n;
  integer probe_line, after_line;
  analog begin
    probe_line = 0;
    `PROBE
    after_line = `__LINE__;
    `CHECKI("`__LINE__ in a file included through a macro is that file's line", probe_line, 3);
    `CHECKI("after it, this file's own line again", after_line, 28);
    I(p, n) <+ V(p, n);
  end
endmodule
