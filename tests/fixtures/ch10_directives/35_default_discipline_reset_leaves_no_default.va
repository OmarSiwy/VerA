// §10.2, the sentence with teeth: "In addition to `resetall, if this directive
// is used without a discipline name, discipline resolution will not use a
// default discipline for nets declared after this directive is encountered in
// the text stream."
//
// 24 issues the bare form too, but then declares both nets `electrical`
// explicitly, so all it can check is that the reset is not retroactive — its
// own header says the reset "has no numeric consequence HERE, and deliberately
// so". The consequence the LRM does fix is negative and needs an UNDECLARED
// net to land on: after the bare directive, discipline resolution supplies
// nothing, the net has no nature, and a nature's access function has nothing to
// resolve against. So V() on it is not a value that comes out wrong — it is a
// name that does not exist.
//
// The pairing is what makes this a test of the RESET and not of ports in
// general: 01 is this same shape with `default_discipline electrical still in
// force, where V(p,n) resolves and reads 0.5. Delete the bare directive from
// this file and it must compile; leave it in and it must not.
//
// The clause that turns the withdrawn default into a DIAGNOSTIC is not in
// chapter 10 — §10.2 only stops supplying one — so this fixture cites the two
// that do. §7.4 is discipline resolution, which §10.2 names outright and which
// now has nothing to resolve; §3.6.1 is where an access function comes from,
// "the `access` attribute of a nature", reached through the net's discipline.
// With no discipline there is no nature and V is not an access function of
// this net, which is E0501's exact subject.
//
// The expectation was the bare word "discipline" until a review pointed out
// that the word occurs inside `default_discipline itself, so any diagnostic
// that merely quoted the offending directive satisfied it and this xfail could
// have XPASSed without the rule ever being implemented. E0501 cannot be
// matched that way. It is a guess at WHICH code VerA will use, and a wrong
// guess is harmless here: an unmatched substring on an xfail fixture stays
// XFAIL, so the failure mode is a debt left standing, not a debt laundered.
//
//! lrm 10.2
//! lrm 7.4
//! lrm 3.6.1
//! reject E0501
//! xfail The RULE now fires — VerA withdraws the default and rejects this module — but with E0337 "net has no declared discipline" rather than the E0501 guessed above, so the substring does not match. Changing the expectation is a fixture decision, not a compiler one; 41 shows the same E0337 is what VerA prints for a net §7.4 resolved nothing onto
`default_discipline electrical
`default_discipline
module ch10_default_discipline_reset_leaves_no_default(p, n);
  inout p, n;
  analog I(p, n) <+ V(p, n);
endmodule
