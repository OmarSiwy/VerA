// IEEE 1364-2005 19.3.1, physical pages 380-382, inherited by VAMS 10.4:
// an empty macro is defined but contributes no text; a trailing // comment
// is not substituted. Definition parentheses must immediately follow the
// name for a function macro, while invocation permits intervening whitespace.
// The object macro's separating space leaves (2+3) as its body. Both it and
// the spaced function invocation yield 5. Empty+comment expansion yields 6.
// A plain variable may be named define independently of the directive name.
//! lrm 10.4
//! checks 4
`include "check.vh"
`include "disciplines.vams"
`define AUDIT_EMPTY
`define AUDIT_THREE 3.0 // this must not swallow the following expression
`define AUDIT_OBJECT (2.0 + 3.0)
`define AUDIT_SUM(A,B) ((A)+(B))
module audit_macro_empty_and_spacing(p);
  inout p; electrical p;
  real define, object_value, function_value, is_defined;
  analog begin
    define = 3.0 `AUDIT_EMPTY + `AUDIT_THREE;
    object_value = `AUDIT_OBJECT;
    function_value = `AUDIT_SUM (2.0, 3.0);
`ifdef AUDIT_EMPTY
    is_defined = 1.0;
`else
    is_defined = 0.0;
`endif
    `CHECKX("empty and line comment substitution", define, 6.0);
    `CHECKX("space makes object macro", object_value, 5.0);
    `CHECKX("space allowed at invocation", function_value, 5.0);
    `CHECKX("empty macro remains defined", is_defined, 1.0);
    I(p) <+ V(p);
  end
endmodule
