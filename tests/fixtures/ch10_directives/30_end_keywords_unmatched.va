// §10.6 makes the pairing normative: the `begin_keywords directive "affects all
// source code that follows the directive, even across source code file
// boundaries, until the matching `end_keywords directive is encountered."
//
// A stray `end_keywords has no matching `begin_keywords and therefore no set to
// restore. A tool that swallows it silently has no way to be right about what is
// reserved afterwards — it either pops a set it never pushed or does nothing,
// and neither is the "matching" behaviour the clause describes.
//
// Nothing else in the file is unusual, so the only thing under test is the
// unpaired directive; the module below is the same one-resistor body as 16.
//
//! lrm 10.6
//! reject E0136
`end_keywords
module ch10_end_keywords_unmatched(p, n);
  inout p, n;
  electrical p, n;
  analog I(p, n) <+ V(p, n);
endmodule
