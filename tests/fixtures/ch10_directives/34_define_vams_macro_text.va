// §10.4's one unambiguous prohibition: "To avoid conflicts with predefined
// Verilog-AMS macros (10.5), the `define compiler directive's macro text shall
// not begin with __VAMS_."
//
// Syntax 10-3 is what makes the target of that sentence the BODY and not the
// name:
//
//   text_macro_definition ::= `define text_macro_name macro_text
//
// macro_text is the second operand. The rationale in the sentence agrees — a
// body opening with __VAMS_ is what can expand into a §10.5 predefined macro
// and shadow it, which a mere name cannot do. 15 is the legal counterpart (a
// __VAMS_-prefixed NAME, which Syntax 10-3 leaves unrestricted) and must keep
// compiling; nothing tested the prohibition itself.
//
// The body here is __VAMS_ENABLE__, i.e. exactly the collision §10.5 is worried
// about: were MY_ENABLE ever expanded, an `ifdef would be reading a predefined
// macro's name out of a user definition.
//
// The expectation is a message substring rather than a code because VerA has no
// code for this rule to name yet; __VAMS_ is the offending text and any
// diagnostic about it will quote it. When the check lands, replace this line
// with its code.
//
//! lrm 10.4
//! reject __VAMS_
//! xfail VerA never inspects macro text: preprocessor.zig protects only the two predefined NAMES, so a body beginning with __VAMS_ is defined silently
`define MY_ENABLE __VAMS_ENABLE__
module ch10_define_vams_macro_text(p, n);
  inout p, n; electrical p, n;
  analog I(p,n) <+ V(p,n);
endmodule
