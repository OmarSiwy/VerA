// §10.5 predefined macros. `__VAMS_ENABLE__` "shall always be defined during
// the parsing of Verilog-AMS source text" — it is not conditional on anything,
// so the `ifdef arm always survives the preprocessor and the `else arm is dead
// text that never reaches the parser.
//
// `gain` is the witness: 1.0 out of the ifdef arm, 2.0 out of the else arm. A
// preprocessor that failed to predefine the macro compiles the other arm and
// reports gain=2 here. At V(p,n) = 0.75 - 0.25 = 0.5 V (§1.3.1) the gain-scaled
// potential is then 1.0*0.5 = 0.5 rather than 1.0.
//
//! lrm 10.5
//! lrm 10.5:1
//! bias V(p) = 0.75, V(n) = 0.25
`include "check.vh"
module ch10_predefined_vams_enable(p, n);
  inout p, n; electrical p, n;
  real gain;
  analog begin
`ifdef __VAMS_ENABLE__
    gain = 1.0;
    I(p,n) <+ 1.0*V(p,n);
`else
    gain = 2.0;
    I(p,n) <+ 2.0*V(p,n);
`endif
    `CHECKX("__VAMS_ENABLE__ is always defined, so the ifdef arm compiled", gain, 1.0);
    `CHECK("gain * V(p,n) at the operating point", gain*V(p,n), 0.5, 1e-15);
  end
endmodule
