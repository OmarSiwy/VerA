// AMS 10.2: qualifier-specific defaults coexist, and a less-specific default
// cannot replace either. Both wire and tri nets are actually observed.
// electrical supplies the standard 1 uV potential tolerance; qualified_elec
// supplies 2 nV. Assigning either default to both types fails one tolerance
// check even though both disciplines use the inherited V access function.
// A later general ddiscrete default must not erase the two specific defaults.
//! lrm 10.2
//! lrm 10.2:1000
//! lrm 10.2:1002
//! bias V(p) = 0.75, V(n) = 0.25, V(q) = 1.0, V(r) = 0.25
//! checks 4
`include "check.vh"
nature qualified_voltage : Voltage;
  abstol = 2n;
endnature
discipline qualified_elec;
  potential qualified_voltage;
  flow Current;
enddiscipline
`default_discipline electrical wire
`default_discipline qualified_elec tri
`default_discipline ddiscrete
module ch10_default_discipline_two_qualifiers(p, n, q, r);
  inout p, n, q, r;
  wire p, n;
  tri q, r;
  analog begin
    `CHECKX("the wire-qualified default supplies electrical", V(p, n), 0.5);
    `CHECKX("the tri-qualified default independently supplies its nature", V(q, r), 0.75);
    `CHECKX("wire keeps the standard potential tolerance", p.potential.abstol, 1e-6);
    `CHECKR("tri keeps the distinct qualified potential tolerance", q.potential.abstol, 2e-9, 1e-14);
    I(p, n) <+ V(p, n);
    I(q, r) <+ V(q, r);
  end
endmodule
