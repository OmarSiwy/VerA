// §10.2 Syntax 10-1 allows `default_discipline a QUALIFIER, and a qualified
// directive applies only to nets declared with that data type — several may be
// in force at once "provided each differs in qualifier". `real` therefore says
// nothing about p and n: they are neither real-typed nor undeclared, they carry
// an explicit `electrical` declaration, which §10.2 leaves untouched.
//
// So the qualified form must be a no-op here and the electrical access must
// still read the branch potential of §1.3.1 — the difference of the node
// potentials. At V(p) = 1.25, V(n) = 0.25 that is 1.0, exactly.
//
//! lrm 10.2
//! bias V(p) = 1.25, V(n) = 0.25
`default_discipline electrical real
`include "check.vh"
module ch10_default_discipline_qualified(p, n);
  inout p, n; electrical p, n;
  analog begin
    `CHECKX("a real-qualified default leaves the electrical nets alone", V(p,n), 1.0);
    I(p,n) <+ V(p,n);
  end
endmodule
