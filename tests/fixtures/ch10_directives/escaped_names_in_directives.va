// 47 pinned that a `define NAME may be escaped, because Syntax 10-3 writes
// text_macro_identifier ::= identifier and A.9.3 makes `identifier` simple OR
// escaped. This file pins the SAME production at every other directive whose
// operand is an identifier: `ifdef/`ifndef/`elsif (IEEE Std 1364, same
// text_macro_identifier), `undef (Syntax 10-3's own second line), and §10.2
// Syntax 10-1's discipline_identifier. A preprocessor that lexes those
// operands with the simple-identifier routine only — as VerA once did —
// rejects each of these lines with E0104/E0107/E0113, or, worst, misreads
// `default_discipline \electrical as a bare withdrawal followed by junk.
//
// §2.8.1 fixes the key on both sides: neither the backslash nor the
// terminating white space is part of the name, so `define \M-X and
// `ifdef \M-X test the SAME macro — and \electrical IS electrical, which is
// what makes the last directive meaningful rather than merely parseable.
// (The escaped spelling is not decoration: annex D.1's `discipline \logic ;`
// can ONLY be named this way, `\M-X` contains a `-` no simple identifier may.)
//
// The value is assembled so every arm is load-bearing:
//   K1 = 1.0  iff `ifdef sees the escaped name as defined
//   K2 = 2.0  iff `undef withdrew it and `ifndef agrees
//   K3 = 4.0  iff `elsif tests the escaped name (first arm dead)
//   K1+K2+K3 = 7.0, exact in binary64; any arm mis-taken lands on 9s.
// And V(p, n) resolves at all iff `default_discipline \electrical reached the
// two undeclared nets (the 41/42 arrangement): 7.0 * 0.5 = 3.5, exact.
//
//! lrm 10.4
//! lrm 10.2
//! lrm 10.2:1000
//! bias V(p) = 0.75, V(n) = 0.25
`define \M-X 1
`ifdef \M-X
`define K1 1.0
`else
`define K1 9.0
`endif
`undef \M-X
`ifndef \M-X
`define K2 2.0
`else
`define K2 9.0
`endif
`define \E-SEL 1
`ifdef \M-X
`define K3 9.0
`elsif \E-SEL
`define K3 4.0
`else
`define K3 9.0
`endif
`default_discipline \electrical
`include "check.vh"
module ch10_escaped_names_in_directives(p, n);
  inout p, n;
  analog begin
    `CHECKX("escaped names thread `ifdef, `undef, `ifndef and `elsif",
            `K1+`K2+`K3, 7.0);
    `CHECKX("`default_discipline \\electrical defaulted the undeclared nets",
            (`K1+`K2+`K3)*V(p, n), 3.5);
    I(p, n) <+ V(p, n);
  end
endmodule
