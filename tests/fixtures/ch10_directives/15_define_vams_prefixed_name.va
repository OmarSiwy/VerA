// §10.4 `define. The rule the LRM writes is about the macro TEXT: "the `define
// compiler directive's macro text shall not begin with __VAMS_", so a user macro
// cannot expand into one of the §10.5 predefined names. Syntax 10-3 splits the
// two halves apart —
//
//   text_macro_definition ::= `define text_macro_name macro_text
//   text_macro_identifier ::= identifier
//
// — and puts no restriction whatever on the NAME. So the definition below, whose
// name carries the prefix and whose body is the ordinary real literal 7.0, is
// legal, and the substitution is the ordinary verbatim one. This file asserts
// that acceptance; the prohibition it does NOT test is 34's job, and the
// filename says so now, because the old name (15_reserved_vams_macro_prefix)
// made the chapter look as though the prohibition were covered.
//
// The check is the expansion AT AN OPERATING POINT rather than the bare macro,
// so `got` is not just the `want` spelled twice: at V(p,n) = 0.75 - 0.25 = 0.5 V
// (§1.3.1) the substituted text gives 7.0 * 0.5 = 3.5, exact in binary because
// both operands are. A preprocessor that swallowed the __VAMS_-prefixed
// definition, or substituted a predefined macro in its place, cannot land there.
//
//! lrm 10.4
//! bias V(p) = 0.75, V(n) = 0.25
`include "check.vh"
`define __VAMS_USER_FORBIDDEN 7.0
module ch10_define_vams_prefixed_name(p, n);
  inout p, n; electrical p, n;
  analog begin
    `CHECKX("the user macro's text is substituted verbatim", `__VAMS_USER_FORBIDDEN*V(p,n), 3.5);
    I(p,n) <+ `__VAMS_USER_FORBIDDEN*V(p,n);
  end
endmodule
