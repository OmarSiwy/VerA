// §10.1's scope sentence, applied to `unconnected_drive inside ONE compilation:
//
//     "The scope of compiler directives extends from the point where it is
//      processed, across all files processed, to the point where another
//      compiler directive supersedes it or the processing completes."
//
// ch10_directives/58, 59 and 60 each put the whole question in its own file:
// 58 and 59 compile with a region open over everything that matters, 60 with no
// region at all. Nothing in that family ever OBSERVES the closing half. A tool
// that latches `unconnected_drive on the first sighting and never clears it is
// green on all three. This file is that tool's counterexample: two identical
// children in one compilation, one on each side of a single
// `nounconnected_drive, and two different answers demanded from them.
//
// WHAT THIS FILE NO LONGER CLAIMS — read this before reusing the shape.
//
// The previous version of this fixture (04_unconnected_drive_follows_the_
// module_definition.va) bet on WHICH text the directive has to enclose: the
// module DEFINITION that declares the input port, or the INSTANTIATION that
// leaves the terminal blank. That claim is WITHDRAWN, for three reasons and
// all three are recorded in tests/fixtures/ch10_directives/d10_SPEC.md at 8b1514d4:
//
//   - nothing in docs/ settles it. §6.2.2 is the only on-disk sentence in the
//     neighbourhood and it points the OTHER way ("a blank port connection shall
//     represent the situation where the port is not to be connected" locates
//     unconnectedness at the connection). The clause that would settle it,
//     IEEE Std 1364 §19.9, is the one §10.1 Table 10-1 defers to and it is not
//     in docs/ — so any citation for either reading fails to survive opening;
//   - the old file asserted V(u.a) = 0.5 and I = 0, which is exactly what a
//     tool that has never heard of `unconnected_drive prints. It could not
//     fail for its own subject's reason;
//   - VerA already hard-codes the definition-site reading, with a comment, at
//     lib/ir/elaborate.zig:663-667. Asserting it here transcribes the
//     implementation rather than the standard.
//
// It comes back the day IEEE Std 1364 clause 19 lands in docs/, in the converse
// arrangement (child defined inside the region, instantiated outside it) so
// that whichever way the clause reads, the asserted value is not the one a tool
// without the feature produces.
//
// HOW THIS FILE SIDESTEPS THAT QUESTION INSTEAD OF BETTING ON IT. Each child is
// paired with its own instantiation inside a wrapper module, and each wrapper
// lies wholly on one side of the `nounconnected_drive. Definition site and
// instantiation site are then the same side for both children, so both readings
// give the same two numbers and this file discriminates only on the thing it
// names: where the region ENDS.
//
// THE ORACLE, derived here and not copied.
//
//   mi.u.a — inside the pull1 region. §19.9's pull holds the unconnected input
//            at 1 of the potential nature's units; that the digit is one volt
//            rather than some other level is 58's argument and this file
//            inherits it, the load-bearing half being that the port is DRIVEN
//            AT ALL. V(mi.u.a) = 1.0. Its `b` is bound to `p`, which the
//            netlist holds at 0.5 V, so the child's one 1 kΩ resistor carries
//              I(a,b) = 0.001 * (1.0 - 0.5) = +5.0e-4 A, a->b.
//            The SIGN is positive: `a` is the high end. -5.0e-4 is the pull0
//            case, which is fixture 06's number, not this one's.
//   mo.u.a — after the `nounconnected_drive. Nothing drives it, so §1.3.2 KCL
//            at `a` has exactly one term, that resistor's current, which must
//            therefore be zero; §1.3.1 then makes the branch potential of a
//            zero-current resistor zero, so `a` sits wherever `b` does, at
//            V(p) = 0.5. V(mo.u.a) = 0.5 and I(mo.u.a, mo.u.b) = 0.
//
// Both of the first pair's numbers are unreachable without the directive and
// both of the second pair's are unreachable with it latched on, so neither half
// of the file can be satisfied by ignoring chapter 10. 1.0, 0.5 and 0.0 are
// binary-exact; 5e-4 is 0.001's double halved, which is exact scaling by a
// power of two and therefore the same double the solver computes. Hence CHECKX
// with no tolerance throughout, as in 06.
//
// `//! solve` is what makes the question askable at all: by default the harness
// ties every unknown no directive names to the reference, and V(mi.u.a) is
// precisely the unknown under test. `p` stays biased, because a port is what
// the netlist supplies.
//
//! lrm 10.1
//! lrm 6.2.2
//! lrm 6.2.2:3
//! lrm 10.1:1000
//! bias V(p) = 0.5
//! solve
`include "check.vh"
`unconnected_drive pull1
module d10_region_open_child(a, b);
    input a;
    inout b;
    electrical a, b;
    analog I(a, b) <+ 0.001 * V(a, b);
endmodule

// The instantiation with the blank lives inside the region too, so the
// definition-site and instantiation-site readings cannot disagree about it.
module d10_region_open_wrapper(b);
    inout b;
    electrical b;
    d10_region_open_child u( , b);
endmodule
`nounconnected_drive

module d10_region_closed_child(a, b);
    input a;
    inout b;
    electrical a, b;
    analog I(a, b) <+ 0.001 * V(a, b);
endmodule

module d10_region_closed_wrapper(b);
    inout b;
    electrical b;
    d10_region_closed_child u( , b);
endmodule

module d10_unconnected_drive_region_closes_mid_compilation(p);
    inout p;
    electrical p;

    d10_region_open_wrapper   mi(p);
    d10_region_closed_wrapper mo(p);

    analog begin
        `CHECKX("inside the region the blank input is pulled", V(mi.u.a), 1.0);
        `CHECKX("and is driven: 0.001*(1.0 - 0.5) A flows a->b", I(mi.u.a, mi.u.b), 5e-4);
        `CHECKX("`nounconnected_drive ended the region in the same compilation", V(mo.u.a), 0.5);
        `CHECKX("so this one carries no current at all", I(mo.u.a, mo.u.b), 0.0);
        I(p) <+ 0.0;
    end
endmodule
