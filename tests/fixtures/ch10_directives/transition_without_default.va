// §10.3: "If a `default_transition directive is not used in the description,
// transition_time is controlled by the simulator."
//
// That is an implementation-defined sentence, so there is no digit to assert
// about the time itself. What can be pinned is that a description with NO
// directive is still legal and that transition() executes under whatever time
// the simulator chose: §4.5.8 gives the filter exactly one value that does not
// depend on the ramp — "In DC analysis, transition() passes the value of the
// expr directly to its output."
//
// So the DC point is the identity on the operand. 3.0*V(p,n) + 1.5 at
// V(p,n) = 0.5 is 1.5 + 1.5 = 3.0, exactly. The operand is scaled and offset
// so that a filter answering a default of its own instead of its operand cannot
// coincide with the want.
//
// This DC identity does not establish which transition time the simulator
// supplies. The exact 10.3:1002 assertion lives in the conditional host test
// test_transition_without_directive_uses_documented_host_default, which observes the
// documented default and the actual transient corners.
//
//! lrm 4.5.8
//! bias V(p) = 0.5
`include "check.vh"
module ch10_transition_without_default(p, n);
  inout p, n; electrical p, n;
  analog begin
    `CHECKX("with no directive, transition passes its operand in DC",
            transition(3.0*V(p,n) + 1.5), 3.0);
    I(p,n) <+ V(p,n);
  end
endmodule
