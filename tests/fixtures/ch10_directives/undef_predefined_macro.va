// §10.4: "The `undef compiler directive shall have no effect on predefined
// Verilog-AMS macros; the simulator may issue a warning for an attempt to
// undefine one of these macros." §10.5 states the same thing from the other
// side: __VAMS_ENABLE__ "shall always be defined during the parsing of
// Verilog-AMS source text" — always, with no exception carved out for a stream
// that tried to undefine it.
//
// 13 checks the macro in a virgin stream and 08 checks `undef on a USER macro;
// nothing crossed them, and the naive implementation — one macro table, one
// uniform `undef — silently violates the rule with both of those still green.
//
// Two witnesses, each a real the surviving `ifdef arm sets to 1.0 and the dead
// `else arm sets to 2.0, so whichever arm the preprocessor keeps is the one that
// reports:
//
//   after_resetall   the macro is still defined after `resetall (§10.5's
//                    "always", which a directive reset cannot narrow)
//   after_undef      the macro is still defined after an explicit `undef of it
//                    (§10.4's "shall have no effect")
//
// The two directives are separated by the first witness so each is observed
// alone; `undef sits inside the module body, which §10.3 confirms is legal for
// this family of directives when it singles out `default_transition as the one
// that "can be used only outside of module definitions".
//
// The optional half of §10.4 — "may issue a warning" — is deliberately not
// asserted: a tool that stays silent is conforming.
//
//! lrm 10.4
//! lrm 10.4:2
//! lrm 10.5
//! lrm 10.5:1
//! bias V(p) = 0.75, V(n) = 0.25
`resetall
`include "check.vh"
module ch10_undef_predefined_macro(p, n);
  inout p, n; electrical p, n;
  real after_resetall, after_undef;
  analog begin
`ifdef __VAMS_ENABLE__
    after_resetall = 1.0;
`else
    after_resetall = 2.0;
`endif
`undef __VAMS_ENABLE__
`ifdef __VAMS_ENABLE__
    after_undef = 1.0;
`else
    after_undef = 2.0;
`endif
    `CHECKX("`resetall cannot undefine a predefined macro", after_resetall, 1.0);
    `CHECKX("`undef cannot undefine a predefined macro", after_undef, 1.0);
    // The device still has to solve: 0.75 - 0.25 = 0.5 V exactly (§1.3.1).
    `CHECKX("branch potential", V(p, n), 0.5);
    I(p, n) <+ V(p, n);
  end
endmodule
