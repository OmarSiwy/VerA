// When __VAMS_COMPACT_MODELING__ is defined, these independently derived
// values check selected advertised extensions: ddx, $mfactor, $param_given,
// and localparam in array bounds and parameter defaults. A missing macro
// does not establish whether all extensions are supported, so that branch
// only checks its ordinary input and makes no exact §10.5:2 claim.
//
// tests/host.py checks the biconditional using
// actual host capability introspection for the complete Annex G.3 set and
// a separately compiled macro probe. No support premise is assumed here.
// ddx of 1.5*(V(p)-V(n)) with respect to V(p) is 1.5; no instance supplies
// multiplicity or rser, so $mfactor is 1 and $param_given(rser) is 0.
// nslot and kfold must be constant in the array bound and parameter default;
// the final array element and rser independently evaluate to 6 and 1.
//
//! lrm 10.5
//! bias V(p) = 0.75, V(n) = 0.25
`include "check.vh"
module d10_compact_modeling_macro_implies_its_extensions(p, n);
  inout p, n;
  electrical p, n;
`ifdef __VAMS_COMPACT_MODELING__
  // G.3 item 3, in the two places a variable may not stand.
  localparam integer nslot = 4;
  localparam real    kfold = 2.0;
  parameter real     rser  = kfold - 1.0;
  real fold[0:nslot-1];
  real g, mf;
  integer pg;
`else
  parameter real     rser  = 1.0;
`endif
  analog begin
`ifdef __VAMS_COMPACT_MODELING__
    g  = ddx(1.5 * V(p, n), V(p));
    mf = $mfactor;
    pg = $param_given(rser);
    fold[nslot - 1] = kfold * 3.0;
    `CHECKX("G.3 item 8: ddx is the symbolic derivative, so exactly 1.5", g, 1.5);
    `CHECKX("G.3 item 18: $mfactor with no multiplicity above is 1", mf, 1.0);
    `CHECKI("G.3 item 17: nothing overrode rser, so $param_given is 0", pg, 0);
    `CHECKX("G.3 item 3: a localparam bounds this array, 2.0*3.0", fold[nslot - 1], 6.0);
    `CHECKX("G.3 item 3: and folds into a parameter default, 2.0-1.0", rser, 1.0);
`else
    `CHECKX("the absent-macro branch retains the biased input", V(p,n), 0.5);
`endif
    I(p, n) <+ V(p, n);
  end
endmodule
