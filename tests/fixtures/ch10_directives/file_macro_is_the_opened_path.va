// §10.7: "`__FILE__ expands to the name of the current input file, in the form
// of a string literal. This is the path by which a tool opened the file, NOT
// THE SHORT NAME SPECIFIED IN `include or as a tool's input file name
// argument. The format of this path name may be implementation dependent."
// And: "An `include directive changes the expansions of `__FILE__ and
// `__LINE__ to correspond to the included file."
//
// d10_file_macro_probe.vh is included below by its short name and found
// through an include directory (the harness passes this fixture's directory
// with -I), so the path the tool opened it by is that directory joined with
// the name — whatever its format, it is not the short name. The header
// compares its own `__FILE__ against the short name as two string literals
// (literal equality is §4.2's, as string_literal_equality.va uses it),
// so `file_is_short_name` must be 0, exact.
//
// No digits of the path itself are asserted: §10.7 leaves the format to the
// implementation, and file_macro.va records why no fixture can read it.
// This one pins only the part the clause does fix — which name it is not.
//
// VerA used to expand the short name ("d10_file_macro_probe.vh") and read 1.
// Compare the include's name with the surrounding file too: a single constant
// path would satisfy the short-name inequality while failing the required
// switch on entry and restoration when the include ends.
//
//! lrm 10.7
//! lrm 10.7:1
//! lrm 10.7:1001
//! lrm 10.7:1003
//! checks 4
`include "check.vh"
module d10_11_file_macro_is_the_opened_path(p, n);
  inout p, n; electrical p, n;
  integer file_is_short_name;
  string parent_before, included_path, parent_after;
  analog begin
    parent_before = `__FILE__;
`include "d10_file_macro_probe.vh"
    parent_after = `__FILE__;
    `CHECKI("`__FILE__ in an include is not the `include short name", file_is_short_name, 0);
    `CHECKI("entering the include changes the current input file", included_path != parent_before, 1);
    `CHECKI("leaving the include restores the enclosing input file", parent_after == parent_before, 1);
    `CHECKI("the include expansion is a nonempty path", included_path != "", 1);
    I(p, n) <+ V(p, n);
  end
endmodule
