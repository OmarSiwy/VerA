// §10.4 `define: a macro's text may use other macros, and every use expands
// in full. D0 is "1.0 +", and each D(k) is two copies of D(k-1), so D4 is 16
// copies of "1.0 +"; followed by 0.0 the expression sums sixteen 1.0s.
//
// Derivation: 16 * 1.0 + 0.0 = 16.0, exact.
//
// The legal neighbour of macro_expansion_too_large_rejected.va: the same
// doubling, small enough to stay far inside the engine's expansion limit.
//
//! lrm 10.4
//! checks 1
`include "check.vh"
`define D0 1.0 +
`define D1 `D0 `D0
`define D2 `D1 `D1
`define D3 `D2 `D2
`define D4 `D3 `D3
module macro_doubling_expands(p);
  inout p; electrical p;
  real x;
  analog begin
    x = `D4 0.0;
    `CHECKX("D4 expands to sixteen 1.0 terms", x, 16.0);
    I(p) <+ 0.0;
  end
endmodule
