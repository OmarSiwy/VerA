// IEEE 1364-2005 19.3.1, physical page 381 (VAMS 10.4): actual/formal counts
// must match. This supplies one expression for two formals; no empty argument
// interpretation is involved. audit_macro_empty_and_spacing.va supplies two.
//! lrm 10.4
//! reject-only E0117
//! neighbour audit_macro_empty_and_spacing.va
`define AUDIT_ADD(A,B) ((A)+(B))
module audit_macro_too_few_actuals_rejected;
  parameter real value = `AUDIT_ADD(1.0);
endmodule
