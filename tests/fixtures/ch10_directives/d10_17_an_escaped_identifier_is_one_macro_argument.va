// §2.8.1: "Escaped identifiers shall start with the backslash character (\)
// and end with white space (space, tab, newline)." Every printable character
// between is part of the name, a comma included. So in
//
//   `ID(\a,b )
//
// the actual argument list holds ONE argument, the identifier `\a,b`, and the
// comma inside it separates nothing. `ID has one formal, so the call is well
// formed and expands to the variable, whose value is 2.0 (exact).
//
//! lrm 10.4
//! lrm 2.8.1
//! lrm 2.8.1:1
//! bias V(p) = 0.5
`define ID(x) x
`include "check.vh"
module d10_an_escaped_identifier_is_one_macro_argument(p, n);
  inout p, n; electrical p, n;
  real \a,b ;
  analog begin
    \a,b = 2.0;
    `CHECKX("the comma inside an escaped identifier splits no argument", `ID(\a,b ), 2.0);
    I(p,n) <+ V(p,n);
  end
endmodule
