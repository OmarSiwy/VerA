// VAMS 10.1 takes `include from IEEE 1364-2005 19.5, which says only that the
// file name may be a full or relative path. Annex D names the standard headers
// disciplines.vams (D.1) and constants.vams (D.2). Models written for the OVI
// Verilog-A 1.0 reference include the same headers as "discipline.h" and
// "constants.h" (CMC r3_cmc 1.0.0, among others). VerA's reading
// (specification/Vague_Decisions.md VD-093): both old names are built-in aliases of the
// Annex D files, searched last like them, so a model's own discipline.h wins.
//
// The two old names bring in the same text, so `electrical` resolves and
// `P_Q is D.2's value: 1.602176462e-19 (the NIST1998 default selection,
// as 18_include_constants.va derives for P_K). The headers are self-guarded,
// so including them after the prelude defines nothing twice.
//
// Legal-neighbour pair: 53_include_unknown_header_name_rejected.va names
// "disciplines.h", which is neither an Annex D name nor a 1.0 one: E0126.
//! lrm 10.1
//! lrm D.2
//! inherited IEEE 1364-2005 19.5
//! nowarn
//! checks 1
`include "check.vh"
`include "discipline.h"
`include "constants.h"
module include_verilog_a_1_0_header_names(p, n);
  inout p, n; electrical p, n;
  analog begin
    `CHECKX("constants.h is annex D.2: P_Q", `P_Q, 1.602176462e-19);
    I(p, n) <+ V(p, n);
  end
endmodule
