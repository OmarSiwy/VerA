// IEEE 1364-2005 §19.5 (taken whole by §10.1): "The number of nesting levels
// for include files shall be finite." This file includes itself 40 times, past
// the 32 levels VerA capped until 2026-10, and stops: each open defines the
// next of L0..L39, so no two opens see the same macros, and the 41st open
// finds them all defined, defines DONE and includes nothing more. The module
// is emitted once, from that innermost open.
//
// HAND DERIVATION. Open k (k = 0 for the file itself) finds L0..L(k-1)
// defined and defines Lk, for k < 40; open 40 defines DONE. Every open but
// the innermost includes the file again; the innermost emits the module,
// whose CHECKI reads `DEPTH, the 40 written there, so it is 40.
//
//! lrm 10.1
//! inherited IEEE 1364-2005 19.5
//! checks 1
`ifndef L0
`define L0
`else
`ifndef L1
`define L1
`else
`ifndef L2
`define L2
`else
`ifndef L3
`define L3
`else
`ifndef L4
`define L4
`else
`ifndef L5
`define L5
`else
`ifndef L6
`define L6
`else
`ifndef L7
`define L7
`else
`ifndef L8
`define L8
`else
`ifndef L9
`define L9
`else
`ifndef L10
`define L10
`else
`ifndef L11
`define L11
`else
`ifndef L12
`define L12
`else
`ifndef L13
`define L13
`else
`ifndef L14
`define L14
`else
`ifndef L15
`define L15
`else
`ifndef L16
`define L16
`else
`ifndef L17
`define L17
`else
`ifndef L18
`define L18
`else
`ifndef L19
`define L19
`else
`ifndef L20
`define L20
`else
`ifndef L21
`define L21
`else
`ifndef L22
`define L22
`else
`ifndef L23
`define L23
`else
`ifndef L24
`define L24
`else
`ifndef L25
`define L25
`else
`ifndef L26
`define L26
`else
`ifndef L27
`define L27
`else
`ifndef L28
`define L28
`else
`ifndef L29
`define L29
`else
`ifndef L30
`define L30
`else
`ifndef L31
`define L31
`else
`ifndef L32
`define L32
`else
`ifndef L33
`define L33
`else
`ifndef L34
`define L34
`else
`ifndef L35
`define L35
`else
`ifndef L36
`define L36
`else
`ifndef L37
`define L37
`else
`ifndef L38
`define L38
`else
`ifndef L39
`define L39
`else
`define DONE
`define DEPTH 40
`endif
`endif
`endif
`endif
`endif
`endif
`endif
`endif
`endif
`endif
`endif
`endif
`endif
`endif
`endif
`endif
`endif
`endif
`endif
`endif
`endif
`endif
`endif
`endif
`endif
`endif
`endif
`endif
`endif
`endif
`endif
`endif
`endif
`endif
`endif
`endif
`endif
`endif
`endif
`endif

`ifndef DONE
`include "include_self_guarded_past_the_old_limit.va"
`else
`ifndef EMITTED
`define EMITTED
`include "check.vh"
module include_self_guarded_past_the_old_limit(p);
  inout p; electrical p;
  integer depth;
  analog begin
    depth = `DEPTH;
    `CHECKI("nested include opens", depth, 40);
    I(p) <+ V(p);
  end
endmodule
`endif
`endif
