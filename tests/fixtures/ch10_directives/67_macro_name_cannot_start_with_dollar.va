// §10.4 Syntax 10-3: `text_macro_identifier ::= identifier`, and A.9.3 makes
// identifier ::= simple_identifier | escaped_identifier. §2.8: "The first
// character of an identifier shall not be a digit or $". So `$X` is not a
// simple_identifier, it is not escaped, and it cannot name a macro.
//
// (A name starting with $ is a system_function_identifier — §2.8.3 — which is
// a different token; `\$X ` written escaped IS an identifier and stays legal.)
//
// E0109 is VerA's "`define requires a macro name": the directive below has no
// macro name, only a word that is not one.
//
//! lrm 10.4
//! lrm 2.8
//! lrm 2.8:4
//! reject-only E0109
`define $X 1
`include "disciplines.vams"
module ch10_macro_name_cannot_start_with_dollar(p, n);
  inout p, n; electrical p, n;
  analog I(p, n) <+ V(p, n);
endmodule
