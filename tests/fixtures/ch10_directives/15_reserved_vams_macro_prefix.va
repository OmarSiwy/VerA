// §10.4 `define. The rule the LRM writes is about the macro TEXT: "the `define
// compiler directive's macro text shall not begin with __VAMS_", so a user macro
// cannot expand into one of the §10.5 predefined names. The NAME carrying the
// prefix, as here, is a plain text_macro_identifier (Syntax 10-3) whose body is
// the ordinary real literal 7.0 — nothing collides with a predefined macro, and
// the substitution is the ordinary verbatim one.
//
// The check is the expansion AT AN OPERATING POINT rather than the bare macro,
// so `got` is not just the `want` spelled twice: at V(p,n) = 0.75 - 0.25 = 0.5 V
// (§1.3.1) the substituted text gives 7.0 * 0.5 = 3.5, exact in binary because
// both operands are. A preprocessor that swallowed the __VAMS_-prefixed
// definition, or substituted a predefined macro in its place, cannot land there.
//
//! bias V(p) = 0.75, V(n) = 0.25
`include "check.vh"
`define __VAMS_USER_FORBIDDEN 7.0
module ch10_reserved_vams_macro_prefix(p, n);
  inout p, n; electrical p, n;
  analog begin
    `CHECKX("the user macro's text is substituted verbatim", `__VAMS_USER_FORBIDDEN*V(p,n), 3.5);
    I(p,n) <+ `__VAMS_USER_FORBIDDEN*V(p,n);
  end
endmodule
