// IEEE 1364-2005 19.3.1, physical page 382 (VAMS 10.4): indirect recursive
// replacement is also erroneous. Two distinct names defeat a self-name-only
// guard. The first definition is not itself an invocation.
//! lrm 10.4
//! reject-only E0118
`define AUDIT_FIRST `AUDIT_SECOND
`define AUDIT_SECOND `AUDIT_FIRST
module audit_macro_indirect_recursion_rejected;
  parameter real value = `AUDIT_FIRST;
endmodule
