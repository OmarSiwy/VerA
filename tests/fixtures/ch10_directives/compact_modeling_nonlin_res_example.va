// §10.5's nonlin_res example: the compact-modeling macro guards the
// ddx-derived thermal noise. The macro is defined here deliberately, because
// this fixture is about the EXAMPLE's code path and not about whether the host
// defines the macro (10.5:2 and its fixtures own that question; VerA currently
// leaves it undefined).
//
// §10.5's example is:
//
//     iab = V(a,b) / (rnom * (1.0 + vc1 * V(a,b)));
//     I(a,b) <+ iab;
//     `ifdef __VAMS_COMPACT_MODELING__
//       reff = ddx(iab, V(a));
//       I(a,b) <+ white_noise(4.0*`P_K*$temperature*reff, "thermal");
//     `endif
//
// DERIVATION. With rnom = 1, vc1 = 0 and V(a,b) = 1, iab = V(a,b), so the
// symbolic derivative ddx(iab, V(a)) is 1.0. At 300 K and annex D's P_K =
// 1.3806503e-23 J/K:
//
//     4 * P_K * 300 * 1 = 1.65678036e-20 A^2/Hz
//
// The `//! noise` row is the host-visible assertion; the CHECK pins the same
// derivative in the device. A tool that leaves the noise inside the `ifdef but
// never evaluates it exports no thermal source, and one that computes the noise
// from rnom instead of the ddx-derived reff reads 4kT (a factor 1/rnom) here.
//
//! lrm 10.5
//! lrm 10.5:3
//! noise thermal(a,b)#0 name=thermal white=1.65678036e-20
//! analysis noise
//! temp 300.0
//! bias V(a) = 1.0, V(b) = 0.0
`define __VAMS_COMPACT_MODELING__
`include "check.vh"
module ch10_compact_nonlin_res(a, b);
  input a, b;
  electrical a, b;
  parameter real rnom = 1.0;
  parameter real vc1 = 0.0;
  real reff, iab;

  analog begin
    iab = V(a,b) / (rnom * (1.0 + vc1 * V(a,b)));
    I(a,b) <+ iab;
`ifdef __VAMS_COMPACT_MODELING__
    reff = ddx(iab, V(a));
    `CHECKX("ddx of iab with respect to V(a) is 1/rnom", reff, 1.0);
    I(a,b) <+ white_noise(4.0*`P_K*$temperature*reff, "thermal");
`endif
  end
endmodule
