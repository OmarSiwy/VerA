// §10.1 Table 10-1 takes `resetall from IEEE Std 1364 Verilog. IEEE 1364-2005
// §19.6, physical page 356: "When `resetall compiler directive is encountered
// during compilation, all compiler directives are set to the default values"
// and "It shall be illegal for the `resetall directive to be specified within
// a module or UDP declaration."
//
// The `resetall below sits between `module` and `endmodule`, so the file is
// illegal. The same directive BEFORE the module is the clause's recommended
// usage ("place `resetall at the beginning of each source text file") and is
// what 36 and 56 in this directory write.
//
// (§10.3 says `default_transition may appear "only outside of module
// definitions" too, and tests/fixtures/ch10_directives/d10_SPEC.md at 8b1514d4 records why that one is left untested;
// §19.6's sentence has no such problem.)
//
// E0236 is VerA's code for this rule.
//
//! lrm 10.1
//! reject-only E0236
`include "disciplines.vams"
module ch10_resetall_inside_a_module_rejected(p, n);
  inout p, n; electrical p, n;
`resetall
  analog I(p, n) <+ V(p, n);
endmodule
