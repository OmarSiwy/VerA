// An engine limit, not a language rule: §10.3 `include names a file and bounds
// nothing about its size. VerA reads an included file whole and stops at 16 MiB
// (specification/Vague_Decisions.md), so a larger file is refused with E1013, which names
// the size, rather than reported as a file that cannot be found (E0126).
//
// /dev/zero is a file every POSIX host has and that never ends, so it stands in
// for a file past any bound without committing one to the tree.
//
//! reject-only E1013
`include "/dev/zero"
module include_file_over_16mib_rejected(p, n);
  inout p, n; electrical p, n;
  analog I(p,n) <+ V(p,n);
endmodule
