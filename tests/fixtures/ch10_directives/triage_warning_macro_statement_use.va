// The legal half of triage_warning_macro_semicolon_rejected.va, and the shape
// CMC's corrected R3_CMC 1.1.2 takes: the macro body is
//
//     `define WARNING(str) $strobe(str);
//
// so a use is a COMPLETE statement and must not add a `;` of its own.
//
//     `WARNING("...")     ->   $strobe("...");
//
// §10.4 makes `define a textual substitution, so the `;` above is the whole
// terminator: the next statement's token follows it directly (here the
// `CHECKX, whose expansion starts with another $strobe). A call site that
// added a second `;` would be the refused neighbour. There is no statement
// after the macro that could supply the missing terminator, which is why the
// `CHECKX line directly below it detects one.
//
//! lrm 10.4
//! lrm A.6.4
//! bias V(p) = 0.5
//! checks 1
`define WARNING(str) $strobe(str);
`include "check.vh"
module ch10_triage_warning_macro_statement_use(p);
  inout p; electrical p;
  analog begin
    `WARNING("WARNING's own semicolon ends its $strobe")
    `CHECKX("the next statement runs after the macro's terminator", V(p), 0.5);
    I(p) <+ 0.0;
  end
endmodule
