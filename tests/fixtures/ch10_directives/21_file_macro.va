// §10.7: "`__FILE__ expands to the name of the current input file, in the form
// of a string literal." A positive requirement — nothing in the clause forbids
// the macro — so the file must COMPILE and the expansion must be a string
// literal that %s consumes, exactly as §10.7's own example spells it.
//
// What is NOT pinned here: the text. §10.7 says the path "is the path by which a
// tool opened the file, not the short name specified in `include", and that its
// "format ... may be implementation dependent". Asserting any spelling would
// fail a conforming tool that opened the file by an absolute path, so the claim
// stops at "it expands, and it is a string".
//
// So where is the §10.7 requirement enforced, given the runner reads only
// `ok=` lines? In the COMPILE, and that is a real floor rather than a
// formality: `__FILE__ is the sole argument of a `$display` whose format
// string ends in "%s.". If the macro is not defined the file does not
// preprocess; if it expands to nothing the call becomes `$display("...%s.", )`
// and does not parse; if it expands to anything that is not a string literal
// the argument does not match §9.4's %s. The one case the compile cannot
// catch is an expansion to the empty string literal "" — which §10.7 does not
// spell out as illegal, and which an analog block has no way to measure,
// there being no string length or comparison in the subset a device can
// evaluate. That is the gap, stated rather than papered over with a check no
// conforming tool would be obliged to pass.
//
// The branch potential is a second, independent assertion, so the fixture
// still carries a digit of its own: 0.75 - 0.25 = 0.5 V exactly (§1.3.1),
// both operands binary-exact.
//
//! lrm 10.7
//! bias V(p) = 0.75, V(n) = 0.25
//! print none
//! xfail VerA rejects `__FILE__ with E0114 "unsupported compiler directive"; §10.7 is unimplemented in the preprocessor
`include "check.vh"
module ch10_file_macro(p, n);
  inout p, n; electrical p, n;
  analog begin
    $display("Internal error: null handle at %s.", `__FILE__);
    `CHECKX("branch potential", V(p, n), 0.5);
    I(p, n) <+ V(p, n);
  end
endmodule
