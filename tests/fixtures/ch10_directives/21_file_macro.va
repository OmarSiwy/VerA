// §10.7: "`__FILE__ expands to the name of the current input file, in the form
// of a string literal." A positive requirement — nothing in the clause forbids
// the macro — so the file must COMPILE and the expansion must be a string
// literal that %s consumes, exactly as §10.7's own example spells it.
//
// What is NOT pinned here: the text. §10.7 says the path "is the path by which a
// tool opened the file, not the short name specified in `include", and that its
// "format ... may be implementation dependent". Asserting any spelling would
// fail a conforming tool that opened the file by an absolute path, so the claim
// stops at "it expands, and it is a string".
//
// That leaves the fixture with nothing numeric of its own, so it carries one
// independent assertion: the branch potential at the operating point,
// 0.75 - 0.25 = 0.5 V exactly (§1.3.1), both operands binary-exact.
//
//! lrm 10.7
//! bias V(p) = 0.75, V(n) = 0.25
//! print none
//! xfail VerA rejects `__FILE__ with E0114 "unsupported compiler directive"; §10.7 is unimplemented in the preprocessor
`include "check.vh"
module ch10_file_macro(p, n);
  inout p, n; electrical p, n;
  analog begin
    $display("Internal error: null handle at %s.", `__FILE__);
    `CHECKX("branch potential", V(p, n), 0.5);
    I(p, n) <+ V(p, n);
  end
endmodule
