// §10.7: "`__LINE__ expands to the current input line number, in the form of a
// simple decimal number." That is a positive requirement — the clause carries no
// prohibition anywhere — so the file must COMPILE, and the oracle is the one
// hard integer in chapter 10: the physical 1-based index of the line the macro
// sits on, counted in this file by a reader with no simulator.
//
// The macro is read into `lineno` on a statement line of its own rather than
// passed to `CHECKI. As an actual argument it would be substituted into a macro body,
// and §10.7 does not say which line an expansion inside a macro invocation
// reports; on its own line there is exactly one answer.
//
// The `include of check.vh sits above the assertion on purpose: §10.7 says the
// expansions "revert to the values they had before the `include", so a
// preprocessor that lets the included lines leak into the count reports a
// number tens larger than the one written below.
//
// The branch potential is the second, directive-independent assertion, so a
// stream that somehow lost the $display still has to solve the device:
// 0.75 - 0.25 = 0.5 V exactly (§1.3.1), both operands binary-exact.
//
//! lrm 10.7
//! lrm 10.7:1002
//! bias V(p) = 0.75, V(n) = 0.25
//! print none
// NOTE: this file's LINE COUNT is load-bearing — 31 below is its own line number.
`include "check.vh"
module ch10_line_macro(p, n);
  inout p, n; electrical p, n;
  integer lineno;
  analog begin
    lineno = `__LINE__;
    // §10.7's own worked example, verbatim in shape.
    $display("Internal error: null handle at line %d.", `__LINE__);
    `CHECKI("`__LINE__ is the physical index of the line it appears on", lineno, 31);
    `CHECKX("branch potential", V(p, n), 0.5);
    I(p, n) <+ V(p, n);
  end
endmodule
