// Selecting VAMS-2.3 must accept a legal model, as well as reject an
// unescaped reserved sin identifier in begin_keywords_vams_2_3.va.
// The escaped spelling denotes a real port: its measured potential is 0.5.
// This control prevents rejecting every VAMS-2.3 region from satisfying the
// neighboring rejection fixture.
//! lrm 10.6:1
//! bias V(sin) = 0.75, V(n) = 0.25
//! checks 1
`begin_keywords "VAMS-2.3"
`include "check.vh"
module ch10_begin_keywords_vams_2_3_accepted(\sin , n);
  inout \sin , n;
  electrical \sin , n;
  analog begin
    `CHECKX("escaped sin remains a port under VAMS-2.3", V(\sin , n), 0.5);
    I(\sin , n) <+ V(\sin , n);
  end
endmodule
`end_keywords
