// §10.1 takes `include from IEEE Std 1364. IEEE 1364-2005 §19.5 Syntax 19-6:
//
//     include_compiler_directive ::= `include "filename"
//
// The file name is the directive's only operand and it is not optional. The
// first line below has none. The legal form, on the next line, is
// 18_include_constants.va's.
//
//! lrm 10.1
//! inherited IEEE 1364-2005 19.5
//! reject-only E0121
//! neighbour 18_include_constants.va
`include
`include "disciplines.vams"
module ch10_include_requires_a_file_name(p, n);
  inout p, n; electrical p, n;
  analog I(p, n) <+ V(p, n);
endmodule
