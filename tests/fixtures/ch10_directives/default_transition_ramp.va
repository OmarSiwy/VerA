// §10.3, the numeric half: "For all transition filters which follow this
// directive and do not have rise time and fall time arguments specified,
// transition_time is used as the default rise and fall time values."
//
// 03 pins §4.5.8's DC pass-through, which still holds with the directive
// deleted, so a tool that lexes `default_transition and throws it away passes
// all of chapter 10. Nothing observes the time the directive actually sets. This
// does, on a transient with a step input, in the two ways the LRM supports:
//
// 1. The identity §10.3 states. An argument-free filter and one written
//    transition(expr, 0, 4n, 4n) are, by the sentence above, the same filter, so
//    they agree at every time point — exactly, tolerance 0.0, because it is the
//    same kernel fed the same numbers. This is CHECKEQ rather than a digit
//    because §10.3 fixes an equality and no value: the ramp shape is §4.5.8's
//    business, and cancels from both sides here.
//
// 2. The slope, which is a digit. §4.5.8 makes the output "a piecewise linear
//    function over time" that traverses the full excursion in the transition
//    time, so with tr = 4n and a 0 -> 1 step its slope while transitioning is
//    1/4n = 0.25 per nanosecond. The input steps somewhere in (0, 1n], and the
//    output leaves 0 no earlier than the step and no later than t = 1n, so at
//    every sampled t
//
//        (t - 1n)/4n  <=  out(t)  <=  t/4n
//
//    which is one unconditional pair of bounds holding at all five points, and
//    is violated in one direction by any default shorter than 4n and in the
//    other by any default longer. The one-nanosecond width is the sampling
//    grid's own ambiguity about when a step between two samples is detected —
//    the LRM does not fix that, so the fixture does not either.
//
//    Each bound carries an explicit 1e-12 epsilon, and that is not slack in
//    the rule. With `//! wave V(in) = 0, 1, 1, 1, 1, 1, 0` on this grid the step lands at
//    EXACTLY t = 1n (a short wave list holds its last value), so a correct
//    §4.5.8 ramp starting at the step sits bit-for-bit ON the lower bound at
//    t = 2n, 3n and 4n, and one that starts at the previous sample sits ON
//    the upper. An inequality whose two sides are the same real reached by
//    two different routes is then decided by the last ulp, which the LRM says
//    nothing about. 1e-12 is some 4000 ulp at 1.0 and three orders below the
//    0.125 by which the nearest wrong transition time (8n or 2n) misses at
//    t = 4n, so it costs the fixture no discrimination.
//
// A falling edge at 6 ns tests the omitted fall time independently; the
// mirrored bounds below prevent a rise-only implementation from passing.
//
// NOTE ON THE EXPECTED FAILURE. Two separate VerA gaps are in play and only the
// first is a chapter-10 defect: the preprocessor marks `default_transition
// `.ignored` and discards the 4n, and codegen implements transition() as a
// first-order lag (zTransition/transitionTau) rather than §4.5.8's linear ramp,
// whose per-step slope exceeds 1/4n at the start. Fixing the directive alone
// leaves bound 2 failing; that residue is a §4.5.8 bug, not a §10.3 one.
//
//! lrm 10.3
//! lrm 10.3:1000
//! bias V(n) = 0
//! wave V(in) = 0, 1, 1, 1, 1, 1, 0
//! time 0, 1n, 2n, 3n, 4n, 5n, 6n, 7n, 8n, 9n, 10n
//! checks 33
//! analysis tran
//! print none
`default_transition 4n
`include "check.vh"
module ch10_default_transition_ramp(in, n);
  inout in, n;
  electrical in, n;
  real defaulted, explicit;
  analog begin
    defaulted = transition(V(in, n));
    explicit = transition(V(in, n), 0, 4n, 4n);
    `CHECKEQ("`default_transition supplies the rise and fall time of an argument-free filter",
             defaulted, explicit, 0.0);
    if ($abstime <= 5n) begin
      `CHECKI("the rising ramp is no faster than 1/4n",
              defaulted <= $abstime/4n + 1e-12, 1);
      `CHECKI("the rising ramp is no slower than 1/4n",
              defaulted >= ($abstime - 1n)/4n - 1e-12, 1);
    end else begin
      // The input falls in (5n,6n]. A 4 ns fall reaches zero in (9n,10n].
      `CHECKI("the falling ramp is no faster than 1/4n",
              defaulted >= (9n - $abstime)/4n - 1e-12, 1);
      `CHECKI("the falling ramp is no slower than 1/4n",
              defaulted <= (10n - $abstime)/4n + 1e-12, 1);
    end
    I(in, n) <+ 0.0;
  end
endmodule
