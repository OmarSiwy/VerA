// §10.1's scope sentence is what makes `default_nettype restorable: "The scope
// of compiler directives extends from the point where it is processed, across
// all files processed, TO THE POINT WHERE ANOTHER COMPILER DIRECTIVE SUPERSEDES
// IT or the processing completes."
//
// So `none` is not a property of the compilation, it is a property of a REGION,
// and a later `` `default_nettype wire `` ends that region. IEEE Std 1364 §19.2
// names `wire` as the state a stream starts in ("If no `default_nettype
// directive is present ... implicit nets are of type wire"), which is why it is
// the word that restores rather than a bare form: §19.2 has no bare form.
//
// This file is 52 with the second directive added, and the verdict flips: `link`
// sits in the `wire` region, so §3.6.5's implicit net is legal again and the
// design elaborates. Delete the `` `default_nettype wire `` line and the file
// becomes 52, E0367 and all — which is the discrimination, since a tool that
// latched `none` for the whole compilation passes 52 and fails this.
//
// The undeclared structural connection is a FREE midpoint between two equal
// resistors. It must solve to 0.75 V. A parser that simply drops the instance
// or its implicit connection cannot pass the child-terminal observations.
//
//! lrm 10.1
//! lrm 3.6.5
//! lrm 2.8.4
//! lrm 2.8.4:2
//! lrm 3.6.5:1000
//! lrm 10.1:1000
//! bias V(p) = 1.5
//! solve
//! checks 3
`include "check.vh"
`default_nettype none
`default_nettype wire
module ch10_nettype_wire_child(a, b);
    inout a, b;
    electrical a, b;
    analog I(a, b) <+ 0.001 * V(a, b);
endmodule

module ch10_default_nettype_wire_restores_implicit_nets(p);
    inout p;
    electrical p;
    electrical g;
    ground g;

    ch10_nettype_wire_child u(p, link);
    ch10_nettype_wire_child v(link, g);

    analog begin
        `CHECKX("the implicit net is legal again inside the `wire region", V(p), 1.5);
        `CHECK("the undeclared structural midpoint is solved through the first instance", V(u.b), 0.75, 1e-12);
        `CHECK("the second instance receives that same implicit connection", V(v.a, v.b), 0.75, 1e-12);
    end
endmodule
