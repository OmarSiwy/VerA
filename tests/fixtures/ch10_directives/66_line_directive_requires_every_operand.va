// §10.7: "A `line directive (as defined in IEEE Std 1364 Verilog) changes
// `__LINE__ and may change `__FILE__ as well." IEEE 1364-2005 §19.7, physical
// page 357, Syntax 19-7:
//
//     line_compiler_directive ::= `line number "filename" level
//
// with no brackets, and the prose: "All parameters in the `line directive are
// required." The level "shall be 0, 1, or 2" and the number "shall be a
// positive integer".
//
// The directive below gives a number and a file name and stops: the level is
// missing, so the directive is illegal. (19 and 44 in this directory write the
// complete `line 100 "virtual.va" 0 and are the legal half.)
//
// E0128 is VerA's "malformed `line directive".
//
//! lrm 10.7
//! reject-only E0128
`include "disciplines.vams"
`line 10 "virtual.va"
module ch10_line_directive_requires_every_operand(p, n);
  inout p, n; electrical p, n;
  analog I(p, n) <+ V(p, n);
endmodule
