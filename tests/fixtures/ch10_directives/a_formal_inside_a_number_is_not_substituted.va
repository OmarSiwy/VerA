// IEEE 1364 §19.3.1, which §10.4 adopts for `define: "The text specified for
// macro text shall not be split across the following lexical tokens:
// comments, numbers, strings, identifiers, keywords, operators." A number is
// one token, so a formal can only replace a whole identifier token; the `e`
// of an exponent and the `k` of a §2.6.1 scale factor are letters inside a
// number, not identifiers.
//
//   `F(2.0) -> (1e-3*2.0)  = 0.002   (substituting the exponent letter gives
//                                     (12.0-3*2.0) = 6.0)
//   `G(1.0) -> (2k + 1.0)  = 2001.0  (substituting the scale letter gives
//                                     (21.0 + 1.0) = 22.0)
//
// 2001.0 is exact. 0.002 is fl(1e-3)*2, exact because scaling by two
// does not round, but compared with a tolerance so the check does not depend
// on it.
//
//! lrm 10.4
//! bias V(p) = 0.5
`define F(e) (1e-3*e)
`define G(k) (2k + k)
`include "check.vh"
module d10_a_formal_inside_a_number_is_not_substituted(p, n);
  inout p, n; electrical p, n;
  analog begin
    `CHECK("exponent e is not the formal e", `F(2.0), 0.002, 1e-15);
    `CHECKX("scale factor k is not the formal k", `G(1.0), 2001.0);
    I(p,n) <+ V(p,n);
  end
endmodule
