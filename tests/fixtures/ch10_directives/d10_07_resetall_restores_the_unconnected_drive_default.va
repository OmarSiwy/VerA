// AMS §10.1 imports IEEE 1364 compiler directives. IEEE §19.6 resets
// directive state, and §19.9 explicitly includes the effect of
// `nounconnected_drive. IEEE §19.3 says the text macro facility is not
// affected: user macros survive `resetall. The separate
// audit_macro_resetall_preserves_user.va checks that behavior.
//
// A first child and its wrapper appear inside an `unconnected_drive pull1
// region; the second pair appear after `resetall. Keeping each definition
// beside its instantiation makes this fixture test the reset boundary.
// The driven first child distinguishes support for the directive from a
// compiler that ignores both directives and leaves both children floating.
//
// `resetall also withdraws default disciplines (AMS §10.2), so every
// module here declares its electrical discipline explicitly. The position
// of the later check.vh include does not test or depend on macro erasure.
//
// THE ORACLE, derived here and not copied.
//
//   mi.u.a — declared and instantiated while `unconnected_drive pull1 is in
//            force. The pull holds the unconnected input at 1 of the potential
//            nature's units; that the digit is one volt rather than some other
//            level is 58's argument and this file inherits it, the load-bearing
//            half being that the port is DRIVEN AT ALL. V(mi.u.a) = 1.0, and
//            with `b` bound to `p` at 0.5 V the child's one 1 kΩ resistor
//            carries I(a,b) = 0.001 * (1.0 - 0.5) = +5.0e-4 A, a->b. The sign
//            is positive because `a` is the high end; -5.0e-4 is the pull0
//            case and belongs to fixture 06.
//   mo.u.a — after the `resetall. Nothing drives it, so §1.3.2 KCL at `a` has
//            exactly one term, that resistor's current, which must therefore be
//            zero; §1.3.1 then makes the branch potential of a zero-current
//            resistor zero, so `a` sits wherever `b` does, at V(p) = 0.5.
//            V(mo.u.a) = 0.5 and I(mo.u.a, mo.u.b) = 0.
//
// 1.0, 0.5 and 0.0 are binary-exact; 5e-4 is 0.001's double halved, exact
// scaling by a power of two, so it is the same double the solver computes.
// CHECKX with no tolerance throughout, as in 06.
//
// WHAT ELSE FAILS IT. A tool that implements `resetall by CLEARING the
// directive's positional event list rather than by appending a reset event gets
// the second pair right and breaks ch10_directives/58, whose region is still
// open when its own module is parsed. The positional reading is the only one
// that satisfies both files.
//
//! lrm 10.1
//! lrm 6.2.2
//! bias V(p) = 0.5
//! solve
`unconnected_drive pull1
module d10_resetall_open_child(a, b);
    input a;
    inout b;
    electrical a, b;
    analog I(a, b) <+ 0.001 * V(a, b);
endmodule

module d10_resetall_open_wrapper(b);
    inout b;
    electrical b;
    d10_resetall_open_child u( , b);
endmodule
`resetall
`include "check.vh"

module d10_resetall_closed_child(a, b);
    input a;
    inout b;
    electrical a, b;
    analog I(a, b) <+ 0.001 * V(a, b);
endmodule

module d10_resetall_closed_wrapper(b);
    inout b;
    electrical b;
    d10_resetall_closed_child u( , b);
endmodule

module d10_resetall_restores_the_unconnected_drive_default(p);
    inout p;
    electrical p;

    d10_resetall_open_wrapper   mi(p);
    d10_resetall_closed_wrapper mo(p);

    analog begin
        `CHECKX("above the `resetall the pull is in force", V(mi.u.a), 1.0);
        `CHECKX("and drives: 0.001*(1.0 - 0.5) A flows a->b", I(mi.u.a, mi.u.b), 5e-4);
        `CHECKX("`resetall put §19.10 back to its default, so this input floats", V(mo.u.a), 0.5);
        `CHECKX("and no current flows into it", I(mo.u.a, mo.u.b), 0.0);
        I(p) <+ 0.0;
    end
endmodule
