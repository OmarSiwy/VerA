// §10.3 scopes the default to filters "which follow this directive and DO NOT
// HAVE rise time and fall time arguments specified"; §4.5.8 says it from the
// filter's side: "If neither rise_time nor fall_time are specified or are equal
// to zero (0.0), the rise and fall time default to the value defined by
// `default_transition."
//
// So a directive and an explicit argument list are not two ways of saying the
// same thing — the argument wins, and only where there is no argument does the
// directive reach. No fixture put the two forms side by side, so two errors
// were invisible: a directive that stomps explicit arguments, and a default
// applied to every filter unconditionally.
//
// One directive (8n, outside the module — §10.3), one step input, two filters,
// and bounds that separate them. §4.5.8 makes the output "a piecewise linear
// function over time" traversing the full 0 -> 1 excursion in the transition
// time, so a filter with transition time tr obeys
//
//     (t - 1n)/tr  <=  out(t)  <=  t/tr
//
// at every sampled t up to tr. The one-nanosecond slack is the sampling grid's
// own ambiguity about when a step falling in (0, 1n] is detected; the LRM does
// not fix that, so neither does the fixture. The two bounds are unconditional
// and hold at all five points, and at t = 4n they are DISJOINT: the defaulted
// filter is confined to [0.375, 0.5] and the explicit one to [0.75, 1.0]. A
// tool that applied 8n to both, or 4n to both, lands outside one of them.
//
// Each of the four bounds carries an explicit 1e-12 epsilon, and that is not
// slack in the rule. With `//! wave V(in) = 0, 1` on this grid the step lands
// at EXACTLY t = 1n (a short wave list holds its last value), so a correct
// ramp starting at the step sits bit-for-bit ON its lower bound and one that
// starts at the previous sample sits ON its upper. An inequality whose two
// sides are the same real reached by two different routes is then decided by
// the last ulp, which the LRM says nothing about. 1e-12 is some 4000 ulp at
// 1.0, and the gap between the two intervals at t = 4n is 0.25, so the
// epsilon costs the fixture none of the separation above.
//
// The CHECKEQ adds §10.3's sentence itself for the argument-free filter: 8n is
// what it must have taken, exactly, same kernel both sides.
//
// NOTE ON THE EXPECTED FAILURE, identical to 38's and 39's: VerA's preprocessor
// marks `default_transition `.ignored` and discards the 8n, and codegen
// implements transition() as a first-order lag rather than §4.5.8's linear
// ramp. The second is a §4.5.8 defect and will outlive the first.
//
//! lrm 10.3
//! lrm 4.5.8
//! bias V(n) = 0
//! wave V(in) = 0, 1
//! time 0, 1n, 2n, 3n, 4n
//! analysis tran
//! print none
//! xfail VerA discards `default_transition (preprocessor marks it .ignored), so the argument-free filter falls back to a simulator default instead of the directive's 8n
`default_transition 8n
`include "check.vh"
module ch10_transition_arguments_override_default(in, n);
  inout in, n;
  electrical in, n;
  analog begin
    `CHECKEQ("the argument-free filter takes the directive's 8n",
             transition(V(in, n)), transition(V(in, n), 0, 8n, 8n), 0.0);
    `CHECKI("the defaulted filter is no faster than 1/8n",
            transition(V(in, n)) <= $abstime/8n + 1e-12, 1);
    `CHECKI("the defaulted filter is no slower than 1/8n",
            transition(V(in, n)) >= ($abstime - 1n)/8n - 1e-12, 1);
    `CHECKI("the explicit argument keeps its own 4n against the directive",
            transition(V(in, n), 0, 4n, 4n) <= $abstime/4n + 1e-12, 1);
    `CHECKI("the directive does not slow the explicit filter to 8n",
            transition(V(in, n), 0, 4n, 4n) >= ($abstime - 1n)/4n - 1e-12, 1);
    I(in, n) <+ 0.0;
  end
endmodule
