// §10.6: the version specifiers "1364-1995", "1364-2001", "1364-2005" and
// "VAMS-2.3" "must also be supported", and "1364-2001" selects the keywords of
// IEEE Std 1364-2001. The LRM says of its own `sin` example that "specifying the
// "1364-1995" or "1364-2001" Verilog keyword lists would also work" — `sin` is
// reserved in Verilog-AMS (Annex B) but in none of the 1364 lists.
//
// Legality alone is not an assertion, so the check is what `sin` then DENOTES:
// a port of this module, at the potential the solver holds it at. §1.3.1 makes
// the branch potential the node difference, 0.75 - 0.25 = 0.5 V. A tool that
// leaked the Verilog-AMS reserved set through the directive never reaches this
// line; one that bound `sin` to the §4.3.2 sine function instead of the port
// cannot produce 0.5.
//
// CHECKX (exact) rather than CHECK: 0.75 and 0.25 are both binary-exact, so
// their difference is exactly 0.5, and CHECKX needs no `abs` — which is itself
// a Verilog-AMS-only identifier and so out of the reserved set in force here.
//
// This file writes `analog` and `<+` inside a 1364-set region, which §10.6
// permits only under the reading spelled out in 16's header: the directives
// "only specify the set of identifiers that are reserved as keywords" and "do
// not affect the semantics, tokens, and other aspects of the Verilog-AMS
// language". A compiler that instead removes Verilog-AMS constructs along with
// their reserved words cannot parse this body. See 16.
//
//! lrm 10.6
//! lrm 10.6:1
//! bias V(sin) = 0.75, V(n) = 0.25
`begin_keywords "1364-2001"
`include "check.vh"
module ch10_begin_keywords_1364_2001(sin, n);
  inout sin, n; electrical sin, n;
  analog begin
    `CHECKX("sin is a port under the 1364-2001 keyword set", V(sin,n), 0.5);
    I(sin,n) <+ V(sin,n);
  end
endmodule
`end_keywords
