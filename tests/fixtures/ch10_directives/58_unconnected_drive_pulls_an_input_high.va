// §10.1 Table 10-1 carries `unconnected_drive over from IEEE Std 1364
// unchanged, and 1364 §19.9 gives it its one effect: an UNCONNECTED INPUT PORT
// of a module declared between `unconnected_drive and `nounconnected_drive is
// pulled — to 1 for `pull1, to 0 for `pull0 — instead of being left undriven.
//
// §6.2.2 supplies the other half of the premise: "A blank port connection shall
// represent the situation where the port is not to be connected". `u( , p)`
// below is that blank, so `a` is the clause's subject.
//
// WHAT A PULL IS IN THE ANALOG KERNEL, since §19.9 describes a logic level and
// a drive STRENGTH, and this engine has neither. It has exactly one way of
// saying "held at a level": a potential source between the node and the
// reference. So `pull1` holds the unconnected input at 1 of the potential
// nature's units, which for `electrical` is one volt. The number is the weakest
// part of the claim and the fixture's header says so; what is NOT weak, and
// what 60 exists to contrast, is that the port is DRIVEN AT ALL.
//
// THE ORACLE. The child is one 1 kΩ resistor between its two ports, so §1.3.2
// KCL at `a` has two terms: the resistor's current and the pull source's. With
// the pull in force `a` is clamped, so V(u.a) = 1 exactly — a binary-exact
// value, hence CHECKX. 60 is the same module with `nounconnected_drive in force
// instead, where the only KCL term at `a` is the resistor's, so no current can
// flow and V(u.a) follows V(p) = 0.5 instead. One directive, two numbers.
//
// `//! solve` is what makes the question askable: by default the harness ties
// every unknown no directive names to the reference, and V(u.a) is precisely
// the unknown under test. `p` stays biased, because a port is what the netlist
// supplies.
//
//! lrm 10.1
//! inherited IEEE 1364-2005 19.9
//! lrm 6.2.2
//! lrm 6.2.2:3
//! bias V(p) = 0.5
//! solve
`include "check.vh"
`unconnected_drive pull1
module ch10_pull1_child(a, b);
    input a;
    inout b;
    electrical a, b;
    analog I(a, b) <+ 0.001 * V(a, b);
endmodule
`nounconnected_drive

module ch10_unconnected_drive_pulls_an_input_high(p);
    inout p;
    electrical p;

    ch10_pull1_child u( , p);

    analog begin
        `CHECKX("`unconnected_drive pull1 drives the blank input port", V(u.a), 1.0);
        I(p) <+ 0.0;
    end
endmodule
