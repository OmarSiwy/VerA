// IEEE Std 1364 §19.9's other operand, carried over by §10.1 Table 10-1:
// `unconnected_drive pull0 pulls an unconnected input DOWN.
//
// The module is 58's, character for character, with the one word changed. That
// is the point of writing both: 58 alone cannot tell a compiler that honours
// the operand from one that pulls every unconnected input to 1 regardless, and
// a `pull0` fixture cannot tell one that honours it from one that leaves the
// port floating at 0. The pair does both, and 60 closes it by showing that a
// FLOATING input is not at 0 either.
//
// THE ORACLE, from §1.3.2 KCL at `a` and §1.3.1's branch potential: the source
// clamps `a` to the reference, so V(u.a) = 0 exactly, and — this is the half
// that distinguishes it from floating — current flows, because the source is a
// KCL term. The 1 kΩ resistor then carries (0 − 0.5)/1000 = −0.5 mA, which is
// the second assertion. Under `nounconnected_drive (60) that current is zero.
//
//! lrm 10.1
//! inherited IEEE 1364-2005 19.9
//! lrm 6.2.2
//! bias V(p) = 0.5
//! solve
`include "check.vh"
`unconnected_drive pull0
module ch10_pull0_child(a, b);
    input a;
    inout b;
    electrical a, b;
    analog I(a, b) <+ 0.001 * V(a, b);
endmodule
`nounconnected_drive

module ch10_unconnected_drive_pulls_an_input_low(p);
    inout p;
    electrical p;

    ch10_pull0_child u( , p);

    analog begin
        `CHECKX("`unconnected_drive pull0 holds the blank input port at the reference", V(u.a), 0.0);
        `CHECK("and it is DRIVEN, so the port resistor carries current", I(u.a, u.b), -0.0005, 1e-18);
        I(p) <+ 0.0;
    end
endmodule
