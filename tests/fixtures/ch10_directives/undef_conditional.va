// §10.4 `undef removes a macro definition, so the following `ifdef is false and
// IEEE Std 1364 §19.4 deletes the true arm: the module contributes 1.0*V(p,n),
// not 2.0*V(p,n).
//
// Each arm carries the assertion for its OWN coefficient against the value the
// surviving arm must produce, 1.0*0.5 = 0.5 at V(p,n) = 0.5. Whichever arm the
// preprocessor keeps is the one that prints, so keeping the wrong one prints
// got = 1.0 against want = 0.5 and fails.
//
//! lrm 10.4
//! bias V(p) = 0.5
`define TEMP_FEATURE
`undef TEMP_FEATURE
`include "check.vh"
module ch10_undef_conditional(p, n);
  inout p, n; electrical p, n;
  analog begin
`ifdef TEMP_FEATURE
    I(p,n) <+ 2.0*V(p,n);
    `CHECKX("undef must have deleted this arm", 2.0*V(p,n), 0.5);
`else
    I(p,n) <+ V(p,n);
    `CHECKX("undef leaves the unity arm", 1.0*V(p,n), 0.5);
`endif
  end
endmodule
