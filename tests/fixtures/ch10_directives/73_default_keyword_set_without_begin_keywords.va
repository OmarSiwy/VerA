// §10.6: "Without this directive, the set of reserved keywords in effect for
// this module shall be the implementation's default set of reserved keywords."
// The chapter's example is a module "with no `begin_keywords directive" and no
// word of what that default set contains; §10.6 leaves the choice to the
// implementation, and 33_end_keywords_restores_previous_set.va works through
// why a fixture cannot pin the default by demanding a diagnostic.
//
// What a fixture CAN pin is a property of the set the implementation actually
// uses: under VerA's default the word `logic` is an ordinary identifier, not a
// keyword. §10.6 says as much of Verilog-AMS 2023 — "'logic' is not a keyword
// in Verilog-AMS 2023, whereas it is a keyword in the IEEE Std 1800
// SystemVerilog" — and lists Annex B as exhaustive. A front end whose default
// set leaked in SystemVerilog's keywords fails this file, while a front end
// whose default is VAMS-2023 compiles it and resolves `logic` to the declared
// variable.
//
// 43_logic_is_an_identifier_vams_2023.va makes the same claim with an explicit
// `begin_keywords "VAMS-2023"; here there is no directive at all, so the module
// is governed by the default set the sentence names. 01_escaped_keyword.va and
// friends in annex_b_keywords cover the other side of the same word — the
// reserved spellings — under their own clauses.
//
// DERIVATION. V(p,n) = 0.75 - 0.25 = 0.5 V (§1.3.1), and 2.5 * 0.5 = 1.25,
// exact in binary because both operands are.
//
//! lrm 10.6
//! lrm 10.6:2
//! bias V(p) = 0.75, V(n) = 0.25
`include "check.vh"
module ch10_default_keyword_set_without_a_directive(p, n);
  inout p, n; electrical p, n;
  real logic;
  analog begin
    logic = 2.5;
    `CHECKX("the default reserved set does not contain logic", logic*V(p,n), 1.25);
    I(p,n) <+ logic*V(p,n);
  end
endmodule
