// The closing half of IEEE Std 1364 §19.9, which §10.1 Table 10-1 lists as its
// own directive: `nounconnected_drive. It restores the state a compilation
// starts in — an unconnected input port is not pulled anywhere, it is simply
// not connected.
//
// This is 58 and 59's control, and it is what makes those two say something.
// The module is theirs with the surrounding directive pair REMOVED, so the only
// difference between the three files is which §19.9 directive is in force over
// the child's declaration.
//
// THE ORACLE. With no source at `a`, §1.3.2 KCL there has exactly one term, the
// port resistor's, so its current is zero; §1.3.1 then makes the branch
// potential zero, so `a` sits wherever `b` does. `b` is bound to `p`, which the
// netlist holds at 0.5 V, so V(u.a) = 0.5 — the number the harness biased, not
// a number the directive supplied.
//
// So the three files read: pulled high → 1, pulled low → 0, not pulled → 0.5.
// A compiler that ignores §19.9 passes this one and fails the other two, which
// is the discrimination this file is here to provide rather than to claim.
//
// The ORDER of the `unconnected_drive pair around a module is pinned by 19,
// whose header reads §10.1's scope sentence ("from the point where it is
// processed ... to the point where another compiler directive supersedes it")
// onto exactly this family.
//
//! lrm 10.1
//! inherited IEEE 1364-2005 19.9
//! lrm 6.2.2
//! lrm 6.2.2:3
//! bias V(p) = 0.5
//! solve
`include "check.vh"
module ch10_undriven_child(a, b);
    input a;
    inout b;
    electrical a, b;
    analog I(a, b) <+ 0.001 * V(a, b);
endmodule

module ch10_nounconnected_drive_leaves_an_input_undriven(p);
    inout p;
    electrical p;

    ch10_undriven_child u( , p);

    analog begin
        `CHECKX("an unpulled blank input port follows the net it is tied to", V(u.a), 0.5);
        `CHECKX("and carries no current, because nothing drives it", I(u.a, u.b), 0.0);
        I(p) <+ 0.0;
    end
endmodule
