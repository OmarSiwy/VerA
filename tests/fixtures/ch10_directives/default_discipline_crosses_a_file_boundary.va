// §10.2, the clause's own file-boundary sentence — the one part of
// `default_discipline's scope that ch10_directives/41 cannot reach because 41
// writes the directive and the defaulted net into one file:
//
//     "The default discipline is applied by discipline resolution (see 7.4 and
//      Annex F) to all discrete signals without a discipline declaration that
//      appear in the text stream following the use of the `default_discipline
//      directive, until either the end of the text stream or another
//      `default_discipline directive with the qualifier (if applicable) is
//      found in the subsequent text, EVEN ACROSS SOURCE FILE BOUNDARIES."
//
// §10.1's general scope sentence says the same thing for every directive
// ("across all files processed"), and ch10_directives/57 pins it for
// `default_nettype — but 57 is a REJECTION, so it is satisfied by a tool that
// keeps the directive alive only to refuse things. This is the positive half,
// on the one §10.1 directive whose clause repeats the rule for itself, and it
// moves a number.
//
// THE SHAPE, and why it discriminates. The directive is in
// `d10_default_discipline.vh` and nothing else is; the module is here, after
// the header has been closed, and declares NO discipline for its two ports. So
// the default is the only thing in the compilation that can give `p` and `n` a
// nature, and `V` is the access function of that nature (§3.6.1). A tool that
// drops the directive at end-of-include has no discipline to resolve and dies
// at E0337 ("net has no declared discipline") — exactly as 41 does with its
// directive deleted, which 41's header records.
//
// THE ORACLE is 41's, unchanged: §1.3.1 makes the potential of a branch the
// difference of its two node potentials, 0.75 - 0.25 = 0.5 V. Both operands are
// binary-exact and so is the subtraction, hence CHECKX with no tolerance.
//
// `check.vh` is included AFTER the directive header on purpose: nothing about
// this fixture should depend on which of the two includes runs first, and
// putting the subject first makes the boundary the reader is meant to look at
// the first one in the file.
//
//! lrm 10.2
//! lrm 10.1
//! lrm 10.1:1000
//! lrm 10.2:1000
//! bias V(p) = 0.75, V(n) = 0.25
`include "d10_default_discipline.vh"
`include "check.vh"
module d10_default_discipline_crosses_a_file_boundary(p, n);
  inout p, n;
  analog begin
    `CHECKX("a default set in an included file still reaches this net", V(p, n), 0.5);
    I(p, n) <+ V(p, n);
  end
endmodule
