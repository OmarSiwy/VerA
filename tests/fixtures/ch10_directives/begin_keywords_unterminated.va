// §10.6 says what an unclosed `begin_keywords does, and it is not an error:
// the directive "affects all source code that follows the directive, EVEN
// ACROSS SOURCE CODE FILE BOUNDARIES, until the matching `end_keywords
// directive is encountered."
//
// A file whose `begin_keywords is still open at its last line is precisely the
// case that sentence exists to describe — the set carries on into whatever the
// tool compiles next. Chapter 10 states no diagnostic for it anywhere, and the
// directive it extends (§10.6's first sentence: "extends the `begin_keywords
// and `end_keywords compiler directives from IEEE Std 1364 Verilog") has the
// same cross-file scope there. This fixture used to demand a rejection, which
// inverted the clause: it FAILed every compiler that implemented the sentence
// and passed only one that did not.
//
// So the requirement is positive, and it is the one thing an unterminated pair
// can be observed to do inside a single file: the selected set stays in force
// through the end of the stream. Under "1364-2005" `sin` is not reserved
// (§10.6's own worked example), so the port name is legal all the way down —
// there is no `end_keywords to put the Verilog-AMS set back before the module
// is parsed.
//
// Legality alone is not an assertion, so the check is what `sin` then DENOTES:
// a port of this module, at the potential the solver holds it at. §1.3.1 makes
// the branch potential the node difference, 0.75 - 0.25 = 0.5 V, exact in
// binary because both operands are. A tool that quietly reverted to the
// Verilog-AMS set at some point before the module never reaches this line.
//
// As in 16, 25 and 26 the body writes `analog` inside a "1364-2005" region;
// see the note in 16 for why §10.6 permits that.
//
//! lrm 10.6
//! lrm 10.6:1002
//! bias V(sin) = 0.75, V(n) = 0.25
`begin_keywords "1364-2005"
`include "check.vh"
module ch10_begin_keywords_unterminated(sin, n);
  inout sin, n;
  electrical sin, n;
  analog begin
    `CHECKX("the unterminated 1364-2005 set is still in force at the module", V(sin, n), 0.5);
    I(sin, n) <+ V(sin, n);
  end
endmodule
