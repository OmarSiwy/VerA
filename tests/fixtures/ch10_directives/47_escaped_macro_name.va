// The permissive half of Syntax 10-3, and the reason 46 is a real rule rather
// than a drafting accident:
//
//   formal_argument_identifier ::= simple_identifier
//   text_macro_identifier      ::= identifier
//
// Annex A.9.3: identifier ::= simple_identifier | escaped_identifier. The
// production for the macro NAME is the wider one, deliberately — the standard
// wrote two different nonterminals into adjacent lines of the same syntax box.
// So an escaped macro name is legal and must expand, and a preprocessor that
// lexes the name with the same routine it uses for a formal rejects source the
// LRM licenses.
//
// §2.7.1 fixes the lexing on both sides: an escaped identifier starts with a
// backslash and ends at the first white space, and neither the backslash nor
// the terminating white space is part of the name. Hence the space before the
// macro text in the definition, and the space before the `*` at the use — with
// the space removed the name would run on into the operator.
//
// The value is written into the model rather than merely echoed, so the
// assertion fails a preprocessor that recognises the name but drops the text:
// 3.0 * (0.75 - 0.25) = 1.5, exact in binary64 (§1.3.1 for the branch
// potential, all three operands binary-exact).
//
//! lrm 10.4
//! bias V(p) = 0.75, V(n) = 0.25
//! xfail VerA rejects an escaped macro name with E0109 "`define requires a macro name"; its `define name lexer accepts only a simple identifier, which Syntax 10-3 requires of the FORMAL and not of the name
`define \MY-GAIN 3.0
`include "check.vh"
module ch10_escaped_macro_name(p, n);
  inout p, n; electrical p, n;
  analog begin
    `CHECKX("the escaped macro name expands to its text", `\MY-GAIN *V(p, n), 1.5);
    I(p, n) <+ `\MY-GAIN *V(p, n);
  end
endmodule
