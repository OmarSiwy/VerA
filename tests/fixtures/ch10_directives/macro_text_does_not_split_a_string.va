// §10.4: "The `define and `undef compiler directives are described in IEEE Std
// 1364 Verilog." IEEE 1364-2005 §19.3.1, physical page 351: "The text
// specified for macro text shall not be split across the following lexical
// tokens: Comments, Numbers, Strings, Identifiers, Keywords, Operators", and
// then, verbatim, "The following is illegal syntax because it is split across
// a string:
//
//     `define first_half "start of string
//     $display(`first_half end of string");"
//
// That example is below, with $strobe for the analog context (§9.4.1). A
// tool that pastes the text anyway prints "start of string end of string";
// the clause says the file is illegal.
//
// E0145 is VerA's code for this rule.
//
//! lrm 10.4
//! reject-only E0145
`include "disciplines.vams"
`define first_half "start of string
module ch10_macro_text_does_not_split_a_string(p, n);
  inout p, n; electrical p, n;
  analog begin
    $strobe(`first_half end of string");
    I(p, n) <+ V(p, n);
  end
endmodule
