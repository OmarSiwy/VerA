// §10.3 `default_transition supplies the rise and fall time for "all transition
// filters which follow this directive and do not have rise time and fall time
// arguments specified" — the argument-free form used below. That value shapes
// the ramp BETWEEN levels, and §4.5.8 gives the filter exactly one value that
// does not depend on the ramp: "In DC analysis, transition() passes the value
// of the expr directly to its output."
//
// So at the DC point the argument-free filter is the identity on its operand.
// 3.0*V(p,n) + 1.5 at V(p,n) = 0.5 is 1.5 + 1.5 = 3.0, exactly; a bare constant
// operand would not tell pass-through apart from a filter answering its own
// default, which is why the operand is scaled and offset.
//
// The 1 ns itself is deliberately NOT pinned. VerA's preprocessor accepts
// `default_transition and discards it (lib/frontend/preprocessor.zig marks it
// `.ignored`), so nothing in this file can depend on the number; and with the
// directive absent §10.3 leaves the transition time to the simulator, so there
// would be no LRM digit to write either.
//
//! lrm 10.3
//! bias V(p) = 0.5
`default_transition 1n
`include "check.vh"
module ch10_default_transition(p, n);
  inout p, n; electrical p, n;
  analog begin
    `CHECKX("DC passes the expr straight through a default-timed filter",
            transition(3.0*V(p,n) + 1.5), 3.0);
    I(p,n) <+ V(p,n);
  end
endmodule
