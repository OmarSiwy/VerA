// IEEE 1364-2005 19.3/19.3.1/19.3.2, physical pages 380-382, inherited by
// VAMS 10.4: nested macros expand at use rather than definition; the newest
// definition wins; undef removes a user macro.
// OUTER is defined before INNER exists. Its uses must observe respectively
// 2.0, then 5.0. A conditional after undef
// must select the absent arm (1 rather than 0). All values are exact literals.
// Definitions inside the module also exercise the absence of module scoping.
// Reset preservation is isolated in audit_macro_resetall_preserves_user.va;
// its known failure must not mask these independent expansion observations.
//! lrm 10.4
//! checks 3
`include "check.vh"
`include "disciplines.vams"
`define AUDIT_OUTER `AUDIT_INNER
module audit_macro_late_binding(p);
  inout p; electrical p;
  real first_value, second_value, absent;
  analog begin
`define AUDIT_INNER 2.0
    first_value = `AUDIT_OUTER;
`define AUDIT_INNER 5.0
    second_value = `AUDIT_OUTER;
`undef AUDIT_INNER
`ifdef AUDIT_INNER
    absent = 0.0;
`else
    absent = 1.0;
`endif
    `CHECKX("nested macro defined later", first_value, 2.0);
    `CHECKX("latest nested definition", second_value, 5.0);
    `CHECKX("undef removes the user macro", absent, 1.0);
    I(p) <+ V(p);
  end
endmodule
