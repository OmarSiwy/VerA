// §10.1 / annex D.2, matching the cites below. (This header opened "§10.5"
// until a review caught it; §10.5 is predefined macros, while `include is the
// §10.1 table row that defers to IEEE Std 1364 and the numbers are D.2's.)
//
// `include "constants.vams" brings in the standard physical
// constants. The header is self-guarded (`ifdef CONSTANTS_VAMS), so including it
// after the implicit prelude must not redefine anything.
//
// Annex D.2 fixes both digits and the DEFAULT selection, which is the part a
// tool gets wrong. The header defines five Boltzmann variants and picks one at
// the bottom of a nested `ifdef chain: with none of PHYSICAL_CONSTANTS_NIST2018,
// _SPICE, _OLD or _NIST2010 defined, the final `else takes
//
//   `define P_K `P_K_NIST1998   ->  1.3806503e-23   J/K
//   `define P_C                     2.99792458e8    m/s   (no variants)
//
// The product pins which variant is in force without restating either literal:
// the nearest neighbours give 1.3806488e-23*P_C = 4.13908097e-15 (NIST2010) and
// 1.380649e-23*P_C = 4.13908157e-15 (NIST2018), both ~1e-6 relative away and so
// far outside the 1e-15 relative band asserted here.
//
//   1.3806503e-23 * 2.99792458e8 = 4.139085470754374e-15
//
// (that is the correctly-rounded double product; verified in binary64.)
//
//! lrm 10.1
//! lrm D.2
`include "check.vh"
`include "constants.vams"
module ch10_include_constants(p, n);
  inout p, n; electrical p, n;
  analog begin
    `CHECKR("annex D.2 defaults P_K to the NIST1998 value: P_K*P_C", `P_K*`P_C, 4.139085470754374e-15, 1e-15);
    I(p,n) <+ `P_K*`P_C*V(p,n);
  end
endmodule
