// §10.5: "Verilog-AMS HDL version 2.2 introduced a number of extensions to
// support compact modeling. ... This predefined macro is called
// __VAMS_COMPACT_MODELING__ and shall be defined during the parsing of
// Verilog-AMS source text if and only if all the compact modeling extensions
// are supported by the simulator."
//
// THE SET. "The compact modeling extensions" are the v2.1 -> v2.2 additions,
// Annex G Table G.3 (items 1-28; item 26 is this macro, item 13 is not
// printed). d10_10 established direction 1 for items 3 (localparam), 8 (ddx),
// 17 ($param_given) and 18 ($mfactor). This file takes the rest of the items
// that state a value a fixture can derive, each under the macro's `ifdef, so a
// tool that defines the macro and lacks one of them fails here:
//
//   item 3   aliasparam and string parameters (§3.4.6, §3.4.7). The alias
//            names rv; nothing overrides either, so rv = 2.0 and
//            (mode == "fast") = 1 (§3.3's string equality).
//   item 5   the added bitwise operator ~^ (Table 4-2, §4.2.9): 3 ~^ 5 =
//            ~(3 ^ 5) = ~6 = -7 in a 32-bit signed integer.
//   item 12  analog function output arguments (§4.7): twice_plus(1.5, y2)
//            returns 1.5 + 1 = 2.5 and writes y2 = 2 * 1.5 = 3.0.
//   item 14  above() (§5.10.3.2): "it also triggers during initialization or
//            dc analysis"; V(p,n) - 0.25 = 0.25 > 0 at this dc point, so the
//            body runs and ab = 1.0.
//   item 17  $port_connected (§9.19): "one (1) if the port was connected to a
//            net ... when the module was instantiated, and zero (0)
//            otherwise". The child is instantiated with `a` connected and `b`
//            open: 1 and 0.
//   item 18  $xposition (§9.18, Table 9-29): top-level value 0.0 m, unchanged
//            when no instance specifies one.
//   item 20  $simparam (§9.15) with a default, for a name no simulator
//            defines: the default, 4.5.
//   item 25  $table_model (§9.21) over the literal arrays {0, 1} -> {0, 2},
//            linear interpolation at 0.5: 1.0.
//   item 28  `M_TWO_PI (§D.3, the corrected value) is 2*`M_PI; CHECKEQ, since
//            the identity is the claim and no digits are written for it.
//
// This samples extension behavior only. The complete capability biconditional
// is checked by tests/host.py using actual
// host capability introspection independent of this predefined macro.
//
// Not re-asserted here, each owned by its own fixtures: items 1, 4, 15, 16
// (attributes, ch02/ch03), 2 (output variables, a host-visible export with no
// transcript observable), 6, 7, 9, 10, 11 (wording or table changes, no new
// construct), 19 (paramsets, ch06_hierarchy), 21 ($random/$rdist_ Monte-Carlo,
// ch09 a10_*), 22 ($debug), 23 (%r, r_format_in_the_digital_context.va),
// 24 ($limit and $discontinuity(-1), ch09 177-184), 27 (keywords, annex_b).
//
//! lrm 10.5
//! bias V(p) = 0.75, V(n) = 0.25
`include "constants.vams"
`include "check.vh"
module d10_18_port_probe(a, b);
  inout a, b; electrical a, b;
  integer pa, pb;
  analog begin
`ifdef __VAMS_COMPACT_MODELING__
    pa = $port_connected(a);
    pb = $port_connected(b);
    `CHECKI("G.3 item 17: $port_connected of a connected port is 1", pa, 1);
    `CHECKI("G.3 item 17: and of an open one is 0", pb, 0);
`endif
    I(a) <+ V(a);
  end
endmodule
module d10_18_compact_modeling_extension_set(p, n);
  inout p, n; electrical p, n;
`ifdef __VAMS_COMPACT_MODELING__
  parameter real rv = 2.0;
  aliasparam ra = rv;
  parameter string mode = "fast";
  real ab, y2, f2, tb, sp, xp;
  analog function real twice_plus;
    input x; output y; real x, y;
    begin
      y = 2.0 * x;
      twice_plus = x + 1.0;
    end
  endfunction
  d10_18_port_probe probe(p, );
`endif
  analog begin
`ifdef __VAMS_COMPACT_MODELING__
    @(above(V(p, n) - 0.25)) ab = 1.0;
    f2 = twice_plus(1.5, y2);
    tb = $table_model(0.5, {0.0, 1.0}, {0.0, 2.0});
    sp = $simparam("vera_no_such_parameter", 4.5);
    xp = $xposition;
    `CHECKX("G.3 item 3: an aliased parameter keeps its default", rv, 2.0);
    `CHECKI("G.3 item 3: a string parameter compares equal to its default", mode == "fast", 1);
    `CHECKI("G.3 item 5: 3 ~^ 5 is ~6", 3 ~^ 5, -7);
    `CHECKX("G.3 item 12: the function returns x + 1", f2, 2.5);
    `CHECKX("G.3 item 12: and writes its output argument 2x", y2, 3.0);
    `CHECKX("G.3 item 14: above() fires at the dc point", ab, 1.0);
    `CHECKX("G.3 item 25: $table_model interpolates the literal table", tb, 1.0);
    `CHECKX("G.3 item 20: $simparam returns the default of an unknown name", sp, 4.5);
    `CHECKX("G.3 item 18: $xposition at the top is 0.0", xp, 0.0);
    `CHECKEQ("G.3 item 28: `M_TWO_PI is twice `M_PI", `M_TWO_PI, 2.0 * `M_PI, 0.0);
`else
    `CHECKX("the absent-macro branch retains the biased input", V(p,n), 0.5);
`endif
    I(p, n) <+ V(p, n);
  end
endmodule
