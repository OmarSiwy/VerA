// §10.3: "If a `default_transition directive is not used in the description,
// transition_time is controlled by the simulator."
//
// That is an implementation-defined sentence, so there is no digit to assert
// about the time itself. What can be pinned is that a description with NO
// directive is still legal and that transition() executes under whatever time
// the simulator chose: §4.5.8 gives the filter exactly one value that does not
// depend on the ramp — "In DC analysis, transition() passes the value of the
// expr directly to its output."
//
// So the DC point is the identity on the operand. 3.0*V(p,n) + 1.5 at
// V(p,n) = 0.5 is 1.5 + 1.5 = 3.0, exactly. The operand is scaled and offset
// so that a filter answering a default of its own instead of its operand cannot
// coincide with the want.
//
// The directive's absence is the whole experiment: 03_default_transition.va is
// the same file with `default_transition 1n in force, so the pair separates
// "simulator-controlled" from "directive-supplied" without either file
// asserting a number the LRM does not fix.
//
//! lrm 10.3
//! lrm 10.3:1002
//! lrm 4.5.8
//! bias V(p) = 0.5
`include "check.vh"
module ch10_transition_without_default(p, n);
  inout p, n; electrical p, n;
  analog begin
    `CHECKX("with no directive, the simulator supplies transition_time",
            transition(3.0*V(p,n) + 1.5), 3.0);
    I(p,n) <+ V(p,n);
  end
endmodule
