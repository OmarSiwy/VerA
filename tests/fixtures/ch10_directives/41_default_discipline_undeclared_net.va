// §10.2's positive effect: "The default discipline is applied by discipline
// resolution (see 7.4 and Annex F) to all discrete signals WITHOUT A DISCIPLINE
// DECLARATION that appear in the text stream following the use of the
// `default_discipline directive".
//
// 01, 02 and 24 all issue the directive and then declare `electrical p, n;`
// anyway, so in every one of them the directive is inert — 01's own header says
// "no value here can depend on it". This file is the same shape with the
// declaration REMOVED, which is the only shape the sentence above talks about:
// p and n are ports with no discipline of their own, so the default is the sole
// thing that can give them a nature, and V() is the access function of that
// nature (§3.6.1). Take the directive away and there is no electrical potential
// to read.
//
// The oracle is §1.3.1: the potential of a branch is the difference of its two
// node potentials, 0.75 - 0.25 = 0.5 V. Both operands are binary-exact, so the
// subtraction is exact and CHECKX is the right form.
//
// HONEST LIMIT, so the next reader does not over-read a green tick: VerA does
// not run discipline resolution at all — it discards `default_discipline in the
// preprocessor and resolves any declared nature's access function against a
// bare port regardless. Delete the directive from this file today and it still
// compiles and still reads 0.5. So this fixture passes without discriminating,
// and it is the spec record of the rule rather than a live check of it; 35 and
// 36 carry the discriminating (negative) half as declared xfails. When
// resolution lands, this file starts doing work with no edit.
//
//! lrm 10.2
//! bias V(p) = 0.75, V(n) = 0.25
//! xfail VerA discards `default_discipline in the preprocessor (marked .ignored) and runs no discipline resolution, so `p` and `n` reach lowering with no discipline at all and `V(p, n)` is now E0337 "net has no declared discipline"; the directive is the only thing that could supply one
`default_discipline electrical
`include "check.vh"
module ch10_default_discipline_undeclared_net(p, n);
  inout p, n;
  analog begin
    `CHECKX("the defaulted net has the electrical potential access", V(p, n), 0.5);
    I(p, n) <+ V(p, n);
  end
endmodule
