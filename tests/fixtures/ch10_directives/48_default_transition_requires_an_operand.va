// The other half of 45: a directive's operands are grammar, not free text.
//
//   Syntax 10-2:  `default_transition transition_time
//                 transition_time ::= constant_expression
//
// No brackets round the operand: it is mandatory. A bare `default_transition
// is therefore a syntax error, and specifically NOT a request for the
// simulator default — §10.3 already spells out what happens when there is no
// directive at all ("If a `default_transition directive is not used in the
// description, transition_time is controlled by the simulator"), so a tool
// that quietly reads the operand-less form as that case has thrown away a line
// the author wrote and reported nothing.
//
// Split out of 45 rather than merged with it: the runner requires every
// `//! reject substring to appear in the diagnostics of ONE compile, so the
// merged form demanded that a compiler diagnose both this rule and Syntax
// 10-1's qualifier alternation from the same source — which a front end that
// stops at the first bad directive will not do however correctly it
// implements them both.
//
// A substring rather than a code because VerA has no code for this rule yet.
// It is the directive's own spelling, which is weaker than the term-of-art 45
// can use: any diagnostic quoting the offending line satisfies it. That is
// tolerable only because the bare directive is the sole defect in the file, so
// there is nothing else here for a diagnostic to be quoting it about. Replace
// it with a code when the check lands.
//
//! lrm 10.3
//! reject default_transition
//! xfail VerA consumes `default_transition to end of line without parsing its operand (preprocessor.zig marks it .ignored), so the operand-less form is accepted silently
`default_transition
module ch10_default_transition_requires_an_operand(p, n);
  inout p, n; electrical p, n;
  analog I(p, n) <+ V(p, n);
endmodule
