// §10.5's last paragraph, the one requirement of that clause with no fixture
// anywhere in the suite:
//
//     "Verilog-AMS simulators shall also provide a predefined macro so that the
//      module can conditionally include (or exclude) portions of the source
//      text specific to a particular simulator. This macro shall be documented
//      in the Verilog-AMS section of the simulator manual."
//
// It is a "shall" on the IMPLEMENTATION, and tests/fixtures/ch10_directives/COVERAGE.md at 8b1514d4
// records it as "unnameable in a portable fixture" and stops there. That is the
// right verdict for a portable suite and the wrong one for a conformance suite
// aimed at a named tool: the clause cannot be satisfied by a tool that defines
// no such macro, and nothing else in chapter 10 would notice.
//
// SO THIS FIXTURE IS ANCHORED, NOT PORTABLE, and says so in its own text. The
// spelling below is the one VerA's manual would have to document; a different
// implementation retargets the `ifdef and keeps everything else. That is the
// whole extent of the non-portability, and it is smaller than leaving a "shall"
// untested.
//
// Historical implementation note: `lib/frontend/preprocessor.zig`'s `predefined_macros`
// array has exactly two entries, `__VAMS_ENABLE__` and
// `__VAMS_COMPACT_MODELING__`. There is no third, so the clause is unmet and
// this fixture fails.
//
// THE SHAPE is ch10_directives/13's gain witness, and it is what makes the file
// assert rather than merely compile. Both arms of the conditional define the
// same macro to DIFFERENT numbers, so the surviving arm names itself in the
// digit. TWO CLAUSES CARRY THAT, NOT ONE, and an earlier draft of this header
// ran them together under §10.5:
//   - §10.5's last paragraph is the "shall" under test — that a tool-specific
//     macro is PROVIDED at all. §10.5 says nothing about `ifdef;
//   - which arm survives is IEEE Std 1364's rule for `ifdef/`else/`endif, three
//     of the entries §10.1 Table 10-1 marks "[IEEE Std 1364 Verilog]". That
//     1364 clause is not offline in docs/, so it is named by the deferral and
//     no subclause number is invented for it here; ch10_directives/09 and 11
//     pin the arm selection itself and this file inherits it.
// So `D10_TOOL is 1.0 exactly when the macro is provided, and the contribution
// stamps 1.0 * V(p,n). A file that simply wrote the `ifdef arm and nothing else
// would compile either way and pin nothing.
//
// THE ORACLE. §1.3.1 makes the branch potential 0.75 - 0.25 = 0.5 V, exact in
// binary. Multiplied by the surviving witness it is 1.0 * 0.5 = 0.5; under the
// dead arm it would be 0.0 * 0.5 = 0.0, half a volt away, so the second
// assertion carries the verdict through the solver as well as the transcript.
//
// Actual manual documentation is checked separately by
// tests/host.py; macro existence does not prove it.
//! lrm 10.5
//! lrm 10.5:3
//! bias V(p) = 0.75, V(n) = 0.25
`include "check.vh"
`ifdef __VERA__
  `define D10_TOOL 1.0
`else
  `define D10_TOOL 0.0
`endif
module d10_the_tool_specific_predefined_macro(p, n);
  inout p, n;
  electrical p, n;
  real witness;
  analog begin
    witness = `D10_TOOL;
    `CHECKX("§10.5 requires a documented tool-specific predefined macro", witness, 1.0);
    `CHECKX("and the surviving arm is the one that scales this branch", witness * V(p, n), 0.5);
    I(p, n) <+ witness * V(p, n);
  end
endmodule
