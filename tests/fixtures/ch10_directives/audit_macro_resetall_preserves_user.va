// IEEE 1364-2005 19.3, physical page 380 (inherited by VAMS 10.4): resetall
// does not affect the text macro facility. Define a USER macro before reset,
// and observe both definedness and value after it. Expected values are 1 and
// 7, with failing-arm witnesses 0 and -1; all are exact. Assertion helpers
// are included after reset so loss of a helper cannot mask the target.
// MAC-RESET-001 (closed): VerA used to remove every non-predefined macro at
// resetall, and a preprocessor unit test asserted it.
//! lrm 10.4
//! checks 2
`include "disciplines.vams"
`define AUDIT_KEEP 7.0
`resetall
`include "check.vh"
module audit_macro_resetall_preserves_user(p);
  inout p; electrical p;
  real defined_after, value_after;
  analog begin
`ifdef AUDIT_KEEP
    defined_after = 1.0;
    value_after = `AUDIT_KEEP;
`else
    defined_after = 0.0;
    value_after = -1.0;
`endif
    `CHECKX("user macro still defined", defined_after, 1.0);
    `CHECKX("user macro value preserved", value_after, 7.0);
    I(p) <+ V(p);
  end
endmodule
