// §10.7 does not stop at "the current input line number". Two further sentences
// say the number is a REMAPPABLE quantity, and both are pinned here:
//
//   "A `line directive (as defined in IEEE Std 1364 Verilog) changes `__LINE__
//    and may change `__FILE__ as well."
//
//   "An `include directive changes the expansions of `__FILE__ and `__LINE__ to
//    correspond to the included file. At the end of that file ... the expansions
//    of `__FILE__ and `__LINE__ revert to the values they had before the
//    `include (but `__LINE__ is then incremented by one as processing moves to
//    the line after the `include)."
//
// The two are stacked on purpose, `line first and the `include under it, so one
// arithmetic covers both. IEEE Std 1364 §19.7 defines the operand as the number
// of the line FOLLOWING the directive, so with `line 100 written below, the
// `include line is 100 and — by the revert rule, "incremented by one" and NOT
// by the length of the included text — the module header is 101. Every literal
// below is 100 plus that line's offset from the `include, counted in this file
// by a reader with no simulator.
//
// That ordering is what makes the include half observable at all: a
// preprocessor that splices check.vh into one flat buffer and keeps counting
// reports numbers inflated by the length of check.vh (tens of lines), which is
// the single most common way to get §10.7 wrong. 22 catches the same bug from
// the un-remapped side; this file catches it on top of a `line remap, where an
// implementation that special-cases one of the two mechanisms falls over.
//
// `__FILE__ is deliberately not asserted: §10.7 says a `line directive "MAY
// change `__FILE__ as well", and §10.7's first paragraph makes the path itself
// "implementation dependent". Neither is a value a conforming tool can be held
// to, so neither is written down.
//
// The branch potential is the directive-independent assertion: 0.75 - 0.25 =
// 0.5 V exactly (§1.3.1), both operands binary-exact.
//
//! lrm 10.7
//! bias V(p) = 0.75, V(n) = 0.25
//! print none
//! xfail VerA rejects `__LINE__ with E0114 "unsupported compiler directive", and its `line handling is a no-op that does not remap anything; §10.7 is unimplemented in the preprocessor
`line 100 "virtual.va" 0
`include "check.vh"
module ch10_line_macro_remapping(p, n);
  inout p, n; electrical p, n;
  integer first, second;
  analog begin
    first = `__LINE__;
    second = `__LINE__;
    `CHECKI("`line 100 renumbers the following lines, and the `include reverts to that numbering", first, 105);
    `CHECKI("the next physical line is the next number", second, 106);
    `CHECKI("consecutive source lines differ by exactly one", second - first, 1);
    `CHECKX("branch potential", V(p, n), 0.5);
    I(p, n) <+ V(p, n);
  end
endmodule
