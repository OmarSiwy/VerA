// IEEE Std 1364 §19.6 `` `resetall ``, which §10.1 Table 10-1 also carries over
// unchanged: it "sets all compiler directives to their default values", and
// §19.2 states `default_nettype's default in so many words — "If no
// `default_nettype directive is present or if the `resetall directive is used,
// implicit nets are of type wire."
//
// So `resetall` is the second way out of a `none` region, and this file is 55
// with the explicit restoration replaced by the global one. Same shape, same
// oracle, different clause: 55 pins §10.1's supersession sentence, this pins
// §19.2's own reset sentence, and a tool can implement one without the other.
//
// 36 is this file's sibling for §10.2: `resetall` withdraws the default
// discipline there, and its header carries the argument for why `resetall` is
// read narrowly in this suite (it does NOT undefine text macros — see the note
// in tests/fixtures/ch10_directives/COVERAGE.md at 8b1514d4 about the deleted 20).
//
// DISCRIMINATING: delete the `` `resetall `` and this is 52, E0367 and all.
//
// The `` `include `` is written BELOW the `` `resetall `` and not above it,
// which is not a style choice: §19.6's reset undefines user text macros too, so
// check.vh's `CHECK` family would be gone by the time the module used it. (It
// is self-guarded on `VERA_CHECK_VH`, so a re-include after a reset works — but
// a fixture that needed one would be testing the guard, not the directive.)
//
//! lrm 10.1
//! lrm 3.6.5
//! bias V(p) = 1.5
`default_nettype none
`resetall
`include "check.vh"
module ch10_resetall_nettype_child(a, b);
    inout a, b;
    electrical a, b;
    analog I(a, b) <+ 0.001 * V(a, b);
endmodule

module ch10_resetall_restores_the_default_nettype(p);
    inout p;
    electrical p;

    ch10_resetall_nettype_child u(p, link);

    analog begin
        `CHECKX("`resetall put `default_nettype back to wire", V(p), 1.5);
    end
endmodule
