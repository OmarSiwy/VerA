// IEEE 1364-2005 §19.5 (taken whole by §10.1): the directive "is used to insert
// the entire contents of a source file in another file during compilation. The
// result is as though the contents of the included source file appear in place
// of the `include compiler directive."
//
// No file of this name exists beside the fixture, on the include path, or among
// the Annex D headers a tool supplies itself. There are no contents to insert,
// and dropping the directive silently would compile a different design from
// the one written.
//
//! lrm 10.1
//! inherited IEEE 1364-2005 19.5
//! reject-only E0126
`include "ch10_no_such_header_exists.vh"
`include "disciplines.vams"
module ch10_include_file_not_found(p, n);
  inout p, n; electrical p, n;
  analog I(p, n) <+ V(p, n);
endmodule
