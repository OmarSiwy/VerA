// §10.6's file-boundary sentence, which no fixture in ch10_directives reaches:
//
//     "The `begin_keywords directive affects all source code that follows the
//      directive, EVEN ACROSS SOURCE CODE FILE BOUNDARIES, until the matching
//      `end_keywords directive is encountered."
//
// 16, 25, 26 and 33 all write the `begin_keywords and the module it governs
// into one file, so every one of them is green under a tool that pushes a
// keyword set on `include and pops it at end-of-file. That tool is what this
// file refuses: the directive is in `d10_keywords_1364_2005.vh` and the module
// it has to reach is here.
//
// WHY THERE IS AN OUTER `begin_keywords "VAMS-2023". Without it the fixture
// would prove nothing, for the reason 33's header works through at length:
// §10.6 says of a module with no directive above it that "the set of reserved
// keywords in effect for this module shall be the implementation's default set
// of reserved keywords", so if the include's region were wrongly dropped, the
// module below would fall back to a set this clause refuses to fix, and a tool
// whose default happens to be 1364-2005 would compile it anyway. Naming
// "VAMS-2023" on the outside removes that escape: if the inner region does NOT
// survive the boundary, the set in force at the module is VAMS-2023, under
// which §10.6's own worked example says 'ERROR: "sin" is a keyword in
// Verilog-AMS'. So the file compiles if and only if the rule holds.
//
// The two `end_keywords at the bottom are the matching closers, innermost
// first: the first closes the region the HEADER opened — a pair split across a
// file boundary, which is the other half of the same sentence — and the second
// closes the one opened here.
//
// `analog` and `<+` appear inside a "1364-2005" region, which is legal under
// §10.6's next paragraph: "The `begin_keywords and `end_keywords directives
// only specify the set of identifiers that are reserved as keywords. The
// directives do not affect the semantics, tokens, and other aspects of the
// Verilog-AMS language." ch10_directives/16's header carries the full argument
// for that reading; this file only borrows it.
//
// THE ORACLE. §1.3.1: the branch potential is the difference of the two node
// potentials, 0.75 - 0.25 = 0.5 V, both operands binary-exact, so CHECKX.
// `sin` is an ordinary net name here and the assertion is that reading it as
// one produced the ordinary answer.
//
//! lrm 10.6
//! lrm 10.6:1002
//! lrm 10.1
//! lrm 10.1:1000
//! bias V(sin) = 0.75, V(n) = 0.25
`begin_keywords "VAMS-2023"
`include "d10_keywords_1364_2005.vh"
`include "check.vh"
module d10_begin_keywords_region_survives_the_include(sin, n);
  inout sin, n;
  electrical sin, n;
  analog begin
    `CHECKX("`sin` is an identifier under a region opened in another file", V(sin, n), 0.5);
    I(sin, n) <+ V(sin, n);
  end
endmodule
`end_keywords
`end_keywords
