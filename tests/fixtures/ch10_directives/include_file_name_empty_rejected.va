// IEEE 1364-2005 §19.5 (taken whole by §10.1): "The filename is the name of
// the file to be included in the source file. The filename can be a full or
// relative path name." An empty string is neither: it names no file.
//
//! lrm 10.1
//! inherited IEEE 1364-2005 19.5
//! reject-only E0124
`include ""
`include "disciplines.vams"
module ch10_include_file_name_empty(p, n);
  inout p, n; electrical p, n;
  analog I(p, n) <+ V(p, n);
endmodule
