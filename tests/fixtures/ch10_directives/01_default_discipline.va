// §10.2 `default_discipline names the discipline that discipline resolution
// gives to discrete signals which carry NO discipline declaration. Both nets
// here declare `electrical` explicitly, so the directive must leave them alone.
//
// What is observable is that the access survives it unchanged: V(p,n) is the
// electrical potential of the branch, and §1.3.1 defines a branch potential as
// the difference of the two node potentials. At V(p) = 0.75, V(n) = 0.25 that
// difference is 0.5 exactly (both endpoints are exact in binary, and so is
// their difference), and the branch taken the other way round is its negation.
//
// The directive's own effect — supplying `electrical` to an UNDECLARED net —
// has nothing to act on in this module, so no value here can depend on it.
//
//! lrm 10.2
//! bias V(p) = 0.75, V(n) = 0.25
`default_discipline electrical
`include "check.vh"
module ch10_default_discipline(p, n);
  inout p, n; electrical p, n;
  analog begin
    `CHECKX("branch potential is the node difference", V(p,n), 0.5);
    `CHECKX("the reversed branch negates it", V(n,p), -0.5);
    I(p,n) <+ V(p,n);
  end
endmodule
