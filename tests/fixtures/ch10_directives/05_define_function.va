// §10.4 Syntax 10-3 `define with a list_of_formal_arguments: every occurrence
// of the formal x in the macro text is replaced by the actual argument TEXT.
// The parentheses the body wraps around x are what keep a compound argument
// together, and this fixture passes one.
//
//   `SQUARE(1.0 + V(p,n))  ->  ((1.0 + V(p,n))*(1.0 + V(p,n)))
//
// At V(p,n) = 0.5 that is 1.5*1.5 = 2.25, exactly. Textual substitution into a
// body written x*x would instead give 1.0 + 0.5*1.0 + 0.5 = 2.0, and a macro
// that ignored its actual argument could give neither, so the one digit string
// pins both the substitution and its bracketing.
//
//! lrm 10.4
//! bias V(p) = 0.5
`define SQUARE(x) ((x)*(x))
`include "check.vh"
module ch10_define_function(p, n);
  inout p, n; electrical p, n;
  analog begin
    `CHECKX("the actual argument is substituted whole", `SQUARE(1.0 + V(p,n)), 2.25);
    I(p,n) <+ `SQUARE(V(p,n));
  end
endmodule
