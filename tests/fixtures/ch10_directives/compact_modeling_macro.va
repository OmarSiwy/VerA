// Host-only probe. No compact-modeling extension is used here, so both
// branches compile even when the simulator supports only a subset.
module compact_modeling_macro;
    initial begin
`ifdef __VAMS_COMPACT_MODELING__
        $display("compact_macro_defined=1");
`else
        $display("compact_macro_defined=0");
`endif
    end
endmodule
