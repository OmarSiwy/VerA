// §10.1 hands `resetall, `nounconnected_drive, `endcelldefine and
// `celldefine to IEEE 1364, and none of them takes an operand (§19.6, §19.10,
// §19.1): the directive is the word. 1364 restricts the rest of the line only
// where it says so — §19.5: "Only white space or a comment may appear on the
// same line as the `include compiler directive." — and it says nothing of the
// kind for these four. So the text after each is ordinary source text.
//
// Every directive below carries the next on its own line, and the last one
// carries the module header. A tool that throws away the rest of any of the
// four lines loses `module ...(p, n);` and cannot compile the file. Compiled,
// the device is the ordinary one: V(p,n) = 0.5 - 0.0 = 0.5, exact.
//
//! lrm 10.1
//! bias V(p) = 0.5
`include "check.vh"
`resetall `nounconnected_drive `endcelldefine `celldefine module d10_a_directive_without_an_operand_is_one_word(p, n);
  inout p, n; electrical p, n;
  analog begin
    `CHECKX("the module header after four operand-free directives survives", V(p,n), 0.5);
    I(p,n) <+ V(p,n);
  end
endmodule
