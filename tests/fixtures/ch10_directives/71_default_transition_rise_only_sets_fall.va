// §4.5.8, the sentence 40_transition_arguments_override_default.va does not
// reach: "If only a positive rise_time value is specified, the simulator uses
// it for both rise and fall times. If neither rise_time nor fall_time are
// specified or are equal to zero (0.0), the rise and fall time default to the
// value defined by `default_transition." §10.3 says the same from the
// directive's side: it serves the filters that "do not have rise time and fall
// time arguments specified".
//
// So with a directive of 8n in force, transition(x, 0, 4n) has a rise time,
// and by the first sentence its fall time is that rise time, 4n. The
// directive's 8n is for a filter with neither. transition(x, 0, 4n) and
// transition(x, 0, 4n, 4n) are then one filter, and they agree at every
// timepoint, exactly: the same kernel fed the same numbers. CHECKEQ, because
// the LRM states the identity and no digit (the ramp's digits are §4.5.8's
// shape, and they cancel from both sides).
//
// The input FALLS: 1 at the DC point, 0 from t = 1n on (a short wave list
// holds its last value), so the fall time is the one in use. A filter that
// took the directive's 8n for its fall sits at 1 - d/8n where the other is at
// 1 - d/4n (d the time since the edge), which differ once d > 0: at t = 2n and
// 3n whichever sample detects the edge.
//
//! lrm 4.5.8
//! lrm 4.5.8:2
//! lrm 10.3
//! analysis tran
//! time 0, 1n, 2n, 3n
//! wave V(in) = 1, 0
//! bias V(n) = 0
//! print none
`default_transition 8n
`include "check.vh"
module ch10_default_transition_rise_only_sets_fall(in, n);
  inout in, n;
  electrical in, n;
  analog begin
    `CHECKEQ("a lone rise time is the fall time too, whatever the directive says",
             transition(V(in, n), 0, 4n), transition(V(in, n), 0, 4n, 4n), 0.0);
    I(in, n) <+ 0.0;
  end
endmodule
