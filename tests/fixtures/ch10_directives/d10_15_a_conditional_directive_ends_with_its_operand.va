// §10.1 hands `ifdef, `ifndef, `elsif, `else and `endif to IEEE 1364, whose
// §19.4 grammar (Syntax 19-5) is a token sequence:
//
//   `ifdef text_macro_identifier ifdef_group_of_lines
//     { `elsif text_macro_identifier elsif_group_of_lines }
//     [ `else else_group_of_lines ] `endif
//
// Nothing in it asks for a line break: a conditional directive is its word
// plus, for the first three, one identifier. Where 1364 does restrict the
// line it says so — §19.5: "Only white space or a comment may appear on the
// same line as the `include compiler directive." — and it says nothing of the
// kind here. So a whole conditional may sit inside one declaration:
//
//   a: NOPE is undefined, so the `else group, 2.0
//   b: `ifndef NOPE holds, so 3.0
//   c: NOPE fails, YES holds, so the `elsif group, 5.0
//
// All three values are exact.
//
//! lrm 10.1
//! bias V(p) = 0.5
`define YES
`include "check.vh"
module d10_a_conditional_directive_ends_with_its_operand(p, n);
  inout p, n; electrical p, n;
  parameter real a = `ifdef NOPE 1.0 `else 2.0 `endif ;
  parameter real b = `ifndef NOPE 3.0 `endif ;
  parameter real c = `ifdef NOPE 1.0 `elsif YES 5.0 `else 6.0 `endif ;
  analog begin
    `CHECKX("`ifdef/`else/`endif on one line", a, 2.0);
    `CHECKX("`ifndef/`endif on one line", b, 3.0);
    `CHECKX("`elsif on one line", c, 5.0);
    I(p,n) <+ V(p,n);
  end
endmodule
