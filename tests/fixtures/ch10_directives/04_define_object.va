// §10.4 `define, object-like form: the macro name is replaced by its macro text
// wherever it is used, so GAIN is the three characters 3.0 and the contribution
// below is 3.0*V(p,n).
//
// At V(p,n) = 0.5 the product is 1.5 — exact, since 3.0 and 0.5 and 1.5 are all
// exact in binary. An empty or mis-captured macro text cannot produce it.
//
//! lrm 10.4
//! bias V(p) = 0.5
`define GAIN 3.0
`include "check.vh"
module ch10_define_object(p, n);
  inout p, n; electrical p, n;
  analog begin
    `CHECKX("GAIN expands to 3.0", `GAIN * V(p,n), 1.5);
    I(p,n) <+ `GAIN * V(p,n);
  end
endmodule
