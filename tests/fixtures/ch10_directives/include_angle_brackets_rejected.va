// §10.1 takes `include from IEEE Std 1364. IEEE 1364-2005 §19.5 Syntax 19-6 has
// ONE form:
//
//     include_compiler_directive ::= `include "filename"
//
// The angle-bracket form `include <file>` is C's, and SystemVerilog's (IEEE
// 1800 §22.4), where it selects a tool-defined search path. Neither 1364 nor
// the Verilog-AMS LRM admits it: §10.1 lists `include as "[IEEE Std 1364
// Verilog]", and Annex A adds no alternative.
//
// So `<` is refused with E0122 exactly as any other opener that is not `"`
// (lib/frontend/pp/directive.zig handleInclude). The legal neighbour, the quoted
// form, is exercised by every fixture that writes `include "disciplines.vams".
//
//! lrm 10.1
//! inherited IEEE 1364-2005 19.5
//! reject-only E0122
`include <disciplines.vams>
module ch10_include_angle_brackets(p, n);
  inout p, n; electrical p, n;
  analog I(p, n) <+ V(p, n);
endmodule
