// §10.5 states __VAMS_COMPACT_MODELING__ as a BICONDITIONAL, and no fixture in
// the suite tests either direction of it:
//
//     "This predefined macro is called __VAMS_COMPACT_MODELING__ and shall be
//      defined during the parsing of Verilog-AMS source text IF AND ONLY IF all
//      the compact modeling extensions are supported by the simulator."
//
// ch10_directives/14 uses the macro and its header is explicit that it declines
// to test this. Its two sentences, quoted exactly and separately because they
// are three paragraphs apart: "Whether it is defined is therefore an
// implementation fact and NOT something this fixture may assert." and "The
// `else arm carries no §10.5 claim". So a tool may define the macro
// unconditionally, support none of the extensions, and pass every chapter-10
// fixture that exists.
//
// This file closes BOTH directions, and the earlier draft closed only one.
//
// DIRECTION 1 — IF THE MACRO IS DEFINED, THE EXTENSIONS MUST WORK. That is the
// `ifdef arm below. "The compact modeling extensions" is read as the normative
// list Annex G Table G.3 gives for v2.1 -> v2.2, the version §10.5 says
// introduced them ("Verilog-AMS HDL version 2.2 introduced a number of
// extensions to support compact modeling"), and Table G.3 item 26 is the row
// that adds this very macro. Four of its rows are sampled — not exhausted, and
// tests/fixtures/ch10_directives/d10_SPEC.md at 8b1514d4 says which are left. Each is asserted against a number derived by
// hand, so a stub that parses the construct and returns zero fails:
//
//   item 8/10  ddx()            §4.5.6 is the symbolic derivative with respect
//                               to a node potential. d/dV(p) of 1.5*(V(p)-V(n))
//                               is 1.5 exactly — a coefficient, not a limit, so
//                               a finite-difference substitute misses it and
//                               CHECKX with no tolerance is the right form.
//   item 17    $param_given()   §6.3.5/§9.19 answer whether the INSTANTIATION
//                               overrode the parameter. This module is the top
//                               of its own netlist and nothing overrides
//                               `rser`, so the answer is 0. A tool that
//                               confuses "has a value" with "was given one"
//                               returns 1, since `rser` does have a value.
//   item 18    $mfactor         §9.18's hierarchical system parameter, whose
//                               value with no multiplicity anywhere above is
//                               the empty product, 1.
//   item 3     localparam       §3.4.5 Local parameters — "identical to
//                               parameters except that they cannot directly be
//                               modified with the defparam statement or by the
//                               ordered or named parameter value assignment",
//                               so a localparam is a CONSTANT everywhere a
//                               parameter is one. (§3.4.3, cited in an earlier
//                               draft, is *Parameter units and descriptions*
//                               and settles nothing here; corrected.)
//                               The earlier draft tested none
//                               of that: it wrote `kfold * 3.0 == 6.0`, which
//                               holds identically for a `parameter`, a `real`
//                               variable, or a literal, and so had no teeth.
//                               Here `nslot` is an array bound and `kfold`
//                               feeds a parameter's default — two sites where
//                               only a constant expression may stand. Replace
//                               either `localparam` with a `real` and the file
//                               stops compiling (measured: E0308 "array bound
//                               is not a constant expression", E0314 on the
//                               name in the parameter default). The VALUE
//                               checks then ride on that: 2.0*3.0 = 6.0 stored
//                               through the constant-bounded array, and
//                               rser = kfold - 1.0 = 1.0 folded at elaboration.
//
// DIRECTION 2 — IF THE EXTENSIONS ARE ALL SUPPORTED, THE MACRO MUST BE DEFINED.
// This is the unconditional check, and it is the one thing in the file that
// cannot be dodged by answering the `else. The earlier draft's unconditional
// check was `V(p,n) == 0.5`, which is true of any tool that can subtract, and a
// reviewer was right that the file could therefore not fail for its own
// clause's reason.
//
//   THE PREMISE, stated so it can be argued with: this directory tests
//   conformance to the whole of the Verilog-AMS LRM whose text is in docs/.
//   Every item in Table G.3 is normative text of that LRM — ddx is §4.5.6,
//   localparam §3.4.5, $param_given §9.19, $mfactor §9.18, paramsets §6.4,
//   $limit §9.17, above §5.10.3.2, and so on. A tool that conforms to it
//   therefore supports all of them, and §10.5's "if and only if" then REQUIRES
//   the macro. The only implementations this check fails are ones that
//   implement a strict subset, and for those it states something true.
//
//   THIS CONTRADICTS ONE SENTENCE OF ch10_directives/14's header — "A tool that
//   supports every extension and never defines the macro is conforming and
//   lands there" — which cannot be squared with the "if and only if" that same
//   header quotes two lines above it. 14 does not ASSERT that sentence (its
//   `else` arm checks 2.0*V(p,n) == 1.0, true whichever arm compiled), so there
//   is no fixture conflict, only a prose one, and the file that carries it is
//   outside this row's scope to edit. tests/fixtures/ch10_directives/d10_SPEC.md at 8b1514d4 records it.
//
// The alternative unconditional check considered and rejected: §10.5's other
// sentence, "__VAMS_ENABLE__ ... shall always be defined". It has teeth, but
// ch10_directives/13 is already exactly that fixture, witness shape and all.
//
// THE REVERSE OF DIRECTION 2 — "and NOT defined if any is unsupported" — stays
// out of reach, and that is a property of the clause and not of this file: the
// source text has no way to ask "is extension X missing?" other than by using
// it, which is exactly what fails to compile when it is missing. Recorded in
// tests/fixtures/ch10_directives/d10_SPEC.md at 8b1514d4 rather than silently dropped.
//
//! lrm 10.5
//! lrm 10.5:2
//! bias V(p) = 0.75, V(n) = 0.25
`include "check.vh"
module d10_compact_modeling_macro_implies_its_extensions(p, n);
  inout p, n;
  electrical p, n;
  real cm;
`ifdef __VAMS_COMPACT_MODELING__
  // G.3 item 3, in the two places a variable may not stand.
  localparam integer nslot = 4;
  localparam real    kfold = 2.0;
  parameter real     rser  = kfold - 1.0;
  real fold[0:nslot-1];
  real g, mf;
  integer pg;
`else
  parameter real     rser  = 1.0;
`endif
  analog begin
`ifdef __VAMS_COMPACT_MODELING__
    cm = 1.0;
    g  = ddx(1.5 * V(p, n), V(p));
    mf = $mfactor;
    pg = $param_given(rser);
    fold[nslot - 1] = kfold * 3.0;
    `CHECKX("G.3 item 8: ddx is the symbolic derivative, so exactly 1.5", g, 1.5);
    `CHECKX("G.3 item 18: $mfactor with no multiplicity above is 1", mf, 1.0);
    `CHECKI("G.3 item 17: nothing overrode rser, so $param_given is 0", pg, 0);
    `CHECKX("G.3 item 3: a localparam bounds this array, 2.0*3.0", fold[nslot - 1], 6.0);
    `CHECKX("G.3 item 3: and folds into a parameter default, 2.0-1.0", rser, 1.0);
`else
    cm = 0.0;
`endif
    `CHECKX("§10.5: extensions supported, so the macro shall be defined", cm, 1.0);
    I(p, n) <+ V(p, n);
  end
endmodule
