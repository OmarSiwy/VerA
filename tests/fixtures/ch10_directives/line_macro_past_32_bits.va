// §10.7: "`__LINE__ expands to the current input line number, in the form of
// a simple decimal number." IEEE Std 1364 §19.7: "The number parameter shall
// be a positive integer that specifies the new line number of the following
// text line." No upper bound is given. So
// `line 4294967295 names the next line 4294967295 (2^32 - 1), and two lines
// further on __LINE__ is 4294967297, past 32 bits. VerA added the offset in a
// 32-bit counter and aborted; it now expands the true number.
//
// HAND DERIVATION. The `line directive is followed by a comment line (line
// 4294967295) and a blank line (4294967296); the CHECK line is 4294967297.
// The literal is compared as a real: 4294967297 < 2^53, so it is exact.
//
//! lrm 10.7
//! lrm 10.7:2
//! bias V(p) = 0
//! print none
`include "check.vh"
module line_macro_past_32_bits(p, n);
  inout p, n; electrical p, n;
  analog begin
`line 4294967295 "far.va" 0
    // 4294967295

    `CHECKX("__LINE__ past 32 bits", `__LINE__ * 1.0, 4294967297.0);
    I(p, n) <+ V(p, n);
  end
endmodule
