// IEEE Std 1364 §19.9's subject is an unconnected INPUT port. §10.1 Table 10-1
// carries the directive over unchanged, and nothing in §10.1 or §6.2.2 widens
// it: §6.2.2's "a blank port connection shall represent the situation where the
// port is not to be connected" describes what a blank IS, not which directions
// get pulled.
//
// ch10_directives/58, 59 and 60 each instantiate a child with ONE unconnected
// port and that port is always an `input`, so the whole family is green under a
// tool that pulls every unconnected terminal regardless of direction. This file
// is the discriminator: one child, one instance, TWO blanks, one `input` and
// one `inout`, one directive in force over both.
//
// THE CIRCUIT. The child is two 1 kΩ resistors in a star from `b`:
//
//       a ---[1k]--- b ---[1k]--- c          b is tied to p, a and c are blank
//
// THE ORACLE, node by node, under `unconnected_drive pull1:
//
//   a — §19.9's subject. The pull is a source holding it at 1 of the potential
//       nature's units (see 58's header for why one volt is the number and why
//       the DRIVENNESS, not the digit, is the load-bearing half). V(u.a) = 1
//       exactly.
//   c — an `inout`, so not the clause's subject and not pulled. §1.3.2 KCL at
//       `c` then has exactly one term, its own resistor's current, which must
//       therefore be zero; §1.3.1 makes the branch potential of a zero-current
//       resistor zero, so `c` sits at `b`. `b` is bound to `p`, biased at
//       0.5 V. V(u.c) = 0.5 exactly.
//
// Both numbers are binary-exact (0.5 and 1.0 are representable, and the KCL
// that produces 0.5 is a copy, not an arithmetic), so CHECKX with no tolerance.
//
// A tool that pulls every direction prints 1 for BOTH, and its `c` node then
// also carries 5e-4 A through the second resistor, so the second assertion
// misses by half a volt rather than by a rounding.
//
//! lrm 10.1
//! lrm 6.2.2
//! lrm 6.2.2:3
//! bias V(p) = 0.5
//! solve
`include "check.vh"
`unconnected_drive pull1
module d10_direction_child(a, c, b);
    input a;
    inout c;
    inout b;
    electrical a, c, b;
    analog begin
        I(a, b) <+ 0.001 * V(a, b);
        I(c, b) <+ 0.001 * V(c, b);
    end
endmodule
`nounconnected_drive

module d10_unconnected_drive_spares_an_unconnected_inout(p);
    inout p;
    electrical p;

    d10_direction_child u( , , p);

    analog begin
        `CHECKX("the unconnected `input` is pulled, as 58 already pins", V(u.a), 1.0);
        `CHECKX("the unconnected `inout` is not: §19.9 names input ports", V(u.c), 0.5);
        `CHECKX("so no current flows in the inout's branch", I(u.c, u.b), 0.0);
        I(p) <+ 0.0;
    end
endmodule
