// IEEE Std 1364 §19.4 `ifndef is the negation of `ifdef: DISABLE_GAIN is never
// defined anywhere in this text stream, so the true arm — the one guarded by
// "not defined" — is what compiles, and the `else arm is deleted. The module
// contributes 5.0*V(p,n).
//
// Each arm asserts its own coefficient against the value the surviving arm must
// produce: 5.0*0.5 = 2.5 at V(p,n) = 0.5. An `ifndef read as `ifdef would take
// the other arm and print got = 0.5 against want = 2.5.
//
//! lrm 10.1
//! bias V(p) = 0.5
`include "check.vh"
module ch10_ifndef(p, n);
  inout p, n; electrical p, n;
  analog begin
`ifndef DISABLE_GAIN
    I(p,n) <+ 5.0*V(p,n);
    `CHECKX("an undefined name takes the ifndef arm", 5.0*V(p,n), 2.5);
`else
    I(p,n) <+ V(p,n);
    `CHECKX("this arm must have been deleted", 1.0*V(p,n), 2.5);
`endif
  end
endmodule
