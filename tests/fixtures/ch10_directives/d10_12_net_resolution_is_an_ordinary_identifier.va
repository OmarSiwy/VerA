// WHAT THIS PINS. `net_resolution` was a keyword of Verilog-AMS 2.3 and is not
// one in 2023, so it is an ordinary identifier in the VAMS-2023 keyword set and
// a port may be named `net_resolution`. This file names a port and a net
// `net_resolution` and reads the potential across it.
//
// THE REMOVAL IS RECORDED TWICE, IN BOTH DIRECTIONS.
//
//   Annex G, Table G.7 "Changes from v2.4 to VAMS-2023", Mantis item 5027:
//
//     "Removed unused keyword net_resolution        B.1, C.16"
//
//   and the two clauses that column names confirm it:
//
//   Annex B: "Verilog-AMS reserves the keywords listed in Table B.1." The word
//   is in neither printing's place in the 2023 table — it would sit among
//   `negedge`/`nmos`/`nor`, and it is not there in the 2023 source PDF or in
//   specification/annex-b-keywords.html.
//
//   Annex C.16: "The keywords in Annex B are the complete set of Verilog-AMS
//   HDL keywords, including those from IEEE Std 1364 Verilog. The following
//   keywords as defined in this LRM are not used by Verilog-A:" — and the nine
//   that follow are connect, connectmodule, connectrules, driver_update,
//   endconnectrules, merged, resolveto, split, wreal. NINE. `net_resolution` is
//   not among them; the 2.4 edition's identical list had ten and it led.
//
// WHY THE WORD LOOKS LIKE IT BELONGS. §9.22's second paragraph uses the phrase:
// "Access to individual drivers and net resolution is necessary for accurate
// implementation of connect modules (see 7.5)." It is prose about resolution,
// never a production in Annex A and never a row of Table B.1, and item 5027's
// own description — "Removed UNUSED keyword" — says the standard noticed.
//
// THE REST OF THE CHAIN is 12_assert_is_an_ordinary_identifier.va's, and it is
// the same one: §2.8.2 ("All keywords are defined in lowercase only. Annex B
// lists all defined Verilog-AMS HDL keywords."), §10.6 ("The version_specifier,
// "VAMS-2023" specifies that only the identifiers listed as reserved keywords
// in the Verilog-AMS HDL are considered to be reserved words. These identifiers
// are listed in Annex B."), and Annex B's own "reserves the keywords listed in
// Table B.1". A closed list that does not contain a word does not reserve it,
// and this word was taken OFF the list on purpose rather than left off by
// accident.
//
// WHY THE `begin_keywords "VAMS-2023" WRAPPER. §10.6: with no directive above
// it, "the set of reserved keywords in effect for this module shall be the
// implementation's default set of reserved keywords." Naming the set is what
// makes this file a statement about VAMS-2023 rather than about whatever a tool
// happens to default to; an implementation defaulting to VAMS-2.3, where the
// word WAS reserved, would otherwise fail the file for being older rather than
// for being wrong.
//
// WHAT IT REPLACES. tests/fixtures/annex_c_analog_subset/20_net_resolution_reserved.va
// asserted the opposite — `//! reject net_resolution` against a
// `real net_resolution;` — and rested on two errors. It read Annex C.16 as
// listing ten keywords, which was the 2.4 count, and it argued that C.16's
// "NOTE—All keywords of Verilog-AMS HDL are reserved words for Verilog-A"
// makes one of them unusable: true, and irrelevant once the word is off the
// list C.16 is quoting. Its own header records that the word "was for a long
// time the one word of the ten VerA did not reserve, so it carried
// `//! xfail`" — which is the shape of a fixture arguing an implementation into
// a bug.
//
// THE ORACLE. §1.3.1: the branch potential is the difference of the two node
// potentials, 1.25 - 0.25 = 1.0 V, both operands binary-exact, so CHECKX.
//
// STATUS. Green:
//
//   `net_resolution` names an ordinary net under VAMS-2023 got=1 want=1 ok=1
//
// It was not. VerA reserved the spelling under its AMS keyword sets and refused
// the port:
//
//   error[E0208]: expected an identifier: found net_resolution
//     = note: LRM 2.8
//
// citing §2.8.2, the clause that makes Annex B the whole list. The reservation
// was one entry in `lib/frontend/token.zig`'s `reserved_keywords` — the entry
// item 5027 says should have been deleted — and deleting it is the whole fix;
// the refusal was never a parsing problem, which is why the identical module
// under `begin_keywords "1364-2005"` compiled even then.
//
// ONE THING THE FIX GIVES UP, recorded rather than hidden. The word WAS
// reserved under "VAMS-2.3" and `isReserved` can no longer say so: VerA models
// §10.6's five sets as a nesting chain with an introduction date per spelling,
// which cannot express a word that LEAVES a later set. Expressing it needs a
// retirement date beside the introduction one. No fixture asks for it — a file
// under `begin_keywords "VAMS-2.3"` naming a net `net_resolution` should be
// refused and is not — and the note sits in `token.zig` beside the deletion.

//! lrm 10.6
//! lrm 2.8.2
//! lrm B
//! lrm C.16
//! lrm G.1
//! lrm C.16:1000
//! bias V(net_resolution) = 1.25, V(n) = 0.25
`begin_keywords "VAMS-2023"
`include "check.vh"
module d10_net_resolution_is_an_ordinary_identifier(net_resolution, n);
  inout net_resolution, n;
  electrical net_resolution, n;

  analog begin
    `CHECKX("`net_resolution` names an ordinary net under VAMS-2023",
            V(net_resolution, n), 1.0);
    I(net_resolution, n) <+ V(net_resolution, n);
  end
endmodule
`end_keywords
