// §10.2 lets a macro's text use other macros and bounds nothing about how
// deep that goes. VerA refused past 128 nested expansions (E0119) until
// 2026-10; it now expands any finite chain, its depth bounded by memory.
// M130 below expands M129, and so on to M0: 131 levels. A macro that uses
// itself, which never ends, is still refused (E0118).
//
// HAND DERIVATION. Every M<k> for k >= 1 is M<k-1>, so `M130 is M0's text,
// 1.0.
//
//! lrm 10.4
//! checks 1
`include "check.vh"
`define M0 1.0
`define M1 `M0
`define M2 `M1
`define M3 `M2
`define M4 `M3
`define M5 `M4
`define M6 `M5
`define M7 `M6
`define M8 `M7
`define M9 `M8
`define M10 `M9
`define M11 `M10
`define M12 `M11
`define M13 `M12
`define M14 `M13
`define M15 `M14
`define M16 `M15
`define M17 `M16
`define M18 `M17
`define M19 `M18
`define M20 `M19
`define M21 `M20
`define M22 `M21
`define M23 `M22
`define M24 `M23
`define M25 `M24
`define M26 `M25
`define M27 `M26
`define M28 `M27
`define M29 `M28
`define M30 `M29
`define M31 `M30
`define M32 `M31
`define M33 `M32
`define M34 `M33
`define M35 `M34
`define M36 `M35
`define M37 `M36
`define M38 `M37
`define M39 `M38
`define M40 `M39
`define M41 `M40
`define M42 `M41
`define M43 `M42
`define M44 `M43
`define M45 `M44
`define M46 `M45
`define M47 `M46
`define M48 `M47
`define M49 `M48
`define M50 `M49
`define M51 `M50
`define M52 `M51
`define M53 `M52
`define M54 `M53
`define M55 `M54
`define M56 `M55
`define M57 `M56
`define M58 `M57
`define M59 `M58
`define M60 `M59
`define M61 `M60
`define M62 `M61
`define M63 `M62
`define M64 `M63
`define M65 `M64
`define M66 `M65
`define M67 `M66
`define M68 `M67
`define M69 `M68
`define M70 `M69
`define M71 `M70
`define M72 `M71
`define M73 `M72
`define M74 `M73
`define M75 `M74
`define M76 `M75
`define M77 `M76
`define M78 `M77
`define M79 `M78
`define M80 `M79
`define M81 `M80
`define M82 `M81
`define M83 `M82
`define M84 `M83
`define M85 `M84
`define M86 `M85
`define M87 `M86
`define M88 `M87
`define M89 `M88
`define M90 `M89
`define M91 `M90
`define M92 `M91
`define M93 `M92
`define M94 `M93
`define M95 `M94
`define M96 `M95
`define M97 `M96
`define M98 `M97
`define M99 `M98
`define M100 `M99
`define M101 `M100
`define M102 `M101
`define M103 `M102
`define M104 `M103
`define M105 `M104
`define M106 `M105
`define M107 `M106
`define M108 `M107
`define M109 `M108
`define M110 `M109
`define M111 `M110
`define M112 `M111
`define M113 `M112
`define M114 `M113
`define M115 `M114
`define M116 `M115
`define M117 `M116
`define M118 `M117
`define M119 `M118
`define M120 `M119
`define M121 `M120
`define M122 `M121
`define M123 `M122
`define M124 `M123
`define M125 `M124
`define M126 `M125
`define M127 `M126
`define M128 `M127
`define M129 `M128
`define M130 `M129
module macro_expansion_past_the_old_128_limit(p);
  inout p; electrical p;
  real r;
  analog begin
    r = `M130;
    `CHECKX("131 nested expansions", r, 1.0);
    I(p) <+ r * V(p);
  end
endmodule
