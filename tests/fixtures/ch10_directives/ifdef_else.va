// IEEE Std 1364 §19.4 `ifdef/`else (§10.1 lists both as Verilog-AMS directives):
// ENABLE_GAIN is defined, so the TRUE arm is compiled and the `else arm is
// deleted. The module contributes 4.0*V(p,n).
//
// Each arm asserts its own coefficient against the value the surviving arm must
// produce: 4.0*0.5 = 2.0 at V(p,n) = 0.5. The `else arm would print got = 0.5
// against want = 2.0 and fail, so the digit pins which arm survived.
//
//! lrm 10.1
//! bias V(p) = 0.5
`define ENABLE_GAIN
`include "check.vh"
module ch10_ifdef_else(p, n);
  inout p, n; electrical p, n;
  analog begin
`ifdef ENABLE_GAIN
    I(p,n) <+ 4.0*V(p,n);
    `CHECKX("defined name selects the true arm", 4.0*V(p,n), 2.0);
`else
    I(p,n) <+ V(p,n);
    `CHECKX("this arm must have been deleted", 1.0*V(p,n), 2.0);
`endif
  end
endmodule
