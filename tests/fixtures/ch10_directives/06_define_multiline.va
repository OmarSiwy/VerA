// §10.4 `define, with the macro text continued onto a second line by a
// backslash-newline (IEEE Std 1364 §19.3.1: the macro text runs to the end of
// the line unless a \ continues it; expansion retains the newline but removes
// the preceding backslash). Both lines therefore belong to POLY. This arithmetic
// observation does not distinguish a retained newline from a replacement space:
//
//   POLY(x) = (x)*(x) + 2.0*(x) + 1.0
//
// At x = V(p,n) = 0.5 that is 0.25 + 1.0 + 1.0 = 2.25, exactly. A preprocessor
// that stopped the body at the first newline would leave (0.5)*(0.5) = 0.25, so
// the digit tells the joined body from the truncated one.
//
//! lrm 10.4
//! bias V(p) = 0.5
`define POLY(x) ((x)*(x) + \
                 2.0*(x) + 1.0)
`include "check.vh"
module ch10_define_multiline(p, n);
  inout p, n; electrical p, n;
  analog begin
    `CHECKX("the continued line is part of the macro text", `POLY(V(p,n)), 2.25);
    I(p,n) <+ `POLY(V(p,n));
  end
endmodule
