// §10.6 worked example, verbatim: under `begin_keywords "1364-2005" the
// identifier `sin` is NOT reserved (it is a keyword in Verilog-AMS, Annex B, but
// not in IEEE Std 1364-2005), so `module m2 (sin ...); input sin;` is legal.
// The companion fixture 17 is the same source under "VAMS-2023", which the LRM
// says "shall result in an error".
//
// Legality alone is not an assertion, so the check is what `sin` then DENOTES:
// a port of this module, whose potential the solver holds at the bias. §1.3.1
// makes the branch potential the difference of the node potentials, 0.75 - 0.25
// = 0.5 V. A compiler that let the reserved-word set leak in would not reach
// this line at all; one that resolved `sin` to the §4.3.2 sine function instead
// of the port could not produce 0.5.
//
// CHECKX (exact) rather than CHECK: 0.75 and 0.25 are both binary-exact, so
// their difference is exactly 0.5, and CHECKX needs no `abs` — which is itself
// a Verilog-AMS-only identifier and so out of the reserved set in force here.
//
// WHAT THIS FIXTURE ASSUMES, written down here because 25, 26, 29, 31 and 33
// assume it too. The body uses `analog`, `electrical` and `<+` inside a
// 1364-2005 region, and `analog` is an Annex B Verilog-AMS reserved word that
// appears in none of the 1364 lists. Read "only the identifiers listed as
// reserved keywords in [that standard] are considered to be reserved words" on
// its own and `analog` is an ordinary identifier here, so `analog begin` would
// not parse and a compiler taking that reading FAILs this file. The reading
// taken instead is §10.6's own next paragraph: "The `begin_keywords and
// `end_keywords directives only specify the set of identifiers that are
// RESERVED as keywords. The directives do not affect the semantics, tokens,
// and other aspects of the Verilog-AMS language." The directive widens what
// may be spelled as a name; it does not delete language. It is also the only
// reading under which the chapter's own third example composes, which writes
// `analog begin` under an explicit `begin_keywords. And the narrow reading
// leaves the rule untestable: if a 1364-set region may not contain an analog
// block, nothing in one can be given an operating point and `sin`-the-port
// can never be shown to denote anything.
//
//! lrm 10.6
//! lrm 10.6:1
//! lrm 10.6:1004
//! bias V(sin) = 0.75, V(n) = 0.25
`begin_keywords "1364-2005"
`include "check.vh"
module ch10_begin_keywords_verilog(sin, n);
  inout sin, n; electrical sin, n;
  analog begin
    `CHECKX("sin is a port under the 1364-2005 keyword set", V(sin,n), 0.5);
    I(sin,n) <+ V(sin,n);
  end
endmodule
`end_keywords
