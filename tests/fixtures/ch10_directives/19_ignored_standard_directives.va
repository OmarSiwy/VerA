// §10.1 lists the compiler directives Verilog-AMS carries over from IEEE Std
// 1364 unchanged; `timescale, `default_nettype, `celldefine/`endcelldefine,
// `pragma, `line and `unconnected_drive/`nounconnected_drive are all directives
// of the DIGITAL engine. None of them takes part in the analog solve, so none
// may perturb a value the analog block computes.
//
// Two things are pinned, both of which a wrongly-honoured directive would move:
//
//   `timescale 1ns/1ps. §9.10 fixes $abstime as "a real value number
//   representing time in seconds", NOT in timescale ticks. At the 2.5 ns time
//   point that is 2.5e-9; a tool that scaled by the 1 ns unit would report 2.5,
//   and one that scaled by the 1 ps precision 2500 — both off by 1e9 or more.
//   The time point is deliberately off a round nanosecond so a truncation to
//   whole ticks fails as well.
//
//   `default_nettype wire / `line 100 "virtual.va" 0 / `unconnected_drive
//   pull1. None of them changes what the declared electrical ports are — the
//   last one only says how an UNCONNECTED digital input port is driven, and
//   both ports here are connected and analog — so §1.3.1 still makes the branch
//   potential the node difference: 0.75 - 0.25 = 0.5 V. The pull1 pair is
//   written open-before/close-after the module, the way §10.1's scope rule
//   ("from the point where it is processed ... to the point where another
//   compiler directive supersedes it") makes the two directives read.
//
//! lrm 10.1
//! analysis tran
//! time 2.5e-9
//! bias V(p) = 0.75, V(n) = 0.25
`timescale 1ns/1ps
`default_nettype wire
`celldefine
`pragma fixture harmless
`line 100 "virtual.va" 0
`unconnected_drive pull1
`include "check.vh"
module ch10_ignored_standard_directives(p, n);
  inout p, n; electrical p, n;
  analog begin
    `CHECK("`timescale does not rescale $abstime, which is seconds", $abstime, 2.5e-9, 1e-21);
    `CHECK("the ignored directives leave the branch potential alone", V(p,n), 0.5, 1e-15);
    I(p,n) <+ V(p,n);
  end
endmodule
`endcelldefine
`nounconnected_drive
