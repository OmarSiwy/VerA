// §10.4 takes `define from IEEE Std 1364. IEEE 1364-2005 §19.3.1, physical
// page 351: "The text specified for macro text shall not be split across the
// following lexical tokens: Comments, ..." — a comment is a whole token of the
// source text (§2.4), and no macro body holds a piece of one.
//
// Below, S is the single operator `/` and ST the single operator `*`. Pasted
// together, `S`ST reads like the two characters that open a block comment and
// `ST`S like the two that close one. They are not a comment: comments are
// recognised in the source text, where there are none on that line, and each
// macro's text is one whole operator token. So the assignment is
//
//     x = 8 / * 2 * / + 1;
//
// which no expression production derives (a binary `/` cannot be followed by
// a binary `*`), and the file is illegal. A tool that lets the pasted
// characters open a comment reads `x = 8 + 1` and compiles 9.
//
// VerA did exactly that (measured: the file compiled clean): its lexer
// skipped comments a second time, after the preprocessor had already removed
// every real one. E0209 is the parser's "expected an expression: found `*`".
//
//! lrm 10.4
//! lrm 2.4
//! reject-only E0209
`include "disciplines.vams"
`define S /
`define ST *
module ch10_pasted_macros_do_not_form_a_comment(p, n);
  inout p, n; electrical p, n;
  real x;
  analog begin
    x = 8 `S`ST 2 `ST`S + 1;
    I(p, n) <+ x * V(p, n);
  end
endmodule
