// §10.5: "The predefined macro is called __VAMS_ENABLE__. This macro shall
// always be defined during the parsing of Verilog-AMS source text. Its purpose
// is to support the creation of modules which are both legal Verilog and
// Verilog-AMS. The Verilog-AMS features of such modules are made visible only
// when the __VAMS_ENABLE__ macro has previously been defined."
//
// The clause's own example, whose Verilog-AMS arm is a RANGED parameter:
//
//   `ifdef __VAMS_ENABLE__
//      parameter integer del = 1 from [1:100];
//   `else
//      parameter del = 1;
//   `endif
//
// This fixture keeps that conditional verbatim (in an analog module, since
// VerA's digital `#del` is not the point) and overrides `del` to 0 from an
// instance. The two arms disagree about that override and nothing else:
//
//   __VAMS_ENABLE__ defined (required):  del has range [1:100], and 0 is
//       outside it — §3.4.2: "Range checking applies to the value of the
//       parameter for the instance ... It shall be an error only if the value
//       of the parameter is out of range during simulation." The instance
//       value is the literal 0, so it is out of range in every simulation;
//   __VAMS_ENABLE__ undefined (a violation): del is an unranged `parameter`,
//       and 0 is an ordinary legal override.
//
// So the refusal IS the evidence that the macro was defined while this text
// was parsed — the rejection-side twin of 13_predefined_vams_enable.va's gain
// witness, which proves the same "shall always be defined" by a value. A tool
// that failed to define the macro would take the `else arm and compile the
// file cleanly. Overriding `del` to 5 instead compiles (probed).
//
// VerA reports E0361 "overridden parameter value is outside its range".
//
//! lrm 10.5
//! lrm 3.4.2
//! lrm 3.4.2:2
//! reject-only E0361
//! reject `g.del` is 0
//! neighbour 13_predefined_vams_enable.va
`include "disciplines.vams"
module d10_not_gate(p, n);
  inout p, n; electrical p, n;
`ifdef __VAMS_ENABLE__
  parameter integer del = 1 from [1:100];
`else
  parameter del = 1;
`endif
  analog I(p, n) <+ V(p, n) * del;
endmodule

module d10_vams_enable_arm_carries_a_range(p, n);
  inout p, n; electrical p, n;
  d10_not_gate #(.del(0)) g(p, n);       // illegal only in the VAMS arm
endmodule
