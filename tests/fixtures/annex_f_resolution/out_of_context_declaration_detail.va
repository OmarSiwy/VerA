// LRM Annex F.2.1 step 3, first paragraph — the LEGAL out-of-context declaration,
// which the LRM prints as source: "Apply all out-of-context node and signal
// declarations. For example, electrical top.middle.bottom.sig; OVERRIDES ANY
// DISCIPLINE WHICH MAY BE DECLARED FOR SIG IN THE MODULE WHERE SIG WAS DECLARED."
// §3.10 says the same as a precedence list and puts this form at order 1, above
// the local declaration at order 2. conflicting_ooc_declarations.va covers the
// error half of step 3 (two of them for one segment); nothing else in the suite
// states that ONE of them must be accepted and must win.
//
// The design is the smallest one in which the override is observable:
//
//   annex_f_dooc_leaf.p   locally declared annex_f_dx   (precedence order 2)
//   annex_f_dooc_over     declares  annex_f_dy ca.p;    (precedence order 1)
//                        and       annex_f_dy cb.p;
//
// ca.p and cb.p are two DIFFERENT segments, so this is not the conflict case:
// each gets exactly one out-of-context declaration, and each of those overrides
// exactly one local declaration. After step 3 both leaf segments are annex_f_dy,
// and step 4 then hands annex_f_dy up to the undeclared top segments a and b
// (4.b, second bullet: a single discipline in the child list).
//
// The two disciplines carry DIFFERENT access function names, which is what makes
// the override observable rather than assumed. annex_f_dx names DXpot/DXflw and
// annex_f_dy names DYpot/DYflw; per §3.6.2.1 a net's access functions are the ones
// its discipline's natures name. So `DYpot(a, b)` compiles only if the
// out-of-context declaration actually replaced the local one. A compiler that
// silently kept the order-2 declaration — the natural way to get this wrong —
// leaves the top segments annex_f_dx, where DYpot does not exist, and the fixture
// fails to build rather than passing by accident.
//
// The want is DERIVED, not read back: `//! bias` supplies the two node potentials
// and the assertion is their DIFFERENCE across the branch. 0.75 - 0.25 = 0.5, all
// three exact in binary, so `CHECKX` is the honest macro.
//
// This is the detail-mode twin of out_of_context_declaration.va. A run
// selects one resolution algorithm, so the basic-mode file keeps F.2.1:2 and
// this one states the same out-of-context precedence under F.2.2 step 3.
//
//! lrm F.2.2
//! lrm F.2.2:3
//! lrm 3.10
//! lrm 3.6.2
//! lrm 3.6.2:4
//! lrm 3.10:1
//! discipline-resolution detail
//! bias a = 0.75, b = 0.25
`include "check.vh"
nature annex_f_dx_pot;
  units = "V";
  access = DXpot;
  abstol = 1u;
endnature
nature annex_f_dx_flow;
  units = "A";
  access = DXflw;
  abstol = 1p;
endnature
nature annex_f_dy_pot;
  units = "V";
  access = DYpot;
  abstol = 1u;
endnature
nature annex_f_dy_flow;
  units = "A";
  access = DYflw;
  abstol = 1p;
endnature
discipline annex_f_dx;
  potential annex_f_dx_pot;
  flow annex_f_dx_flow;
  domain continuous;
enddiscipline
discipline annex_f_dy;
  potential annex_f_dy_pot;
  flow annex_f_dy_flow;
  domain continuous;
enddiscipline
module annex_f_dooc_child(p);
  inout p; annex_f_dx p;
endmodule
module annex_f_dooc_over(a, b);
  inout a, b;
  annex_f_dooc_child ca(a);
  annex_f_dooc_child cb(b);
  annex_f_dy ca.p;
  annex_f_dy cb.p;
  analog begin
    `CHECKX("the out-of-context declaration overrides the local one, so the y access function reads the branch", DYpot(a, b), 0.5);
    DYflw(a, b) <+ DYpot(a, b);
  end
endmodule
