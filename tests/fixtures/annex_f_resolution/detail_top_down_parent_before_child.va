// Annex F.2's traversal ORDER, on the shape F.2:5 and F.2:6 define:
//
//   F.2:5 "When a signal is being traversed top-down, this means that the
//   traversal shall start at the top net segment(s) of the signal — these are
//   net segments which have no parent net segments."
//   F.2:6 "It further means that all the parent net segments of a child net
//   segment shall be traversed before that child net segment is traversed."
//
// DETAIL MODE ONLY, selected by the simulator option F.2.2:2 requires
// (`//! discipline-resolution detail`). Step 4 (F.2.2:5, depth-first) leaves
// NetB digital because its children are all digital (F.2.2:7), then NetA
// digital because its children — blk1, blk2 and NetB — are all digital. Step 5
// (F.2.2:11, top-down) revisits both: NetA's parent NetD is analog, so NetA
// becomes analog and takes NetD's electrical discipline; NetB is visited only
// AFTER its parent NetA and becomes electrical too. That is F.2:6's order, and
// the CHECK below is what measures it.
//
// The design is Figure 7-4's (ch07_mixed_signal/
// discipline_resolution_detail_figure_7_4.va, which pins step 4's F.2.2:8 on
// its own cites; the sentence this file adds is step 5's F.2.2:14). NetD is
// top's `netd`, NetA is digital_blk's `out`, NetB is
// twoblks' `out`, NetC is mix's `out`. Five leaves become mixed ports (blk1,
// blk2 and blk3, blk4, plus mix's blk2), each bridged by one d2a loading 1 kohm;
// `ablk` drives 1 mA, so V = 1e-3 * 1000 / 5 = 0.2 for N = 5.
//
// WHY THE ORDER IS LOAD-BEARING. Visit NetB before NetA in step 5 and NetB's
// parent is still digital when it is decided, so NetB stays digital while NetA
// becomes electrical: four bridges (blk1, blk2, twoblks' own port and mix's
// blk2) load the node and V = 0.25. Basic mode (7.4.4.1, no top-down pass)
// keeps NetA digital too, so only two bridges (digital_blk's port and mix's
// blk2) and V = 0.5. So 0.2 requires the traversal to start at the top segments
// (F.2:5) and to finish every parent before its child (F.2:6), not merely to
// run the depth-first pass; and the answer it gives those digital nets is
// step 5's "Any others shall be considered analog" (F.2.2:14), which is what
// turns NetA and NetB electrical and moves the bridges down to the leaves.
// Step 4's own bullets are NOT cited: a run that left both nets unknown before
// step 5 reaches the same five bridges through the step-5 parent rule, so this
// CHECK does not discriminate them.
//
//! lrm F.2
//! lrm F.2:5
//! lrm F.2:6
//! lrm F.2.2
//! lrm F.2.2:2
//! lrm F.2.2:7
//! lrm F.2.2:11
//! lrm F.2.2:14
//! discipline-resolution detail
//! solve
//! checks 1
`include "check.vh"
discipline annex_f_td_c1; domain discrete; enddiscipline
discipline annex_f_td_c2; domain discrete; enddiscipline
discipline annex_f_td_c3; domain discrete; enddiscipline
discipline annex_f_td_c4; domain discrete; enddiscipline
connectmodule annex_f_td_d2a(d, a);
  input d; annex_f_td_c1 d;
  output a; electrical a;
  analog I(a) <+ V(a) / 1000.0;
endmodule
connectrules annex_f_td_rules;
  connect annex_f_td_c3, annex_f_td_c4 resolveto annex_f_td_c3;
  connect annex_f_td_c1, annex_f_td_c2, annex_f_td_c3 resolveto annex_f_td_c1;
  connect annex_f_td_d2a;
endconnectrules
module annex_f_td_blk1(out); output out; annex_f_td_c1 out; endmodule
module annex_f_td_blk2(out); output out; annex_f_td_c2 out; endmodule
module annex_f_td_blk3(out); output out; annex_f_td_c3 out; endmodule
module annex_f_td_blk4(out); output out; annex_f_td_c4 out; endmodule
module annex_f_td_ablk(out);
  output out; electrical out;
  analog begin
    I(out) <+ -1.0e-3;
    `CHECK("top-down after parent: five leaf bridges, V = 1 mA * 1 kohm / 5",
           V(out), 0.2, 1e-12);
  end
endmodule
module annex_f_td_twoblks(out);
  output out;
  annex_f_td_blk3 b3(out);
  annex_f_td_blk4 b4(out);
endmodule
module annex_f_td_digital_blk(out);
  output out;
  annex_f_td_blk1 b1(out);
  annex_f_td_blk2 b2(out);
  annex_f_td_twoblks t(out);
endmodule
module annex_f_td_mix(out);
  output out;
  annex_f_td_blk2 b(out);
  annex_f_td_ablk a(out);
endmodule
module annex_f_td_top;
  annex_f_td_digital_blk d(netd);
  annex_f_td_mix m(netd);
endmodule
