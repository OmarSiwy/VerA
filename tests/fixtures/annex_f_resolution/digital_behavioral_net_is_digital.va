// Annex F.2.1 step 4.a: "Any net which is used in digital behavioral code
// shall be considered digital." The rule applies whatever the net's children
// are, so it is the one place a discrete net beats a continuous child.
//
// `w` in the top module is UNDECLARED and is the target of `assign w = s;`,
// digital behavioral code (§6.5.2.1's split: a port "can only be used in a
// structural description (passed to instances but not accessed in
// behavioral code)", and the assignment accesses `w`). Its only child is
// annex_f_dw_load.p, electrical. 4.a makes w digital; 4.b's list of discrete
// child disciplines is empty and no `default_discipline is in force, so w
// keeps §3.6.2.4's "no discipline with a domain binding of discrete". The
// leaf port is then a mixed port (§7.8.4), and the connect statement below
// inserts annex_f_dw_d2a there: a discrete net with no nature is compatible
// with the bridge's ddiscrete side by §3.11.1's Natureless Discipline Rule.
// Had w been resolved continuous instead, `assign w = s` would write a
// continuous net from a discrete context and be refused (E0435).
//
// The leaf port is an `input`: §7.6 Example 1's d2a (discrete input,
// electrical output) "can bridge a mixed input port whose upper connection
// is compatible with discipline ddiscrete and whose lower connection is
// compatible with electrical, or a mixed output port" with the roles
// swapped; an inout port needs Example 3's inout/inout module. (An earlier
// version of this file declared the leaf `inout`, which no conforming
// compiler can bridge with this statement: E0927.)
//
// Derivation: s = 1 after #0, the bridge drives vsup = 2.0 V behind 1 kohm
// into the leaf's 1 kohm to ground: (V - 2.0)/1000 + V/1000 = 0, so
// V(p) = 1.0, asserted inside the leaf.
//
// Neighbour: continuous_domain_wins.va, the same shape with no behavioral
// code on w, where 4.a's "any others shall be considered analog" applies.
//
//! lrm F.2.1
//! lrm F.2.1:5
//! lrm 7.4
//! lrm 7.8
//! solve
//! checks 1
`include "check.vh"
connectmodule annex_f_dw_d2a(cm, el);
  input cm; output el;
  ddiscrete cm; electrical el;
  parameter real rout = 1000.0;
  parameter real vsup = 2.0;
  reg lvl;
  initial lvl = 1'b0;
  always @(cm) lvl = cm;
  analog I(el) <+ (V(el) - vsup * ((lvl == 1'b1) ? 1.0 : 0.0)) / rout;
endmodule
module annex_f_dw_load(p);
  input p; electrical p;
  analog begin
    I(p) <+ V(p) / 1000.0;
    `CHECK("w resolved digital and bridged: 2.0 V behind 1k into the 1k leaf", V(p), 1.0, 1e-12);
  end
endmodule
module annex_f_digital_behavioral_net_is_digital;
  reg s;
  initial begin #0; s = 1'b1; end
  assign w = s;
  annex_f_dw_load l(w);
endmodule
connectrules annex_f_dw_rules;
  connect annex_f_dw_d2a;
endconnectrules
