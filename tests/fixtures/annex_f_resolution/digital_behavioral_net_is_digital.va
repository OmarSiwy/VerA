// Annex F.2.1 step 4.a: "Any net which is used in digital behavioral code
// shall be considered digital." The rule applies whatever the net's children
// are, so it is the one place a discrete net beats a continuous child.
//
// `w` in the top module is UNDECLARED and is the target of `assign w = s;`,
// digital behavioral code. Its only child is annex_f_dw_load.p, electrical.
// 4.a makes w digital; 4.b's list of discrete child disciplines is empty, so
// the first bullet applies `default_discipline (§3.8; VerA's prelude sets
// logic, compatible with ddiscrete). The leaf port is then a mixed port, and
// the connect statement below inserts annex_f_dw_d2a there (§7.8). Had w
// been resolved continuous instead, `assign w = s` would write a continuous
// net from a discrete context and be refused (VerA's E0435), which is what
// the snapshot compiler does today.
//
// Derivation: s = 1 after #0, the bridge drives vsup = 2.0 V behind 1 kohm
// into the leaf's 1 kohm to ground: (V - 2.0)/1000 + V/1000 = 0, so
// V(p) = 1.0, asserted inside the leaf.
//
// Neighbour: continuous_domain_wins.va, the same shape with no behavioral
// code on w, where 4.a's "any others shall be considered analog" applies.
//
//! xfail an undeclared net driven by `assign` resolves continuous (E0435) instead of digital; even declared `ddiscrete w`, the electrical leaf port is not its own segment (E0501 on the leaf's I/V)
//! lrm F.2.1
//! lrm 7.4
//! lrm 7.8
//! solve
`include "check.vh"
connectmodule annex_f_dw_d2a(cm, el);
  input cm; output el;
  ddiscrete cm; electrical el;
  parameter real rout = 1000.0;
  parameter real vsup = 2.0;
  reg lvl;
  initial lvl = 1'b0;
  always @(cm) lvl = cm;
  analog I(el) <+ (V(el) - vsup * ((lvl == 1'b1) ? 1.0 : 0.0)) / rout;
endmodule
module annex_f_dw_load(p);
  inout p; electrical p;
  analog begin
    I(p) <+ V(p) / 1000.0;
    `CHECK("w resolved digital and bridged: 2.0 V behind 1k into the 1k leaf", V(p), 1.0, 1e-12);
  end
endmodule
module annex_f_digital_behavioral_net_is_digital;
  reg s;
  initial begin #0; s = 1'b1; end
  assign w = s;
  annex_f_dw_load l(w);
endmodule
connectrules annex_f_dw_rules;
  connect annex_f_dw_d2a;
endconnectrules
