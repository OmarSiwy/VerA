// Annex F.2.1 step 2 (F.2.1:1001): "Apply all in-context node and signal
// declarations. For example, electrical sig; makes all instances of sig
// electrical, unless they have been overridden by an out-of-context
// declaration."
//
// The declaration here is the child module's own `annex_f_ci sig;`. The child
// is instantiated TWICE, so the declaration applies to both of its `sig` net
// segments: c1.sig and c2.sig. Neither name exists in the top module, so no
// out-of-context declaration touches them — this is the sentence's plain case.
//
// HOW IT IS OBSERVED. The top module reaches the two internal nets with
// §6.7.1 hierarchical names and reads each through the access function its
// discipline's natures name (§3.6.2.1). Cpot exists on a segment only after
// resolution gave it annex_f_ci; a compiler that applied the declaration to
// one instance only (or neither) does not print a wrong number — it fails to
// build the other access, which is the failure this shape is chosen for.
// `//! bias` stores 0.5 and 0.7 into the two unknowns and Cpot loads the same
// doubles back, so CHECKX is the honest macro and the two values differ: a
// build that crossed or shared the instances fails both checks.
//
// This is the in-context sibling of out_of_context_internal_net.va, which
// reads a child's internal net after an out-of-context declaration overrides
// its local one; here nothing overrides anything.
//
//! lrm F.2.1
//! lrm F.2.1:1001
//! bias V(c1.sig) = 0.5, V(c2.sig) = 0.7
`include "check.vh"
nature annex_f_ci_pot;
  units = "V";
  access = Cpot;
  abstol = 1u;
endnature
nature annex_f_ci_flow;
  units = "A";
  access = Cflw;
  abstol = 1p;
endnature
discipline annex_f_ci;
  potential annex_f_ci_pot;
  flow annex_f_ci_flow;
  domain continuous;
enddiscipline
module annex_f_ci_cell(p);
  inout p;
  annex_f_ci p;
  // The in-context node declaration under test: one per instance of this module.
  annex_f_ci sig;
endmodule
module annex_f_in_context_instances(a);
  inout a;
  annex_f_ci a;
  annex_f_ci_cell c1(a);
  annex_f_ci_cell c2(a);
  analog begin
    `CHECKX("the in-context declaration makes the first instance's sig electrical",
            Cpot(c1.sig), 0.5);
    `CHECKX("and the second instance's sig too, with its own value",
            Cpot(c2.sig), 0.7);
    Cflw(c1.sig) <+ Cpot(c1.sig) / 1000.0;
    Cflw(c2.sig) <+ Cpot(c2.sig) / 1000.0;
  end
endmodule
