// LRM Annex F.2.1 / F.2.2, discipline resolution step 3: "More than one
// conflicting in-context discipline declaration ... for the same hierarchical
// segment of a signal is an error. In this case, conflicting simply means an
// attempt to declare more than one discipline regardless of whether the
// disciplines are compatible or not."  §3.10 says the same from the other side:
// the two declarations are at the SAME level of precedence (both local, order 2)
// and "it is not legal to have two different disciplines at the same level of
// precedence for the same net".
//
// This file IS the "compatible or not" half of that sentence: annex_f_a and
// annex_f_b are both natureless with `domain continuous`, so §3.11.1's Natureless
// Discipline Rule makes them COMPATIBLE with each other — and step 3 is an error
// anyway. No second fixture is needed for the compatible case.
//
// Step 3 is printed IDENTICALLY in F.2.1 and in F.2.2 (the alternate expanded
// analog algorithm) — same four lines, same words — so this source pins both,
// hence both cites. F.1 ("it is also possible to develop and use other
// algorithms") cannot widen the answer here: the error is raised in step 3,
// before either algorithm's traversal begins, so every conforming algorithm
// agrees.
//
// There is no value to CHECK: the only observable is the diagnostic. The reject
// line is a CODE, not a message fragment, per the suite contract — a fragment is
// a bet on wording, and the generic `DiagnosticsReported` would XPASS on the
// first unrelated diagnostic VerA ever learns to emit on this source, losing the
// step-3 requirement quietly. E0902 is the step-3 conflict, in class 9
// (hierarchy and elaboration, lib/diag_code.zig). lower.zig raises it from the
// net-declaration loop, the one site that can see a second declaration for a
// name the port loop already interned. conflicting_ooc_declarations.va pins the
// same code for the other half of the same sentence and is still xfail: that
// half needs a real instance tree.
//
//! lrm F.2.1
//! lrm F.2.2
//! lrm 3.10
//! lrm 7.4.4
//! lrm 7.4.4:3
//! lrm F.2.1:3
//! lrm F.2.2:4
//! reject-only E0902
//! neighbour in_context_declaration.va
discipline annex_f_a; domain continuous; enddiscipline
discipline annex_f_b; domain continuous; enddiscipline
module annex_f_conflict(sig);
  inout sig;
  annex_f_a sig;
  annex_f_b sig;
endmodule
