//! reject expected `;`
// EXPECT: error -- OOC discipline paths are resolved by a hierarchy elaborator.
module annex_f_ooc;
  electrical top.middle.bottom.sig;
endmodule
