// Annex F.2.1 step 4.a: "It shall be determined whether the net is analog or
// digital. Any net which is used in digital behavioral code shall be
// considered digital. Any net whose child nets are all digital shall be
// considered digital (discrete domain), any others shall be considered analog
// (continuous domain)."
//
// The first sentence comes before the child-based ones, in F.2.1 and again in
// F.2.2 (where it precedes "If any of the connections are analog, the net
// shall be considered analog"), so a net that digital behavioral code uses is
// digital even when its only child is analog.
//
// THE DESIGN. `n` is a discipline-less `wire` in the top module. Its only
// child segment is `u1.p`, an electrical OUTPUT. The top module's `always`
// block reads `n`: digital behavioral code uses it. So step 4.a makes `n`
// digital. Step 4.b: no child discipline of the discrete domain, so "apply
// any `default_discipline directives to the net, provided their domain is the
// same as the domain of the net" -- `default_discipline ddiscrete (§10.2, a
// discrete discipline) is in force, so `n` is ddiscrete.
//
// INSERTION (step 5, §7.8). `u1.p` is then an output port with lower
// connection electrical and upper connection ddiscrete: a mixed port. §7.6
// Example 2's a2d (`electrical` input, `ddiscrete` output) "can bridge ... a
// mixed output port whose upper connection is compatible with ddiscrete and
// whose lower connection is compatible with electrical", so
// `connect b5_nrd_a2d;` inserts one instance across it, loading u1's node
// with rin = 1 kohm.
//
// DERIVATION. u1 holds a 1 kohm shunt and a 1 mA source on p:
//     V/1000 - 1e-3 + V/1000 = 0   =>   V(u1.p) = 0.5
// A tool that ignored the digital use resolves `n` electrical from its child:
// no bridge (V = 1.0), and an always block reading a continuous net by name.
//
//! lrm F.2.1
//! lrm F.2.1:5
//! lrm F.2.1:1002
//! lrm 10.2
//! lrm 7.6
//! lrm 7.8.4
//! solve
//! xfail n now resolves discrete and the a2d is inserted, but the inserted connect module's `reg cm` lands on n's flat name and is refused as a second declaration of n (E0362, reported at `reg cm`)
`include "check.vh"

connectmodule b5_nrd_a2d(el, cm);
  input el;
  output cm;
  electrical el;
  ddiscrete cm;
  reg cm;
  parameter real rin = 1000.0 from (0.0:inf);
  analog I(el) <+ V(el) / rin;
  initial cm = 1'b0;
endmodule

module b5_nrd_src(p);
  output p;
  electrical p;
  analog begin
    I(p) <+ V(p) / 1000.0;
    I(p) <+ -1.0e-3;
  end
endmodule

`default_discipline ddiscrete
module b5_net_read_by_digital_code_resolves_digital;
  wire n;
  reg seen;

  b5_nrd_src u1(n);

  always @(n) seen = n;

  analog
    `CHECK("F.2.1 n is used by an always block, so digital: one a2d at u1.p, V = 1/(1+1)",
           V(u1.p), 0.5, 1e-12);
endmodule
`default_discipline

connectrules b5_nrd_rules;
  connect b5_nrd_a2d;
endconnectrules
