// Annex F.2.2's step 4 (the depth-first pass) decides a segment before step 5
// sees it, and step 5 re-determines only nets "which still ha[ve] not been
// assigned a discipline or which ha[ve] been assigned a digital domain from
// step 4" (F.2.2:11). A segment step 4 made ANALOG from its children is
// therefore final, even when its parent is digital:
//
//   F.2.2:5 "Traverse each signal hierarchically (depth-first) when a net is
//   encountered which has still not been assigned a discipline: It shall be
//   determined whether the net is analog or digital."
//   F.2.2:8 "If any of the connections are analog, the net shall be considered
//   analog."
//
// SELECTED BY THE OPTION F.2.2:2 requires: `//! discipline-resolution detail`.
//
// THE DESIGN. `annex_f_s4_top` declares `annex_f_s4_d netd;`, a discrete
// (digital) net, and instantiates mid on it. mid's port `out` is undeclared;
// its two children, leaf1.p and leaf2.p, are electrical. Step 4 walks the
// leaves first and then mid.out: its connections are analog, so F.2.2:8 makes
// it analog (electrical). Step 5 starts at the top segments and re-determines
// nets step 4 made digital or left unknown; mid.out was made analog, so its
// digital parent never reaches it. One a2d bridges mid's port (upper netd
// digital, lower mid.out electrical); the leaf ports then match their upper
// connection and take no bridge.
//
// WHAT A VIOLATION READS. Ignore step 4's analog answer and leave mid.out
// unknown: step 5 decides it from its parent — "Any net whose parent nets are
// digital shall be considered digital" (F.2.2:13) — so mid.out becomes
// digital, and now both leaf ports are mixed, each taking its own d2a. The
// two leaf nodes are then separate analog nodes: each d2a's electrical side
// loads the leaf's own port, not mid.out.
//
//   correct (step 4 analog, one a2d): mid.out carries leaf2's 1 kohm and the
//     a2d's 1 kohm, so V(leaf1.p) = 1 mA / (1k || 1k) = 0.5.
//   step 4 skipped (mid.out digital): leaf1.p carries only its own d2a's
//     1 kohm and its 1 mA source, so V(leaf1.p) = 1 mA * 1 kohm = 1.0.
//
// The CHECK is the difference. §7.6 Table 7-2 picks the modules by direction:
// at mid's OUTPUT port the source is the lower connection (electrical), so
// the continuous-input a2d bridges it; at the leaves' INPUT ports the source
// is the upper connection (digital), so the discrete-input d2a bridges them.
//
//! lrm F.2.2
//! lrm F.2.2:2
//! lrm F.2.2:5
//! lrm F.2.2:8
//! discipline-resolution detail
//! solve
//! checks 1
`include "check.vh"
discipline annex_f_s4_d; domain discrete; enddiscipline
connectmodule annex_f_s4_d2a(dg, el);
  input dg;
  output el;
  annex_f_s4_d dg;
  electrical el;
  analog I(el) <+ V(el) / 1000.0;
endmodule
connectmodule annex_f_s4_a2d(el, dg);
  input el;
  output dg;
  electrical el;
  annex_f_s4_d dg;
  reg dg;
  initial dg = 1'b0;
  analog I(el) <+ V(el) / 1000.0;
endmodule
connectrules annex_f_s4_rules;
  connect annex_f_s4_d2a;
  connect annex_f_s4_a2d;
endconnectrules
module annex_f_s4_leaf1(p);
  input p; electrical p;
  analog begin
    I(p) <+ -1.0e-3;
    `CHECK("step 4's analog answer keeps the digital parent out: one a2d, V = 0.5",
           V(p), 0.5, 1e-12);
  end
endmodule
module annex_f_s4_leaf2(p);
  input p; electrical p;
  analog I(p) <+ V(p) / 1000.0;
endmodule
module annex_f_s4_mid(out);
  output out;
  annex_f_s4_leaf1 l1(out);
  annex_f_s4_leaf2 l2(out);
endmodule
module annex_f_s4_top;
  annex_f_s4_d netd;
  annex_f_s4_mid m(netd);
endmodule
