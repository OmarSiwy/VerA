// LRM Annex F.2.1 step 4.b, fourth bullet (printed verbatim in F.2.2 4.b and
// F.2.2 5.b, so both are cited): "Otherwise the discipline is unknown. This is
// legal provided the net has no mixed-port connections (i.e., it does not connect
// through a port to a segment of a different domain). Otherwise this is an error."
//
// `sig` is left undeclared, so it goes into step 4 with no discipline:
//
//   4.a  its child nets are not all digital (two are continuous), so per
//        "any others shall be considered analog" sig is in the CONTINUOUS domain;
//   4.b  the list of child disciplines whose domain matches that of the segment
//        is {annex_f_a, annex_f_b} — more than one, and there is no
//        `connect ... resolveto` statement whose discipline list matches it, so
//        the first three bullets are all skipped and the discipline is UNKNOWN;
//   4.b  fourth bullet: unknown is legal only with no mixed-port connections, and
//        sig connects through the port of `annex_f_dig_leaf` to a discrete
//        segment. Different domain => mixed-port connection => this is an error.
//
// Two competing diagnostics are ruled OUT by construction, so bullet 4 is the
// only rule a conforming compiler can reach:
//
//   §3.11 Signal Connection Rule (same domain, incompatible disciplines) —
//        annex_f_a and annex_f_b are natureless and both `domain continuous`, so
//        §3.11.1's Natureless Discipline Rule makes them compatible.
//   §3.11 Signal Domain Rule ("it shall be an error to connect two ports or nets
//        of different domains UNLESS THERE IS A CONNECT STATEMENT (see 7.4)
//        defined between the disciplines of the nets or ports") — this is why the
//        two connectmodules and the connectrules block are here. Without them the
//        a-to-dig and b-to-dig crossings are an error on their own, before
//        resolution runs at all, and the fixture would be demanding a diagnostic
//        a conforming compiler has no reason to reach. Their bodies are empty
//        exactly as §7.6's example 3 prints them ("// insert connect module
//        behavioral here"); nothing here reaches the insertion phase, because
//        §7.6 puts it AFTER resolution ("the disciplines of mixed nets are
//        determined prior to the connect module insertion phase") and resolution
//        errors out first.
//
// The connect statements are §7.7.1 connect_insertion, NOT §7.7.2
// connect_resolution: an insertion statement names a bridging module and does
// not resolve a discipline list, so {annex_f_a, annex_f_b} still matches no
// resolution statement and the net stays unknown. That distinction is the whole
// mechanism of this fixture.
//
// There is no value to CHECK: the only observable is the diagnostic. The reject
// line is a CODE, not a message fragment, per the suite contract — E0903 was
// the code RESERVED for the unresolvable-plus-mixed-port error, next to E0902
// for the step-3 conflict, in class 9 (hierarchy and elaboration,
// lib/diag_code.zig), and reserving the number is why this line never had to
// change when the rule landed: `Elaborate.resolveMultiCandidates` now collects
// the SET of a signal's segment disciplines, partitions it by domain (4.a),
// matches it against the `connectrules` block's resolution statements (4.b
// bullet 3 — none here, by construction), and fires the fourth bullet on the
// discrete crossing. resolveto_resolution.va is the positive half of the same
// arm, and exclude_resolution.va the §7.7.2 `exclude` half.
//
// The `connectmodule` halves PARSE and are accepted (§7.6, A.1.2 — see
// ch07_mixed_signal/connectmodule_accepted.va), and the `connectrules` block
// parses too (§7.7, A.1.8): its two insertion statements name real connect
// modules, so they survive §7.7.1's own check (E0915) and then — being
// insertions — resolve nothing, which is the distinction the whole fixture
// stands on.
//
//! lrm F.2.1
//! lrm F.2.2
//! lrm F.2.2:10
//! lrm F.2.2:15
//! lrm F.2.1:7
//! reject E0903
//! neighbour ../ch07_mixed_signal/connectmodule_accepted.va
//! neighbour resolveto_resolution.va
discipline annex_f_a; domain continuous; enddiscipline
discipline annex_f_b; domain continuous; enddiscipline
discipline annex_f_dig; domain discrete; enddiscipline
connectmodule annex_f_a_bridge(c, d);
  inout c; inout d;
  annex_f_a   c;
  annex_f_dig d;
  // insert connect module behavioral here
endmodule
connectmodule annex_f_b_bridge(c, d);
  inout c; inout d;
  annex_f_b   c;
  annex_f_dig d;
  // insert connect module behavioral here
endmodule
connectrules annex_f_domain_crossings;
  connect annex_f_a_bridge;
  connect annex_f_b_bridge;
endconnectrules
module annex_f_a_leaf(p);
  inout p; annex_f_a p;
endmodule
module annex_f_b_leaf(p);
  inout p; annex_f_b p;
endmodule
module annex_f_dig_leaf(d);
  inout d; annex_f_dig d;
endmodule
module annex_f_unknown_mixed(sig);
  inout sig;
  annex_f_a_leaf   la(sig);
  annex_f_b_leaf   lb(sig);
  annex_f_dig_leaf ld(sig);
endmodule
