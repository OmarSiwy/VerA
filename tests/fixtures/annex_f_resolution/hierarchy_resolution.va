// LRM Annex F.2 — the traversal itself, which no other fixture in the suite
// pins. F.2: "The undeclared nets are resolved at each level of the hierarchy in
// which continuous (analog) has precedence over discrete (digital). In both
// algorithms, the continuous domain is passed up the hierarchy from lower levels
// to the top level."  And the definitions this file exercises: "A net segment of
// a signal on the upper connection of a port shall be considered as the parent
// to a net segment on the lower connection of the port"; a post-order depth-first
// traversal "shall start at the bottom (leaf) net segments" and "all the children
// net segments of a parent net segment shall be traversed before that parent net
// segment is traversed".
//
// One signal, three segments deep, exactly one declaration in the whole design:
//
//   annex_f_h_leaf.p   declared annex_f_h        (the only declared segment)
//   annex_f_h_mid.p    undeclared, PARENT of leaf.p
//   annex_f_hier.a/.b  undeclared, PARENT of mid.p — the top segments
//
// Post-order means leaf.p is visited first. mid.p is then visited with its child
// list already resolved: F.2.1 step 4.a puts it in the continuous domain (its
// children are not all digital), 4.b builds the list of child disciplines of that
// domain — {annex_f_h}, a single entry — and the second bullet applies: "If there
// is only a single discipline in the list, the signal is of that discipline".
// The same two steps then run at the top. That is the continuous domain being
// passed up the hierarchy, one level per step, which is the sentence above.
//
// The cite includes F.1 ("this annex provides A POSSIBLE algorithm ... it is also
// possible to develop and use other algorithms to match the semantics") because
// this design is one where the two printed algorithms provably cannot disagree:
// there is no discrete segment anywhere, so F.2.2's step 5 — the top-down pass
// over nets "assigned a digital domain from step 4" — has nothing to re-examine
// and reproduces F.2.1's answer exactly. The assertion is therefore a claim about
// 7.4's SEMANTICS, which is what F.1 says the annex is about, and not about which
// algorithm a compiler chose.
//
// The access functions are Hpot/Hflw and not V/I on purpose. Per §3.6.2.1 a net's
// access function is the one its discipline's natures name, so `Hpot(a, b)` only
// compiles if resolution really assigned annex_f_h to a and b — if the traversal
// stopped short and left them unknown, or never left the leaf, there is no access
// function to call and the fixture cannot even build.
//
// The want is DERIVED, not read back: `//! bias` supplies the two node potentials
// and the assertion is their DIFFERENCE across the branch (§3.6.2 a conservative
// potential is measured between two nodes). 0.75 - 0.25 = 0.5, and all three are
// exact in binary, so `CHECKX` is the honest macro.
//
//! lrm F.1
//! lrm F.2
//! lrm F.2.1
//! bias a = 0.75, b = 0.25
//! xfail VerA compiles one flat module — `annex_f_h_mid ma(a)` is refused with E0204 "module instantiation is not supported", so no signal hierarchy is ever built and the traversal never runs
`include "check.vh"
nature annex_f_h_pot;
  units = "V";
  access = Hpot;
  abstol = 1u;
endnature
nature annex_f_h_flow;
  units = "A";
  access = Hflw;
  abstol = 1p;
endnature
discipline annex_f_h;
  potential annex_f_h_pot;
  flow annex_f_h_flow;
  domain continuous;
enddiscipline
module annex_f_h_leaf(p);
  inout p; annex_f_h p;
endmodule
module annex_f_h_mid(p);
  inout p;
  annex_f_h_leaf leaf(p);
endmodule
module annex_f_hier(a, b);
  inout a, b;
  annex_f_h_mid ma(a);
  annex_f_h_mid mb(b);
  analog begin
    `CHECKX("the leaf discipline reaches the top segment, so its potential spans the branch", Hpot(a, b), 0.5);
    Hflw(a, b) <+ Hpot(a, b);
  end
endmodule
