// LRM Annex F.2.1 step 4.b, third bullet (also printed in F.2.2 4.b and
// F.2.2 5.b, though this input exercises basic-mode bottom-up resolution):
// "If there is more than one discipline in the
// list and the contents of the list match the discipline list of a resolution
// connect statement, the net is of the resolved discipline given by the
// statement." The statement is §7.7.2's `connect d1, d2 resolveto d3;`, and
// this fixture is the POSITIVE half of the arm whose error half is
// unknown_discipline_mixed_port.va — the same two-candidate topology, with the
// resolution statement that file deliberately lacks.
//
// `sig` is left undeclared, so it goes into step 4 with no discipline:
//
//   4.a  its child nets are not all digital (both are continuous), so per
//        "any others shall be considered analog" sig is in the CONTINUOUS
//        domain;
//   4.b  the list of child disciplines whose domain matches is
//        {annex_f_ra, annex_f_rb} — more than one, and this time
//        `connect annex_f_ra, annex_f_rb resolveto annex_f_rc;` matches it
//        exactly, so the third bullet applies and sig IS annex_f_rc.
//
// The resolved discipline is deliberately NOT one of the two candidates.
// §7.7.2.1: "The resolved discipline need not be one of the disciplines
// specified in the discipline list." That choice is also what makes the
// resolution OBSERVABLE rather than assumed, the same trick
// out_of_context_declaration.va plays: per §3.6.2.1 a net's access functions
// are the ones its discipline's natures name, annex_f_ra/annex_f_rb name
// Rpot/Rflw and annex_f_rc names Cpot/Cflw, so `Cpot(sig)` compiles only if
// the resolveto statement really assigned annex_f_rc. A compiler that ignored
// the statement and kept a candidate — the way VerA's first-declaration-wins
// walk would on its own — leaves sig where Cpot does not exist, and the
// fixture fails to build rather than passing by accident.
//
// The two candidates share one nature pair, because they must: §7.7.2 scopes
// the statement to "multiple nets with compatible disciplines ... part of the
// same mixed net", and §3.11's Signal Connection Rule already judges the two
// declared child segments. Identical natures is compatibility by §3.11.1's
// first rule, so resolution — not compatibility — is the only question this
// source asks.
//
// The want is the bias read back: `//! bias` stores 0.75 into the unknown
// vector and `Cpot(sig)` loads that same double back, exact in binary, so
// `CHECKX` is the honest macro (continuous_discipline.va states the same
// argument for the same shape).
//
//! lrm F.2.1
//! lrm F.2.2
//! lrm 7.7.2
//! lrm 7.4.1
//! lrm 7.4.1:1000
//! lrm 7.7.2:1000
//! lrm F.2.1:6
//! lrm F.2.1:1004
//! bias sig = 0.75
`include "check.vh"
nature annex_f_r_pot;
  units = "V";
  access = Rpot;
  abstol = 1u;
endnature
nature annex_f_r_flow;
  units = "A";
  access = Rflw;
  abstol = 1p;
endnature
nature annex_f_c_pot;
  units = "V";
  access = Cpot;
  abstol = 1u;
endnature
nature annex_f_c_flow;
  units = "A";
  access = Cflw;
  abstol = 1p;
endnature
discipline annex_f_ra;
  potential annex_f_r_pot;
  flow annex_f_r_flow;
  domain continuous;
enddiscipline
discipline annex_f_rb;
  potential annex_f_r_pot;
  flow annex_f_r_flow;
  domain continuous;
enddiscipline
discipline annex_f_rc;
  potential annex_f_c_pot;
  flow annex_f_c_flow;
  domain continuous;
enddiscipline
connectrules annex_f_resolutions;
  connect annex_f_ra, annex_f_rb resolveto annex_f_rc;
endconnectrules
module annex_f_ra_leaf(p);
  inout p; annex_f_ra p;
endmodule
module annex_f_rb_leaf(p);
  inout p; annex_f_rb p;
endmodule
module annex_f_resolved(sig);
  inout sig;
  annex_f_ra_leaf la(sig);
  annex_f_rb_leaf lb(sig);
  analog begin
    `CHECKX("the resolveto statement assigns annex_f_rc, so its access function reads the net", Cpot(sig), 0.75);
    Cflw(sig) <+ Cpot(sig);
  end
endmodule
