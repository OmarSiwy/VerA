// Specialized input for AMS F.2.2:9; observed by
// lib/elab/elaborate/resolution_observations_test.zig.
//
// The host selects DETAIL resolution and stops after the bottom-up pass.
// Both child.p and child.leaf.p have no discipline, digital behavioral use,
// or classified children. Their domains must still be unknown, despite the
// continuous parent. Step 5 can subsequently inherit that parent's domain.
// A final-domain check alone cannot establish the intermediate answer.
// There are no ordinary fixture assertions: this input earns evidence only
// through the exact specialized observer.
discipline observer_continuous;
  domain continuous;
enddiscipline

module detail_unknown_parent;
  observer_continuous signal;
  detail_unknown_child child(signal);
endmodule

module detail_unknown_child(p);
  input p;
  detail_unknown_leaf leaf(p);
endmodule

module detail_unknown_leaf(p);
  input p;
endmodule
