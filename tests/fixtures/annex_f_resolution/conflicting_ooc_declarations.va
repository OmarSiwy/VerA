// LRM Annex F.2.1 / F.2.2, discipline resolution step 3, second half: "More than
// one conflicting in-context discipline declaration OR MORE THAN ONE CONFLICTING
// OUT-OF-CONTEXT DISCIPLINE DECLARATION for the same hierarchical segment of a
// signal is an error."  conflicting_declarations.va covers the in-context half;
// this is the out-of-context half. The four lines are printed verbatim in both
// F.2.1 and F.2.2, so both are cited.
//
// The hierarchy below is REAL, and that is the point of the file. Step 3 runs
// after step 1 "Elaborate the design", so an out-of-module reference to a path
// that does not exist is diagnosed as an unresolved hierarchical name and never
// reaches the conflict rule — with a dangling path the fixture is unsatisfiable
// by any compiler. So annex_f_ooc_top instantiates annex_f_ooc_mid, which
// instantiates annex_f_ooc_leaf, and `mid.leaf.p` names the lower connection of
// the leaf's port: an existing net segment, of the same three-component shape as
// the LRM's own `electrical top.middle.bottom.sig;`.
//
// `p` carries no discipline in the module it belongs to, so both declarations are
// out-of-context ones (§3.10 precedence order 1) for that one segment, at the same
// level of precedence, which §3.10 also calls illegal. annex_f_a and annex_f_b are
// natureless and both `domain continuous`, so §3.11.1's Natureless Discipline Rule
// makes them compatible — and step 3 is an error regardless ("whether the
// disciplines are compatible or not"). Nothing else in the design is a domain
// crossing or an incompatibility, so step 3 is the only rule this source trips.
//
// There is no value to CHECK: the only observable is the diagnostic. The reject
// line is a CODE, not a message fragment, per the suite contract. It cannot be
// the generic `DiagnosticsReported`: VerA already fails this source in the PARSER
// on the dotted name, so a generic pattern would match that unrelated diagnostic
// and XPASS today. E0902 is the code RESERVED for the step-3 conflict (class 9,
// hierarchy and elaboration, src/diag_code.zig; E0901 is the last one
// implemented), shared with conflicting_declarations.va — the two halves of one
// sentence are one rule.
//
//! lrm F.2.1
//! lrm F.2.2
//! lrm 3.10
//! reject E0902
//! xfail VerA's parser stops at the `.` of a dotted net declaration with E0207 "expected `;`" and refuses the instances with E0204 "module instantiation is not supported", so no hierarchy is elaborated: the out-of-context declaration form and the step-3 conflict check are both missing
discipline annex_f_a; domain continuous; enddiscipline
discipline annex_f_b; domain continuous; enddiscipline
module annex_f_ooc_leaf(p);
  inout p;
endmodule
module annex_f_ooc_mid(p);
  inout p;
  annex_f_ooc_leaf leaf(p);
endmodule
module annex_f_ooc_top(p);
  inout p;
  annex_f_ooc_mid mid(p);
  annex_f_a mid.leaf.p;
  annex_f_b mid.leaf.p;
endmodule
