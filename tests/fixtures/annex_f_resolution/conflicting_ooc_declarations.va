// LRM Annex F.2.1 / F.2.2, discipline resolution step 3, second half: "More than
// one conflicting in-context discipline declaration OR MORE THAN ONE CONFLICTING
// OUT-OF-CONTEXT DISCIPLINE DECLARATION for the same hierarchical segment of a
// signal is an error."  conflicting_declarations.va covers the in-context half;
// this is the out-of-context half.
//
// The dotted form is the LRM's own: step 3 prints `electrical top.middle.bottom.sig;`
// as the legal way to override the discipline declared in the module where sig was
// declared, and §3.10 lists it as precedence order 1. Two of them for the SAME
// segment are at the same level of precedence, which §3.10 also calls illegal.
//
// annex_f_a and annex_f_b are natureless and both `domain continuous`, so §3.11.1
// makes them compatible — step 3 is an error regardless ("whether the disciplines
// are compatible or not").
//
// There is no value to CHECK: the only observable is the diagnostic. The reject
// substring is deliberately rule-specific rather than the generic
// `DiagnosticsReported`, because VerA today dies in the PARSER on the dotted name
// and a generic substring would match that unrelated diagnostic and XPASS.
//
//! lrm F.2.1
//! lrm 3.10
//! reject conflicting discipline declaration
//! xfail VerA's parser rejects a dotted (out-of-module) net declaration with "expected `;`", so it never reaches a conflict check; both the OOC declaration form and the step-3 conflict rule are missing
discipline annex_f_a; domain continuous; enddiscipline
discipline annex_f_b; domain continuous; enddiscipline
module annex_f_ooc_conflict;
  annex_f_a top.child.sig;
  annex_f_b top.child.sig;
endmodule
