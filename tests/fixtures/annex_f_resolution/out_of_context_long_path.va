// LRM Annex F.2.1 step 3 / §3.10 precedence order 1, at a path length the
// implementation used to lose. The out-of-context table is keyed by the FLAT
// hierarchical name, and `oocDiscipline` built its lookup key in a fixed
// 256-byte buffer whose overflow was swallowed (`catch return null`) — so a
// segment whose path exceeded 256 bytes silently KEPT its local declaration,
// inverting §3.10's order-1 precedence for long paths only. Every sibling key
// join in the elaborator allocates; this one now does too, and this file is
// what fails if the cap ever comes back.
//
// The design is out_of_context_internal_net.va's, byte for byte, except that
// the instance is named with a 270-character §2.8 identifier, putting the flat
// key `ooc_long_xxxxxxxxxxxxxxxxxxxxxxxxxxxxxxxxxxxxxxxxxxxxxxxxxxxxxxxxxxxxxxxxxxxxxxxxxxxxxxxxxxxxxxxxxxxxxxxxxxxxxxxxxxxxxxxxxxxxxxxxxxxxxxxxxxxxxxxxxxxxxxxxxxxxxxxxxxxxxxxxxxxxxxxxxxxxxxxxxxxxxxxxxxxxxxxxxxxxxxxxxxxxxxxxxxxxxxxxxxxxxxxxxxxxxxxxxxxxxxxxxxxxxxxxxxxxxxxxxxxxx.mid`
// at 274 bytes. §2.8 places no length limit on an identifier ("Identifiers
// shall be at least 1024 characters long" is annex H's floor for TOOLS), so
// the name is legal and only the buffer was not. The observable is the access
// function, exactly as in the sibling: `Ypot` resolves only if the
// out-of-context declaration actually replaced the child's local one.
//
//! lrm F.2.1
//! lrm 3.10
//! lrm F.2.1:2
//! bias V(ooc_long_xxxxxxxxxxxxxxxxxxxxxxxxxxxxxxxxxxxxxxxxxxxxxxxxxxxxxxxxxxxxxxxxxxxxxxxxxxxxxxxxxxxxxxxxxxxxxxxxxxxxxxxxxxxxxxxxxxxxxxxxxxxxxxxxxxxxxxxxxxxxxxxxxxxxxxxxxxxxxxxxxxxxxxxxxxxxxxxxxxxxxxxxxxxxxxxxxxxxxxxxxxxxxxxxxxxxxxxxxxxxxxxxxxxxxxxxxxxxxxxxxxxxxxxxxxxxxxxxxxxxx.mid) = 0.5
`include "check.vh"
nature annex_f_l_x_pot;
  units = "V";
  access = Xpot;
  abstol = 1u;
endnature
nature annex_f_l_x_flow;
  units = "A";
  access = Xflw;
  abstol = 1p;
endnature
nature annex_f_l_y_pot;
  units = "V";
  access = Ypot;
  abstol = 1u;
endnature
nature annex_f_l_y_flow;
  units = "A";
  access = Yflw;
  abstol = 1p;
endnature
discipline annex_f_l_x;
  potential annex_f_l_x_pot;
  flow annex_f_l_x_flow;
  domain continuous;
enddiscipline
discipline annex_f_l_y;
  potential annex_f_l_y_pot;
  flow annex_f_l_y_flow;
  domain continuous;
enddiscipline
module annex_f_long_child(p);
  inout p;
  annex_f_l_x p;
  annex_f_l_x mid;
endmodule
module annex_f_long_over(a);
  inout a;
  annex_f_l_x a;
  annex_f_long_child ooc_long_xxxxxxxxxxxxxxxxxxxxxxxxxxxxxxxxxxxxxxxxxxxxxxxxxxxxxxxxxxxxxxxxxxxxxxxxxxxxxxxxxxxxxxxxxxxxxxxxxxxxxxxxxxxxxxxxxxxxxxxxxxxxxxxxxxxxxxxxxxxxxxxxxxxxxxxxxxxxxxxxxxxxxxxxxxxxxxxxxxxxxxxxxxxxxxxxxxxxxxxxxxxxxxxxxxxxxxxxxxxxxxxxxxxxxxxxxxxxxxxxxxxxxxxxxxxxxxxxxxxxx(a);
  annex_f_l_y ooc_long_xxxxxxxxxxxxxxxxxxxxxxxxxxxxxxxxxxxxxxxxxxxxxxxxxxxxxxxxxxxxxxxxxxxxxxxxxxxxxxxxxxxxxxxxxxxxxxxxxxxxxxxxxxxxxxxxxxxxxxxxxxxxxxxxxxxxxxxxxxxxxxxxxxxxxxxxxxxxxxxxxxxxxxxxxxxxxxxxxxxxxxxxxxxxxxxxxxxxxxxxxxxxxxxxxxxxxxxxxxxxxxxxxxxxxxxxxxxxxxxxxxxxxxxxxxxxxxxxxxxxx.mid;
  analog begin
    `CHECKX("an out-of-context declaration still wins past 256 path bytes", Ypot(ooc_long_xxxxxxxxxxxxxxxxxxxxxxxxxxxxxxxxxxxxxxxxxxxxxxxxxxxxxxxxxxxxxxxxxxxxxxxxxxxxxxxxxxxxxxxxxxxxxxxxxxxxxxxxxxxxxxxxxxxxxxxxxxxxxxxxxxxxxxxxxxxxxxxxxxxxxxxxxxxxxxxxxxxxxxxxxxxxxxxxxxxxxxxxxxxxxxxxxxxxxxxxxxxxxxxxxxxxxxxxxxxxxxxxxxxxxxxxxxxxxxxxxxxxxxxxxxxxxxxxxxxxx.mid), 0.5);
    Yflw(ooc_long_xxxxxxxxxxxxxxxxxxxxxxxxxxxxxxxxxxxxxxxxxxxxxxxxxxxxxxxxxxxxxxxxxxxxxxxxxxxxxxxxxxxxxxxxxxxxxxxxxxxxxxxxxxxxxxxxxxxxxxxxxxxxxxxxxxxxxxxxxxxxxxxxxxxxxxxxxxxxxxxxxxxxxxxxxxxxxxxxxxxxxxxxxxxxxxxxxxxxxxxxxxxxxxxxxxxxxxxxxxxxxxxxxxxxxxxxxxxxxxxxxxxxxxxxxxxxxxxxxxxxx.mid) <+ Ypot(ooc_long_xxxxxxxxxxxxxxxxxxxxxxxxxxxxxxxxxxxxxxxxxxxxxxxxxxxxxxxxxxxxxxxxxxxxxxxxxxxxxxxxxxxxxxxxxxxxxxxxxxxxxxxxxxxxxxxxxxxxxxxxxxxxxxxxxxxxxxxxxxxxxxxxxxxxxxxxxxxxxxxxxxxxxxxxxxxxxxxxxxxxxxxxxxxxxxxxxxxxxxxxxxxxxxxxxxxxxxxxxxxxxxxxxxxxxxxxxxxxxxxxxxxxxxxxxxxxxxxxxxxxx.mid) / 1000.0;
  end
endmodule
