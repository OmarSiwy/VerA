// LRM Annex F.2.1 step 3 / §3.10 precedence order 1, on the half its sibling
// `out_of_context_declaration.va` does not reach: an out-of-context declaration
// naming a child's INTERNAL net rather than one of its ports.
//
// The clause's printed example is one sentence and this is the clause of it
// that decides the case: "electrical top.middle.bottom.sig; overrides any
// discipline which may be DECLARED FOR SIG IN THE MODULE WHERE SIG WAS
// DECLARED". The thing being overridden is a LOCAL declaration in the module
// that owns the name — which is a net declaration, port or not. VerA used to
// consult the out-of-context table only where a port was bound, so a
// declaration naming a child's own net was read, checked for conflicts, and
// then ignored.
//
// The design is the sibling's, moved one net inward:
//
//   annex_f_int_child.mid   locally declared annex_f_x   (precedence order 2)
//   annex_f_int_over        declares  annex_f_y c1.mid;  (precedence order 1)
//
// `mid` is not a port of the child, so nothing in the flatten's port loop can
// see it; it is reached only by §6.7.1 hierarchical name from the parent, which
// is also how the assertion observes it.
//
// The observable is the ACCESS FUNCTION, exactly as in the sibling and for the
// same reason: §3.6.2.1 gives a net the access functions its discipline's
// natures name, annex_f_x names Xpot/Xflw and annex_f_y names Ypot/Yflw, so
// `Ypot(c1.mid)` resolves only if the out-of-context declaration actually
// replaced the local one. A compiler that keeps the order-2 declaration does
// not print a wrong number here — it fails to build, which is the failure mode
// this shape is chosen for.
//
// The child's own body deliberately does not touch `mid`: after the override
// `mid` and `p` are of two different disciplines, and what happens to a branch
// spanning those is §3.11's question, not step 3's. This file is about which
// declaration wins.
//
//! lrm F.2.1
//! lrm 3.10
//! lrm F.2.1:2
//! bias V(c1.mid) = 0.5
`include "check.vh"
nature annex_f_i_x_pot;
  units = "V";
  access = Xpot;
  abstol = 1u;
endnature
nature annex_f_i_x_flow;
  units = "A";
  access = Xflw;
  abstol = 1p;
endnature
nature annex_f_i_y_pot;
  units = "V";
  access = Ypot;
  abstol = 1u;
endnature
nature annex_f_i_y_flow;
  units = "A";
  access = Yflw;
  abstol = 1p;
endnature
discipline annex_f_i_x;
  potential annex_f_i_x_pot;
  flow annex_f_i_x_flow;
  domain continuous;
enddiscipline
discipline annex_f_i_y;
  potential annex_f_i_y_pot;
  flow annex_f_i_y_flow;
  domain continuous;
enddiscipline
module annex_f_int_child(p);
  inout p;
  annex_f_i_x p;
  annex_f_i_x mid;
endmodule
module annex_f_int_over(a);
  inout a;
  annex_f_i_x a;
  annex_f_int_child c1(a);
  annex_f_i_y c1.mid;
  analog begin
    `CHECKX("an out-of-context declaration overrides a child's INTERNAL net declaration, so the y access function reads it", Ypot(c1.mid), 0.5);
    Yflw(c1.mid) <+ Ypot(c1.mid) / 1000.0;
  end
endmodule
