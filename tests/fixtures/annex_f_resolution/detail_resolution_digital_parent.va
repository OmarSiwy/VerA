// Specialized input for AMS F.2.2:13; observed by
// lib/elab/elaborate/resolution_observations_test.zig.
//
// The host selects DETAIL resolution. The child and leaf have no discipline,
// digital behavioral use, or classified descendant: step 4 leaves them
// unknown. Only the parent's domain can make them digital in step 5.
// Analog-parent and unknown-parent controls share exactly the same child
// modules; the host also checks that BASIC mode does not run step 5.
// These are observer inputs, not ordinary simulation assertions.
discipline observer_discrete;
  domain discrete;
enddiscipline

discipline observer_continuous;
  domain continuous;
enddiscipline

module detail_digital_parent;
  observer_discrete signal;
  detail_inherited_child child(signal);
endmodule

module detail_analog_parent_control;
  observer_continuous signal;
  detail_inherited_child child(signal);
endmodule

module detail_unknown_parent_control;
  wire signal;
  detail_inherited_child child(signal);
endmodule

module detail_inherited_child(p);
  input p;
  detail_inherited_leaf leaf(p);
endmodule

module detail_inherited_leaf(p);
  input p;
endmodule
