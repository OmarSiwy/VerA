// LRM Annex F.2.1 step 3, first paragraph — the LEGAL out-of-context declaration,
// which the LRM prints as source: "Apply all out-of-context node and signal
// declarations. For example, electrical top.middle.bottom.sig; OVERRIDES ANY
// DISCIPLINE WHICH MAY BE DECLARED FOR SIG IN THE MODULE WHERE SIG WAS DECLARED."
// §3.10 says the same as a precedence list and puts this form at order 1, above
// the local declaration at order 2. conflicting_ooc_declarations.va covers the
// error half of step 3 (two of them for one segment); nothing else in the suite
// states that ONE of them must be accepted and must win.
//
// The design is the smallest one in which the override is observable:
//
//   annex_f_ooc_leaf.p   locally declared annex_f_x   (precedence order 2)
//   annex_f_ooc_over     declares  annex_f_y ca.p;    (precedence order 1)
//                        and       annex_f_y cb.p;
//
// ca.p and cb.p are two DIFFERENT segments, so this is not the conflict case:
// each gets exactly one out-of-context declaration, and each of those overrides
// exactly one local declaration. After step 3 both leaf segments are annex_f_y,
// and step 4 then hands annex_f_y up to the undeclared top segments a and b
// (4.b, second bullet: a single discipline in the child list).
//
// The two disciplines carry DIFFERENT access function names, which is what makes
// the override observable rather than assumed. annex_f_x names Xpot/Xflw and
// annex_f_y names Ypot/Yflw; per §3.6.2.1 a net's access functions are the ones
// its discipline's natures name. So `Ypot(a, b)` compiles only if the
// out-of-context declaration actually replaced the local one. A compiler that
// silently kept the order-2 declaration — the natural way to get this wrong —
// leaves the top segments annex_f_x, where Ypot does not exist, and the fixture
// fails to build rather than passing by accident.
//
// The want is DERIVED, not read back: `//! bias` supplies the two node potentials
// and the assertion is their DIFFERENCE across the branch. 0.75 - 0.25 = 0.5, all
// three exact in binary, so `CHECKX` is the honest macro.
//
//! lrm F.2.1
//! lrm F.2.2
//! lrm 3.10
//! bias a = 0.75, b = 0.25
//! xfail VerA's parser stops at the `.` of a dotted net declaration with E0207 "expected `;`" and refuses the instances with E0204 "module instantiation is not supported": the out-of-context declaration form of §3.10 order 1 is not implemented
`include "check.vh"
nature annex_f_x_pot;
  units = "V";
  access = Xpot;
  abstol = 1u;
endnature
nature annex_f_x_flow;
  units = "A";
  access = Xflw;
  abstol = 1p;
endnature
nature annex_f_y_pot;
  units = "V";
  access = Ypot;
  abstol = 1u;
endnature
nature annex_f_y_flow;
  units = "A";
  access = Yflw;
  abstol = 1p;
endnature
discipline annex_f_x;
  potential annex_f_x_pot;
  flow annex_f_x_flow;
  domain continuous;
enddiscipline
discipline annex_f_y;
  potential annex_f_y_pot;
  flow annex_f_y_flow;
  domain continuous;
enddiscipline
module annex_f_ooc_child(p);
  inout p; annex_f_x p;
endmodule
module annex_f_ooc_over(a, b);
  inout a, b;
  annex_f_ooc_child ca(a);
  annex_f_ooc_child cb(b);
  annex_f_y ca.p;
  annex_f_y cb.p;
  analog begin
    `CHECKX("the out-of-context declaration overrides the local one, so the y access function reads the branch", Ypot(a, b), 0.5);
    Yflw(a, b) <+ Ypot(a, b);
  end
endmodule
