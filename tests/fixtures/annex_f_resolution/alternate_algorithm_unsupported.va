// DEBT — this rejection is NOT conformance.
// The LRM permits what VerA refuses here. The substrings below record
// CURRENT behavior so the suite stays green on it; they do not claim it
// is right. `zig build ledger` counts this rule against VerA.
//
// VAMS-F.2.2-02  (annex-f-resolution.html)
// It shall be determined whether the net is analog or digital.
// VAMS-F.2.2-03  (annex-f-resolution.html)
// Any net which is used in digital behavioral code shall be considered digital.
// VAMS-F.2.2-04  (annex-f-resolution.html)
// Any net whose child nets are all digital shall be considered digital.
// VAMS-F.2.2-05  (annex-f-resolution.html)
// If any of the connections are analog, the net shall be considered analog.
// … and 5 more rule(s); see tests/lrm-rules/
//
//! reject module instantiation is not supported
// EXPECT: error -- expanded top-down pass requires hierarchy elaboration.
module annex_f_expanded(sig);
  electrical sig;
  mixed_child u(sig);
endmodule
