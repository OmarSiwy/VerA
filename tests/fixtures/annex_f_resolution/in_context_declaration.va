// Annex F.2.1 step 2: "Apply all in-context node and signal declarations. For
// example, `electrical sig;` makes all instances of sig electrical." Here the
// port is declared with no discipline (`inout sig;`) and the discipline is
// supplied by a separate in-context net declaration on the next line.
//
// The natures carry DISTINCT access names on purpose. Per §3.6.2.2/§3.5 the
// access function of a net is the one its discipline's natures name, so
// `Fpot(sig)` only resolves at all if the in-context declaration really bound
// annex_f_local to sig — a natureless discipline (what this fixture used to
// declare) has no access functions and §3.6.3 forbids using such a net in
// analog behavioral code, which is why there was nothing to assert before.
//
// The want is the bias the testbench holds sig at, not anything VerA computed.
//
//! bias sig = 0.7
`include "check.vh"
nature annex_f_local_pot;
  units = "V";
  access = Fpot;
  abstol = 1u;
endnature
nature annex_f_local_flow;
  units = "A";
  access = Fflw;
  abstol = 1p;
endnature
discipline annex_f_local;
  potential annex_f_local_pot;
  flow annex_f_local_flow;
  domain continuous;
enddiscipline
module annex_f_in_context(sig);
  inout sig;
  annex_f_local sig;
  analog begin
    `CHECK("in-context declaration binds the discipline, so its access function reads the node", Fpot(sig), 0.7, 1e-15);
    Fflw(sig) <+ Fpot(sig);
  end
endmodule
