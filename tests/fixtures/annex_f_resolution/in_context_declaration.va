// §3.10 precedence order 2 — "the local declaration of the net in the module to
// which it belongs" — spelled with the §3.6.3 net_discipline declaration form
// `discipline_identifier list_of_net_identifiers ;`. The port is declared with
// no discipline (`inout sig;`) and the discipline is supplied by a separate
// local net declaration on the next line; sig therefore has a declared
// discipline, and §3.10's third and lowest level of precedence — discipline
// resolution, §7.4 and Annex F — never runs. That is why this pins §3.10 and
// not an Annex F step: Annex F only resolves nets left UNDECLARED.
//
// The natures carry DISTINCT access names on purpose. Per §3.6.2.1/§3.6.3 the
// access function of a net is the one its discipline's natures name, so
// `Fpot(sig)` only resolves at all if the local declaration really bound
// annex_f_local to sig — a natureless discipline (what this fixture used to
// declare) has no access functions and §3.6.3 forbids using such a net in
// analog behavioral code, which is why there was nothing to assert before.
//
// The want is the bias the testbench holds sig at, not anything VerA computed,
// and the read-back is bit-exact: `//! bias` stores 0.7 into the unknown vector
// and `Fpot(sig)` loads that same double back, so `CHECKX` is the honest macro.
//
//! lrm 3.10
//! lrm 3.6.2.2
//! lrm 3.6.3
//! lrm 3.10:1
//! bias sig = 0.7
`include "check.vh"
nature annex_f_local_pot;
  units = "V";
  access = Fpot;
  abstol = 1u;
endnature
nature annex_f_local_flow;
  units = "A";
  access = Fflw;
  abstol = 1p;
endnature
discipline annex_f_local;
  potential annex_f_local_pot;
  flow annex_f_local_flow;
  domain continuous;
enddiscipline
module annex_f_in_context(sig);
  inout sig;
  annex_f_local sig;
  analog begin
    `CHECKX("in-context declaration binds the discipline, so its access function reads the node", Fpot(sig), 0.7);
    Fflw(sig) <+ Fpot(sig);
  end
endmodule
