// Annex F.2.2 step 4's behavioral bullet — the depth-first pass must consider
// a net used in digital behavioral code digital before anything else about it
// is decided:
//
//   F.2.2:6 "Any net which is used in digital behavioral code shall be
//   considered digital."
//
// This is the detail-mode twin of digital_behavioral_net_is_digital.va (which
// pins F.2.1:5, the same sentence in the default algorithm). SELECTED BY THE
// OPTION F.2.2:2 requires: `//! discipline-resolution detail`.
//
// `w` in the top module is UNDECLARED and is the target of `assign w = s;`,
// digital behavioral code (§6.5.2.1). Its only child is annex_f_d6_load.p,
// electrical. Step 4's analog-child rule (F.2.2:8) would make w analog if the
// behavioral bullet did not reach it first; w digital makes the leaf a mixed
// port (§7.8.4) and the d2a bridge drives it. The derivation is the basic
// fixture's: s = 1 after #0, the bridge drives vsup = 2.0 V behind 1 kohm into
// the leaf's 1 kohm to ground, (V - 2.0)/1000 + V/1000 = 0, V(p) = 1.0.
//
// WHAT A VIOLATION READS. A step 4 without the bullet resolves w analog from
// its electrical child, and `assign w = s` then writes a continuous net from a
// discrete context, which is refused (E0435). So the fixture passing at all —
// and the CHECK reading 1.0 — is the observation.
//
//! lrm F.2.2
//! lrm F.2.2:2
//! lrm F.2.2:6
//! lrm 7.4
//! lrm 7.8
//! discipline-resolution detail
//! solve
//! checks 1
`include "check.vh"
connectmodule annex_f_d6_d2a(cm, el);
  input cm; output el;
  ddiscrete cm; electrical el;
  parameter real rout = 1000.0;
  parameter real vsup = 2.0;
  reg lvl;
  initial lvl = 1'b0;
  always @(cm) lvl = cm;
  analog I(el) <+ (V(el) - vsup * ((lvl == 1'b1) ? 1.0 : 0.0)) / rout;
endmodule
module annex_f_d6_load(p);
  input p; electrical p;
  analog begin
    I(p) <+ V(p) / 1000.0;
    `CHECK("step 4's behavioral bullet keeps w digital: 2.0 V behind 1k into the 1k leaf",
           V(p), 1.0, 1e-12);
  end
endmodule
module annex_f_d6_top;
  reg s;
  initial begin #0; s = 1'b1; end
  assign w = s;
  annex_f_d6_load l(w);
endmodule
connectrules annex_f_d6_rules;
  connect annex_f_d6_d2a;
endconnectrules
