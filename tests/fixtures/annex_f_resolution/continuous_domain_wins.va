// Annex F.2.1 step 4.a: "It shall be determined whether the net is analog or
// digital. Any net which is used in digital behavioral code shall be
// considered digital. Any net whose child nets are all digital shall be
// considered digital (discrete domain), any others shall be considered analog
// (continuous domain)." And F.2: "continuous (analog) has precedence over
// discrete (digital)."
//
// `w` in the top module is UNDECLARED and no behavioral code in the top uses
// it. Its two child segments are annex_f_cw_inv.q (ddiscrete, digital) and
// annex_f_cw_load.p (electrical, analog). Not all children are digital, so
// 4.a puts w in the continuous domain; 4.b's list of continuous child
// disciplines is {electrical}, a single entry, so w is electrical. The top
// can then read V(w), which only compiles if w resolved to a continuous
// discipline with a V access, and the q port becomes a mixed port that
// §7.8 bridges with the one connect statement below.
//
// Derivation, as in ch07_mixed_signal/m03_11: the inverter drives ~0 = 1
// (its input is 0 after #0), the bridge's Thevenin source is vsup = 2.0 V
// behind rout = 1 kohm, the leaf loads w with 1 kohm to ground, so
// (V - 2.0)/1000 + V/1000 = 0 and V(w) = 1.0. A design in which w stayed
// digital has no V(w) to read and does not compile.
//
// Refusal neighbour: digital_behavioral_net_is_digital.va, where
// the same top writes w from an `assign`, which 4.a's first sentence makes
// digital whatever its children are.
//
//! xfail an undeclared net with a continuous and a discrete child compiles as analog, but no connect module bridges the discrete port (V(w) reads 0; declared `electrical w` reads 1.0)
//! lrm F.2.1
//! lrm F.2
//! lrm 7.4
//! solve
`include "check.vh"
connectmodule annex_f_cw_d2a(cm, el);
  input cm; output el;
  ddiscrete cm; electrical el;
  parameter real rout = 1000.0;
  parameter real vsup = 2.0;
  reg lvl;
  initial lvl = 1'b0;
  always @(cm) lvl = cm;
  analog I(el) <+ (V(el) - vsup * ((lvl == 1'b1) ? 1.0 : 0.0)) / rout;
endmodule
module annex_f_cw_inv(d, q);
  input d; output q;
  ddiscrete d, q;
  reg q;
  initial q = 1'b0;
  always @(d) q = ~d;
endmodule
module annex_f_cw_load(p);
  inout p; electrical p;
  analog I(p) <+ V(p) / 1000.0;
endmodule
module annex_f_continuous_domain_wins;
  ddiscrete sel;
  reg s;
  assign sel = s;
  initial begin #0; s = 1'b0; end
  annex_f_cw_inv u(sel, w);
  annex_f_cw_load l(w);
  analog begin
    `CHECK("w resolved continuous: the d2a's 2.0 V behind 1k into the 1k leaf", V(w), 1.0, 1e-12);
  end
endmodule
connectrules annex_f_cw_rules;
  connect annex_f_cw_d2a;
endconnectrules
