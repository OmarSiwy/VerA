// Annex F.2.2's alternate algorithm keeps a net that DIGITAL BEHAVIORAL code
// uses digital even when its parent segment is analog. Step 4 makes the net
// digital ("Any net whose child nets are all digital shall be considered
// digital", F.2.2:7, and the behavioral bullet above it), and step 5's
// re-determination keeps it digital only because the same bullet is repeated
// there:
//
//   F.2.2:12 "Any net which is used in digital behavioral code shall be
//   considered digital."
//
// ahead of "Any others shall be considered analog" (F.2.2:14).
//
// SELECTED BY THE OPTION F.2.2:2 requires: `//! discipline-resolution detail`.
//
// THE DESIGN. `annex_f_bd_logic.out` is an undeclared output port whose two
// child segments (b1, b2) are annex_f_bd_d, a discrete discipline. The module's
// `always @(out)` block reads it, so step 4 makes the port digital, and step 5
// must keep it digital when it re-examines it under the analog parent `netd`.
// The port is then the only mixed port in the design: its upper connection
// `netd` resolves electrical (the other child, ablk's port, is electrical) and
// its lower connection is annex_f_bd_d, so §7.8 inserts ONE d2a at the top,
// loading 1 kohm; ablk drives 1 mA and V(netd) = 1.0.
//
// WHAT THIS CHECK PINS, AND WHAT IT DOES NOT. It pins step 5's F.2.2:12, not
// step 4's F.2.2:6: the port's two children are digital, so a step 4 that
// ignored the always block still leaves the port digital (F.2.2:7) and the
// bridge count is unchanged. A step 5 that re-determined the port from its
// parent and dropped the behavioral bullet does fail: the port becomes
// electrical (F.2.2:14), b1's and b2's ports are then mixed and take the two
// bridges, so V = 0.5. The two candidate values name the rule.
//
//! lrm F.2.2
//! lrm F.2.2:2
//! lrm F.2.2:12
//! discipline-resolution detail
//! solve
//! checks 1
`include "check.vh"
discipline annex_f_bd_d; domain discrete; enddiscipline
connectmodule annex_f_bd_d2a(d, a);
  input d; annex_f_bd_d d;
  output a; electrical a;
  analog I(a) <+ V(a) / 1000.0;
endmodule
connectrules annex_f_bd_rules;
  connect annex_f_bd_d2a input annex_f_bd_d, output electrical;
endconnectrules
module annex_f_bd_blk(out);
  output out; annex_f_bd_d out;
endmodule
module annex_f_bd_logic(out);
  output out;
  reg seen;
  annex_f_bd_blk b1(out);
  annex_f_bd_blk b2(out);
  always @(out) seen = out;
endmodule
module annex_f_bd_ablk(out);
  output out; electrical out;
  analog begin
    I(out) <+ -1.0e-3;
    `CHECK("step 5 keeps the behavioral port digital: one d2a, V = 1.0",
           V(out), 1.0, 1e-12);
  end
endmodule
module annex_f_detail_behavioral;
  annex_f_bd_logic u(netd);
  annex_f_bd_ablk a(netd);
endmodule
