// LRM 4.7.1 bullet list, verbatim: an analog user-defined function "shall have
// at least one formal argument declared". `noargs` declares none, so the
// DEFINITION is already the violation; A.8.2's `analog_function_call` says the
// same thing from the call side, requiring at least one `analog_expression`
// between the parentheses.
//
// This previously carried no `reject` and asserted CHECKX(noargs(), 1.0) — the
// 4.7.2.1 return-variable rule applied to a function 4.7.1 forbids declaring.
// That rule is worth pinning and is pinned on a legal function by
// 28_user_function.va, so demanding the diagnostic here loses nothing.
//
//! lrm 4.7.1
//! lrm 4.7.1:3
//! reject-only formal argument
//! neighbour 28_user_function.va
module ch4_fn_noargs(p);
  inout p;
  electrical p;
  analog function real noargs;
    noargs = 1.0;
  endfunction
  analog begin
    I(p) <+ noargs();
  end
endmodule
