// §4.5.8, the fourth of the four interrupted-transition cases (Figure 4-12):
//
//   "If the original transition was falling and the new destination value is
//    above the value at the interruption, then the original transition's
//    destination shall be used to compute the new origin. ... Then the
//    original transition's destination (v2) shall be used along with the
//    rescheduled transition's actual rise time (tr3), when calculating the
//    slope: (v3-v2)/tr3. This slope will be applied from the point of
//    interruption (ti,vi), and the readjusted transition's expected end time
//    (t3) is then calculated using this slope ... t3 = ti + (v3-vi)/slope."
//
// HAND DERIVATION. transition(V(p, n), 0, 2n, 4n): td = 0, rise 2ns, fall 4ns.
// The input is 4 at the DC point, 0 from t = 1ns, then 4 again from 3ns.
//
//   Original fall: (t1,v1) = (1ns, 4) to (t2,v2) = (5ns, 0), slope -1 V/ns.
//   At ti = 3ns the output is vi = 2 and the input becomes v3 = 4 > vi.
//   tr3 = 2ns (the rise time). slope = (v3 - v2)/tr3 = (4 - 0)/2ns = 2 V/ns,
//   from (3ns, 2); t3 = ti + (v3 - vi)/slope = 3 + 2/2 = 4ns.
//
//   t/ns   0   1   2   3   3.5   4   5   6
//   out    4   4   3   2   3     4   4   4
//
// The wrong reading, a fresh rise from (ti,vi) over tr3, slope
// (v3-vi)/tr3 = 1 V/ns, reads 2.5 at 3.5ns and 3 at 4ns; the fall time in
// place of tr3, (v3-v2)/tf = 1 V/ns, reads the same 2.5 and 3.
// (python3 check: piecewise-linear through (1,4), (3,2), (4,4).)
//
//! lrm 4.5.8
//! lrm 4.5.8:10
//! lrm 4.5.8:11
//! lrm 4.5.8:5
//! lrm 4.5.8:8
//! analysis tran
//! bias V(n) = 0
//! wave V(p) = 4, 0, 0, 4
//! time 0, 1n, 2n, 3n, 3.5n, 4n, 5n, 6n
//! print none
//! checks 8
`include "check.vh"
module b2_transition_interrupted_falling_higher(p, n);
    inout p, n;
    electrical p, n;
    real tns, y;

    analog begin
        tns = $abstime * 1e9;
        y = transition(V(p, n), 0, 2n, 4n);
        if (tns < 0.5)
            `CHECK("falling, interrupted upward: at t = 0", y, 4.0, 1e-9);
        else if (tns < 1.5)
            `CHECK("falling, interrupted upward: at t = 1ns", y, 4.0, 1e-9);
        else if (tns < 2.5)
            `CHECK("falling, interrupted upward: at t = 2ns", y, 3.0, 1e-9);
        else if (tns < 3.25)
            `CHECK("falling, interrupted upward: at t = 3ns (ti, vi)", y, 2.0, 1e-9);
        else if (tns < 3.75)
            `CHECK("falling, interrupted upward: at t = 3.5ns", y, 3.0, 1e-9);
        else if (tns < 4.5)
            `CHECK("falling, interrupted upward: at t = 4ns = t3", y, 4.0, 1e-9);
        else if (tns < 5.5)
            `CHECK("falling, interrupted upward: at t = 5ns", y, 4.0, 1e-9);
        else
            `CHECK("falling, interrupted upward: at t = 6ns", y, 4.0, 1e-9);
        I(p, n) <+ 1e-3 * y;
    end
endmodule
