// §4.7.2.3 output arguments: "At the end of the execution of the analog
// user-defined function, the last value assigned to the output argument is then
// assigned to the corresponding analog variable reference that was passed into
// the function." §4.7.2.4 inout arguments: same copy-out, but "the inout
// arguments ... do not get initialized like those defined as output" — the
// caller's value is copied IN.
//
// At V(p,n) = 1.5 and width = 2.0, with the accumulator primed to 4.0:
//     result_area      = 1.5 * 2.0        = 3.0
//     result_perimeter = 2.0 * (1.5+2.0)  = 7.0
//     accumulator      = 4.0 + 3.0        = 7.0   <- 3.0 if the inout were
//                                                    zero-initialized like an
//                                                    output argument
// and §4.7.2.1 makes the returned value the last one assigned to the function
// identifier, which is that same 7.0.
//
// The geometry formulas are symmetric in length and width (l*w and 2*(l+w)),
// so a tool that swapped the two inputs would still pass them. `ordered` below
// is antisymmetric on purpose: with V(p,n) = 1.5 and the second actual 2.0,
//     difference = 1.5 - 2.0 = -0.5
//     negated    = 2.0 - 1.5 =  0.5
// so assigning the actual expressions to the declared formals in any other
// order changes both values.
//
//! lrm 4.7.2.3
//! lrm 4.7.2.3:1001
//! lrm 4.7.2.4:1001
//! lrm 4.7.3:1001
//! lrm 4.7.2.4
//! bias V(p) = 1.5
`include "check.vh"
module ch04_function_output_inout(p, n);
    inout p, n;
    electrical p, n;
    real area, perimeter, value;
    real order_diff, order_mirror;
    real unassigned_output, untouched_inout, dummy;

    analog function real geometry;
        input length, width;
        output result_area, result_perimeter;
        inout accumulator;
        real length, width, result_area, result_perimeter, accumulator;
        begin
            result_area = length * width;
            result_perimeter = 2.0 * (length + width);
            accumulator = accumulator + result_area;
            geometry = accumulator;
        end
    endfunction

    analog function real ordered;
        input first, second;
        output difference, negated;
        real first, second, difference, negated;
        begin
            difference = first - second;
            negated = second - first;
            ordered = difference;
        end
    endfunction

    analog function real untouched_arguments;
        output reset_value;
        inout preserved_value;
        real reset_value, preserved_value;
        begin
            untouched_arguments = 1.0;
        end
    endfunction

    analog begin
        value = 4.0;
        value = geometry(V(p, n), 2.0, area, perimeter, value);
        `CHECKX("output argument carries l*w back out", area, 3.0);
        `CHECKX("output argument carries 2*(l+w) back out", perimeter, 7.0);
        `CHECKX("inout argument was copied in, not zero-initialized", value, 7.0);
        dummy = ordered(V(p, n), 2.0, order_diff, order_mirror);
        `CHECKX("the first actual binds to the first declared input", order_diff, -0.5);
        `CHECKX("the second actual binds to the second declared input", order_mirror, 0.5);
        unassigned_output = 99.0;
        untouched_inout = 17.0;
        dummy = untouched_arguments(unassigned_output, untouched_inout);
        `CHECKX("an unassigned output resets the caller's previous value to zero", unassigned_output, 0.0);
        `CHECKX("an unassigned inout preserves the caller's previous value", untouched_inout, 17.0);
        `CHECKX("the call with untouched arguments still returns normally", dummy, 1.0);
        I(p, n) <+ value + area + perimeter;
    end
endmodule
