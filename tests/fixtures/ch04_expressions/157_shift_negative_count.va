// LRM 4.2.11: "The right operand is always treated as an unsigned number" —
// so a negative count is not "shift the other way", it is a reinterpreted
// value of at least 2^31, an over-wide shift of §3.2's 32-bit integer, and
// both operators "fill the vacated bit positions with zeroes": every one of
// the 32 bits is vacated, the result is 0.
//
// This pins the exact bug of taking the count as SIGNED and reversing the
// direction: 8 << -1 came out 4 and 8 >> -1 came out 16. The two over-wide
// positive counts alongside are the already-correct neighbours the fix must
// not disturb — 8 << 33 pushes every bit past §3.2.1's width, 8 >> 32 drains
// them all.
//
// The operands are variables assigned from literals, not literals: a literal
// shift folds in lowering, and the value under test is the compiled runtime
// operator (the constant folder deliberately declines these counts and defers
// to it).
//
//! lrm 4.2.11
//! lrm 4.2.11:1000
`include "check.vh"
module ch04_shift_negative_count(p, n);
    inout p, n;
    electrical p, n;
    integer a, nsh, sl, sr, slw, srw;

    analog begin
        a = 8;
        nsh = -1;
        sl = a << nsh;
        `CHECKI("8 << -1 vacates all 32 bits (count is unsigned)", sl, 0);
        sr = a >> nsh;
        `CHECKI("8 >> -1 vacates all 32 bits (count is unsigned)", sr, 0);
        nsh = 33;
        slw = a << nsh;
        `CHECKI("8 << 33 is over-wide and stays 0", slw, 0);
        nsh = 32;
        srw = a >> nsh;
        `CHECKI("8 >> 32 is over-wide and stays 0", srw, 0);
        I(p, n) <+ V(p, n) + sl + sr;
    end
endmodule
