// §4.6.4.1 white_noise, and the half of it no `CHECK` can reach.
//
// The clause is printed with its own example, which this is verbatim except for
// spelling out `P_K:
//
//     I(a,b) <+ V(a,b)/R + white_noise(4 * `P_K * $temperature/R, "thermal");
//
// Two things are being claimed and they need two different instruments.
//
// The VALUE is checkable from the model: §4.6 says "when not active, the
// small-signal source functions return zero", and a dc point is not active, so
// the branch carries the resistive current and nothing else. `CHECKX` pins that
// — a lowering that let a noise source leak into the operating point would move
// the current, and a noisy device's dc solution must equal its noiseless one.
//
// The TOPOLOGY is not checkable from the model, at all. "White noise processes
// are those whose current value is completely uncorrelated with any previous or
// future values" is a statement about a generator that a dc evaluation never
// runs, and there is no expression in Verilog-A that reads back which generator
// was declared or which branch it was declared on. That leaves the device's
// §4.6.4 export as the only place the clause is observable, so this fixture
// states it with `//! noise` and the runner reads the table a host would read.
// Without that line the fixture could compile a model with no generator at all
// and still print ok=1 on every assertion it makes.
//
// `white_noise` is the `thermal` kind because §4.6.4.1's own worked example IS
// the thermal noise of a resistor and 4kT/R is what it computes; the tag names
// the physics the clause names, not a second concept.
//
//! lrm 4.6.4.1
//! lrm 4.6.2
//! noise thermal(a,b)#0
//! analysis dc
//! temp 300.15
//! bias V(a) = 1.0
//! bias V(b) = 0.0
`include "check.vh"
module ch04_white_noise_topology(a, b);
    inout a, b;
    electrical a, b;
    parameter real R = 1000.0 from (0:inf);

    analog begin
        I(a, b) <+ V(a, b)/R + white_noise(4.0 * `P_K * $temperature / R, "thermal");
        // 1.0 V across 1 kΩ. The noise term contributes exactly nothing here,
        // which is the point: 1.0/1000.0 and not 1.0/1000.0 plus a draw.
        `CHECKX("the dc current is the resistive term alone", V(a,b)/R, 1e-3);
        `CHECKX("$temperature is the declared ambient in kelvin", $temperature, 300.15);
        `CHECKX("white_noise is inactive outside a small-signal analysis", white_noise(1.0), 0.0);
    end
endmodule
