// §5.9.3: "The analog_for statements are syntactically equivalent to for()
// statements except the associated analog statement can contain analog
// operators." The genvar form unrolls onto the spine at elaboration, so every
// `ddt` instance is stepped on every evaluation and none of them can miss a
// timestep. This is the LEGAL counterpart of 89/90/91 and must keep compiling —
// it is what proves E0514 rejects the construct and not the shape.
//
// Two assertions, both independent of how the unroll is implemented:
//
//   trips == 2   §5.9.3 makes the analog_for "syntactically equivalent to
//                for()", so the §5.9 for-loop semantics apply: i takes 0 and 1
//                and the body runs exactly twice. `trips` is accumulated by an
//                ordinary statement sitting beside the `ddt`, so it counts the
//                unrolled copies whatever the operator lowers to.
//
//   x == 0       §4.5.3: "In DC analysis, ddt() returns zero (0)." p is biased
//                to 0.7 so the ARGUMENT is nonzero and the zero has to come
//                from the operator, not from its input. Both unrolled `ddt`
//                instances must give it, so the sum is exactly 0 -- no
//                integration scheme enters, this is the analysis kind alone.
//
//! lrm 4.5.15
//! lrm 4.5.3
//! bias V(p) = 0.7
`include "check.vh"
module ch4_op_genvar_for(p);
  inout p;
  electrical p;
  genvar i;
  real x, trips;
  analog begin
    x = 0.0;
    trips = 0.0;
    for (i = 0; i < 2; i = i + 1) begin
      x = x + ddt(V(p));
      trips = trips + 1.0;
    end
    `CHECKX("genvar for unrolls twice", trips, 2.0);
    `CHECK("both ddt instances are zero in DC", x, 0.0, 0.0);
    I(p) <+ x;
  end
endmodule
