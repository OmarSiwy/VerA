// VerA's `vera_interp` attribute (§2.9) on `absdelay` (§4.5.7): 2 reads the
// delay history by 3-point Lagrange interpolation, the reading SPICE's
// lossless transmission line uses (ngspice traload.c).
//
// §4.5.7: "the absdelay() operator will use linear interpolation as needed",
// so linear is the default and the twin `absdelay_vera_interp_linear.va`
// holds it. §2.9: an attribute_instance "can appear as a suffix to an
// operator or a Verilog-AMS function name in an expression" and as a prefix
// to a statement; VerA reads this one the way it reads `vera_lte`: the
// call's own suffix wins, then the nearest enclosing statement, then linear.
//
// INPUT: V(p) = tn^2 at the declared points tn = $abstime/1ns = 0..5, so the
// accepted history is (tn, tn^2). A parabola through three samples of tn^2
// IS tn^2, so the quadratic reading is exact wherever it has three points;
// linear between two samples a unit apart misses a parabola by h^2/4 = 0.25
// at the midpoint. The ring holds the points accepted BEFORE the one being
// evaluated.
//
// SITE yh, td = 1.5 ns, statement prefix: the query tn - 1.5 lies inside the
// history.
//   tn   query  samples   quadratic             linear
//   0    -      -         0 (DC: the input)     0
//   1    -0.5   {0}       0 (before history: Input(0))
//   2    0.5    {0,1}     0.5 (two samples: linear fallback)
//   3    1.5    {0,1,2}   (0,1,2) -> 2.25       2.5
//   4    2.5    {0..3}    (1,2,3) -> 6.25       6.5
//   5    3.5    {0..4}    (2,3,4) -> 12.25      12.5
//
// SITE yf, td = 0.5 ns, suffix: the query tn - 0.5 is past the newest sample,
// so the parabola runs through the last two samples and the in-flight
// (tn, tn^2). tn = 1 has one sample: linear, 0.5. From tn = 2 on it is
// (tn - 0.5)^2: 2.25, 6.25, 12.25, 20.25 (linear: +0.25).
// Its derivative w.r.t. the input is the Lagrange weight of `now`:
//   (t - ta)(t - tb) / ((now - ta)(now - tb)) = (1.5)(0.5) / ((2)(1)) = 0.375
// for every tn >= 2 (linear: (t - tb)/(now - tb) = 0.5); 0.5 at tn = 1, and 1
// at the DC point, where the input passes through.
//
// SITE yl, td = 1.5 ns: a suffix of 1 inside a statement prefixed 2 — the
// innermost wins, so it is yh's LINEAR column.
//! lrm 4.5.7
//! lrm 2.9
//! bias V(n) = 0
//! wave V(p) = 0, 1, 4, 9, 16, 25
//! time 0, 1n, 2n, 3n, 4n, 5n
//! analysis tran
//! print none
`include "check.vh"
module absdelay_vera_interp_quadratic(p, n);
    inout p, n;
    electrical p, n;
    real yh, yf, yl, dyf;
    analog begin
        (* vera_interp = 2 *) yh = absdelay(V(p, n), 1.5n);
        yf = absdelay (* vera_interp = 2 *) (V(p, n), 0.5n);
        dyf = ddx(yf, V(p));
        (* vera_interp = 2 *) begin
            yl = absdelay (* vera_interp = 1 *) (V(p, n), 1.5n);
        end
        `CHECK("history, quadratic", yh,
            $abstime < 0.5n ? 0.0 : ($abstime < 1.5n ? 0.0 : ($abstime < 2.5n ? 0.5 : ($abstime < 3.5n ? 2.25 : ($abstime < 4.5n ? 6.25 : 12.25)))), 1e-9);
        `CHECK("in flight, quadratic", yf,
            $abstime < 0.5n ? 0.0 : ($abstime < 1.5n ? 0.5 : ($abstime < 2.5n ? 2.25 : ($abstime < 3.5n ? 6.25 : ($abstime < 4.5n ? 12.25 : 20.25)))), 1e-9);
        `CHECK("in flight, d/dvin", dyf,
            $abstime < 0.5n ? 1.0 : ($abstime < 1.5n ? 0.5 : ($abstime < 2.5n ? 0.375 : ($abstime < 3.5n ? 0.375 : ($abstime < 4.5n ? 0.375 : 0.375)))), 1e-9);
        `CHECK("innermost suffix 1 is linear", yl,
            $abstime < 0.5n ? 0.0 : ($abstime < 1.5n ? 0.0 : ($abstime < 2.5n ? 0.5 : ($abstime < 3.5n ? 2.5 : ($abstime < 4.5n ? 6.5 : 12.5)))), 1e-9);
        I(p, n) <+ 0.0;
    end
endmodule
