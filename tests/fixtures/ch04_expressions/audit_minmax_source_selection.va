// AMS 4.3.1, printed p.62 (physical PDF75): min(x,y) is (x<y)?x:y;
// max(x,y) is (x>y)?x:y at derivative discontinuities. Table4-14 lists
// both spellings. With independent V(p)=V(q)=0.5, the strict relation is
// false: derivative follows the SECOND operand. Swapping operands swaps
// the selected partial. A constant second operand has zero partial; a
// constant first operand leaves the variable second partial equal to one.
// Non-tie neighbors verify that the strict winning branches remain intact.
// The numeric partials below are derived by differentiating the selected
// argument, holding the other unknown fixed as required by AMS4.5.6.
//! lrm 4.3.1
//! lrm 4.5.6
//! checks 32
//! bias V(p) = 0.5, V(q) = 0.5
`include "check.vh"
module audit_minmax_source_selection(p,q);
    inout p,q; electrical p,q;
    analog begin
        `CHECKX("min pq dp", ddx(min(V(p),V(q)),V(p)), 0.0);
        `CHECKX("min pq dq", ddx(min(V(p),V(q)),V(q)), 1.0);
        `CHECKX("min qp dp", ddx(min(V(q),V(p)),V(p)), 1.0);
        `CHECKX("min qp dq", ddx(min(V(q),V(p)),V(q)), 0.0);
        `CHECKX("min const second", ddx(min(V(p),0.5),V(p)), 0.0);
        `CHECKX("min const first", ddx(min(0.5,V(p)),V(p)), 1.0);
        `CHECKX("min unequal +1.0", ddx(min(V(p),V(q)+1.0),V(p)), 1.0);
        `CHECKX("min unequal -1.0", ddx(min(V(p),V(q)-1.0),V(p)), 0.0);
        `CHECKX("max pq dp", ddx(max(V(p),V(q)),V(p)), 0.0);
        `CHECKX("max pq dq", ddx(max(V(p),V(q)),V(q)), 1.0);
        `CHECKX("max qp dp", ddx(max(V(q),V(p)),V(p)), 1.0);
        `CHECKX("max qp dq", ddx(max(V(q),V(p)),V(q)), 0.0);
        `CHECKX("max const second", ddx(max(V(p),0.5),V(p)), 0.0);
        `CHECKX("max const first", ddx(max(0.5,V(p)),V(p)), 1.0);
        `CHECKX("max unequal +1.0", ddx(max(V(p),V(q)+1.0),V(p)), 0.0);
        `CHECKX("max unequal -1.0", ddx(max(V(p),V(q)-1.0),V(p)), 1.0);
        `CHECKX("$min pq dp", ddx($min(V(p),V(q)),V(p)), 0.0);
        `CHECKX("$min pq dq", ddx($min(V(p),V(q)),V(q)), 1.0);
        `CHECKX("$min qp dp", ddx($min(V(q),V(p)),V(p)), 1.0);
        `CHECKX("$min qp dq", ddx($min(V(q),V(p)),V(q)), 0.0);
        `CHECKX("$min const second", ddx($min(V(p),0.5),V(p)), 0.0);
        `CHECKX("$min const first", ddx($min(0.5,V(p)),V(p)), 1.0);
        `CHECKX("$min unequal +1.0", ddx($min(V(p),V(q)+1.0),V(p)), 1.0);
        `CHECKX("$min unequal -1.0", ddx($min(V(p),V(q)-1.0),V(p)), 0.0);
        `CHECKX("$max pq dp", ddx($max(V(p),V(q)),V(p)), 0.0);
        `CHECKX("$max pq dq", ddx($max(V(p),V(q)),V(q)), 1.0);
        `CHECKX("$max qp dp", ddx($max(V(q),V(p)),V(p)), 1.0);
        `CHECKX("$max qp dq", ddx($max(V(q),V(p)),V(q)), 0.0);
        `CHECKX("$max const second", ddx($max(V(p),0.5),V(p)), 0.0);
        `CHECKX("$max const first", ddx($max(0.5,V(p)),V(p)), 1.0);
        `CHECKX("$max unequal +1.0", ddx($max(V(p),V(q)+1.0),V(p)), 0.0);
        `CHECKX("$max unequal -1.0", ddx($max(V(p),V(q)-1.0),V(p)), 1.0);
        I(p) <+ V(p); I(q) <+ V(q);
    end
endmodule
