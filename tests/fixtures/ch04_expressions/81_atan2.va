// atan2(y, x) (LRM 4.3.2 Table 4-15): arc-tangent of y/x resolved into the
// correct quadrant. Domain is all x and all y, with atan2(0,0) = 0 called out.
`include "check.vh"
//! lrm 4.3.2
//! bias V(p) = 1.0
module ch04_atan2(p, n);
  inout p, n; electrical p, n;
  analog begin
    I(p, n) <+ atan2(V(p, n), 1.0);
    // (x, y) = (1, 1) is 45 degrees into the first quadrant: pi/4 rad.
    `CHECK("atan2(1, 1) = pi/4", atan2(V(p, n), 1.0), 0.7853981633974483, 1e-15);
    // Quadrant II: y = +1, x = -1 is 135 degrees, i.e. 3*pi/4 — this is what
    // separates atan2 from atan(y/x), which would give -pi/4 for both.
    `CHECK("atan2(1, -1) = 3pi/4", atan2(V(p, n), -1.0), 2.356194490192345, 1e-15);
    // The special case stated in the table.
    `CHECKX("atan2(0, 0) = 0", atan2(0.0, 0.0), 0.0);
  end
endmodule
