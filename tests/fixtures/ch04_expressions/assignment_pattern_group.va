// AMS 4.2.14: "repeat 0.0 five times" explains pattern replication.
// Syntax 4-2 also permits a comma-separated group inside the repeated braces.
// Repeating [0.75, 2.5] twice therefore gives [0.75, 2.5, 0.75, 2.5],
// not [0.75, 0.75, 2.5, 2.5] or a bit-concatenation. Observe every element.
// The variable form uses a signal operand; the constant form uses parameter
// initialization. Both use exact binary fractions. This tests values/order,
// not operand evaluation count or every permitted pattern context.
//! lrm 4.2.14
//! lrm 4.2.14:1000
//! checks 8
//! bias V(p) = 0.75
//! bias V(n) = 0.0
`include "check.vh"
module audit_assignment_pattern_group(p, n);
    inout p, n;
    electrical p, n;
    parameter real constants[0:3] = '{2{0.75, 2.5}};
    real values[0:3];
    analog begin
        values = '{2{V(p, n), 2.5}};
        `CHECKX("constant first group first", constants[0], 0.75);
        `CHECKX("constant first group second", constants[1], 2.5);
        `CHECKX("constant second group first", constants[2], 0.75);
        `CHECKX("constant second group second", constants[3], 2.5);
        `CHECKX("variable first group first", values[0], 0.75);
        `CHECKX("variable first group second", values[1], 2.5);
        `CHECKX("variable second group first", values[2], 0.75);
        `CHECKX("variable second group second", values[3], 2.5);
        I(p, n) <+ values[2];
    end
endmodule
