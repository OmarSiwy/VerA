// §4.6.2: "Variables shall be re-initialized to zero (or x, for integers whose
// values are assigned in a digital context) at the start of each new
// analysis."
//
// `//! sweep` WITH a `//! time` line runs each sweep value as its own
// transient analysis (lib/backend/tb/runner.zig: "With `//! time` each sweep
// block is its own transient analysis"; §5.10.2's initial_step fires at the
// first point of each). So this file is two analyses in one run:
// V(p) = 0.5 for the first, 0.25 for the second, each at t = 0 and 1ns.
//
// The variables are running maxima (idempotent, so iteration counts cannot
// move them): `if (v > peak) peak = v;` and the same over the integer
// level = V * 8 (§4.2.1.1: 4.0 -> 4, 2.0 -> 2), both assigned in the analog
// context, so both start at zero.
//
// HAND DERIVATION.
//   analysis 1: peak starts 0, becomes 0.5 and stays (bias constant in time);
//               ipeak becomes 4.
//   analysis 2: re-initialized, peak starts 0 and becomes 0.25; ipeak 2.
// So peak equals this analysis's own bias at every point, and ipeak its own
// level: the checks are peak - V(p, n) == 0 and ipeak - level == 0. A
// simulator that carried the first analysis's values into the second reads
// 0.5 - 0.25 = 0.25 and 4 - 2 = 2 there. Two checks at each of four points.
//
//! lrm 4.6.2
//! lrm 4.6.2:5
//! analysis tran
//! sweep V(p) = 0.5, 0.25
//! bias V(n) = 0.0
//! time 0, 1n
//! checks 8
`include "check.vh"
module b2_new_analysis_reinitializes_variables(p, n);
    inout p, n;
    electrical p, n;
    real peak;
    integer level, ipeak;

    analog begin
        if (V(p, n) > peak)
            peak = V(p, n);
        level = V(p, n) * 8.0;
        if (level > ipeak)
            ipeak = level;
        `CHECKX("a real restarts at zero in each analysis: peak is this analysis's bias",
                peak - V(p, n), 0.0);
        `CHECKI("an integer restarts at zero in each analysis: ipeak is this analysis's level",
                ipeak - level, 0);
        I(p, n) <+ V(p, n);
    end
endmodule
