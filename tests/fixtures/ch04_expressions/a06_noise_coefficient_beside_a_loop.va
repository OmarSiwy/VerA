// §4.6.4.6's coefficient on a branch whose LATER contribution carries a value
// a §5.9 loop computed, and no generator.
//
// §4.6.4.6: "Perfectly correlated noise is generated by using the output of one
// noise function for more than one noise source." The output is an amplitude
// and `3.0*n` scales it, so the branch density is 3²·pwr
// (a06_noise_correlated_scale.va pins that rule). §5.6.1.3: "multiple
// contributions to the same potential branch or same flow branch will be
// additive." The branch's generator factor is therefore the sum over its
// statements of each statement's factor, and a statement in which `n` does
// not occur adds 0 to it — whatever else that statement computes, and however
// (a loop included) it computed it.
//
// THE NUMBERS. pwr = 1e-18 A²/Hz, nloop = 2.
//
//   I(a,b) <+ 3.0*n            factor 3
//   s = 0.5 + 0.5 (the loop)   s = 1.0
//   I(a,b) <+ V(a,b)*s/1k      n does not occur: factor 0
//   branch factor 3 + 0 = 3, density 3² · 1e-18 = 9e-18
//
// The wrong answer this tells apart: a factor that gives up (falls back to 1,
// density 1e-18) because the second statement's value passes through the
// loop's join. That join carries `s`, not `n`.
//
// `nloop` is a parameter, so the loop cannot be unrolled away at elaboration.
// The CHECKX pins that the loop ran twice, so `s` is exactly 1.0 and the
// second statement is the 1k resistor the linearization expects.
//
//! lrm 4.6.4.6
//! lrm 5.6.1.3
//! lrm 5.9
//! noise thermal(a,b)#0 name=n white=9e-18
//! analysis noise
//! bias V(a) = 0.0
//! bias V(b) = 0.0
`include "check.vh"
module a06_noise_coefficient_beside_a_loop(a, b);
    inout a, b;
    electrical a, b;
    parameter real pwr = 1e-18 from [0:inf);
    parameter integer nloop = 2 from [1:inf);
    real n, s;
    integer i;

    analog begin
        n = white_noise(pwr, "n");
        I(a, b) <+ 3.0 * n;

        s = 0.0;
        for (i = 0; i < nloop; i = i + 1)
            s = s + 0.5;
        `CHECKX("the loop ran nloop = 2 times", s, 1.0);

        I(a, b) <+ V(a, b) * s / 1k;
    end
endmodule
