// §4.7.3 / §5.7: a SLICE of a multidimensional array is an array actual for
// an array formal, in all three directions.
//
//   §4.7.3 "The argument expressions are assigned to the declared inputs,
//   outputs, and inouts in the order of their declaration."
//
//   §5.7 "The array on the LHS of the assignment shall be an array variable, a
//   slice of an array variable or an array parameter ... An array, or a slice
//   of such an array, shall be assignment compatible with any other such array
//   or slice if ... Every dimension of the source array shall have the same
//   number of elements as the target array."
//
// A.8.5 spells the slice: `array_analog_variable_rvalue ::= array_variable_
// identifier [ analog_expression ] { [ analog_expression ] }`, so on §3.2's
// `real m[0:1][0:1]`, `m[1]` is the two-element row. Passing an argument IS an
// assignment (§4.7.3), and a row is assignment compatible with a `[0:1]`
// formal, so `f(m[1])` is legal. §4.7.2.3/§4.7.2.4's "an analog variable or an
// array assignment pattern" for output/inout actuals is met by the same
// reading: §5.7 lists the slice among the things an array assignment writes.
// ARPice coupled_ltra.va passes `[i][j]` rows this way (vera-gaps item 7).
//
// THE DERIVATION, by hand, with `arrayadd` verbatim from §4.7.1 Example 3:
//
//   m = {{1, 2}, {10, 20}}
//   arrayadd(m[1], m[0])   inout row 1 += input row 0   m[1] = {11, 22}
//                          the input row is not written  m[0] = {1, 2}
//   fill(3, m[0])          output row 0 = {3, 2*3}       m[0] = {3, 6}
//   k = 1 (V(p) = 0, so the select is decided during the solve)
//   sum2(m[k])             11 + 22                       33
//
// All small integers, exact in IEEE 754, so every check is CHECKX.
//
//! lrm 4.7.3
//! lrm 5.7
//! lrm 5.7:4
//! lrm 5.7:7
//! lrm 5.7:8
//! lrm 4.7.2.3
//! lrm 4.7.2.4
//! lrm 4.7.2.4:2
//! bias V(p) = 0
`include "check.vh"
module ch4_fn_array_slice(p);
  inout p;
  electrical p;
  real m[0:1][0:1];
  real dummy, s;
  integer k;

  analog function real arrayadd;
    inout [0:1]a;
    input [0:1]b;
    real a[0:1], b[0:1];
    integer i;
    begin
      for(i = 0; i < 2; i = i + 1) begin
        a[i] = a[i] + b[i];
      end
    end
  endfunction

  analog function real fill;
    input x;
    output [0:1] out;
    real x, out[0:1];
    begin
      out[0] = x;
      out[1] = 2.0 * x;
    end
  endfunction

  analog function real sum2;
    input [0:1] v;
    real v[0:1];
    sum2 = v[0] + v[1];
  endfunction

  analog begin
    m[0][0] = 1; m[0][1] = 2; m[1][0] = 10; m[1][1] = 20;
    dummy = arrayadd(m[1], m[0]);
    `CHECKX("inout slice copies out m[1][0] = 10 + 1", m[1][0], 11.0);
    `CHECKX("inout slice copies out m[1][1] = 20 + 2", m[1][1], 22.0);
    `CHECKX("the input slice is not written back: m[0][0]", m[0][0], 1.0);
    `CHECKX("the input slice is not written back: m[0][1]", m[0][1], 2.0);
    dummy = fill(3.0, m[0]);
    `CHECKX("output slice receives m[0][0] = 3", m[0][0], 3.0);
    `CHECKX("output slice receives m[0][1] = 6", m[0][1], 6.0);
    k = (V(p) > 0.5) ? 0 : 1;
    s = sum2(m[k]);
    `CHECKX("an input slice chosen during the solve: 11 + 22", s, 33.0);
    I(p) <+ V(p) + s * 0.0;
  end
endmodule
