// LRM 4.2.10's prohibition: "The reduction operators can not be
// used inside the analog block and only have meaning when used in the digital
// context." The prohibition is 4.2.10, not Annex C.5 (which excludes case
// equality). The former C.5 coverage claim moves to this fixture's 4.2.10
// obligation; no xor-specific Annex C prohibition is claimed.
//
// This isolates unary xor. 06_reduction_rejected.va isolates unary or;
// the audit_reduction_* fixtures isolate the other five spellings.
//
// The expectation is E0320, "xor reduction is not in the analog subset", which
// is the code that STATES the rule. It used to be E0215, "expected an operand"
// — a parser-recovery diagnostic that fires because VerA's expression parser
// has no unary `^` at all and reports the token it could not start an operand
// with. E0215 is green here by accident of the grammar, not because the analog
// subset was checked: it would fire for any unparseable token in that
// position, and the day VerA parses `^bits` and diagnoses it properly this
// fixture would have FAILED for being fixed.
//
//! lrm 4.2.10
//! lrm 4.2.10:1000
//! reject-only E0320
module ch04_reduction_xor_rejected;
    integer bits, parity;
    analog parity = ^bits;
endmodule
