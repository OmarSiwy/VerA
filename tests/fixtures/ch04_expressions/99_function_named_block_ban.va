// LRM 4.7.1 bullet list, verbatim: an analog user-defined function "shall not
// use named blocks". `begin : forbidden` is exactly that, so a conforming tool
// diagnoses this module.
//
// The hazard the bullet heads off is concrete: 4.7.2.1 makes the function name
// an implicitly declared variable holding the return value, and a named block
// is a 5.3.2 sequential block that may carry its own declarations — one named
// `named` would shadow the return variable and the function would hand back the
// initial 0. The LRM's answer is to ban the construct rather than to specify
// the shadowing, so this fixture demands the ban and nothing else.
//
// It previously carried no `reject` and asserted CHECKX(named(0.75), 0.75) —
// i.e. it pinned what the banned construct computes, which a conforming
// compiler never reaches. The 4.7.2.1 return-variable rule it was really after
// is pinned on a legal function by 28_user_function.va.
//
//! lrm 4.7.1
//! reject named block
//! xfail VerA enforces none of the 4.7.1 bullet-list restrictions on an analog function body; a labelled sequential block inside `analog function` parses and lowers. src/diag_code.zig has no code for the named-block ban
module ch4_fn_named(p);
  inout p;
  electrical p;
  analog function real named;
    input x;
    real x;
    begin : forbidden
      named = x;
    end
  endfunction
  analog begin
    I(p) <+ named(V(p));
  end
endmodule
