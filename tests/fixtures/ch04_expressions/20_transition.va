// §4.5.8 transition filter, at the one operating point the LRM assigns it a
// value at: "In DC analysis, transition() passes the value of the expr directly
// to its output." Directly — the td/rise/fall arguments below shape the ramp
// between levels, and a DC point has no ramp to shape.
//
// Two different operands are passed through, 1 and 3*1 + 1.5 = 4.5, because one
// would not distinguish "passes its input through" from "answers 1".
//
// 4.5.8's general form is `transition(expr [, td [, rise_time [, fall_time
// [, time_tol ]]]])` — five shapes, and every one of them passes expr straight
// through at a DC point, because the sentence above is about the operator and
// not about how its ramp was configured. So all five are asserted against the
// same literal. The defaults 4.5.8 states are what makes the shorter shapes
// legal rather than incomplete: "If td is not specified, it is taken to be zero
// (0.0)", "If only a positive rise_time value is specified, the simulator uses
// it for both rise and fall times", and "If neither rise_time nor fall_time are
// specified or are equal to zero (0.0), the rise and fall time default to the
// value defined by `default_transition". None of those defaults has an
// observable value at a DC point, so nothing here asserts one — what the extra
// lines pin is that the shapes parse, lower, and do not disturb the
// pass-through. Before this the four-argument form was the only shape written
// anywhere in the chapter.
//
// The transient shape is deliberately not pinned here: §4.5.8 draws a
// piecewise-linear ramp but leaves the simulator to place the time points, and
// tests/fixtures/exhaustive/063_transition.va already pins the implemented
// kernel and names the divergence.
//
//! lrm 4.5.8
//! lrm 4.5.8:1002
//! lrm 4.5.8:2
//! bias V(p) = 1.0
//! bias V(n) = 0
//! print none
`include "check.vh"
module ch04_transition(p, n);
    inout p, n;
    electrical p, n;
    integer level;

    analog begin
        level = V(p, n) > 0.0;

        // §4.2.5: a relational operator yields an integer, 1 when true.
        `CHECKI("a relational yields integer 1", level, 1);
        `CHECKX("DC passes the expr straight through", transition(level, 1n, 2n, 3n), 1.0);
        `CHECKX("and it is the expr, not a constant",
                transition(3.0 * level + 1.5, 1n, 2n, 3n), 4.5);
        `CHECKX("transition(expr): no td, no rise, no fall",
                transition(3.0 * level + 1.5), 4.5);
        `CHECKX("transition(expr, td)", transition(3.0 * level + 1.5, 1n), 4.5);
        `CHECKX("transition(expr, td, rise_time) uses rise_time for both edges",
                transition(3.0 * level + 1.5, 1n, 2n), 4.5);
        `CHECKX("transition(expr, td, rise_time, fall_time, time_tol)",
                transition(3.0 * level + 1.5, 1n, 2n, 3n, 1p), 4.5);

        I(p, n) <+ transition(level, 1n, 2n, 3n);
    end
endmodule
