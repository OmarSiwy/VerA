// LRM 4.2.11: `<<` shifts its left operand left by the number of bit positions
// given by the right operand, filling the vacated positions with zeroes.
//
//   1 << 3 = 0001 shifted three places = 1000 = 8
//
// The second line is the LRM's own worked example verbatim: "start = 1;
// result = (start << 2)" is "assigned the binary value 0100", i.e. 4. Together
// they pin the shift COUNT against an off-by-one and against `**`, which would
// read 1 ** 3 = 1.
//
//! lrm 4.2.11
//! lrm 4.2.11:1000
`include "check.vh"
module ch04_shift_left(p, n);
    inout p, n;
    electrical p, n;
    integer a;

    analog begin
        a = 1 << 3;
        `CHECKI("1 << 3 = 1000", a, 8);
        `CHECKI("LRM 4.2.11 example: 1 << 2 = 0100", (1 << 2), 4);
        I(p, n) <+ a;
    end
endmodule
