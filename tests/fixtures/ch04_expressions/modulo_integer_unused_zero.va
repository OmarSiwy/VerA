// AMS §4.2.4 requires an error for a zero modulus divisor. §4.2.3 allows
// optimizations only when simulation behaviour is preserved: discarding a
// variable's unused value must not discard this evaluated runtime error.
// d=3 is legal and prints one verdict; d=0 reports E0601 before another print.
// The executable's exit-1 policy is documented in Vague_Decisions.md.
// The legal unused-but-guarded neighbour is modulo_integer_short_circuit.va.
//! lrm 4.2.3
//! lrm 4.2.4
//! lrm 4.2.4:1
//! sweep V(p) = 3, 0
//! exit 1
//! checks 1
//! print none
//! fd-exempt §4.2.4: the device stops with E0601 wherever round(V(p,n)) = 0, which L4b's random unknowns reach; stopping there is the rule this fixture pins
`include "check.vh"
module modulo_integer_unused_zero(p, n);
  inout p, n; electrical p, n;
  integer d, unused;
  analog begin
    d = V(p,n);
    unused = 11 % d;
    `CHECKI("only the nonzero point completes", d, 3);
    I(p,n) <+ V(p,n);
  end
endmodule
