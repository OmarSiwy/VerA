// §4.6.1 Table 4-21: "nodeset" is the phase of an equilibrium point
// calculation in which nodesets are applied; Table 4-22 puts it in the first
// part of a static solve, only when nodesets are applied. §4.6.2: the phase
// "may occur" in a single-point dc analysis or a sweep's first point. How a
// solver applies a nodeset is not stated (§3.6.3.2 gives it to "the analog
// solver"), so whether that phase holds any evaluation is VerA's choice:
// specification/Vague_Decisions.md VD-117 (#67). VerA starts Newton at the
// nodeset (a08_nodeset_01_nodeset_is_the_dc_initial_guess.va) and clamps
// nothing, so no evaluation is in the phase: analysis("nodeset") is 0 at
// every evaluation, and initial_step("nodeset") never fires (§5.10.2: its list
// matches the name of the analysis being run, and none is "nodeset").
//
// The device HAS a nodeset (`electrical p = 0.5`), so the phase would exist
// if VerA had one. V(p) is solved (`//! solve`, V(n) pinned at 0) from the
// nodeset 0.5 to the root of I = V(p, n), 0 V: the first Newton evaluation is
// at the nodeset itself, the evaluation a clamping phase would make.
//
// The transient's t = 0 point is the TRAN OP (Table 4-22), where a nodeset
// phase would sit; 1n is a Tran point. At both: analysis("nodeset") is 0, and
// the two counters, carried from point to point (§4.6.2), stay 0, since any
// accepted evaluation that saw "nodeset" (by analysis() or by the event)
// would leave 1 behind. Expected values by hand: 0, 0, 0 at each point.
//
// The wrong implementation this catches: a host that evaluates the whole
// operating point of a device with `u_nodeset` as `.nodeset` (which also
// turns Table 4-22's "ic" and "tran" off there).
//
// Checks: 3 per point x 2 points = 6.
//
//! lrm 4.6.1
//! analysis tran
//! time 0, 1n
//! bias V(n) = 0.0
//! solve
//! checks 6
`include "check.vh"
module ch04_nodeset_phase_has_no_evaluation(p, n);
    inout p, n;
    electrical n;
    electrical p = 0.5;
    integer n_seen, n_event;

    analog begin
        @(initial_step("nodeset")) n_event = n_event + 1;
        if (analysis("nodeset")) n_seen = n_seen + 1;
        `CHECKI("analysis(\"nodeset\") is 0 (VD-117)", analysis("nodeset"), 0);
        `CHECKI("no accepted evaluation saw analysis(\"nodeset\")", n_seen, 0);
        `CHECKI("initial_step(\"nodeset\") never fires", n_event, 0);
        I(p, n) <+ V(p, n);
    end
endmodule
