// §4.3.1 Table 4-14: `$ln1p(x)` / `ln1p(x)` / C `log1p(x)`, "Natural logarithm
// of 1 plus x", domain "x > -1". §4.3.2: "Input values outside of the valid
// range for the operator shall report an error." (114_standard_math_domain_rejected.va
// reads the same sentence for ln, log and sqrt.)
//
// The argument below is the constant -2.0, so ln(1 + x) = ln(-1), which has no
// real value, and the violation is known before the solve. The in-domain side
// is 33_ln1p_expm1.va.
//
//! lrm 4.3.1
//! lrm 4.3.2
//! lrm 4.3.2:2
//! reject-only E0603
//! neighbour 33_ln1p_expm1.va
`include "disciplines.vams"
module ch04_ln1p_domain(p, n);
  inout p, n; electrical p, n;
  analog I(p, n) <+ ln1p(-2.0) * V(p, n);
endmodule
