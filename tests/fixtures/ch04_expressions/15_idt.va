// §4.5.4 time integral, the `idt(expr, ic)` form. "When used in DC or IC
// analyses, idt() returns the initial condition (ic) if specified" — so at the
// DC point the operator's value is the SECOND argument and nothing else.
//
// Two different initial conditions are checked because one is not a claim: an
// operator that ignored ic and answered 0 would satisfy `idt(x, 0.0) == 0`.
// -3 and 5 cannot both be that accident.
//
// Table 4-18 gives idt five argument shapes. The three below the two-argument
// form add an `assert` reset and then a tolerance, and 4.5.4 fixes what they do
// at this operating point without ambiguity: "When specified with both initial
// conditions and assert, idt() returns the initial conditions during DC and IC
// analyses". The tolerance argument "is used to derive an absolute tolerance if
// needed" and changes no value. So all four forms answer the same 5.0 here, and
// the extra lines prove the shapes parse and lower — 4.5.4's assert form is
// otherwise unwritten anywhere in the suite. The fifth shape,
// idt(expr, ic, assert, nature), is 145_ddt_idt_nature_tolerance.va.
//
//! lrm 4.5.4
//! lrm 4.5.4:1001
//! print none
`include "check.vh"
module ch04_idt(p, n);
    inout p, n;
    electrical p, n;

    analog begin
        `CHECKX("idt in DC returns its ic", idt(I(p, n), 5.0), 5.0);
        `CHECKX("a different ic gives a different DC value", idt(I(p, n), -3.0), -3.0);
        `CHECKX("idt(expr, ic, assert) returns ic in DC", idt(I(p, n), 5.0, 0), 5.0);
        `CHECKX("idt(expr, ic, assert, abstol) returns ic in DC", idt(I(p, n), 5.0, 0, 1e-9), 5.0);

        V(p, n) <+ idt(I(p, n), 0.0);
    end
endmodule
