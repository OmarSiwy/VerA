// §4.5.4 time integral, the `idt(expr, ic)` form. "When used in DC or IC
// analyses, idt() returns the initial condition (ic) if specified" — so at the
// DC point the operator's value is the SECOND argument and nothing else.
//
// Two different initial conditions are checked because one is not a claim: an
// operator that ignored ic and answered 0 would satisfy `idt(x, 0.0) == 0`.
// -3 and 5 cannot both be that accident.
//
//! print none
`include "check.vh"
module ch04_idt(p, n);
    inout p, n;
    electrical p, n;

    analog begin
        `CHECKX("idt in DC returns its ic", idt(I(p, n), 5.0), 5.0);
        `CHECKX("a different ic gives a different DC value", idt(I(p, n), -3.0), -3.0);

        V(p, n) <+ idt(I(p, n), 0.0);
    end
endmodule
