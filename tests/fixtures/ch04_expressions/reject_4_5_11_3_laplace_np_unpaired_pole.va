// §4.5.11.3 (laplace_np): "Each pair represents a pole, the first number in
// the pair is the real part of the pole and the second is the imaginary part.
// ... If a pole is real, the imaginary part shall be specified as zero (0). If
// a pole is complex, its conjugate shall also be present."
//
// The pole vector '{-1.0, 1.0} is ONE pole, -1 + 1j, and -1 - 1j is absent.
// The numerator '{1.0} is a legal constant. Adding the conjugate
// ('{-1.0, 1.0, -1.0, -1.0}) makes the same call legal, and VerA compiles
// that form (probed), so the missing conjugate is the only error.
//
// 133_laplace_unpaired_complex_root_rejected.va pins the same sentence for
// laplace_zp under §4.5.11.1; this file is the numerator-pole form's own cite.
// VerA enforces it in codegen, so the expectation is the message fragment.
//
//! lrm 4.5.11.3
//! lrm 4.5.11.3:2
//! reject-only no conjugate partner
//! neighbour 152_laplace_np_dc_gain.va
`include "disciplines.vams"
module ch4_laplace_np_unpaired_pole(p, n);
  inout p, n;
  electrical p, n;

  analog I(p, n) <+ laplace_np(V(p, n), '{1.0}, '{-1.0, 1.0});
endmodule
