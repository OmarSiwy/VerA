// §4.2.4 Table 4-4: `a + b` is "a plus b". At V(p,n) = 3.0 the sum with the
// real literal 2.0 is 5.0 — every value here is exact in IEEE 754 binary, so
// the comparison is exact.
//
//! lrm 4.2.4
//! bias V(p) = 3.0
`include "check.vh"
module ch04_add(p, n);
    inout p, n;
    electrical p, n;
    analog begin
        `CHECKX("3.0 + 2.0", V(p, n) + 2.0, 5.0);
        I(p, n) <+ V(p, n) + 2.0;
    end
endmodule
