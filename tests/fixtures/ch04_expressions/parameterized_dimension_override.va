// §3.2 Integer and real data types:
//
//   "Arrays of integers can be declared using a range which defines the upper
//    and lower indices of the array. BOTH INDICES SHALL BE CONSTANT EXPRESSIONS
//    and shall evaluate to a positive integer, a negative integer, or zero (0)."
//
// A `constant_expression` is not a literal. §3.4 Parameters makes a parameter's
// value a property of the INSTANCE, verbatim:
//
//   "Parameters represent constants, hence it is illegal to modify their value
//    at runtime. However, PARAMETERS CAN BE MODIFIED AT COMPILATION TIME TO
//    HAVE VALUES WHICH ARE DIFFERENT FROM THOSE SPECIFIED IN THE DECLARATION
//    ASSIGNMENT. This allows customization of module instances. A parameter can
//    be modified with the defparam statement or in the module_instantiation
//    statement."
//
// (Corrected after review: an earlier draft of this header printed a paraphrase
// of that sentence — "compile time", "a value which is different from the one
// specified" — inside quotation marks. The clause and the conclusion are
// unchanged; only the quotation is now the LRM's own words.)
//
// So a dimension written `[0:N]` is a constant expression whose value is
// whatever the model card says N is, and the array has that many elements in
// that instance. The parameter's declared default is what an instance gets when
// the card is silent; it is not the shape of the type.
//
// THE DERIVATION, by hand.
//
//   parameter integer N = 3;   // the DEFAULT
//   real b[0:N];               // so a default instance holds 4 elements
//
//   The card below overrides N to 5, so this instance holds SIX elements,
//   b[0] .. b[5]. The loop writes b[i] = 2*i for i = 0 .. N:
//
//     b[0]=0  b[1]=2  b[2]=4  b[3]=6  b[4]=8  b[5]=10
//
//   Every one of those is a small even integer, exact in IEEE 754, so the
//   asserted values carry no rounding argument at all.
//
//   top = b[N] must be 10.0 — the last element, the one that exists ONLY
//   because the override widened the array. On a device built to the default
//   shape there is no such element.
//
//   mid = b[N-2] must be 6.0 — 6, not 10 and not 0: it pins that the override
//   moved the whole index arithmetic and not just the upper bound. If N were
//   still 3 this expression would read b[1] and give 2.0.
//
//   b[0] must be 0.0 — the low end is unaffected by the override, which is the
//   guard against "widen the array by shifting it".
//
// HOW VERA MEETS IT — decided 2026-09-24 by the user. §3.4's own sentence is
// the rule: parameters "can be modified at compilation time". A parameter that
// determines a storage shape (this array bound; a replication count that sizes
// a string) is a SHAPE parameter, and its override is applied BEFORE lowering,
// so the device is compiled for that shape: here the `//! param N = 5` card is
// the compile-time value (as `vera --param N=5` would give it), and the device
// holds the six cells b[0] .. b[5]. §3.4.4's "the array size may be changed by
// overriding the appropriate parameters" is then true of this device.
//
// A card is still written at RUN time, and a compiled device has one shape.
// So the device refuses — through `checkShape`, which the host calls after
// `derive` — any card that sets N to a value it was not compiled for, rather
// than letting a folded shape and a card-read index silently disagree (which
// is what this row observed before: `top` read got=0 want=10, the writes to
// b[4] and b[5] were dropped by the masked-write path). A parameter that shapes
// nothing stays a run-time card value exactly as before. An instance-line
// override (`#(.N(5))`) was always folded at elaboration (ch06 h01_11).
//
//! lrm 3.2
//! lrm 3.2:1
//! lrm 3.2:2
//! lrm 3.4
//! lrm 3.4:3
//! param N = 5
//! bias V(p) = 0.5
//! print none
//! checks 7
`include "check.vh"
module a01_parameterized_dimension_override(p, n);
  inout p, n;
  electrical p, n;
  parameter integer N = 3;
  real b[0:N];
  real negative[-2:0];
  integer descending[2:-1];
  integer i;
  real top, mid;

  analog begin
    for (i = 0; i <= N; i = i + 1) b[i] = 2.0 * i;

    top = b[N];
    mid = b[N - 2];
    negative[-2] = 1.25;
    negative[0] = -0.5;
    descending[2] = 11;
    descending[-1] = -7;

    `CHECKX("the top element exists because the card widened the array", top, 10.0);
    `CHECKX("the override moved the whole index range, not just its end", mid, 6.0);
    `CHECKX("the low end is where it always was", b[0], 0.0);
    `CHECKX("a real array permits a negative lower index", negative[-2], 1.25);
    `CHECKX("zero is a distinct real array bound", negative[0], -0.5);
    `CHECKI("an integer array permits descending bounds", descending[2], 11);
    `CHECKI("a negative integer array endpoint is retained", descending[-1], -7);

    I(p, n) <+ V(p, n);
  end
endmodule
