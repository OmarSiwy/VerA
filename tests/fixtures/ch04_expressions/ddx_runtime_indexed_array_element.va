// §4.5.14 ddx() of a value read back from a real array at a RUNTIME index.
//
//   §4.5.14: "The operator returns the partial derivative of its first
//    argument with respect to the unknown indicated by the second argument,
//    holding all other unknowns fixed and evaluated at the current operating
//    point."
//
// Storing a value in an array element and reading it back is an identity on
// that value (§3.2.2), so the partials of what comes out are the partials of
// what went in. The index `sp` is an integer PARAMETER, which a host may
// override, so the element is chosen at run time, not folded.
//
// THE HAND DERIVATION, at V(a) = 0.5, V(b) = 0.3:
//
//   z = st[sp], st[sp] = 2 V(a):       dz/dV(a) = 2,   dz/dV(b) = 0
//   w = pr[sp], pr[sp] = V(a) V(b):    dw/dV(a) = V(b) = 0.3
//                                      dw/dV(b) = V(a) = 0.5
//
// z is also contributed, so the residual reads it; w is read only here. Both
// used to answer 0 for the first partial: the display tasks read the array
// out of the shared core, which returns its plain values (no lanes), and w's
// array was additionally stored without lanes because no contribution read
// it. The device Jacobian was right throughout (d res[a]/d x[a] = 2 in the
// transcript); only the ddx() value was wrong.
//
//! lrm 4.5.14
//! bias V(a) = 0.5
//! bias V(b) = 0.3
//! checks 4
`include "check.vh"
module ddx_runtime_indexed_array_element(a, b);
    inout a, b;
    electrical a, b;
    parameter integer k0 = 1;
    real st[0:3];
    real pr[0:3];
    integer sp;
    real z, w;

    analog begin
        sp = k0;
        st[sp] = V(a) * 2.0;
        z = st[sp];
        pr[sp] = V(a) * V(b);
        w = pr[sp];
        `CHECK("ddx of a runtime-indexed element that the residual also reads", ddx(z, V(a)), 2.0, 1e-12);
        `CHECK("and its partial on an unknown it does not read is 0", ddx(z, V(b)), 0.0, 1e-12);
        `CHECK("ddx of a runtime-indexed element read only by ddx, on V(a)", ddx(w, V(a)), 0.3, 1e-12);
        `CHECK("and on V(b)", ddx(w, V(b)), 0.5, 1e-12);
        I(a, b) <+ z;
    end
endmodule
