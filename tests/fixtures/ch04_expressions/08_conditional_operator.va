// LRM 4.2.12: "The conditional operator, also known as ternary operator, is
// right associative". So the nest parses as
//
//   V(p,n) > 1.0 ? 10.0 : (V(p,n) < -1.0 ? -10.0 : 0.0)
//
// The bias of 2.0 is what makes that a RESTRICTING claim. At V(p,n) = 2.0 the
// first condition is true, so the right-associative parse yields 10.0. A
// left-associative parse, ((V>1.0 ? 10.0 : V<-1.0) ? -10.0 : 0.0), would take
// the nonzero 10.0 as its condition and yield -10.0 instead. (At V(p,n) = -2.0
// the two parses agree, which is why the bias is not negative.)
//
// 4.2.12 also fixes what counts as the true arm: "If expression1 evaluates to
// false (0), then expression3 is evaluated ... If expression1 evaluates to true
// (ANY value other than zero (0)), then expression2 is evaluated". The nest
// above cannot test that — both its conditions are relational, and 4.2.5 says a
// relation "yields the value zero (0) ... or the value one (1)", so they are
// already normalised. The last three lines feed conditions that are not 0 or 1:
// a positive integer, a negative integer, and a real fraction. A compiler that
// tested `cond == 1`, or that truncated the condition to an integer before
// testing it, passes the first assertion and fails these.
//
//! lrm 4.2.12
//! lrm 4.2.3
//! lrm 4.2.3:1
//! lrm 4.2.12:1
//! bias V(p) = 2.0
`include "check.vh"
module ch04_conditional_operator(p, n);
    inout p, n;
    electrical p, n;
    real value;

    analog begin
        value = V(p, n) > 1.0 ? 10.0 : V(p, n) < -1.0 ? -10.0 : 0.0;
        `CHECKX("nested ?: is right associative", value, 10.0);
        `CHECKX("7 is true: any value other than zero takes expression2", 7 ? 3.0 : 4.0, 3.0);
        `CHECKX("-1 is true: the test is != 0, not == 1", (-1) ? 3.0 : 4.0, 3.0);
        `CHECKX("0.5 is true: a real condition is not truncated first", 0.5 ? 3.0 : 4.0, 3.0);
        I(p, n) <+ value;
    end
endmodule
