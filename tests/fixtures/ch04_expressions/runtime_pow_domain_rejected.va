// §4.3.2: "Input values outside of the valid range for the operator shall
// report an error." Table 4-14: `pow(x, y)`, domain "if x > 0, all y; if
// x = 0, y > 0; if x < 0, all integer y" (#59). One fixture per spelling the
// device has: a constant exponent (`zPowK`) and one that moves with the solve
// (`zPow`). Both are E0609, the prover's code for the provable forms.
//
//   point 0, V(p) = 2:   pow(2, 0.5) = sqrt(2) = 1.4142135623730951 (mpmath:
//                        1.41421356237309504880...); RTOL 1e-15 admits a
//                        faithful pow. pow(V - 3, V) = pow(-1, 2) = 1, exact:
//                        a negative base with an integer exponent is legal.
//   point 1, V(p) = 2.5: pow(2.5, 0.5) is legal, but pow(V - 3, V) =
//                        pow(-0.5, 2.5) is a negative base with a fractional
//                        exponent (NaN, silently, before #59): the run
//                        reports E0609 and exits 1.
//
// The constant-exponent violation is runtime_pow_constant_exponent_rejected.va.
//
//! lrm 4.3.1
//! lrm 4.3.2
//! lrm 4.3.2:2
//! sweep V(p) = 2, 2.5
//! reject-run E0609
//! neighbour runtime_domain_legal_neighbour.va
//! neighbour 158_pow_negative_base_runtime_exponent.va
//! checks 2
//! print none
`include "check.vh"
module runtime_pow_domain(p, n);
  inout p, n; electrical p, n;
  real k, r;
  analog begin
    k = pow(V(p, n), 0.5);
    r = pow(V(p, n) - 3.0, V(p, n));
    `CHECKR("pow(2, 0.5) is sqrt(2)", k, 1.4142135623730951, 1e-15);
    `CHECKX("pow(-1, 2) is 1, at the in-domain point only", r, 1.0);
    I(p, n) <+ V(p, n);
  end
endmodule
