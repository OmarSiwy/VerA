// LRM 4.3.1 Table 4-14 carries a Domain column exactly as Table 4-15 does, and
// 4.3.2's "Input values outside of the valid range for the operator shall
// report an error" is the rule both tables' Domain columns exist to state.
// Table 4-14's bounds:
//
//   ln(x)     x > 0        ($ln,    C log)
//   log(x)    x > 0        ($log10, C log10 — the DECIMAL log; see 68_log10.va)
//   sqrt(x)   x >= 0
//
// One call per bound. `ln` and `log` are two rows of the table with one domain
// between them and are both written out, because they are two different C
// functions and a compiler could easily guard one and not the other. `sqrt` is
// the half-open case: 0.0 is IN the domain, so the argument is -1.0.
//
// Constant arguments, so the violation is static. The in-domain side of Table
// 4-14 is 10_standard_math_traditional.va, 65_sqrt.va, 67_ln.va and 68_log10.va.
//
// Not pinned here: pow(x,y)'s three-clause domain ("if x > 0, all y; if x = 0,
// y > 0; if x < 0, all integer y"). It is a joint condition on two arguments
// rather than a bound on one, and it belongs with 85_pow.va.
//
//! lrm 4.3.1
//! lrm 4.3.2
//! lrm 4.3.2:2
//! reject-only E0602
//! reject E0604
//! neighbour 10_standard_math_traditional.va
//! neighbour 65_sqrt.va
//! neighbour 67_ln.va
//! neighbour 68_log10.va
//! neighbour 85_pow.va
module ch04_standard_math_domain_rejected(p, n);
    inout p, n;
    electrical p, n;
    real natural, decimal, root;

    analog begin
        natural = ln(-1.0);
        decimal = log(-1.0);
        root = sqrt(-1.0);
        I(p, n) <+ natural + decimal + root;
    end
endmodule
