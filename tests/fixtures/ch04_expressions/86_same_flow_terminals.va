// LRM 4.4, Table 4-16: `V(n1,n1)  Error` and `I(n1,n1)  Error`, and the prose
// under the table is normative -- "If two net expressions are given as
// arguments to a flow access function, they shall not evaluate to the same
// signal." Annex G Table G.1 records why the spelling exists at all: `I(a,a)`
// was the OVI Verilog-A v1.0 form of the port flow, replaced in v2.0 by
// `I(<a>)`. A branch from p to p is not a branch with zero potential; it is
// not a branch.
//
// The replacement spelling is covered by 34_port_access.va.
//
//! lrm 4.4
//! lrm G.1
//! reject E0315
//! xfail VerA accepts I(n,n)/V(n,n) and folds the self-referential branch away instead of diagnosing the same-signal flow arguments (Table 4-16); E0315's explain text already claims the rule ("LRM 4.4 also forbids V(n1, n1)") but nothing raises it
module ch4_same_flow(p);
  inout p; electrical p;
  analog begin
    I(p,p) <+ 1m;
  end
endmodule
