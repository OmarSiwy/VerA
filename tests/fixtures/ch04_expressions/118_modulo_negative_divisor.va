// LRM 4.2.4 Table 4-6, row four, verbatim: "11 % -3   2   The result takes the
// sign of the first operand."
//
// This is the row that pins WHICH operand the sign comes from. 45_modulo.va
// asserts -10 % 3 == -1, which a floor-modulus lowering gets wrong; this one
// asserts 11 % -3 == 2, which a lowering that took the sign from the DIVISOR
// gets wrong, returning -1. Neither row alone fixes the rule. Both are exact
// integers, so the want is a plain CHECKI.
//
// It is a separate file only because VerA cannot compile it: 45 would lose its
// other four Table 4-6 rows to this one line.
//
//! lrm 4.2.4
//! xfail VerA's range analysis does not fold unary minus on an integer literal, so `11 % -3` raises E0601 "divisor cannot be proven non-zero: `%` divisor is a computed expression with known range [-9223372036854776000:9223372036854776000]"
`include "check.vh"
module ch04_modulo_negative_divisor(p, n);
    inout p, n;
    electrical p, n;
    integer value;

    analog begin
        value = 11 % (-3);
        `CHECKI("Table 4-6: 11 % -3 takes the sign of the FIRST operand", value, 2);
        I(p, n) <+ value;
    end
endmodule
