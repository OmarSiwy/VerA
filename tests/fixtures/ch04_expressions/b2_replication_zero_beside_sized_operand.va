// §4.2.13: "A replication with a zero replication constant is considered to
// have a size of zero and is ignored. Such a replication shall appear only
// within a concatenation in which at least one of the operands of the
// concatenation has a positive size."
//
// The legal neighbour of b2_replication_zero_alone_rejected.va: the same
// zero replication, with the 4-bit operand 4'b0101 beside it supplying the
// positive size. The replication contributes nothing, so the value is
// 4'b0101 = 5.
//
//! lrm 4.2.13
//! lrm 4.2.13:4
//! checks 1
`include "check.vh"
module b2_replication_zero_beside_sized_operand(p, n);
    inout p, n;
    electrical p, n;
    integer k;

    analog begin
        k = { {0{1'b1}}, 4'b0101 };
        `CHECKI("a zero replication beside a sized operand is ignored", k, 5);
        I(p, n) <+ k * V(p, n);
    end
endmodule
