// §4.5.11.1 (laplace_zp): "ρ is a vector of N pairs of real numbers. Each
// pair represents a pole, the first number in the pair is the real part of
// the pole and the second is the imaginary part." §4.5.11 lets the vector be
// "a reference to a vector parameter".
//
// The pole vector here is a parameter array of FIVE reals, which is no list
// of pairs: the fifth number has no imaginary part. Its length is fixed by
// the declaration, not by the card, so E0540 refuses it at the call.
//
// Legal neighbour: the same call with an even-length pole array,
// laplace_zp_parameter_roots_step.va, where the card sets both parts and
// VerA pairs the roots at run time. Before E0540 the CLI printed only
// "codegen refused a construct" for any refused filter.
//
//! lrm 4.5.11.1
//! reject-only E0540
//! reject PAIRS
//! neighbour laplace_zp_parameter_roots_step.va
`include "disciplines.vams"
module reject_4_5_11_1_laplace_zp_parameter_roots(in, out);
  inout in, out;
  electrical in, out;
  parameter real z[0:3] = '{-1e9, 0.0, -2e9, 0.0};
  parameter real p[0:4] = '{-1e9, 1e9, -1e9, -1e9, -3e9};

  analog V(out) <+ laplace_zp(V(in), z, p);
endmodule
