// LRM 4.2.3 Expression evaluation order, verbatim: "Some operators (&&, ||, and
// ?:) shall use short-circuit evaluation ... All other operators shall not use
// short-circuit evaluation - all of their operand expressions are always
// evaluated. When short circuiting occurs, any side effects or runtime errors
// that would have occurred due to evaluation of the short-circuited operand
// expression shall not occur."
//
// The rule is only observable through a side effect, so `bump` is a function
// whose whole job is to have one: it adds 1 to the inout counter it is handed
// and returns 1. 4.7.2.4 makes that copy-in/copy-out, so the caller sees it.
// Every counter starts at 0 and each is passed to exactly one call, so its
// final value is the number of times that operand was evaluated — 0 or 1, an
// exact CHECKI want with nothing to round.
//
//   0 && bump(a)      a stays 0   left operand settles the && at zero
//   1 && bump(b)      b becomes 1 the right operand is required
//   1 || bump(c)      c stays 0   left operand settles the || at one
//   0 || bump(d)      d becomes 1 the right operand is required
//   0 & (0|bump(f))   f becomes 1 LRM 4.2.3 Example 1, verbatim: bitwise & is
//                                 NOT a short-circuit operator, so "even if
//                                 varA is known to be zero, the subexpression
//                                 (varB | myFunc(varC)) will be evaluated and
//                                 any side effects ... will occur"
//
// The `&` line is the half that a compiler which short-circuits everything gets
// wrong, and the `&&`/`||` lines are the half that one which short-circuits
// nothing gets wrong. 4.2.3 closes by allowing an implementation to reorder or
// omit evaluation only "as long as the simulation behavior (including side
// effects) is as if the standard rules were followed", so constant-folding the
// calls away does not license a different answer here.
//
// The third short-circuiting operator, `?:`, is 125_short_circuit_ternary.va —
// a separate file only because VerA fails it, and keeping it here would take
// the ten assertions above down with it.
//
//! lrm 4.2.3
//! lrm 4.2.3:3
//! lrm 4.2.3:4
//! lrm 4.2.3:2
`include "check.vh"
module ch04_short_circuit_side_effects(p, n);
    inout p, n;
    electrical p, n;
    integer a, b, c, d, f;
    integer r_and, r_and_true, r_or, r_or_false, r_bitand;

    analog function integer bump;
        inout counter;
        integer counter;
        begin
            counter = counter + 1;
            bump = 1;
        end
    endfunction

    analog begin
        a = 0;
        b = 0;
        c = 0;
        d = 0;
        f = 0;

        r_and       = 0 && bump(a);
        r_and_true  = 1 && bump(b);
        r_or        = 1 || bump(c);
        r_or_false  = 0 || bump(d);
        r_bitand    = 0 & (0 | bump(f));

        `CHECKI("&& suppresses its right operand when the left is 0", a, 0);
        `CHECKI("&& evaluates its right operand when the left is 1", b, 1);
        `CHECKI("|| suppresses its right operand when the left is 1", c, 0);
        `CHECKI("|| evaluates its right operand when the left is 0", d, 1);
        `CHECKI("LRM 4.2.3 Example 1: bitwise & does not short-circuit", f, 1);

        `CHECKI("0 && x is 0", r_and, 0);
        `CHECKI("1 && 1 is 1", r_and_true, 1);
        `CHECKI("1 || x is 1", r_or, 1);
        `CHECKI("0 || 1 is 1", r_or_false, 1);
        `CHECKI("0 & (0 | 1) is 0", r_bitand, 0);

        I(p, n) <+ V(p, n);
    end
endmodule
