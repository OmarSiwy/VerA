// AMS 4.2.13: zero replication contributes no bits, but its operands must
// still be evaluated exactly once. A positive-sized sibling makes it legal.
// Prefix 1 and suffix 0101 give binary 10101 = 21 with no intervening bits.
// An erroneous extra zero bit gives 100101 = 37, so this does observe width,
// unlike a zero replication at the leading edge of an integer assignment.
// bump increments its inout counter once and returns integer 0. Its return
// contributes no bits at replication count zero, but the counter must be 1.
// Binding the result before CHECK avoids textual macro re-evaluation.
//! lrm 4.2.13
//! checks 2
//! xfail REPL-EVAL-001 analog parser erases the zero-count operand before its side effects can be evaluated
`include "check.vh"
module audit_replication_zero_effect(p, n);
    inout p, n;
    electrical p, n;
    integer count, value;
    analog function integer bump;
        inout calls;
        integer calls;
        begin
            calls = calls + 1;
            bump = 0;
        end
    endfunction
    analog begin
        count = 0;
        value = {1'b1, {0{bump(count)}}, 4'b0101};
        `CHECKI("zero replication has no intervening bits", value, 21);
        `CHECKI("zero replication evaluates operand once", count, 1);
        I(p,n) <+ V(p,n);
    end
endmodule
