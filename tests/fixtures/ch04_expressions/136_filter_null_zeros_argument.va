// LRM 4.5.11 and 4.5.12 carry the identical sentence, one for the Laplace
// filters and one for the Z filters: "The zeros argument may be represented as
// a null argument. The null argument is characterized by two adjacent commas
// (,,) in the argument list."
//
// A null zeros vector means the numerator product is empty, and an empty
// product is 1 — so the transfer function is the poles alone. 4.5.11.5 prints
// the form itself, in the band-limited noise example:
//
//     V(out) <+ laplace_zp(white_noise(k), , '{1,0,1,0,-1,0,-1,0});
//
// The wants come from the poles and nothing else:
//
//   laplace_zp(x, , '{-1,0})            H(s) = 1 / (1 - s/(-1)) = 1/(1+s)
//                                       H(0) = 1
//   zi_zp(x, , '{0,0}, 1u)              a single pole AT THE ORIGIN, which
//                                       4.5.12.1 implements "as z" rather than
//                                       (1 - z/r), so H(z) = 1/z — one sample
//                                       of pure delay, unity magnitude
//
// The Laplace want has digits: every (1 - s/r) factor is 1 at s = 0 and there
// are no zero factors left, so H(0) = 1 exactly. The Z-filter's DC value is not
// something 4.5.12 fixes (see the header of 24_z_transform_filters.va, which
// works through why), so it is only required to AGREE with the same filter
// written with an explicit empty numerator — which is the identity the null
// argument is an abbreviation for, and the case CHECKEQ exists for.
//
//! lrm 4.5.11
//! lrm 4.5.12
//! xfail VerA rejects the legal null argument at E0505 "analog operator does not accept an empty argument" for both `laplace_zp(x, , poles)` and `zi_zp(x, , poles, T)`; E0505 is the 4.5.14 rule and is over-firing on the 4.5.11/4.5.12 carve-out
//! analysis dc
//! bias V(p) = 1.0
//! bias V(n) = 0.0
`include "check.vh"
module ch04_filter_null_zeros_argument(p, n);
    inout p, n;
    electrical p, n;
    real y_laplace, y_z_null, y_z_spelled;

    analog begin
        y_laplace   = laplace_zp(V(p, n), , '{-1.0, 0.0});
        y_z_null    = zi_zp(V(p, n), , '{0.0, 0.0}, 1u);
        y_z_spelled = zi_np(V(p, n), '{1.0}, '{0.0, 0.0}, 1u);

        `CHECK("a null zeros vector is an empty product, so H(0) is the poles alone",
               y_laplace, 1.0, 1e-12);
        `CHECKEQ("the null zeros argument abbreviates a unit numerator",
                 y_z_null, y_z_spelled, 1e-12);

        I(p, n) <+ y_laplace + y_z_null + y_z_spelled;
    end
endmodule
