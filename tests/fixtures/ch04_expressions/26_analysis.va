// §4.6.1 analysis(). Table 4-22's "DC Sweep" column is the whole assertion: in
// a dc analysis "dc" and "static" are both true — "static" covers *any*
// equilibrium point calculation, of which a dc point is one — while "tran",
// "ac", "noise" and "ic" are all false. A multi-argument call is an OR, so
// analysis("dc", "static") is 1 here for two independent reasons; the singleton
// calls below separate them so a compiler that matched only the first argument,
// or that treated "static" as a synonym for "ic", still fails.
//
// §4.6.2 states the same two answers as a duty: "The analysis("dc") and
// analysis("static") function calls shall return true for a single-point dc
// analysis". This file is that single point, and
// dc_sweep_every_point_is_dc_and_static.va is the sweep half.
//
//! lrm 4.6.1
//! lrm 4.6.1:1001
//! lrm 4.6.2
//! lrm 4.6.2:1
//! lrm 4.6.1:1
//! analysis dc
//! bias V(p) = 0.5
`include "check.vh"
module ch04_analysis(p, n);
    inout p, n;
    electrical p, n;

    analog begin
        `CHECKI("analysis(\"dc\",\"static\") is the OR of its arguments", analysis("dc", "static"), 1);
        `CHECKI("analysis(\"dc\") in a dc analysis", analysis("dc"), 1);
        `CHECKI("analysis(\"static\") covers a dc point", analysis("static"), 1);
        `CHECKI("analysis(\"tran\") in a dc analysis", analysis("tran"), 0);
        `CHECKI("analysis(\"ac\") in a dc analysis", analysis("ac"), 0);
        `CHECKI("analysis(\"noise\") in a dc analysis", analysis("noise"), 0);
        `CHECKI("analysis(\"ic\") is not a dc point", analysis("ic"), 0);

        if (analysis("dc", "static"))
            I(p, n) <+ V(p, n);
        else if (analysis("tran"))
            I(p, n) <+ 2.0 * V(p, n);
    end
endmodule
