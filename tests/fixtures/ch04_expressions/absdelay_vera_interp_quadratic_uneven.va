// VerA's `(* vera_interp = 2 *)` (§2.9) on `absdelay` (§4.5.7) over UNEVEN
// steps, where a Lagrange weight with two spans swapped gives the wrong
// value (on the even grid of `absdelay_vera_interp_quadratic.va` it does not).
//
// INPUT: V(p) = tn^2 at tn = $abstime/1ns = 0, 1, 3, 4, 6, 7, 8. Any parabola
// through three samples of tn^2 is tn^2, so wherever three points exist the
// quadratic reading is exact: (tn - td)^2. The ring holds the points accepted
// BEFORE the one being evaluated. The window is the two samples bracketing
// the query and the one before them (ngspice traload.c's choice), clamped to
// the first three; a query past the newest sample uses the last two and the
// in-flight (now, input).
//
// SITE y1, td = 1.5 ns:
//   tn  query  path       points          quadratic  linear  d/dinput
//   0   -      DC         -               0          0       1
//   1   -0.5   before history, Input(0)   0          0       0
//   3   1.5    in flight  (0,1,3)         2.25       3       (1.5)(0.5)/((3)(2)) = 0.125
//   4   2.5    history    (0,1,3)         6.25       7       0
//   6   4.5    in flight  (3,4,6)         20.25      21      (1.5)(0.5)/((3)(2)) = 0.125
//   7   5.5    history    (3,4,6)         30.25      31      0
//   8   6.5    history    (4,6,7)         42.25      42.5    0
// (d/dinput in flight is the Lagrange weight of `now`,
//  (t - ta)(t - tb) / ((now - ta)(now - tb)); linear's would be 0.25.)
//
// SITE y3, td = 3.5 ns, always inside the history:
//   tn  query  points     quadratic  linear
//   0..3       -          0 (DC, then before history: Input(0))
//   4   0.5    (0,1,3)    0.25       0.5
//   6   2.5    (0,1,3)    6.25       7
//   7   3.5    (1,3,4)    12.25      12.5    <- a window short of the newest
//   8   4.5    (3,4,6)    20.25      21
//! lrm 4.5.7
//! lrm 2.9
//! bias V(n) = 0
//! wave V(p) = 0, 1, 9, 16, 36, 49, 64
//! time 0, 1n, 3n, 4n, 6n, 7n, 8n
//! analysis tran
//! print none
`include "check.vh"
module absdelay_vera_interp_quadratic_uneven(p, n);
    inout p, n;
    electrical p, n;
    real y1, y3, d1;
    analog begin
        (* vera_interp = 2 *) begin
            y1 = absdelay(V(p, n), 1.5n);
            y3 = absdelay(V(p, n), 3.5n);
        end
        d1 = ddx(y1, V(p));
        `CHECK("td 1.5n", y1,
            $abstime < 0.5n ? 0.0 : ($abstime < 2n ? 0.0 : ($abstime < 3.5n ? 2.25 : ($abstime < 5n ? 6.25 : ($abstime < 6.5n ? 20.25 : ($abstime < 7.5n ? 30.25 : 42.25))))), 1e-9);
        `CHECK("td 1.5n, d/dinput", d1,
            $abstime < 0.5n ? 1.0 : ($abstime < 2n ? 0.0 : ($abstime < 3.5n ? 0.125 : ($abstime < 5n ? 0.0 : ($abstime < 6.5n ? 0.125 : ($abstime < 7.5n ? 0.0 : 0.0))))), 1e-9);
        `CHECK("td 3.5n", y3,
            $abstime < 0.5n ? 0.0 : ($abstime < 2n ? 0.0 : ($abstime < 3.5n ? 0.0 : ($abstime < 5n ? 0.25 : ($abstime < 6.5n ? 6.25 : ($abstime < 7.5n ? 12.25 : 20.25))))), 1e-9);
        I(p, n) <+ 0.0;
    end
endmodule
