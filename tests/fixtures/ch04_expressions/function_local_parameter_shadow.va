// LRM 4.7.2: an analog function "can contain ... parameter declarations",
// and §6.8 lists the analog function among the six scopes an identifier can be
// declared in — so a function-local `parameter` declares a NEW item whose name
// "can be used to declare another item of a different scope", i.e. it shadows
// a module parameter of the same name for the body's duration, exactly as a
// local variable would (§4.7.1's isolation says the body sees its own
// declarations, not the module's).
//
// The wants are arithmetic on the two declared defaults, nothing solved:
//
//     module k = 2.0, function-local k = 99.0
//     scaled(x) = x * k  reads the LOCAL  ->  scaled(1.0) = 99.0
//     module code after the call reads k  ->  the MODULE's 2.0 again
//
// The third check is the non-colliding case that always worked and must keep
// working: a function-local parameter whose name exists nowhere else.
//
//! lrm 4.7.2
//! lrm 6.8
//! lrm 4.7.1
//! lrm 4.7.1:3
//! bias V(p) = 1.0
`include "check.vh"
module ch04_function_local_parameter_shadow(p, n);
    inout p, n;
    electrical p, n;
    parameter real k = 2.0;
    real y;

    // Local k shadows module k inside the body only.
    analog function real scaled;
        input x;
        real x;
        parameter real k = 99.0;
        scaled = x * k;
    endfunction

    // No collision: `gain` names nothing at module scope.
    analog function real amplified;
        input x;
        real x;
        parameter real gain = 7.0;
        amplified = x * gain;
    endfunction

    analog begin
        y = scaled(1.0);
        `CHECKX("a function-local parameter shadows the module parameter", y, 99.0);
        `CHECKX("the module parameter is itself again after the call", k, 2.0);
        `CHECKX("a non-colliding local parameter still folds", amplified(1.0), 7.0);
        I(p, n) <+ V(p, n) * 1.0e-3;
    end
endmodule
