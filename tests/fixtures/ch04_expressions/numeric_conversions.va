// LRM 4.2.1.1 real-to-integer conversion, and 4.2.4 integer vs real division.
//
// 4.2.1.1: "Real numbers are converted to integers by rounding the real number
// to the nearest integer, rather than by truncating it. ... If the fractional
// part of the real number is exactly 0.5, it shall be rounded away from zero."
// So 35.5 -> 36 (not 35), and -1.5 -> -2 (not -1, and not a truncation to -1).
//
// 4.2.4: "Integer division truncates any fractional part toward zero." Both
// operands of 1/2 are integers, so the result is 0. In 1/2.0 the denominator is
// real, so the operation is real division and the result is 0.5 exactly.
//
// The original ties, 35.5 and -1.5, also pass a ties-to-even implementation.
// Runtime +2.5 and -2.5 must instead become +3 and -3. Values on either side
// of a tie distinguish nearest rounding from truncation or rounding away
// from zero unconditionally. Negative integer division distinguishes
// truncation toward zero from floor division.
//! lrm 4.2.1.1
//! lrm 4.2.1.1:1001
//! lrm 4.2.1.1:1002
//! lrm 4.2.1.1:1
//! lrm 4.2.4
//! lrm 4.2.4:1001
//! lrm 4.2.1.3
//! lrm 4.2.1.3:1000
//! bias V(p) = 2.5, V(n) = 0.0
//! checks 13
`include "check.vh"
module ch04_numeric_conversions(p, n);
    inout p, n;
    electrical p, n;
    integer rounded_positive, rounded_negative, integer_division;
    integer positive_odd_tie, negative_odd_tie;
    integer positive_below, negative_below, positive_above, negative_above;
    real mixed_division;

    analog begin
        rounded_positive = 35.5;
        rounded_negative = -1.5;
        integer_division = 1 / 2;
        mixed_division = 1 / 2.0;
        positive_odd_tie = V(p, n);
        negative_odd_tie = -V(p, n);
        positive_below = 1.25;
        negative_below = -1.25;
        positive_above = 1.75;
        negative_above = -1.75;
        `CHECKI("35.5 rounds away from zero", rounded_positive, 36);
        `CHECKI("-1.5 rounds away from zero", rounded_negative, -2);
        `CHECKI("1 / 2 is integer division", integer_division, 0);
        `CHECKX("1 / 2.0 is real division", mixed_division, 0.5);
        `CHECKI("runtime 2.5 rounds away from zero rather than to even", positive_odd_tie, 3);
        `CHECKI("runtime -2.5 rounds away from zero rather than to even", negative_odd_tie, -3);
        `CHECKI("1.25 rounds to its nearest integer", positive_below, 1);
        `CHECKI("-1.25 rounds to its nearest integer", negative_below, -1);
        `CHECKI("1.75 rounds up rather than truncating", positive_above, 2);
        `CHECKI("-1.75 rounds down rather than truncating", negative_above, -2);
        `CHECKI("negative numerator division truncates toward zero", -3 / 2, -1);
        `CHECKI("negative denominator division truncates toward zero", 3 / -2, -1);
        `CHECKI("two negative operands give a positive truncated quotient", -3 / -2, 1);
        I(p, n) <+ rounded_positive + rounded_negative + integer_division + mixed_division;
    end
endmodule
