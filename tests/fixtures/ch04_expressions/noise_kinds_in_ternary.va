// §4.6.4 with the source selection written as §4.2.12's ?: — a real shape for
// a model with a corner switch:
//
//     I(a,b) <+ (sel > 0.5) ? white_noise(...) : flicker_noise(...);
//
// WHICH generators does that declare? Both. The export is a topology table —
// the set of generators the model declares, each with its PSD kind — and the
// solve-time value of `sel` does not undeclare an arm: a host asks the device
// for its generators once, before any operating point exists, and §4.6.4.2's
// flicker source is on the branch whether or not this bias selects it. (The
// same reasoning already governs a source under `if`: the E0514 family warns
// about operator STATE under a runtime branch, but the declaration set walk
// has always unioned everything it reaches.)
//
// This fixture exists because the kinds walk handled every operand position
// EXCEPT the ternary's third: ?:'s else arm lives in the expression store's
// `extra` column, which the lhs/rhs catch-all cannot see, so the table
// exported `thermal` alone and the flicker generator vanished — a PSD the
// host had no way to know it should have asked for.
//
// The dc values are §4.6.2's "when not active, the small-signal source
// functions return zero": both arms are 0 at this point, so the branch
// carries the resistive term alone whichever arm `sel` picks.
//
//! lrm 4.6.4
//! lrm 4.2.12
//! noise thermal(a,b)#0
//! noise flicker(a,b)#1
//! analysis dc
//! bias V(a) = 1.0
//! bias V(b) = 0.0
`include "check.vh"
module ch04_noise_kinds_in_ternary(a, b);
    inout a, b;
    electrical a, b;
    parameter real sel = 1.0;
    parameter real R = 1000.0 from (0:inf);

    analog begin
        I(a, b) <+ V(a, b)/R + ((sel > 0.5)
            ? white_noise(1.0e-18, "wn")
            : flicker_noise(1.0e-15, 1.0, "fn"));
        `CHECKX("the dc current is the resistive term whichever arm is picked", V(a,b)/R, 1e-3);
    end
endmodule
