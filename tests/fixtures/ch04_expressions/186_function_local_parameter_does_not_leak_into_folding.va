// LRM 4.7.1, the last two items of the analog-function restriction list: a
// function body "shall only reference ... locally-defined parameters and
// module-level parameters; and if a locally-defined parameter with the
// specified name does not exist, then the module-level parameter of the
// specified name will be used." §6.8 lists the analog function as one of the
// scopes a name can be declared in, so the local `N` below is a different item
// from the module's `N` and is visible inside the body only.
//
// 157_function_local_parameter_shadow.va pins the RUNTIME read of the module
// parameter after the call. This file pins the CONSTANT-EXPRESSION read: a
// genvar loop bound is folded at compile time (§3.5, §6.6.1), and the fold
// must see the module's `N` too. The two are separate paths in a compiler,
// which is why both need a row.
//
// The wants are arithmetic on the declared defaults, nothing solved:
//
//     module N = 2, function-local N = 7
//     f(0.0) = 0.0 + N(local)                    =  7.0
//     y = f(0.0), then the loop adds 1.0 N(module) = 2 times:  7.0 + 2.0 = 9.0
//
// A compiler that let the local `N` survive the call runs the loop 7 times
// and gets 14.0; one that ignored the local inside the body gets f = 2.0 and
// y = 4.0. Only the scoping the clause states gives 7.0 and 9.0.
//
//! lrm 4.7.1
//! lrm 6.8
//! lrm 3.5
//! lrm 4.7.1:3
`include "check.vh"
module ch04_function_local_parameter_does_not_leak_into_folding(p, n);
    inout p, n;
    electrical p, n;
    parameter integer N = 2;
    real y;
    genvar k;

    analog function real f;
        input x;
        real x;
        parameter integer N = 7;
        f = x + N;
    endfunction

    analog begin
        y = f(0.0);
        `CHECKX("the body reads its own N", y, 7.0);
        for (k = 0; k < N; k = k + 1)
            y = y + 1.0;
        `CHECKX("the loop bound folds the module's N after the call", y, 9.0);
        I(p, n) <+ V(p, n) * 1.0e-3;
    end
endmodule
