// §4.5.12: "Each filter supports a parameter T which specifies the sampling
// period of the filter." A discrete-time filter's recurrence runs once per T of
// SIMULATED TIME. Where the simulator chose to place its timepoints is not an
// input to it — §4.5.12's own transition-time rules have the simulator moving
// timepoints around to resolve a corner, so a filter whose output depended on
// their density would change answer for a reason the model never wrote down.
//
// This is the same filter, the same T and the same constant input, evaluated
// over the same NUMBER of points at two different spacings. With T = 1 us:
//
//   points every 1 us   ->  20 us elapsed, 20 sampling periods
//   points every 10 us  ->  200 us elapsed, 200 sampling periods
//
// H(z) = 1/(1 - z^-1/2) has DC gain 2 and each sample halves the remaining
// error, so after 200 periods the second filter is at 2 to within 2^-200 —
// indistinguishable from 2 in double precision — while after 20 it is only
// within 2^-20. The two must therefore NOT be equal, and the far one must be
// the settled value. Both are asserted, because either alone can be passed by
// accident: "not equal" alone is satisfied by any two wrong numbers, and
// "settled" alone is satisfied by a filter that ignores time and happens to
// have run long enough.
//
// The sample-and-hold half of T was always correct — `exhaustive/067_zi_sample_hold.va`
// shows the output held constant between sample instants, and the instants
// landing on multiples of T. It was the STATE that did not advance: the
// recurrence stepped once per EVALUATION, so this fixture's two spacings came
// back bit-identical and 200 us at T = 1 us advanced the filter 20 samples.
// `codegen.zig`'s accepted-step block now runs the recurrence once per elapsed
// T and re-arms on the sample grid rather than from the accepted time, which
// also stops the instants drifting with the timestep.
//
// Corrected 2026-10-08 (construct only, the wants are unchanged): the
// coefficient vectors were VAMS 2.x concatenations, `{...}`. A.8.2's
// analog_filter_function_arg is a parameter, a part of one or a `'{...}`
// assignment pattern (annex G: "Add apostrophe before opening { in list of
// values"), and a concatenation there is E0572
// (reject_4_5_11_concatenation_coefficients.va), so each is now `'{...}`.
//
//! lrm 4.5.12
//! analysis tran
//! bias V(n) = 0
//! wave V(in) = 1, 1, 1, 1, 1, 1, 1, 1, 1, 1, 1, 1, 1, 1, 1, 1, 1, 1, 1, 1, 1
//! time 0, 10u, 20u, 30u, 40u, 50u, 60u, 70u, 80u, 90u, 100u, 110u, 120u, 130u, 140u, 150u, 160u, 170u, 180u, 190u, 200u
//! print none
`include "check.vh"
module ch04_zi_sampling_period(in, n);
    inout in, n;
    electrical in, n;
    real slow;

    analog begin
        // T = 1 us, and the timepoints are 10 us apart: 10 sampling periods
        // elapse between consecutive evaluations.
        slow = zi_zp(V(in, n), '{0.0, 0.0}, '{0.5, 0.0}, 1u);
        $strobe("t=%g slow=%.17g", $abstime / 1u, slow);
        // 200 sampling periods at |pole| = 1/2 is 2^-200 of remaining error, so
        // the settled value is exact to the last bit of a double. A filter that
        // counted 20 periods instead lands on 2 - 2^-20, which fails this by
        // four orders of magnitude — the tolerance is deliberately far looser
        // than the claim so that only the miscount, not the arithmetic, can
        // trip it.
        `CHECKI("200 periods of a |p|=1/2 filter have settled to its DC gain",
                ($abstime < 200u) || (abs(slow - 2.0) < 1e-9), 1);
        I(in, n) <+ 0.0;
    end
endmodule
