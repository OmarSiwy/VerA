// §4.4: "The net identifiers shall be scalar or resolve to a constant net of a
// composite net type (array or bus) accessed by a genvar expression."
//
// The legal neighbour of b2_access_bus_variable_index_rejected.va: `b` is a
// two-element bus and V(b[g]) is indexed by the genvar of a §5.9.3 analog
// for, so each unrolled copy names one constant element.
//
// HAND DERIVATION. V(b[0]) = 0.25 and V(b[1]) = 0.5 (both biased). The loop
// weights element g by g + 1, so the order is visible:
//   s = 1 * 0.25 + 2 * 0.5 = 1.25        (swapped elements would give 1.0)
// Exact in binary64, so CHECKX.
//
//! lrm 4.4
//! bias V(b[0]) = 0.25, V(b[1]) = 0.5
//! checks 1
`include "check.vh"
module b2_access_bus_genvar_index(p);
    inout p;
    electrical p;
    electrical [0:1] b;
    genvar g;
    real s;

    analog begin
        s = 0.0;
        for (g = 0; g < 2; g = g + 1)
            s = s + (g + 1) * V(b[g]);
        `CHECKX("V(b[g]) over the genvar reads each element", s, 1.25);
        I(p) <+ 1e-3 * s * V(p);
    end
endmodule
