// The device of spice_noise_shared_generator.sp, and §4.6.4.6's Example 1 in
// a circuit: "Perfectly correlated noise is generated by using the output of
// one noise function for more than one noise source." One white_noise n of
// density pwr, contributed as c1·n on (p, r) and as -c2·n on (q, r), over
// three conductances g1 (p, r), g2 (q, r) and g3 (p, q).
//
// WHAT THIS FILE ASSERTS ON ITS OWN: what it publishes to a host. Both rows
// share one generator (#0), so the correlation of the two contributions is
// the sign of the product of their factors (a06_noise_anticorrelated_
// coefficient.va derives it): rho = (2·-3)/(2·3) = -1. Their densities are
// 2²·1e-18 = 4e-18 and (-3)²·1e-18 = 9e-18. The CHECK pins the conductance
// the deck's transfer uses: d(g3·V(p,q))/dV(p) = g3 = 1e-3 S (§4.5.6).
//
//! lrm 4.6.4.6
//! lrm 4.5.6
//! noise thermal(p,r)#0 name=shared white=4e-18 corr=1:-1
//! noise thermal(q,r)#0 name=shared white=9e-18 corr=0:-1
//! analysis noise
//! bias V(p) = 0.0, V(q) = 0.0, V(r) = 0.0
`include "check.vh"
module spice_noise_shared_pair(p, q, r);
    inout p, q, r;
    electrical p, q, r;
    parameter real g1 = 1e-3;
    parameter real g2 = 2e-3;
    parameter real g3 = 1e-3;
    parameter real pwr = 1e-18 from [0:inf);
    parameter real c1 = 2.0;
    parameter real c2 = 3.0;
    real n;

    analog begin
        n = white_noise(pwr, "shared");
        `CHECK("the bridge conductance g3", ddx(g3 * V(p, q), V(p)), 1e-3, 1e-18);
        I(p, r) <+ g1 * V(p, r);
        I(q, r) <+ g2 * V(q, r);
        I(p, q) <+ g3 * V(p, q);
        I(p, r) <+ c1 * n;
        I(q, r) <+ -c2 * n;
    end
endmodule
