// AMS4.5.11.2: the nonreal zero -1+j has its required conjugate -1-j.
// Same zero/denominator form and denominator1 as the unpaired-zero negative.
// H(s)=(1-s/(-1+j))*(1-s/(-1-j)); H(0)=1. Input2 therefore yields2.
// This observes legal-pair DC behavior only, not its transient/AC transfer.
//! lrm 4.5.11.2
//! bias V(p) = 2.0, V(n) = 0.0
//! checks 1
`include "check.vh"
module audit_laplace_zd_conjugate_zeros(p,n);
    inout p,n;
    electrical p,n;
    real y;
    analog begin
        y = laplace_zd(V(p,n), '{-1.0,1.0,-1.0,-1.0}, '{1.0});
        `CHECK("conjugate zero pair DC gain", y, 2.0, 1e-12);
        I(p,n) <+ y;
    end
endmodule
