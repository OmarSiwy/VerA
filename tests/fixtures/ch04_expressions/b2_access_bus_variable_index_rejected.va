// §4.4: "The net identifiers shall be scalar or resolve to a constant net of a
// composite net type (array or bus) accessed by a genvar expression."
//
// `g` below is an `integer` VARIABLE, so the analog for is an ordinary
// run-time loop and `V(b[g])` indexes the bus with a variable, not a genvar
// expression. The legal neighbour, b2_access_bus_genvar_index.va, differs
// only in `g` being declared `genvar`.
//
//! lrm 4.4
//! lrm 4.4:3
//! reject-only E0352
//! neighbour b2_access_bus_genvar_index.va
`include "disciplines.vams"
module b2_access_bus_variable_index_rejected(p);
    inout p;
    electrical p;
    electrical [0:1] b;
    integer g;
    real s;

    analog begin
        s = 0.0;
        for (g = 0; g < 2; g = g + 1)
            s = s + (g + 1) * V(b[g]);
        I(p) <+ 1e-3 * s * V(p);
    end
endmodule
