// §4.4: "A port access function also takes its name from the discipline of the
// port to which it is associated but utilizes the port access (< >) operator."
// and "The access function name shall match the discipline declaration for the
// port identifier."
//
// The legal neighbour of b2_port_access_wrong_discipline_rejected.va: `p` is
// `b2_pa_d`, whose flow nature declares `access = PaI`, so `PaI(<p>)` is the
// port access function that matches p's discipline. It reads the flow into
// the module through p (Table 4-16's I(<p1>) row): biased to 0.375 A, exact.
//
// The `I(<p>)` on the bias line is harness notation for "the flow into port p"
// (lib/backend/tb/directive.zig), not the source-level access function.
//
//! lrm 4.4
//! bias I(<p>) = 0.375
//! bias V(p) = 0.25
//! checks 1
`include "check.vh"
`include "disciplines.vams"
nature b2_pa_p; units = "V"; access = PaV; abstol = 1u; endnature
nature b2_pa_f; units = "A"; access = PaI; abstol = 1p; endnature
discipline b2_pa_d; potential b2_pa_p; flow b2_pa_f; enddiscipline
module b2_port_access_custom_discipline(p);
    inout p;
    b2_pa_d p;

    analog begin
        `CHECKX("PaI(<p>) is p's discipline's port access", PaI(<p>), 0.375);
        PaI(p) <+ PaI(<p>);
    end
endmodule
