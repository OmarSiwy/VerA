// Full operator behavior is observed by tests/host.py;
// these local value/Jacobian checks alone do not prove the live tolerance or AC rule.
// §4.5.3, Table 4-17 ddt(expr): "Returns d/dt x(t), the time-derivative of
// x". "In DC analysis, ddt() returns zero (0)." Nothing in the clause ties the
// value to where it is used: assigned to a variable and read back, ddt() is
// the same derivative it is inside a contribution.
//
// THE DESIGN. `n` is an internal node driven by an ideal source of 1 V/ns,
// V(n) = 1e9 * $abstime. `dv = ddt(V(n))` is held in a variable and read back
// by $strobe (check.vh), with no contribution using it.
//
// DERIVATION. Points 0 (dc), 5n, 10n, 15n. At the dc point ddt is 0 and is
// not checked. At every transient point the derivative of a straight line is
// its slope, 1e9 V/s; a backward difference reproduces it exactly on a
// linear segment (python3: (1e9*t1 - 1e9*t0)/(t1 - t0) = 1e9 within 4e-16
// relative on this grid). Three checks, CHECKR at 1e-9.
//
// Found while writing ch07_mixed_signal/digital_value_has_zero_derivative.va:
// the same ramp read as `I(m) <+ V(m)/1000 - 1e-12*ddt(V(n))` integrates
// correctly (that file's V(m) = 1.0), while the value held in `dv` reads 0,
// in the analog runner (this file) and in the mixed one, and also when `dv`
// itself feeds a contribution.
//
//! lrm 4.5.3
//! analysis tran
//! time 0, 5n, 10n, 15n
//! solve
//! checks 3
`include "check.vh"
module b5_ddt_of_a_ramp_held_in_a_variable;
  electrical n;
  real dv;
  analog begin
    V(n) <+ 1.0e9 * $abstime;
    dv = ddt(V(n));
    if ($abstime > 0)
      `CHECKR("§4.5.3 ddt of a 1 V/ns ramp, held in a variable, is its slope", dv, 1.0e9, 1e-9);
  end
endmodule
