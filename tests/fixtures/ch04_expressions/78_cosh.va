// cosh() (LRM 4.3.2 Table 4-15): hyperbolic cosine, (e^x + e^-x) / 2, all x.
`include "check.vh"
//! lrm 4.3.2
//! bias V(p) = 1.0
module ch04_cosh(p, n);
  inout p, n; electrical p, n;
  analog begin
    I(p, n) <+ cosh(V(p, n));
    // (e + 1/e) / 2 = (2.718281828459045 + 0.36787944117144233) / 2.
    `CHECK("cosh(1)", cosh(V(p, n)), 1.5430806348152437, 1e-15);
    // Even function with its minimum, exactly 1, at the origin.
    `CHECKX("cosh(0) = 1", cosh(0.0), 1.0);
    `CHECK("cosh(-1) = cosh(1)", cosh(-1.0), 1.5430806348152437, 1e-15);
  end
endmodule
