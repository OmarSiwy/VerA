// §4.4: "For port access functions, the expression list is a single port of
// the module. ... The access function name shall match the discipline
// declaration for the port identifier."
//
// `p` is `b2_pa_d`, whose flow nature declares `access = PaI`. `I` is the
// flow access function of annex D's electrical discipline (included, so `I`
// is a known access function); it does not match p's discipline, so
// `I(<p>)` is the violation. The legal neighbour,
// b2_port_access_custom_discipline.va, differs only in that one name.
//
//! lrm 4.4
//! lrm 4.4:7
//! reject-only E0501
//! neighbour b2_port_access_custom_discipline.va
`include "disciplines.vams"
nature b2_pa_p; units = "V"; access = PaV; abstol = 1u; endnature
nature b2_pa_f; units = "A"; access = PaI; abstol = 1p; endnature
discipline b2_pa_d; potential b2_pa_p; flow b2_pa_f; enddiscipline
module b2_port_access_wrong_discipline_rejected(p);
    inout p;
    b2_pa_d p;

    analog begin
        PaI(p) <+ I(<p>);
    end
endmodule
