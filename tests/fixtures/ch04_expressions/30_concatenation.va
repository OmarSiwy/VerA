// §4.2.13 concatenation joins BITS, it does not add or list. The operands are
// sized (§4.2.13 forbids unsized constants here) so the width and the placement
// are both fixed:
//
//   {4'b1010, 4'b0101}  ->  8'b1010_0101  =  128+32+4+1  =  165
//
// The three wrong answers a sloppy lowering gives are all excluded by that one
// number: adding the operands gives 15, taking the last gives 5, and treating
// `{}` as the §4.1 assignment pattern '{} gives an array rather than 165.
//
//! lrm 4.2.13
//! lrm 4.2.13:1
//! bias V(p) = 0.0
`include "check.vh"
module ch04_concatenation(p, n);
    inout p, n;
    electrical p, n;
    integer packed_value;

    analog begin
        packed_value = {4'b1010, 4'b0101};
        `CHECKI("concatenation shifts the left operand up by the right operand's width", packed_value, 165);
        I(p, n) <+ packed_value;
    end
endmodule
