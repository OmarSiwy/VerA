// EXPECT: success -- idt() with a reset argument is legal (LRM 4.5.4).
//
// The `_rejected` in the file name is HISTORY: this fixture was written while
// the reset form was unimplemented and failing loudly on purpose. It compiles
// and behaves now, and the check below is what proves it rather than the
// absence of an .expected-error.txt.
//
// The assertion below is what the third argument MEANS, per §4.5.4: "When
// specified with both initial conditions and assert, idt() returns the initial
// conditions during DC and IC analyses, and whenever assert is nonzero."
//
// It has to be checked in a TRANSIENT with a nonzero integrand, or it checks
// nothing: at a DC point §4.5.4 already makes idt(expr, ic) answer ic, so an
// implementation that parsed the third argument and threw it away would pass.
// With a constant integrand of 1e9 and 1 ns steps a plain idt(1e9, 7.0) reads
// 7, 8, 9, 10 — while assert pinned nonzero forever must hold it at 7 for all
// four points.
//
//! lrm 4.5.4
//! analysis tran
//! time 0, 1n, 2n, 3n
//! print none
`include "check.vh"
module ch04_idt_reset_rejected(p, n);
    inout p, n;
    electrical p, n;
    analog begin
        `CHECKX("assert held nonzero pins idt at its ic", idt(1e9, 7.0, 1.0), 7.0);
        V(p, n) <+ idt(I(p, n), 0.0, 1.0);
    end
endmodule
