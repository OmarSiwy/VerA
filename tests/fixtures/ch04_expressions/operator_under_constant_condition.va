// LRM 4.5.15, verbatim, with the carve-out that the rest of the family only
// ever tests from the outside: "Analog operators shall not be used inside
// conditional (if, case, or ?:) statements UNLESS the conditional expression
// controlling the statement consists of terms which can not change their value
// during the course of a simulation."
//
// 36 and 88..93 are all rejects. This is the LEGAL side, and it is the only
// thing in the chapter that can catch OVER-rejection — a compiler that refuses
// every analog operator under every conditional satisfies all seven rejects and
// still cannot compile a device with a `parameter`-selected filter, which is
// most compact models.
//
// `use_filter` is a parameter: 3.4 makes it fixed for the whole simulation, so
// each `if`/`case`/`?:` below is controlled by terms that cannot change. The
// `analysis("dc")` guard is the other legal form — 4.6.1 makes an analysis
// function call constant for the duration of one analysis.
//
// Every want comes from 4.5.8's DC rule: "In DC analysis, transition() passes
// the value of the expr directly to its output." So at V(p,n) = 1.5 each
// guarded branch is that same 1.5, and each assertion is unconditional and
// outside the conditional it is checking.
//
//! lrm 4.5.15
//! lrm 4.5.15:1
//! bias V(p) = 1.5
//! analysis dc
//! print none
`include "check.vh"
module ch04_operator_under_constant_condition(p, n);
    inout p, n;
    electrical p, n;
    parameter integer use_filter = 1;
    real by_if, by_case, by_ternary, by_analysis;

    analog begin
        if (use_filter)
            by_if = transition(V(p, n), 0, 1n);
        else
            by_if = 0.0;

        case (use_filter)
            1: by_case = transition(V(p, n), 0, 1n);
            default: by_case = 0.0;
        endcase

        by_ternary = use_filter ? transition(V(p, n), 0, 1n) : 0.0;

        if (analysis("dc"))
            by_analysis = transition(V(p, n), 0, 1n);
        else
            by_analysis = 0.0;

        `CHECKX("analog operator under a parameter-guarded if", by_if, 1.5);
        `CHECKX("analog operator under a parameter-guarded case", by_case, 1.5);
        `CHECKX("analog operator under a parameter-guarded ?:", by_ternary, 1.5);
        `CHECKX("analog operator under an analysis() guard", by_analysis, 1.5);

        I(p, n) <+ by_if;
    end
endmodule
