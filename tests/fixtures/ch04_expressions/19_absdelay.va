// §4.5.7 absolute transport delay. The LRM gives the time-domain behaviour as a
// formula rather than a filter shape:
//
//   Output(t) = Input(max(t - td, 0))
//
// and "In DC and operating point analyses, absdelay() returns the value of its
// input", which is the t = 0 point below.
//
// The driven waveform is a 1 V/ns ramp sampled at every nanosecond, so the LRM
// formula with td = 2ns reads max(t/1ns - 2, 0). That closed form is written in
// $abstime and NOT in V(p,n): an oracle spelled with the same probe the
// operator is reading passes on any error common to both sides, which is the
// weaker CHECKEQ claim. Output minus the $abstime closed form is one literal
// want, 0.0, at every point:
//
//   t/ns    0    1    2    3    4    5
//   in      0    1    2    3    4    5
//   out     0    0    0    1    2    3
//
// A first-order lag substituted for the transport delay misses every point from
// t = 3ns on; a delay of the wrong length misses t = 3ns onward too.
//
// 4.5.7 gives the operator two shapes, `absdelay(input, td)` and
// `absdelay(input, td, maxdelay)`, and fixes what the second one adds: "If the
// optional maxdelay is specified, then td can vary. If td becomes greater than
// maxdelay, maxdelay will be used as a substitute for td." Here td is the
// constant 2ns and maxdelay is 5ns, so td never reaches the substitution and
// the three-argument form shall answer exactly what the two-argument form does
// — the same $abstime closed form, same literal want. The clamping half needs a
// td that varies with time and is not written here.
//
//! lrm 4.5.7
//! lrm 4.5.7:1002
//! bias V(n) = 0
//! wave V(p) = 0, 1, 2, 3, 4, 5
//! time 0, 1n, 2n, 3n, 4n, 5n
//! analysis tran
//! print none
`include "check.vh"
module ch04_absdelay(p, n);
    inout p, n;
    electrical p, n;

    analog begin
        `CHECK("output(t) == input(max(t - 2ns, 0))",
               absdelay(V(p, n), 2n) - max($abstime * 1e9 - 2.0, 0.0), 0.0, 1e-12);
        `CHECK("a maxdelay wider than td changes nothing",
               absdelay(V(p, n), 2n, 5n) - max($abstime * 1e9 - 2.0, 0.0), 0.0, 1e-12);
        // The delay is transport, not attenuation: on a rising ramp the delayed
        // value can never lead the input.
        `CHECKI("a delayed rising ramp never leads its input",
                absdelay(V(p, n), 2n) <= V(p, n), 1);

        V(p, n) <+ absdelay(I(p, n), 1n);
    end
endmodule
