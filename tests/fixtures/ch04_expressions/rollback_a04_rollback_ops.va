// The device under test for a04_rollback_rollback_host.zig beside it.
//
// Deliberately minimal: one slew filter whose limit is always active, so every
// expected number in the host test is an exact multiple of the slew step with
// no integration-rule freedom left anywhere. The operator keeps its history in
// the device (`<n>__prev`), which is what a rejected step has to put back.
// idt and ddt keep no device history: they are host unknowns (§4.5.2), whose
// history is the host integrator's to revert.
//
//   §4.5.9 "slew() forces all transitions of expr faster than
//   max_pos_slew_rate to change at max_pos_slew_rate rate"; "In DC analysis,
//   slew() simply passes the value of the destination to its output."
//
// V(p,n) is driven at 1 V/ns, twice the 0.5 V/ns limit, so the output rises at
// exactly the limit after the DC point. The contribution is scaled by 1e-3 so
// the host reads the operator from one residual row: f[p] = 1e-3 · slew.
//
// WHAT THE HOST OWNS AND WHAT THIS FILE OWNS. The ROLLBACK behaviour — eval,
// updateState, stateCtl(.revert), eval again — is a sequence of host calls the
// `//!` directive language cannot express, so it stays in the host driver
// beside this file. What the host CANNOT do without this file first being
// right is distinguish "the revert was dropped" from "the operator was never
// correct on an accepted step at all", so the accepted-step half of its table
// is asserted here.
//
//   t       slew(V(p,n), 0.5e9)
//   0       0.0   §4.5.9 DC passes the destination, V(p,n) = 0
//   1ns     0.5   0 + 0.5e9 V/s · 1ns
//   2ns     1.0   0.5 + 0.5e9 V/s · 1ns
//
// so the want is `$abstime * 0.5e9` volts.
//
//! lrm 4.5.9
//! time 0, 1n, 2n
//! wave V(p) = 0.0, 1.0, 2.0
//! bias V(n) = 0.0
`include "check.vh"
module a04_rollback_ops(p, n);
    inout p, n;
    electrical p, n;

    real out;

    analog begin
        out = slew(V(p, n), 0.5e9);

        `CHECK("the slew-limited ramp rises 0.5 V per nanosecond",
            out, $abstime * 0.5e9, 1e-12);

        I(p, n) <+ 1e-3 * out;
    end
endmodule
