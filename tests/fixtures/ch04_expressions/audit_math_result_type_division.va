// AMS 4.3.1: integer min/max/abs return integer; mixed min/max return real.
// 4.2.4 integer division truncates: integer 3/2 gives 1, real 3.0/2 gives
// 1.5. Observe the quotient directly, before assignment to an integer could
// hide an incorrect real result. System-style counterparts are isolated in
// audit_system_math_result_type_division.va so their failures do not mask this.
//! lrm 4.3.1
//! lrm 4.3.1:1001
//! lrm 4.2.4
//! checks 6
`include "check.vh"
module audit_math_result_type_division(p);
    inout p;
    electrical p;
    analog begin
        `CHECKX("integer min quotient", min(3, 5) / 2, 1.0);
        `CHECKX("integer max quotient", max(1, 3) / 2, 1.0);
        `CHECKX("integer abs quotient", abs(-3) / 2, 1.0);
        `CHECKX("mixed min quotient", min(3, 5.0) / 2, 1.5);
        `CHECKX("mixed max quotient", max(1.0, 3) / 2, 1.5);
        `CHECKX("real abs quotient", abs(-3.0) / 2, 1.5);
        I(p) <+ V(p);
    end
endmodule
