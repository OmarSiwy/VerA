// §4.3.1 Table 4-14 and §4.3.2 Table 4-15 give every function an "Equivalent C
// function" (log10, asin, acos, atan2, asinh, acosh, atanh). Until #60 the
// run-time kernels were the textbook formulas instead (log as ln·0.4343, acos
// as pi/2 - asin, asinh as ln(x + sqrt(x² + 1)), ...), which lose digits where
// the C functions do not, while the constant folder already used the C ones:
// the same expression folded and at run time gave different answers. Every
// argument here is `z + c` with z = V(p) = 0 (`nz` = -V(p) = -0.0), so each is
// computed at run time.
//
// The wants, from mpmath at 50 digits, rounded to the nearest double:
//   asinh(-1e8)        = -19.11382792451231080...   was -inf (x + sqrt(x²+1) = 0)
//   asinh(1e300)       = 691.46867507877365057...   was +inf (x² overflows)
//   acosh(1e300)       = 691.46867507877365057...   was +inf
//   asinh(1e-10)       = 1.0000000000000000364e-10  was off by 1e-7 relative
//   atanh(1e-10)       = 1.0000000000000000364e-10  was off by 1e-7 relative
//   acos(0.9999999999) = 1.414213620891156364e-05   was off by 2e-11 relative
//   acosh(1.0000000001) = 1.414213620867586135e-05
//   log(1e15)          = 15, exact in C log10       was 14.999999999999998, so
//                                                   floor(log(1e15)) was 14
// RTOL 4e-16 is two ulp at every one of these magnitudes (one ulp is 1.2e-16
// to 1.9e-16 relative there), the bound VerA's functions are measured to
// (specification/Vague_Decisions.md VD-123); the old kernels miss by 1e-7 or
// more.
//
// atan2, Table 4-15 "All x, all y; atan2(0,0) = 0", C atan2 (C99 F.10.1.4):
//   atan2(-0, -1) = -pi and atan2(+0, -0) = +pi (both were +pi and 0: the old
//   kernel tested y >= 0, which -0 passes, and returned 0 on the y axis);
//   atan2(+0, +0) = 0, the clause's own case. Exact doubles, so CHECKX.
// Its derivative, d atan2(y, x) = (x dy - y dx)/(x² + y²): at x = 0, y = 1,
// d/dx = -1 and d/dy = 0, exactly (the old kernel gave d/dx = 0 there).
//
// The other derivatives, analytic, at points away from every pole, from
// mpmath; RTOL 5e-16 (a slope is one or two more roundings than a value):
//   d asinh(x)/dx at 0.5  = 1/sqrt(1.25)  = 0.89442719099991587856...
//   d asinh(x)/dx at 1e300 = 1e-300 (1/sqrt(x² + 1) taken as 1/|x|; x² overflows)
//   d acosh(x)/dx at 2    = 1/sqrt(3)     = 0.57735026918962576450...
//   d atanh(x)/dx at 0.5  = 1/0.75        = 1.33333333333333333333...
//   d asin(x)/dx at 0.5   = 1/sqrt(0.75)  = 1.15470053837925152901...
//   d log(x)/dx at 2      = 1/(2 ln 10)   = 0.21714724095162591382...
//
// Last, the fold: the same calls on constants fold at compile time, with the
// same function (§9.14: `$asinh` and `asinh` are one function), so each is
// CHECKEQ, tolerance 0, against its run-time twin: bit for bit.
//
//! lrm 4.3.1
//! lrm 4.3.2
//! lrm 4.3.2:1002
//! bias V(p) = 0, V(n) = 0
//! checks 24
//! print none
`include "check.vh"
module c_math_values_at_run_time(p, n);
    inout p, n;
    electrical p, n;
    real z, nz;
    analog begin
        z = V(p);
        nz = -V(p);
        `CHECKR("asinh(-1e8)", asinh(z - 1e8), -19.11382792451231, 4e-16);
        `CHECKR("asinh(1e300)", asinh(z + 1e300), 691.4686750787737, 4e-16);
        `CHECKR("acosh(1e300)", acosh(z + 1e300), 691.4686750787737, 4e-16);
        `CHECKR("asinh(1e-10)", asinh(z + 1e-10), 1e-10, 4e-16);
        `CHECKR("atanh(1e-10)", atanh(z + 1e-10), 1e-10, 4e-16);
        `CHECKR("acos(0.9999999999)", acos(z + 0.9999999999), 1.4142136208911564e-05, 4e-16);
        `CHECKR("acosh(1.0000000001)", acosh(z + 1.0000000001), 1.4142136208675862e-05, 4e-16);
        `CHECKX("log(1e15) is C log10, exact", log(z + 1e15), 15.0);
        `CHECKX("floor(log(1e15))", floor(log(z + 1e15)), 15.0);
        `CHECKX("atan2(-0, -1)", atan2(nz, z - 1.0), -3.141592653589793);
        `CHECKX("atan2(+0, -0)", atan2(z, nz), 3.141592653589793);
        `CHECKX("atan2(0, 0) = 0", atan2(z, z), 0.0);
        `CHECKX("d atan2(y, x)/dx at x = 0, y = 1", ddx(atan2(V(p) + 1.0, V(n)), V(n)), -1.0);
        `CHECKX("d atan2(y, x)/dy at x = 0, y = 1", ddx(atan2(V(p) + 1.0, V(n)), V(p)), 0.0);
        `CHECKR("d asinh/dx at 0.5", ddx(asinh(V(p) + 0.5), V(p)), 0.8944271909999159, 5e-16);
        // Absolute 5e-16 * 1e-300: CHECKR floors its denominator at 1e-30, which
        // would make a relative 5e-16 an absolute 5e-46, blind at 1e-300.
        `CHECK("d asinh/dx at 1e300", ddx(asinh(V(p) + 1e300), V(p)), 1e-300, 5e-316);
        `CHECKR("d acosh/dx at 2", ddx(acosh(V(p) + 2.0), V(p)), 0.5773502691896257, 5e-16);
        `CHECKR("d atanh/dx at 0.5", ddx(atanh(V(p) + 0.5), V(p)), 1.3333333333333333, 5e-16);
        `CHECKR("d asin/dx at 0.5", ddx(asin(V(p) + 0.5), V(p)), 1.1547005383792515, 5e-16);
        `CHECKR("d log/dx at 2", ddx(log(V(p) + 2.0), V(p)), 0.2171472409516259, 5e-16);
        `CHECKEQ("asinh(-1e8) folds to its run-time bits", asinh(z - 1e8), asinh(-1e8), 0.0);
        `CHECKEQ("acosh(1e300) folds to its run-time bits", acosh(z + 1e300), acosh(1e300), 0.0);
        `CHECKEQ("log(1e15) folds to its run-time bits", log(z + 1e15), log(1e15), 0.0);
        `CHECKEQ("atan2(-0, -1) folds to its run-time bits", atan2(nz, z - 1.0), atan2(-0.0, -1.0), 0.0);
        I(p, n) <+ V(p, n);
    end
endmodule
