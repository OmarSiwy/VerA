// §4.3.1 Table 4-14: `ceil(x)` is C `ceil` — the smallest integer >= x, for all
// x. The bias picks 2.3, which separates ceil from the other two ways a real
// becomes whole: §4.2.1.1 real-to-integer rounds to NEAREST (2) and truncation
// toward zero also gives 2; only ceil goes up to 3. Exact small integer, so
// equality is exact.
//
//! lrm 4.3.1
//! bias V(p) = 2.3
`include "check.vh"
module ch04_ceil(p, n);
  inout p, n;
  electrical p, n;
  analog begin
    `CHECKX("ceil(2.3) rounds up, not to nearest", ceil(V(p, n)), 3.0);
    I(p, n) <+ ceil(V(p, n));
  end
endmodule
