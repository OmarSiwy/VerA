// §4.5.11.3 (laplace_np): "If a pole is complex, its conjugate shall also be
// present." With the poles in a parameter array the card decides whether
// they pair, so the rule cannot be checked when the model compiles: VerA
// pairs them as the model is evaluated (`zRootSecs`), and a complex pole with
// no conjugate within 1e-9 relative is a pole vector §4.5.11.3 does not
// define. VerA then makes every coefficient of the cascade NaN, so the
// filter's output is NaN (specification/Vague_Decisions.md, AMS 4.5.11 runtime roots):
// a wrong-but-finite filter (the pole dropped, or paired with a neighbour)
// would look like an answer.
//
// THE NUMBERS. The default card has −1 + j and −1 − 2j: neither is the
// other's conjugate, so y is NaN at the operating point and in a transient.
// The legal neighbour is ok_pair, the same declaration with the conjugate
// −1 − j; laplace_np H(0) = num/∏(1) = 2, so it reads 2·V(in) = 1.
//
//! lrm 4.5.11.3
//! bias V(in) = 0.5
//! bias V(n) = 0
//! time 0, 1, 2
//! analysis tran
//! checks 6
`include "check.vh"
module laplace_np_parameter_roots_unpaired_is_nan(in, n);
  inout in, n;
  electrical in, n;
  parameter real bad[0:3] = '{-1.0, 1.0, -1.0, -2.0};
  parameter real ok_pair[0:3] = '{-1.0, 1.0, -1.0, -1.0};
  real y, yk;
  analog begin
    y = laplace_np(V(in, n), '{2.0}, bad);
    yk = laplace_np(V(in, n), '{2.0}, ok_pair);
    `CHECKI("an unpaired run-time pole makes the output NaN", y != y, 1);
    `CHECK("the paired neighbour holds its H(0) = 2", yk, 1.0, 1e-12);
    I(in, n) <+ 0.0;
  end
endmodule
