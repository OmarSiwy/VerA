// §4.7 a user-defined analog function, and §4.4.3 the conditional operator it
// is built from. `max_value` is max() written by hand, so its value is fixed by
// arithmetic alone.
//
// The bias makes both arms reachable in one operating point: with
// V(p,n) = -0.5 the call in the contribution must select the SECOND argument
// (0.0, not -0.5 — a function lowered as "return the first argument" fails
// there), while max_value(V(p,n) + 1.5, 0.0) must select the FIRST (1.0).
// The tie case pins the operator as a strict `>`: 4 > 4 is false, so the second
// argument is returned.
//
//! bias V(p) = -0.5
//! bias V(n) = 0.0
`include "check.vh"
module ch04_user_function(p, n);
    inout p, n;
    electrical p, n;
    real clamped;

    analog function real max_value;
        input real first, second;
        begin
            max_value = first > second ? first : second;
        end
    endfunction

    analog begin
        clamped = max_value(V(p, n), 0.0);

        `CHECKX("second argument wins", max_value(3.0, 5.0), 5.0);
        `CHECKX("first argument wins", max_value(-2.0, -7.0), -2.0);
        `CHECKX("a tie falls to the second argument", max_value(4.0, 4.0), 4.0);
        `CHECKX("a negative signal is clamped to the constant", clamped, 0.0);
        `CHECKX("a positive signal passes through", max_value(V(p, n) + 1.5, 0.0), 1.0);

        I(p, n) <+ clamped;
    end
endmodule
