// §4.5.5 the circular integrator with a NONZERO OFFSET and a NEGATIVE
// integrand — the corner where the wrap has to subtract a negative multiple of
// the modulus. ch04_expressions/17 and exhaustive/068 both integrate upward
// from zero with offset 0, where floor((y−offset)/modulus) is never negative
// and the sign handling is untested.
//
//   Table 4-19: "idtmod(expr,ic,modulus,offset) — Returns k, where
//    offset ≤ k < offset + modulus, k is ∫t0..t x(τ)dτ + c = n × modulus + k,
//    and c is the value of ic at t0."
//   "The output of the idtmod() function shall remain in the range
//    offset <= idtmod < offset+modulus"
//   "The default for offset shall be zero (0)."
//   "The following relationship between idt() and idtmod() shall hold at all
//    times. If y = idt(expr, ic); z = idtmod(expr, ic, modulus, offset); then
//    y = n * modulus + z;    // n is an integer
//    where offset ≤ z < modulus + offset"
//
// THE HAND DERIVATION. expr = −1e9 (so the raw integral loses exactly 1.0 per
// nanosecond), ic = 0, modulus = 2, offset = −1, i.e. the output window is
// [−1, +1). The raw integral is y = −t/1ns, and z is y brought into that
// window by subtracting an integer multiple of 2:
//
//   t/ns     0     1     2     3     4
//   y        0    -1    -2    -3    -4
//   n        0     0    -1    -1    -2
//   z        0    -1     0    -1     0
//
// Read off the table: at t = 1ns the raw integral is exactly −1, which is the
// CLOSED end of the window, so z = −1 and not +1. At t = 2ns the window has to
// be re-entered from below — n = −1, i.e. +modulus is ADDED — which is the
// case a wrap written as `y − modulus*floor(y/modulus)` with the offset
// forgotten gets wrong (it answers −2 − 2*floor(−1) = 0 by luck here, but at a
// non-integer crossing it answers +1.5 where the correct offset-aware wrap
// answers −0.5 — for y = −2.5, `y − 2*floor((y+1)/2)` = −2.5 − 2*(−1) = −0.5,
// while `y − 2*floor(y/2)` = −2.5 − 2*(−2) = +1.5. So the third check below
// samples the half-step too).
//
// Every z above lies in [−1, 1) as the clause requires, and y − z is an even
// integer at every point, which is the y = n*modulus + z identity written as a
// number a fixture can assert.
//
//! lrm 4.5.5
//! lrm 4.5.5:3
//! lrm 4.5.5:5
//! lrm 4.5.5:6
//! bias V(p) = 0
//! bias V(n) = 0
//! time 0, 0.5n, 1n, 1.5n, 2n, 2.5n, 3n, 3.5n, 4n
//! analysis tran
//! print none
`include "check.vh"
module a04_idtmod_offset(p, n);
    inout p, n;
    electrical p, n;
    real y, z;

    analog begin
        y = idt(-1e9, 0.0);
        z = idtmod(-1e9, 0.0, 2.0, -1.0);

        // The raw integral is the reference the clause writes the relation
        // against, and it is exact for a constant integrand under any
        // consistent integration rule: -1.0 per nanosecond.
        `CHECKEQ("idt of a constant is exact", y, -($abstime * 1e9), 1e-12);
        // §4.5.5's own window, as a literal pair of bounds.
        `CHECKI("offset <= idtmod < offset + modulus", (z >= -1.0) && (z < 1.0), 1);
        // The identity, as a number: (y - z)/modulus shall be an integer.
        `CHECK("y - z is an integer multiple of the modulus",
               (y - z) / 2.0 - floor((y - z) / 2.0 + 0.5), 0.0, 1e-12);
        // And the wrapped value itself, from the table above, written as the
        // clause's definition z = y - modulus*floor((y - offset)/modulus) with
        // the hand-computed constants substituted.
        `CHECKEQ("the wrapped integral re-enters the window from below",
                 z, -($abstime * 1e9) - 2.0 * floor((-($abstime * 1e9) + 1.0) / 2.0), 1e-12);

        I(p, n) <+ 0.0;
    end
endmodule
