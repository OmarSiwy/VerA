// §4.6.4.3 the ARRAY PARAMETER form of noise_table.
//
// "When the input is a vector it contains pairs of real numbers: the first
// number in each pair is the frequency in Hertz and the second is the power.
// The vector can either be specified as AN ARRAY PARAMETER or an array
// assignment pattern."
//
// A.8.2 says the same thing in grammar:
//
//     noise_table_input_arg ::=
//           parameter_identifier
//         | parameter_identifier [ msb_constant_expression : lsb_constant_expression ]
//         | string
//         | constant_assignment_pattern
//
// Three of those four spellings were refused by VerA when this file was
// written (E0519 covered the parameter and the file; only the assignment
// pattern compiled), and the parameter form is the one the clause names FIRST.
// It is also the form a process design kit uses, because a table that lives in
// a parameter is a table a model card can replace per corner without
// recompiling the model.
//
// THE EXPORT. The declared default is
//
//     '{1.0, 1e-18, 1e3, 1e-21, 1e6, 1e-24}
//
// i.e. three knots — (1 Hz, 1e-18), (1 kHz, 1e-21), (1 MHz, 1e-24) — with
// `.interp = .linear` (§4.6.4.3, not .4). The powers drop by 1e-3 per three
// decades on purpose: that is a slope of exactly −1 per decade on a log-log
// plot, so the same knots under §4.6.4.4's rule would be a straight 1/f line,
// and any confusion between the two clauses shows up as a different table mode
// rather than as numbers that happen to agree.
//
// The MODEL-CARD OVERRIDE is deliberately not exercised: the harness's `//!
// param` line binds scalars only, so this fixture pins the declared default
// reaching the export. That is already the whole gap — E0519's own explain text
// used to say the parameter form was refused "rather than frozen at its
// default, which a model card may override", so a compiler that closed this
// fixture by folding the default would only have moved the problem to the
// override, which a later fixture (and a vector-valued `//! param`) has to
// catch.
//
// FIXED 2026-09-20, and NOT by folding. `noise_tables` carries the declared
// defaults this file pins — that is what a comptime array can hold — and a
// `noiseTablePoints(model)` hook beside it carries the card's own knots, which
// `contract.validateHost` makes a linking host declare it reads. So the
// override is REPRESENTABLE; it is still untested here, for the `//! param`
// reason above, and the later fixture is still owed.
//
// The second half of the module is a plain resistor so the branch has a dc
// current to check; the tabulated generator sits on the same branch.
//
//! lrm 4.6.4.3
//! noise table(p,n)#0 name=tbl interp=linear points=1.0:1e-18,1000.0:1e-21,1000000.0:1e-24
//! analysis noise
//! bias V(p) = 1.0
//! bias V(n) = 0.0
`include "check.vh"
module a06_noise_table_array_parameter(p, n);
    inout p, n;
    electrical p, n;
    parameter real R = 1000.0 from (0:inf);
    parameter real tbl[0:5] = '{1.0, 1e-18, 1e3, 1e-21, 1e6, 1e-24};

    analog begin
        `CHECKR("the knots fall a decade in power per decade in frequency",
            tbl[1] / tbl[3], 1000.0, 1e-12);
        `CHECKR("the dc current is the resistive term alone", V(p, n) / R, 1e-3, 1e-15);

        I(p, n) <+ V(p, n) / R + noise_table(tbl, "tbl");
    end
endmodule
