// LRM 4.2.4 has exactly one zero rule, verbatim: "It shall be an error to pass
// zero (0) as the second argument to the modulus operator." It is an error
// when the divisor IS zero, and says nothing about `/`. A divisor that is a
// parameter, whose value arrives with the model card, is therefore legal
// source: 111_modulus_by_zero_rejected.va and
// audit_real_modulus_zero_rejected.va are the cases where it IS zero.
//
// Two rows, both digits from the clause itself:
//   - "Integer division truncates any fractional part toward zero (0)":
//     k = 4, so 10 / k = 2.5 truncated = 2.
//   - Table 4-6, row five: "10 % 3.75   2.5". With r = 3.75 as a parameter,
//     10.0 % r is that row with the divisor unknown at compile time.
// VerA used to refuse both with E0601 ("cannot be proven non-zero"). It now
// accepts both and warns W0653 on `10 / k`: were k zero at run time the
// device would yield 0, a value the LRM does not give (IEEE 1364 §5.1.5's
// `x` has no analog integer). The harness cannot expect a warning in an
// analog fixture; lib/ir/proof/test.zig pins W0653.
//
//! lrm 4.2.4
//! lrm 4.2.4:1
`include "check.vh"
module ch04_divisor_unproven_accepted(p, n);
    inout p, n;
    electrical p, n;
    parameter integer k = 4;
    parameter real r = 3.75;
    integer q;
    real m;

    analog begin
        q = 10 / k;
        m = 10.0 % r;
        `CHECKI("4.2.4: 10 / k with k = 4 truncates toward zero", q, 2);
        `CHECK("Table 4-6: 10 % 3.75 with the divisor a parameter", m, 2.5, 1e-12);
        I(p, n) <+ q + m;
    end
endmodule
