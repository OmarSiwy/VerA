// §4.6.4.3 noise_table — the piecewise PSD, and the export that carries it.
//
//     noise_table ( input [ , name ] )
//
// "The noise_table() function interpolates a set of values to model a process
// where the spectral density of the noise varies as a piecewise linear function
// of frequency." Every word of that is about frequency, and a dc point has
// none: §4.6 makes the source read zero here, so the model's own text can only
// assert the zero. What distinguishes this clause — that the PSD is a TABLE and
// not 4kT·g and not kf/f^ef — survives into the device only as a `table` row in
// §4.6.4's generator table plus the table itself, and `//! noise` is what reads
// the row.
//
// The pairs are written OUT OF ORDER on purpose. The clause says "Although the
// user is encouraged to specify each noise pair in order of ascending
// frequency, the simulator shall internally sort the pairs into ascending
// frequency if required" — so a descending vector is legal input and sorting it
// is the compiler's job, not the host's. This fixture is the one that fails if
// that sentence is ever dropped: an unsorted table reaches the host as a
// spectrum that jumps backwards in frequency, and no interpolation over it
// means anything.
//
//! lrm 4.6.4.3
//! lrm 4.6.4.3:5
//! lrm 4.6.2
//! noise table(p,n)#0
//! analysis dc
//! bias V(p) = 1.0
//! bias V(n) = 0.0
`include "check.vh"
module ch04_noise_table_topology(p, n);
    inout p, n;
    electrical p, n;
    parameter real R = 1000.0 from (0:inf);

    analog begin
        I(p, n) <+ V(p, n)/R +
            noise_table('{1e6, 1.0e-24, 1.0, 1.0e-18, 1e3, 1.0e-21}, "tbl");
        `CHECKX("the dc current is the resistive term alone", V(p,n)/R, 1e-3);
        `CHECKX("noise_table is inactive outside a small-signal analysis",
            noise_table('{1.0, 1.0e-18, 1e6, 1.0e-24}), 0.0);
    end
endmodule
