// LRM 4.2.9 Table 4-12: `~^` (spelled `^~` too) is the bit-wise exclusive nor —
// a result bit is 1 exactly when the two source bits AGREE. It is complemented
// over the FULL width, and LRM 3.2 makes an integer a 32-bit 2's complement
// value ("-2**31 to 2**31-1", "arithmetic operations [...] produce 2's
// complement results"), so the leading agreeing bits all come back as ones:
//
//   5     = 0000...0101
//   3     = 0000...0011
//   5 ^ 3 = 0000...0110 = 6
//   5 ~^ 3 = ~6 = 1111...1001 = 0xFFFFFFF9 = -7
//
// A 4-bit or unsigned reading would give +9; only the 32-bit signed one gives
// -7. The second line checks the alternate spelling is the same operator.
//
//! lrm 4.2.9
//! lrm 4.2.9:1001
`include "check.vh"
module ch04_bitwise_xnor(p, n);
    inout p, n;
    electrical p, n;
    integer a;

    analog begin
        a = 5 ~^ 3;
        `CHECKI("5 ~^ 3 = ~(0110) over 32 bits = -7", a, -7);
        `CHECKI("^~ is the same operator as ~^", (5 ^~ 3), -7);
        I(p, n) <+ a;
    end
endmodule
