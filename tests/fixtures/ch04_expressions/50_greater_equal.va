// §4.2.5: a relational expression "yields the value zero (0) if the specified
// relation is false or the value one (1) if it is true". The bias sits exactly
// ON the boundary, which is the only place `>=` differs from `>`: 1.0 >= 1.0 is
// TRUE, so the value is the integer 1. Below the boundary it is 0.
//
//! lrm 4.2.5
//! lrm 4.2.5:1000
//! bias V(p) = 1.0
`include "check.vh"
module ch04_greater_equal(p, n);
    inout p, n;
    electrical p, n;
    analog begin
        `CHECKI("1.0 >= 1.0 is true", V(p, n) >= 1.0, 1);
        `CHECKI("0.5 >= 1.0 is false", V(p, n) - 0.5 >= 1.0, 0);
        I(p, n) <+ (V(p, n) >= 1.0);
    end
endmodule
