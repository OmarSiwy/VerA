// max() (LRM 4.3.1 Table 4-14): "max(x,y) is equivalent to (x > y) ? x : y",
// all x, all y, with the same integer/real result typing as min().
`include "check.vh"
//! lrm 4.3.1
//! bias V(p) = 2.5
module ch04_max(p, n);
  inout p, n; electrical p, n;
  analog begin
    I(p, n) <+ max(V(p, n), 1.0);
    // 2.5 vs 1.0 — the first operand wins.
    `CHECKX("max picks the larger (x)", max(V(p, n), 1.0), 2.5);
    // -2.5 vs 1.0 — the second operand wins, so both arms are exercised.
    `CHECKX("max picks the larger (y)", max(-V(p, n), 1.0), 1.0);
    // max is not abs: it does not fold the sign, it only compares.
    `CHECKX("max(-2.5, -4) = -2.5", max(-V(p, n), -4.0), -2.5);
    // Two integer operands keep an integer result.
    `CHECKI("max of two integers is integer", max(-7, 3), 3);
  end
endmodule
