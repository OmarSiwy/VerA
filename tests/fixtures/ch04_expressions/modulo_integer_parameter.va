// AMS §4.2.4 permits a parameter divisor with no range proof. With the host
// override divisor=4, 11 % 4=3. §6.3.4 updates the dependent default too.
// The other parameter's default would divide by zero at zero_divisor=0,
// but the host supplies its value 5, so that default is not evaluated.
// This is a legal neighbour to 111_modulus_by_zero_rejected.va; it also keeps
// a model-card default out of the procedural runtime-error effect chain.
//! lrm 4.2.4
//! lrm 6.3.4
//! lrm 6.3.4:1000
//! param divisor=4
//! param overridden=5
//! checks 3
`include "check.vh"
module modulo_integer_parameter(p, n);
  inout p, n; electrical p, n;
  parameter integer divisor=3;
  parameter integer derived=11 % divisor;
  parameter integer zero_divisor=0;
  parameter integer overridden=11 % zero_divisor;
  analog begin
    `CHECKI("procedural host divisor", 11 % divisor, 3);
    `CHECKI("dependent default follows host divisor", derived, 3);
    `CHECKI("explicitly supplied parameter skips default", overridden, 5);
    I(p,n) <+ V(p,n);
  end
endmodule
