// §4.7.2.1: "An analog user-defined function shall always return a scalar
// value, either numeric or string based on the type specified for the analog
// user-defined function."
//
// A.2.6 makes that a grammar fact: analog_function_type is one of integer,
// real or string, with no range. `analog function real [0:1] f;` asks for a
// two-element return and is therefore not derivable.
//
// This is the minimal source in which the range is the ONLY thing wrong. The
// parser stops at the `[` with E0208; recoverStatement consumes the rest of
// that declaration's line at the `;`, and `endmodule` follows, so no recovery
// diagnostic is added. The existing reject_4_7_2_1_analog_function_with_range
// fixture keeps the full function body for readability; this sibling is what
// pins that E0208 is the refusal, alone.
//
// The legal neighbour is 28_user_function.va, the same scalar function
// declared without a range.
//
//! lrm 4.7.2.1
//! lrm 4.7.2.1:1
//! reject-only E0208
//! neighbour 28_user_function.va
`include "disciplines.vams"
module ch4_analog_function_range_only_error(p, n);
  inout p, n;
  electrical p, n;

  analog function real [0:1] f;
endmodule
