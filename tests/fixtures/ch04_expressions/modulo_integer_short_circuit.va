// AMS §4.2.3 says runtime errors in a short-circuited operand "shall not
// occur". §4.2.4 makes a zero modulus divisor an error only if evaluated.
// Both sweep points are legal: d=0 takes the guard's other arm; d=3 gives
// 11 % 3=2. The six assertions run at each point. The unused guarded
// assignment also checks that preserving its error does not unguard it.
// modulo_integer_unused_zero.va executes that assignment at d=0 and fails.
//! lrm 4.2.3
//! lrm 4.2.4
//! lrm 4.2.3:4
//! sweep V(p) = 0, 3
//! checks 12
`include "check.vh"
module modulo_integer_short_circuit(p, n);
  inout p, n; electrical p, n;
  integer d, unused;
  analog begin
    d = V(p,n);
    if (d != 0) unused = 11 % d;
    if (d == 0) begin
      `CHECKI("and skips zero divisor", d != 0 && 11 % d == 2, 0);
      `CHECKI("conditional skips then operand", d != 0 ? 11 % d : 99, 99);
      `CHECKI("conditional skips else operand", d == 0 ? 99 : 11 % d, 99);
    end else begin
      `CHECKI("and evaluates nonzero divisor", d != 0 && 11 % d == 2, 1);
      `CHECKI("conditional evaluates then operand", d != 0 ? 11 % d : 99, 2);
      `CHECKI("conditional evaluates else operand", d == 0 ? 99 : 11 % d, 2);
    end
    `CHECKI("or skips zero divisor", d == 0 || 11 % d == 2, 1);
    `CHECKI("constant and skips literal invalid operand", 0 && 11 % 0, 0);
    `CHECKI("constant conditional skips literal invalid operand", 1 ? 7 : 11 % 0, 7);
    I(p,n) <+ V(p,n);
  end
endmodule
