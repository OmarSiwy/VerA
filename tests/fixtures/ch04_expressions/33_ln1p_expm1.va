// §4.3.1 Table 4-14: ln1p(x) is C `log1p` and expm1(x) is C `expm1`. ln1p() is
// defined only for x > -1 and expm1() overflows for large x; a node voltage is
// unbounded, so both are guarded.
//
// These two exist ONLY because ln(1+x) and exp(x)-1 lose the answer to
// cancellation near zero, so that is what is pinned here. At x = 1e-12:
//
//   log1p(1e-12) = 1e-12 - 5e-25 + ...  = 9.999999999995e-13
//   ln(1 + 1e-12) computed in double    = 1.000088900581841e-12
//
// — 1 + 1e-12 is not representable, and the rounding survives the log as an
// 8.9e-5 relative error. The 1e-10 tolerance below sits two orders inside that
// gap: correct log1p passes with 5e-13 to spare, ln(1+x) fails. expm1 is the
// same story with exp(x)-1.
//
// The ordinary-argument checks at the bias (0.5) are the sanity half:
//   ln1p(0.5)  = ln(1.5)     = 0.4054651081081644
//   expm1(0.5) = sqrt(e) - 1 = 0.6487212707001282
//
//! bias V(p) = 0.5
//! bias V(n) = 0.0
//! lrm 4.3.1
//! xfail VerA emits the cancelling forms: codegen.zig `zLn1p` is `a.addC(1.0).log()` and `zExpm1` is `a.exp().addC(-1.0)`, so ln1p(1e-12) returns 1.000088900581841e-12 and expm1(1e-12) returns 1.000088900582341e-12 — the 8.9e-5 error Table 4-14's C log1p/expm1 exist to avoid. ir/proof.zig:1791 already folds constants with std.math.expm1/log1p, so only the emitted device is wrong
`include "check.vh"
module ch04_ln1p_expm1(p, n);
  inout p, n; electrical p, n;

  analog begin
    `CHECKR("ln1p(0.5) is ln(1.5)", ln1p(V(p, n)), 0.4054651081081644, 1e-15);
    `CHECKR("expm1(0.5) is exp(0.5) - 1", expm1(V(p, n)), 0.6487212707001282, 1e-15);
    `CHECKR("ln1p keeps full precision where ln(1+x) cancels", ln1p(1e-12), 1e-12, 1e-10);
    `CHECKR("expm1 keeps full precision where exp(x)-1 cancels", expm1(1e-12), 1e-12, 1e-10);
    `CHECKX("ln1p(0) is exactly 0", ln1p(0.0), 0.0);
    `CHECKX("expm1(0) is exactly 0", expm1(0.0), 0.0);

    if (V(p, n) > -1.0)
      if (V(p, n) < 100.0)
        I(p, n) <+ ln1p(V(p, n)) + expm1(V(p, n));
  end
endmodule
