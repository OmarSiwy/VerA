// §4.5.4 idt() is integrated by the simulator's numerical integration process,
// so the host sees it as a charge site of its own and checks its truncation
// error.
//
//   §4.5.4 idt(expr,ic,assert,abstol): "the absolute tolerance used to control
//   the error in the numerical integration process is specified explicitly".
//
//   §4.5.2: "Occasionally, analog operators require new equations and new
//   unknowns be introduced by the simulator to convert a module description
//   into a set of first-order differential equations."
//
// So idt(x, ic) is one new unknown s and one new first-order equation,
// ds/dt = x, whose integration the simulator controls. §5.6.1.2 is how VerA
// hands a host a d/dt: a charge site (`q_stamps`, `q_lte`). The new unknown's
// row carries the charge s with sign +1, and the row's resistive half is -x.
//
// THE SITES, in source order. The unknowns are named `idt$0`, `idt$1` and
// print through the device's `U` spelling, where `$` is escaped to `Z24`:
//
//   0  V(o)  <+ idt(V(i), 0.0)                        idt$0 +   lte
//   1  (* vera_lte = 0 *) V(o2) <+ idt(V(i), 1.0)     idt$1 +   nolte
//
// The statement prefix leaves the second out of the truncation check, as it
// does for a ddt charge (charge_sites_lte_attribute.va).
//
// The DC values are the §4.5.4 initial conditions, "When used in DC or IC
// analyses, idt() returns the initial condition (ic) if specified": 0 and 1.
//
//! lrm 4.5.4
//! lrm 5.6.1.2
//! bias V(i) = 0.75
//! solve
//! print none
//! qsite idtZ240+ lte
//! qsite idtZ241+ nolte
//! xfail C1: idt integrates inside the device, so the host sees no charge site for it
`include "check.vh"
module idt_is_a_charge_site(i, o, o2);
    inout i, o, o2;
    electrical i, o, o2;

    analog begin
        V(o) <+ idt(V(i), 0.0);
        (* vera_lte = 0 *) V(o2) <+ idt(V(i), 1.0);
        `CHECKX("idt(x, 0) is its ic in DC", V(o), 0.0);
        `CHECKX("idt(x, 1) is its ic in DC", V(o2), 1.0);
    end
endmodule
