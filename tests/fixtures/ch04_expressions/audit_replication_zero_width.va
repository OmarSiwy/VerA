// AMS 4.2.13: a legal zero replication has zero width. Put it between
// nonzero prefix and suffix so an erroneous extra zero bit changes the value:
// correct {1, empty, 0101} is binary 10101 = 21; one extra zero gives 37.
// All operands are explicitly sized, and both siblings have positive size.
// Evaluation side effects are isolated in audit_replication_zero_effect.va.
//! lrm 4.2.13
//! lrm 4.2.13:4
//! checks 1
`include "check.vh"
module audit_replication_zero_width(p, n);
    inout p, n;
    electrical p, n;
    integer value;
    analog begin
        value = {1'b1, {0{1'b0}}, 4'b0101};
        `CHECKI("zero replication contributes no middle bit", value, 21);
        I(p,n) <+ V(p,n);
    end
endmodule
