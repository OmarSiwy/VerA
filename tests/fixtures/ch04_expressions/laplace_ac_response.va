// §4.5.11 the Laplace filters in a small-signal analysis. The clause defines
// each filter by its transfer function, H(s) = Σ n_k s^k / Σ d_k s^k for
// §4.5.11.4 laplace_nd and
//
//   H(s) = ∏ (1 − s/(ζ_kr + jζ_ki)) / ∏ (1 − s/(ρ_kr + jρ_ki))
//
// for §4.5.11.1 laplace_zp, and calls them "lumped linear continuous-time
// filters". A linear filter's small-signal response at ω is its transfer
// function at s = jω; no digits for it appear in the clause, so they are
// derived here. A host reads the response through `acDyn`
// (`contract.acDynSlots`): `//! acdyn (row,col) f= re= im=` at ω = 2πf.
//
// THE NUMBERS. Each row is a KCL current into its node, so slot (row, in) is
// H(jω) itself.
//
//   a  laplace_nd(V(in), '{1}, '{1, τ}), τ = 1/(2π·1 MHz) = 1.5915494309189535e-7:
//      H(jω) = 1/(1 + jωτ), and ωτ = f/1MHz.
//        f = 0     H = 1                         (1, 0)   §4.5.11's DC gain
//        f = 1M    1/(1 + j)  = (1 − j)/2        (0.5, −0.5)
//        f = 3M    1/(1 + 3j) = (1 − 3j)/10      (0.1, −0.3)
//   c  §4.5.11.3 laplace_np(V(in), '{3}, '{-2, 0}): one real pole at −2,
//      H(s) = 3/(1 − s/(−2)) = 3/(1 + s/2). H(0) = 3; at ω = 2 (f = 1/π),
//      3/(1 + j) = 3(1 − j)/2 = (1.5, −1.5).
//   d  §4.5.11.2 laplace_zd(V(in), '{-4, 0}, '{2, 1}): one real zero at −4,
//      H(s) = (1 + s/4)/(2 + s). H(0) = 1/2; at ω = 2,
//      (1 + 0.5j)/(2 + 2j) = (1 + 0.5j)(2 − 2j)/8 = (3 − j)/8 = (0.375, −0.125).
//   b  §4.5.11.5's own example, laplace_zp(V(in), '{-1,0}, '{-1,-1,-1,1}):
//      "H(s) = (1 + s) / ((1 + s/(1 + j))(1 + s/(1 − j)))"; the denominator
//      multiplies out to 1 + s + s²/2. At ω = 1 (f = 1/2π = 0.15915494309189535):
//        (1 + j)/(0.5 + j) = (1 + j)(0.5 − j)/1.25 = (1.5 − 0.5j)/1.25 = (1.2, −0.4)
//      and at ω = 2 (f = 1/π = 0.3183098861837907):
//        (1 + 2j)/(−1 + 2j) = (1 + 2j)(−1 − 2j)/5 = (3 − 4j)/5 = (0.6, −0.8)
//
// At f = 0 every form reads its DC gain EXACTLY (tol=0): H(0) is a ratio
// of dyadic coefficients here, 1, 1, 3 and 1/2, and the operating-point
// analysis scales by the same ratio.
//
// A filter left at its DC gain in AC (the answer before this fixture) reads
// (1, 0) at every f and fails every other line; an H(−jω) fails every
// imaginary part. The operating point is the DC gain the model can see:
// H(0) = 1 for both, so each filter reads V(in) = 0.5 there.
//
// Corrected 2026-10-08 (construct only, the wants are unchanged): the
// coefficient vectors were VAMS 2.x concatenations, `{...}`. A.8.2's
// analog_filter_function_arg is a parameter, a part of one or a `'{...}`
// assignment pattern (annex G: "Add apostrophe before opening { in list of
// values"), and a concatenation there is E0572
// (reject_4_5_11_concatenation_coefficients.va), so each is now `'{...}`.
//
//! lrm 4.5.11.1
//! lrm 4.5.11.2
//! lrm 4.5.11.3
//! lrm 4.5.11.4
//! lrm 4.5.11.4:1000
//! lrm 4.5.11.5
//! bias V(in) = 0.5
//! print none
//! acdyn (a,in) f=0 re=1 im=0 tol=0
//! acdyn (b,in) f=0 re=1 im=0 tol=0
//! acdyn (c,in) f=0 re=3 im=0 tol=0
//! acdyn (d,in) f=0 re=0.5 im=0 tol=0
//! acdyn (c,in) f=0.3183098861837907 re=1.5 im=-1.5
//! acdyn (d,in) f=0.3183098861837907 re=0.375 im=-0.125
//! acdyn (a,in) f=1M re=0.5 im=-0.5
//! acdyn (a,in) f=3M re=0.1 im=-0.3
//! acdyn (b,in) f=0.15915494309189535 re=1.2 im=-0.4
//! acdyn (b,in) f=0.3183098861837907 re=0.6 im=-0.8
`include "check.vh"
module laplace_ac_response(in, a, b, c, d);
    inout in, a, b, c, d;
    electrical in, a, b, c, d;

    analog begin
        `CHECK("laplace_nd at the operating point is H(0)·V(in)",
               laplace_nd(V(in), '{1.0}, '{1.0, 1.5915494309189535e-7}), 0.5, 1e-12);
        `CHECK("laplace_zp at the operating point is H(0)·V(in)",
               laplace_zp(V(in), '{-1.0, 0.0}, '{-1.0, -1.0, -1.0, 1.0}), 0.5, 1e-12);
        I(a) <+ laplace_nd(V(in), '{1.0}, '{1.0, 1.5915494309189535e-7});
        I(b) <+ laplace_zp(V(in), '{-1.0, 0.0}, '{-1.0, -1.0, -1.0, 1.0});
        I(c) <+ laplace_np(V(in), '{3.0}, '{-2.0, 0.0});
        I(d) <+ laplace_zd(V(in), '{-4.0, 0.0}, '{2.0, 1.0});
    end
endmodule
