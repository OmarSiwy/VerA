// AMS 4.2.10 prohibits reduction operators inside analog blocks.
// This isolates the ~^ spelling: another rejected reduction cannot satisfy
// its diagnostic expectation. Digital reduction legality is a separate rule.
//! lrm 4.2.10
//! reject E0320
module audit_reduction_xnor_tilde_caret_rejected(p, n);
    inout p, n;
    electrical p, n;
    integer bits, value;
    analog begin
        bits = 15;
        value = ~^bits;
        I(p,n) <+ value;
    end
endmodule
