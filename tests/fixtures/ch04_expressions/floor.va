// §4.3.1 Table 4-14: `floor(x)` is C `floor` — the largest integer <= x, for
// all x. The bias picks -2.3, which separates floor from the other two ways a
// real becomes whole: §4.2.1.1 real-to-integer rounds to NEAREST (-2), C-style
// truncation goes toward zero (-2), and only floor goes toward -infinity (-3).
// The result is an exact small integer, so equality is exact.
//
//! lrm 4.3.1
//! bias V(p) = -2.3
`include "check.vh"
module ch04_floor(p, n);
  inout p, n;
  electrical p, n;
  analog begin
    `CHECKX("floor(-2.3) goes toward -infinity, not toward zero", floor(V(p, n)), -3.0);
    I(p, n) <+ floor(V(p, n));
  end
endmodule
