// §4.6.4.4 noise_table_log — a STRAIGHT LINE ON A LOG-LOG PLOT.
//
//     noise_table_log ( input [ , name ] )
//
//     "The noise_table_log() function interpolates a set of values to model a
//      process where the spectral density of the noise varies as a piecewise
//      linear function of the base-10 logarithm of frequency. ... The
//      difference is that noise_table_log() interpolates logarithmically. For
//      a frequency f not specified in the input data, the noise power shall be
//      computed using the two pairs (f1,p1) and (f2,p2) in the input ... where
//      f1 is the largest frequency value in the input data less than f and f2
//      is the smallest frequency larger than f (that is, f1 < f < f2); the
//      noise power P is computed as:
//
//        P = pow(10, log(p1) + (log(p2)-log(p1)) * (log(f)-log(f1)) /
//                              (log(f2)-log(f1)) )"
//
//     "As with noise_table(), for frequencies lower than the lowest frequency
//      in the value set, noise_table_log() returns the power specified for the
//      lowest frequency, and for frequencies higher than the highest
//      frequency, noise_table_log() returns the power specified for the
//      highest frequency."
//
// TWO POINTS ONLY, which is exactly the shape §4.6.4.4's own example uses
// ("The noise_table_log() function produces a straight line on a log-log plot
// from just two points"):
//
//     f [Hz]     S_I(f) [A^2/Hz]
//       1.0e3      1.0e-18
//       1.0e6      1.0e-24
//
// Slope on the log-log plane: log10(1e-24/1e-18) / log10(1e6/1e3) = -6/3 = -2,
// so the closed form of the clause's formula over this table is
//
//     S_I(f) = 1.0e-18 * (f/1000)^-2      for 1e3 <= f <= 1e6
//
// A power-of-two decade is chosen so the interior expectations (f = 2000,
// 3000) are exact rationals and are FAR from what §4.6.4.3's linear rule would
// give on the same knots — 2.5e-19 versus 9.98999e-19 at 2000 Hz. That gap is
// the whole point of Figure 4-14, and it is what makes this file a test of the
// interpolation MODE and not merely of table lookup.
//
// WHAT THIS FILE ASSERTS ON ITS OWN, i.e. without the deck and its oracle.
//
// The `//! noise` line carries the TABLE: both knots as the device exports
// them, with `interp=log` — §4.6.4.4 and not §4.6.4.3. That tag is the whole
// difference between the two clauses on these knots, and it is a comptime
// property of the model, so it needs no solve to read.
//
// The two `CHECK`s carry the two sentences that say what a noise generator is
// NOT, both of which are readable inside the analog block:
//
//   §4.6.4, on every one of the four functions: "The noise functions are only
//   active in small-signal noise analyses and return zero (0) otherwise." This
//   run is the default dc analysis, so `noise_table_log()` reads exactly 0.0 —
//   an exact want, because the clause gives a literal zero.
//
//   §4.5.6: "If the expression does not depend explicitly on the unknown, then
//   ddx() returns zero (0)." The tabulated density is a constant vector, so the
//   branch conductance is the resistor's alone, 1/R = 1.0e-3 S exactly at the
//   declared default, with a band of 1e-18 S against it.
//
// The call is bound to a variable first, as check.vh's own warning requires: a
// macro expands its operands twice and a noise call is a generator-creating
// site, not a pure expression.
//
//! lrm 4.6.4
//! lrm 4.6.4.4
//! lrm 4.6.4.4:1001
//! lrm 4.6.4.4:1
//! lrm 4.5.6
//! noise table(p,n)#0 name=tbl_log interp=log points=1000.0:1e-18,1000000.0:1e-24 psd=100.0:1e-18,10000.0:1e-20,100000.0:1e-22,10000000.0:1e-24
//! bias V(p) = 1.0
//! bias V(n) = 0.0
`include "check.vh"
module a06_ntab_log(p, n);
    inout p, n;
    electrical p, n;

    parameter real R = 1000.0 from (0:inf);
    real ntab;

    analog begin
        ntab = noise_table_log('{1.0e3, 1.0e-18, 1.0e6, 1.0e-24}, "tbl_log");

        `CHECKX("a noise function is inactive outside a small-signal noise analysis",
            ntab, 0.0);
        `CHECK("the tabulated generator is outside the branch linearization",
            ddx(V(p, n) / R + ntab, V(p)), 1.0e-3, 1e-18);

        I(p, n) <+ V(p, n) / R + ntab;
    end
endmodule
