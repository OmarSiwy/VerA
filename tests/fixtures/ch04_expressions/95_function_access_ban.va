// LRM 5.2.1/4.7.2: access functions are forbidden inside an analog function.
//! reject E0421
module ch4_fn_access(p); inout p; electrical p; analog function real probe; input x; real x; probe=V(p)+x; endfunction analog I(p)<+probe(1.0); endmodule
