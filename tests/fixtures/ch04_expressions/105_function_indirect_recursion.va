// LRM 4.7.3: an analog user-defined function "shall not call itself directly or
// indirectly". `first` calls `second` and `second` calls `first`, so neither
// names itself, yet the cycle in the call graph is exactly the indirect case the
// sentence bans. Neither is reached from the analog block, which does not save
// it: the rule constrains the declarations, not the reachable calls.
//! reject E0510
module ch4_fn_indirect(p); inout p; electrical p; analog function real first; input x; real x; first=second(x); endfunction analog function real second; input x; real x; second=first(x); endfunction analog I(p)<+V(p); endmodule
