// LRM 3.4.2 + 4.3.1/4.3.2, jointly: `exclude 0` punctures a value range, and a
// compiler that folds that puncture into a plain interval gets division WRONG
// in both directions. With b from [-10:10] exclude 0, the true range of a/b is
// TWO branches, (-inf, -|a|/10] U [|a|/10, +inf); evaluating only the range
// corners a/(-10) and a/10 fabricates the COMPLEMENT [-|a|/10, |a|/10].
//
// Both ln() calls below are therefore UNDECIDABLE at compile time — for every
// one there are model cards that put the argument in ln's x > 0 domain and
// cards that do not — and 4.3.2's "input values outside of the valid range for
// the operator shall report an error" speaks about VALUES, not about programs
// whose values might stray. So the only conforming verdict is to accept and
// evaluate; a compiler working from the fabricated corner interval instead
//   - "proved" ln(0.3 - a/b) in-domain (argument allegedly in [0.1, 0.5]) and
//     compiled it under a no-NaN fast-math assertion the card a=2, b=0.1
//     (argument 0.3 - 20) then violated silently, and
//   - REJECTED ln(1.0/b - 0.5) outright (argument allegedly in [-0.6, -0.4]),
//     refusing every legal card — b = 0.5 below gives ln(1.5).
//
// This fixture pins the acceptance and the values. The defaults a = -1.0,
// b = 0.5 are legal members of their ranges and keep both arguments strictly
// inside ln's domain:
//   0.3 - (-1.0)/0.5 = 0.3 + 2.0 = 2.3,  ln(2.3) = 0.8329091229351039
//   1.0/0.5 - 0.5    = 2.0 - 0.5 = 1.5,  ln(1.5) = 0.4054651081081644
// (wants computed on IEEE 754 doubles, including 0.3's representation error).
//
//! lrm 3.4.2
//! lrm 4.3.2
//! lrm 4.3.2:2
`include "check.vh"
module ch04_punctured_divisor_accepted(p, n);
    inout p, n;
    electrical p, n;
    parameter real a = -1.0 from [-2:2];
    parameter real b = 0.5 from [-10:10] exclude 0;

    analog begin
        `CHECK("ln(0.3 - a/b) at the card default", ln(0.3 - a/b), 0.8329091229351039, 1e-15);
        `CHECK("ln(1.0/b - 0.5) at the card default", ln(1.0/b - 0.5), 0.4054651081081644, 1e-15);
        I(p, n) <+ ln(0.3 - a/b) * V(p, n);
        I(p, n) <+ ln(1.0/b - 0.5) * V(p, n);
    end
endmodule
