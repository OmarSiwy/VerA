// §4.2.4 Table 4-4: `a * b` is "a multiply by b". At V(p,n) = 3.0 the product
// with 2.0 is 6.0, exact in IEEE 754 binary.
//
//! lrm 4.2.4
//! bias V(p) = 3.0
`include "check.vh"
module ch04_multiply(p, n);
    inout p, n;
    electrical p, n;
    analog begin
        `CHECKX("3.0 * 2.0", V(p, n) * 2.0, 6.0);
        I(p, n) <+ V(p, n) * 2.0;
    end
endmodule
