// The legal neighbour of 88_operator_in_event.va. §4.5.15: "Analog operators
// shall not be used inside event triggered statements." This module is 88's
// module with that one thing changed: `ddt(V(p))` is evaluated in the analog
// block itself, every iteration, and the event body only copies the result.
// The event, its cross() arguments, the variable and the contribution are 88's.
// So the pair separates "an analog operator inside an event body" from "an
// event body" and from "ddt" — 88's refusal cannot be a blanket refusal of
// either.
//
// THE DIGITS. A dc operating point at V(p) = 0.5: §4.5.3 "In DC analysis,
// ddt() returns zero (0)", so d = 0.0 exactly. §5.10.3.1: cross() "will not
// generate events for non-transient analyses", so the body never runs and x
// keeps the 0.0 it is given first.
//
//! lrm 4.5.15
//! lrm 4.5.3
//! bias V(p) = 0.5
//! checks 2
`include "check.vh"
module ch4_op_outside_event(p); inout p; electrical p; real x, d;
  analog begin
    x = 0.0;
    d = ddt(V(p));
    @(cross(V(p),1)) x = d;
    `CHECKX("ddt in the analog block, outside the event: dc gives 0", d, 0.0);
    `CHECKX("the event body is legal and, in dc, does not run", x, 0.0);
    I(p)<+x;
  end
endmodule
