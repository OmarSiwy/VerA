// §4.5.11.5 Examples — the clause's own listing, run.
//
//     V(out) <+ laplace_zp(V(in), '{-1,0}, '{-1,-1,-1,1});
//
// One zero at -1 + 0j, and two poles at -1 - 1j and -1 + 1j. §4.5.11.1 fixes
// the shape:
//
//     H(s) = ∏(1 - s/(ζkr + j·ζki)) / ∏(1 - s/(ρkr + j·ρki))
//
// At s = 0 every factor on both sides is 1, so H(0) = 1 for ANY zero and pole
// set that has no root at the origin — which makes this the one form whose DC
// gain is fixed by the clause without reference to its arguments. That is the
// assertion: a lowering that mixed up the real and imaginary halves of a pair,
// or that took the conjugate pair as two independent real poles, still has to
// come back with exactly 1.
//
// The contribution is written as the clause writes it — `V(out) <+ ...`, a
// potential contribution — rather than read into a variable, so what is
// exercised is the example and not a paraphrase of it. `out` is left for the
// solver, which is what `//! solve` is for.
//
// Corrected 2026-10-08 (construct only, the wants are unchanged): the
// coefficient vectors were VAMS 2.x concatenations, `{...}`. A.8.2's
// analog_filter_function_arg is a parameter, a part of one or a `'{...}`
// assignment pattern (annex G: "Add apostrophe before opening { in list of
// values"), and a concatenation there is E0572
// (reject_4_5_11_concatenation_coefficients.va), so each is now `'{...}`.
//
//! lrm 4.5.11.5
//! lrm 4.5.11.1
//! analysis dc
//! bias V(in) = 1.0
//! bias V(n) = 0.0
//! solve
`include "check.vh"
module ch04_laplace_zp_lrm_example(in, out, n);
    inout in, out, n;
    electrical in, out, n;

    analog begin
        V(out, n) <+ laplace_zp(V(in, n), '{-1.0, 0.0}, '{-1.0, -1.0, -1.0, 1.0});
        // H(0) = 1, so the output settles at the input the harness pins.
        `CHECKX("§4.5.11.5's filter has unity DC gain", V(out, n), 1.0);
        `CHECKX("and it is the INPUT that fixes it, not a constant", V(out, n) - V(in, n), 0.0);
    end
endmodule
