// §2.9 VerA's `vera_nodiff` statement attribute: every assignment inside
// stores its value with no derivative, the frozen coefficient a SPICE load
// stamps. Read here through §4.5.6 `ddx`.
//
// §2.9: "An attribute_instance can appear in the Verilog-AMS description as a
// prefix attached to a declaration, a module item, a statement, or a port
// connection." And: "If a value is not specifically assigned to the attribute,
// then its value shall be 1." §2.9 leaves an attribute's meaning to the tool;
// this one is VerA's.
//
// WHY. ngspice integrates a Meyer charge with the capacitance frozen at the
// iterate: niinteg.c:78 stamps geq = ag0 * C, and no dC/dV term. Forward AD of
// `C(V) * ddt(V)` adds dC/dV * dV/dt to the Jacobian. `(* vera_nodiff *) c = c;`
// is the model's way to say "C is a coefficient here".
//
// §4.5.6: "The operator returns the partial derivative of its first argument
// with respect to the unknown indicated by the second argument ... evaluated at
// the current operating point." So ddx reads exactly the lanes the device
// computes. At V(a) = 0.5, V(b) = 0:
//
//   c  = V(a)^2 = 0.25              ddx(c,  V(a)) = 2 V(a) = 1.0
//   cs = c under vera_nodiff        value 0.25,  ddx(cs, V(a)) = 0
//   cs * V(a): the stop is on cs only, so the product keeps V(a)'s lane:
//                                   ddx = cs * 1 = 0.25   (not 0.25 + 0.5 = 0.75)
//   cl under an inner `= 0`, inside a block whose prefix says 1: the innermost
//   wins, so cl keeps its derivative, 1.0.
//
// The stop changes lanes, never a value: `cs` equals `c` to the last bit.
//! lrm 2.9
//! lrm 2.9:3
//! lrm 4.5.6
//! fd-exempt `(* vera_nodiff *)` stores its assignments with no derivative by design (AGENTS.md §6), so the Jacobian omits what a difference sees
//! bias V(a) = 0.5, V(b) = 0.0
`include "check.vh"
module ddx_vera_nodiff_assignment(a, b);
  inout a, b; electrical a, b;
  real c, cs, cl;
  analog begin
    c = V(a) * V(a);
    (* vera_nodiff *) cs = c;
    (* vera_nodiff *) begin
      (* vera_nodiff = 0 *) cl = c;
    end
    I(a, b) <+ cs * V(a, b) + cl * 1e-3;
    `CHECKX("the stopped value is the value", cs, 0.25);
    `CHECKX("its derivative is zero", ddx(cs, V(a)), 0.0);
    `CHECKX("a consumer keeps its other operand's lane", ddx(cs * V(a), V(a)), 0.25);
    `CHECKX("an inner vera_nodiff = 0 keeps the derivative", ddx(cl, V(a)), 1.0);
  end
endmodule
