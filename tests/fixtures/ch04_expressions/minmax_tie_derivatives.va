// AMS 4.3.1, printed p.62: at a derivative discontinuity min(x,y) uses
// (x < y) ? x : y, and max uses (x > y) ? x : y. At equal independent
// node potentials both comparisons are false, hence the derivative follows y:
// d/dx = 0, d/dy = 1. Checking only the equal numeric values cannot tell.
// 4.5.6 holds other unknowns fixed when computing these partial derivatives.
//! lrm 4.3.1
//! lrm 4.3.1:1002
//! lrm 4.5.6
//! checks 4
//! bias V(p) = 0.5, V(q) = 0.5
`include "check.vh"
module audit_minmax_tie_derivatives(p, q);
    inout p, q;
    electrical p, q;
    analog begin
        `CHECKX("min tie derivative first", ddx(min(V(p), V(q)), V(p)), 0.0);
        `CHECKX("min tie derivative second", ddx(min(V(p), V(q)), V(q)), 1.0);
        `CHECKX("max tie derivative first", ddx(max(V(p), V(q)), V(p)), 0.0);
        `CHECKX("max tie derivative second", ddx(max(V(p), V(q)), V(q)), 1.0);
        I(p) <+ V(p);
        I(q) <+ V(q);
    end
endmodule
