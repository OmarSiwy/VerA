// §4.3.2: "Input values outside of the valid range for the operator shall
// report an error." Table 4-14: `sqrt(x)`, "Square root", domain "x >= 0"
// (#59). The constant form, sqrt(-1.0), is E0604 at compile time
// (114_standard_math_domain_rejected.va).
//
//   point 0, V(p) = 4:  sqrt(4) = 2, exact in IEEE 754 (sqrt is correctly
//                       rounded), so CHECKX 2.
//   point 1, V(p) = -1: outside "x >= 0" (NaN, silently, before #59). The run
//                       reports E0604 and exits 1.
//
//! lrm 4.3.1
//! lrm 4.3.2
//! lrm 4.3.2:2
//! sweep V(p) = 4, -1
//! reject-run E0604
//! neighbour runtime_domain_legal_neighbour.va
//! checks 1
//! print none
`include "check.vh"
module runtime_sqrt_domain(p, n);
  inout p, n; electrical p, n;
  real r;
  analog begin
    r = sqrt(V(p, n));
    `CHECKX("sqrt(4) is 2, at the in-domain point only", r, 2.0);
    I(p, n) <+ V(p, n);
  end
endmodule
