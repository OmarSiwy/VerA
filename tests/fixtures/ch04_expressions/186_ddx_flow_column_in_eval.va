// LRM 4.5.6: "The second argument shall be the potential of a scalar net or
// port or the flow through a branch, because these are the unknown variables
// in the system of equations for the analog solver."
//
// The flow half, asked where a narrow host would get it wrong. `V(br) <+ v0`
// makes I(br) a branch-flow unknown — the kind of column a host may leave
// without a derivative lane (`contract.derivReads`). ddx() reads a lane BY
// INDEX (`ddxAt`), so codegen keeps every ddx column live (`ddx_reads ⊆
// deriv_reads`). Here the result feeds a contribution, so it sits in `eval`,
// where the testbench's wide-vs-narrow Jacobian gate compares it bit for bit:
// a dropped lane would make the narrow `k` zero and fail the run.
// 147_ddx_flow_unknown.va asks ddx() of a flow only inside `$strobe`, which
// the gate does not see.
//
// By hand. V(p) = 1 is driven; the branch relation pins V(p,n) = v0 = 0.5, so
// V(n) = 0.5. KCL at n: the branch current leaves n (§1.3.1.2, flow runs p to
// n inside the branch, so it is stamped −I(br) at n) and the 1 kohm load takes
// V(n)/1000 to ground:
//
//     −I(br) + 0.5/1000 = 0      I(br) = 0.5e-3 A
//
//     k = d/dI(br) of I(br)*I(br) = 2*I(br) = 1.0e-3
//
// The `I(p) <+ k` row is the driven node's, which the bias replaces, so it
// moves nothing in the solve; it exists to put ddx() in `eval`.
//
//! lrm 4.5.6
//! lrm 4.5.6:1
//! bias V(p) = 1.0
//! solve
`include "check.vh"
module ch04_ddx_flow_column_in_eval(p, n);
    inout p, n;
    electrical p, n;
    branch (p, n) br;
    parameter real v0 = 0.5;
    real k;

    analog begin
        k = ddx(I(br) * I(br), I(br));
        `CHECK("the branch relation leaves V(n) = 1 - v0", V(n), 0.5, 1e-15);
        `CHECK("the load's current is the branch current", I(br), 0.5e-3, 1e-18);
        `CHECK("ddx of I(br)^2 by its own flow is 2*I(br)", k, 1.0e-3, 1e-18);
        V(br) <+ v0;
        I(n) <+ V(n) / 1000.0;
        I(p) <+ k;
    end
endmodule
