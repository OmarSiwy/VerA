// §4.5.12.3 (zi_np): "If a pole is real, the imaginary part shall be
// specified as zero (0). If a pole is complex, its conjugate shall also be
// present."
//
// The pole vector '{0.1, 0.5} is one pole, 0.1 + 0.5j, with no 0.1 - 0.5j.
// The numerator '{1.0} is a legal coefficient vector and T = 1u is positive.
// The only error is the unpaired complex pole.
//
//! lrm 4.5.12.3
//! lrm 4.5.12.3:2
//! reject-only no conjugate partner
//! neighbour zi_np_parameter_roots_dc_gain.va
`include "disciplines.vams"
module ch4_zi_np_unpaired_pole(p, n);
  inout p, n;
  electrical p, n;

  analog I(p, n) <+ zi_np(V(p, n), '{1.0}, '{0.1, 0.5}, 1u);
endmodule
