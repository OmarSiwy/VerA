// A06 helper: a 1 kOhm resistor that declares NO noise generator.
//
// §4.6.4 makes noise a property of what the model CONTRIBUTES: "noise_table()
// ... interpolates a set of values to model a process where the spectral
// density of the noise varies as a piecewise linear function of frequency."
// A module with no `white_noise`/`flicker_noise`/`noise_table` call emits no
// `noise_gens` row at all, so the host's `collect_noise` hook is null for this
// batch and it contributes exactly zero to the output spectrum.
//
// WHY THIS EXISTS INSTEAD OF A SPICE `R`. A built-in `R` carries 4kT/R, which
// would put a temperature-dependent term into every expected value in this row
// and bury the thing under test. This device is a pure conductance: every
// electron of noise in the A06 decks comes from the tabulated source, so the
// arithmetic in tests/fixtures/ch04_expressions/a06_noisetables_SPEC.md at 8b1514d4 is exact and has no kB, no T and no tolerance slack.
//
// WHAT THIS FILE ASSERTS ON ITS OWN. Two things, and neither needs the deck.
//
// `//! noise none` is the export claim: §4.6.4's generators are the ones a
// model CALLS, so a module that calls none exports an empty `noise_gens`, and
// spelling that as a directive is a claim where an absent directive would be
// silence.
//
// The `CHECK` is the constitutive claim, and it is what "pure conductance"
// above means as a number. §4.5.6: "ddx() returns the partial derivative of
// the expression with respect to the unknown ... If the expression does not
// depend explicitly on the unknown, then ddx() returns zero (0)." The branch
// here is Ohm's law alone, so
//
//     ddx(V(p,n)/R, V(p)) = 1/R = 1/1000 = 1.0e-3 S      exactly
//
// with R at its declared default. A conductance of exactly 1e-3 and no more is
// the whole of this device: a 4kT/R term, a temperature coefficient or a
// stray tabulated contribution would all move it, and any of them would put a
// number into tests/fixtures/ch04_expressions/a06_noisetables_SPEC.md at 8b1514d4's arithmetic that the A06 oracles do not carry. Band
// 1e-18 S against 1e-3 S — fifteen orders of headroom, so nothing but a real
// extra term can fail it.
//
//! lrm 4.6.4
//! lrm 4.5.6
//! noise none
//! bias V(p) = 1.0
//! bias V(n) = 0.0
`include "check.vh"
module a06_noiseless_res(p, n);
    inout p, n;
    electrical p, n;

    parameter real R = 1000.0 from (0:inf);

    analog begin
        `CHECK("the branch is a pure 1 kOhm conductance and nothing else",
            ddx(V(p, n) / R, V(p)), 1.0e-3, 1e-18);
        `CHECK("and the same seen from the other terminal",
            ddx(V(p, n) / R, V(n)), -1.0e-3, 1e-18);

        I(p, n) <+ V(p, n) / R;
    end
endmodule
