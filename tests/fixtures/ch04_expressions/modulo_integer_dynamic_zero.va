// AMS §4.2.4: "It shall be an error to pass zero (0) as the second argument
// to the modulus operator." The divisor is probe-dependent: 3 at the first
// point, then 0. The first point prints 11 % 3=2; the second reports E0601
// before printing. VerA's executable error policy is exit 1; this exit code
// is an implementation choice, not a numeral required by §4.2.4.
// modulo_integer_dynamic.va and modulo_integer_short_circuit.va are legal
// neighbours, including a guarded zero that must not raise this error.
//! lrm 4.2.4
//! lrm 4.2.4:1
//! sweep V(p) = 3, 0
//! exit 1
//! checks 1
//! print none
`include "check.vh"
module modulo_integer_dynamic_zero(p, n);
  inout p, n; electrical p, n;
  integer d, remainder;
  analog begin
    d = V(p,n);
    remainder = 11 % d;
    `CHECKI("only the nonzero point completes", remainder, 2);
    I(p,n) <+ remainder;
  end
endmodule
