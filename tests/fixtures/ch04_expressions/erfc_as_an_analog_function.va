// §4.3 / §4.7: erfc() is NOT an LRM built-in, so a model defines it as an
// analog user-defined function — tests/fixtures/erfc.vh, checked here.
//
// §4.3.1 Table 4-14 (standard mathematical functions) lists ln, log, exp,
// sqrt, min, max, abs, pow, floor, ceil; §4.3.2 Table 4-15 lists the
// trigonometric and hyperbolic functions. Neither lists erf or erfc, and no
// other clause adds one (the LRM text has no occurrence of either name). So the
// portable spelling is §4.7.1's: "analog function real erfc; input x; ...".
// VerA refuses a bare `erfc(x)` with E0512, correctly, and must accept this.
//
// THE WANTS are Abramowitz & Stegun Table 7.1's erf to 15 places, turned into
// erfc = 1 - erf by hand:
//
//   erf(1) = 0.842700792949715   erfc(1)  = 0.157299207050285
//   erf(2) = 0.995322265018953   erfc(2)  = 0.004677734981047
//                                erfc(-1) = 2 - erfc(1) = 1.842700792949715
//   erfc(0) = 1 exactly: the series arm sums nothing at a = 0 and 1 - 0 = 1.
//
// The table's 15th place is its rounding, so the relative band is 1e-12 on
// erfc(1) and erfc(-1) and 1e-10 on erfc(2), whose 15 decimal places carry
// only 13 significant digits. The helper's own measured error (its header) is
// 1.9e-13, inside every band.
//
//! lrm 4.3.1
//! lrm 4.3.2
//! lrm 4.7.1
//! bias V(p) = 0
`include "check.vh"
module ch4_erfc_function(p);
  inout p;
  electrical p;

`include "erfc.vh"

  analog begin
    `CHECKX("erfc(0) = 1", erfc(0.0), 1.0);
    `CHECKR("erfc(1), A&S 7.1", erfc(1.0), 0.157299207050285, 1e-12);
    `CHECKR("erfc(2), A&S 7.1", erfc(2.0), 0.004677734981047, 1e-10);
    `CHECKR("erfc(-1) = 2 - erfc(1)", erfc(-1.0), 1.842700792949715, 1e-12);
    I(p) <+ V(p);
  end
endmodule
