// AMS 4.3.1: "The min(), max(), and abs() functions have discontinuous
// derivatives; it is necessary to define the behavior of the derivative of
// these functions at the point of the discontinuity. In this context, these
// functions are defined so: ... abs(x) is equivalent to (x > 0) x : -x"
//
// At x = 0 the test `x > 0` is false, so abs takes the -x arm and its
// derivative there is -1, not +1 and not 0. audit_minmax_tie_derivatives.va
// pins the min/max half of the sentence; this is the abs half, in both
// Table 4-14 spellings (abs and $abs). A compiler that used sign(x) (0 at
// zero) or the +x arm reads 0 or +1. No invalid form exists: abs takes any x.
//
//! lrm 4.3.1
//! lrm 4.5.6
//! checks 2
//! bias V(p) = 0.0
`include "check.vh"
module audit_abs_zero_derivative(p);
    inout p;
    electrical p;
    analog begin
        `CHECKX("abs takes the -x arm at zero", ddx(abs(V(p)), V(p)), -1.0);
        `CHECKX("$abs takes the -x arm at zero", ddx($abs(V(p)), V(p)), -1.0);
        I(p) <+ abs(V(p));
    end
endmodule
