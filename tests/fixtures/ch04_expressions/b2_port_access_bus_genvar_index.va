// §4.4: "For port access functions, the expression list is a single port of
// the module. The port identifier shall be scalar or resolve to a constant net
// of a bus port accessed by a genvar expression."
//
// The legal neighbour of b2_port_access_bus_variable_index_rejected.va: `pb`
// is a two-element bus port and I(<pb[g]>) is indexed by the genvar of a
// §5.9.3 analog for, so each unrolled copy names one constant port element.
//
// HAND DERIVATION. The port flows are biased: I(<pb[0]>) = 0.375,
// I(<pb[1]>) = 0.125. The loop weights element g by g + 1:
//   s = 1 * 0.375 + 2 * 0.125 = 0.625    (swapped elements would give 0.875)
// Exact in binary64, so CHECKX.
//
//! lrm 4.4
//! bias I(<pb[0]>) = 0.375, I(<pb[1]>) = 0.125
//! checks 1
`include "check.vh"
module b2_port_access_bus_genvar_index(pb);
    inout [0:1] pb;
    electrical [0:1] pb;
    genvar g;
    real s;

    analog begin
        s = 0.0;
        for (g = 0; g < 2; g = g + 1)
            s = s + (g + 1) * I(<pb[g]>);
        `CHECKX("I(<pb[g]>) over the genvar reads each port flow", s, 0.625);
        I(pb[0]) <+ I(<pb[0]>);
        I(pb[1]) <+ I(<pb[1]>);
    end
endmodule
