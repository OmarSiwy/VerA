// asin() is defined only for -1 <= x <= 1 (LRM 4.3.2 Table 4-15); a node
// voltage is unbounded, so the call is guarded into that domain.
//
// The bias sits at 0.5, inside the domain. Table 4-15 says the inverse
// trigonometric functions RETURN radians, so asin(0.5) = pi/6 =
// 0.52359877559829887308..., nearest double 0.5235987755982989 (the libm result
// is within one ulp of the rounded pi/6). A degree-returning implementation
// would answer 30. The checks are OUTSIDE the guard: §9.4.6 display tasks must
// announce themselves whichever way the comparison goes.
//
//! lrm 4.3.2
//! bias V(p) = 0.5
`include "check.vh"
module ch04_asin(p, n);
  inout p, n; electrical p, n;
  analog begin
    `CHECK("asin(0.5) returns pi/6 in radians", asin(V(p, n)), 0.5235987755982989, 1e-15);
    `CHECK("asin inverts sin on the principal branch", asin(sin(0.5)), 0.5, 1e-15);
    if (V(p, n) >= -1.0)
      if (V(p, n) <= 1.0)
        I(p, n) <+ asin(V(p, n));
  end
endmodule
