// §4.6.4.1/.2 the PSDs THEMSELVES — the numbers, not the topology.
//
// §4.6.4.1: "white_noise ( pwr [ , name ] ) … generates white noise with a
// power of pwr." §4.6.4.2: "flicker_noise ( pwr , exp [ , name ] ) … generates
// pink noise with a power of pwr at 1Hz which varies in proportion to 1/f exp."
// Together those two sentences define the generator's spectrum outright:
//
//   S_white(f)   = pwr                    [units²/Hz], for all f
//   S_flicker(f) = pwr / f^exp            [units²/Hz], pwr is its value at 1 Hz
//
// Nothing in the model's own text can read this back — §4.6.4 makes every
// source return 0 outside a noise analysis, and inside one it returns a
// stochastic quantity with no scalar value — so the assertion has to be made on
// the EXPORT, which is what the `white=` / `flicker=` / `ef=` fields of the
// `//! noise` lines below are. The suite already pins WHICH generator sits on
// WHICH branch (`ch04_expressions/148_white_noise_topology.va`); no fixture
// anywhere pins the POWER, which is the only thing a host can integrate.
//
// THE NUMBERS.
//
// Thermal, Nyquist's 4kT/R, with `//! temp 300.0` and R = 1 kΩ. No
// PHYSICAL_CONSTANTS_* selector is defined, so annex D.2's innermost `else`
// gives `P_K = `P_K_NIST1998 = 1.3806503e-23 J/K:
//
//   pwr = 4 · 1.3806503e-23 · 300.0 / 1000.0 = 1.65678036e-23 A²/Hz
//
// Flicker: pwr is the density AT 1 Hz, so the exported `flicker` is the
// coefficient itself, kf = 1e-20 A²/Hz, and `ef` is the exponent as written,
// 1.25. The exponent is deliberately NOT 1: a lowering that hard-coded the 1/f
// slope, or that defaulted `ef` and dropped the argument, reads 1.0 here and
// fails. 1.25 is also not an integer, which rules out an integer-exponent
// shortcut. At 1 Hz the flicker generator's density is 1e-20/1^1.25 = 1e-20,
// and at 100 Hz it is 1e-20/100^1.25 = 3.1622776601683795e-23 — the second
// number is the one that separates ef = 1.25 from ef = 1 (which would give
// 1e-22, a factor of 3.16 out).
//
// The two generators are INDEPENDENT (§4.6.4.6: "each noise function generates
// noise which is uncorrelated with the noise generated by other functions"), so
// they carry distinct source ids #0 and #1 and a host adds their densities.
//
// The `CHECK`s below are the dc-observable half — the arithmetic of the two
// powers as the model computes them ($temperature and `P_K into 4kT/R, and the
// 1/f^1.25 roll-off) — so the fixture still asserts something when the
// `//! noise` value fields are stripped. (Two checks that could not fail were
// dropped: kf/pow(1, 1.25) against kf, and the bias V(p,n)/R against 1e-3,
// which the harness sets and no device code computes.)
//
//! lrm 4.6.4.1
//! lrm 4.6.4.2
//! lrm 4.6.4.1:1000
//! lrm 4.6.4.2:1000
//! noise thermal(p,n)#0 name=thermal white=1.65678036e-23
//! noise flicker(p,n)#1 name=flicker flicker=1e-20 ef=1.25
//! analysis noise
//! temp 300.0
//! bias V(p) = 1.0
//! bias V(n) = 0.0
`include "check.vh"
module a06_psd_white_flicker_export(p, n);
    inout p, n;
    electrical p, n;
    parameter real R = 1000.0 from (0:inf);
    parameter real kf = 1e-20 from [0:inf);

    analog begin
        `CHECKR("Nyquist 4kT/R at 300 K into 1 kOhm",
            4.0 * `P_K * $temperature / R, 1.65678036e-23, 1e-12);
        `CHECKR("and at 100 Hz it is kf/100^1.25",
            kf / pow(100.0, 1.25), 3.1622776601683795e-23, 1e-12);

        I(p, n) <+ V(p, n) / R
            + white_noise(4.0 * `P_K * $temperature / R, "thermal")
            + flicker_noise(kf, 1.25, "flicker");
    end
endmodule
