// §4.7 a user-defined analog function, and §4.2.12 the conditional operator it
// is built from. `max_value` is max() written by hand, so its value is fixed by
// arithmetic alone. `pick_larger` is the same choice written with the
// conditional-execution statement §4.7.1 permits inside a function, so the
// permission is exercised and not merely described.
//
// The formals are spelled the way A.2.6 and every §4.7.1 example spell them: a
// direction (A.2.1.2 `input_declaration`, which has no slot for `real`) and a
// separate `real_declaration` for the type — which is also what 4.7.1's "all
// formal arguments shall have an associated block item declaration specifying
// the data type" asks for, and what function_untyped_argument.va rejects
// the absence of. `input real first;` is IEEE 1364 task syntax; the
// Verilog-AMS grammar does not admit it.
//
// The bias makes both arms reachable in one operating point: with
// V(p,n) = -0.5 the call in the contribution must select the SECOND argument
// (0.0, not -0.5 — a function lowered as "return the first argument" fails
// there), while max_value(V(p,n) + 1.5, 0.0) must select the FIRST (1.0).
// The tie case pins the operator as a strict `>`: 4 > 4 is false, so the second
// argument is returned.
//
//! lrm 4.7.1
//! lrm 4.7.1:3
//! lrm 4.7.2.1
//! lrm 4.7.2.1:1
//! bias V(p) = -0.5
//! bias V(n) = 0.0
`include "check.vh"
module ch04_user_function(p, n);
    inout p, n;
    electrical p, n;
    real clamped;

    analog function real max_value;
        input first, second;
        real first, second;
        begin
            max_value = first > second ? first : second;
        end
    endfunction

    analog function real pick_larger;
        input first, second;
        real first, second;
        begin
            if (first > second)
                pick_larger = first;
            else
                pick_larger = second;
        end
    endfunction

    analog begin
        clamped = max_value(V(p, n), 0.0);

        `CHECKX("second argument wins", max_value(3.0, 5.0), 5.0);
        `CHECKX("first argument wins", max_value(-2.0, -7.0), -2.0);
        `CHECKX("a tie falls to the second argument", max_value(4.0, 4.0), 4.0);
        `CHECKX("a negative signal is clamped to the constant", clamped, 0.0);
        `CHECKX("a positive signal passes through", max_value(V(p, n) + 1.5, 0.0), 1.0);
        `CHECKX("a function may use a conditional-execution statement", pick_larger(3.0, 5.0), 5.0);
        `CHECKX("and takes the first arm when it holds", pick_larger(5.0, 3.0), 5.0);

        I(p, n) <+ clamped;
    end
endmodule
