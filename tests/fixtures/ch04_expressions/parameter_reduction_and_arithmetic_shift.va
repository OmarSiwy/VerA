// §4.2.10: "The reduction operators can not be used inside the analog block
// and only have meaning when used in the digital context." §4.2.11: "The
// arithmetic shift operators can not be used in an analog block." Both bar the
// analog BLOCK; a parameter declaration is outside it, and §3.4's initializer
// is "a constant expression" with no operator excluded. The values are IEEE
// 1364-2005's, which both clauses refer to:
//
//   §5.1.11: "The unary reduction operators shall perform a bitwise operation
//   on a single operand to produce a single-bit result", nand/nor/xnor being
//   the inversions of and/or/xor.
//
//   §5.1.12: "The left shift operators, << and <<<, shall shift their left
//   operand to the left ... the vacated bit positions shall be filled with
//   zeroes. ... The arithmetic right shift shall fill the vacated bit
//   positions with zeroes if the result type is unsigned. It shall fill the
//   vacated bit positions with the value of the most significant (i.e., sign)
//   bit of the left operand if the result type is signed."
//
// VerA refused every one of these with E0348 ("not a constant expression")
// or E0324.
//
// THE NUMBERS, bit by bit.
//   &3'b111       1 & 1 & 1                         = 1
//   ~&3'b111      not 1                             = 0
//   |3'b000       0 | 0 | 0                         = 0
//   ~|3'b000      not 0                             = 1
//   ^3'b101       1 ^ 0 ^ 1                         = 0
//   ~^3'b100      not (1 ^ 0 ^ 0)                   = 0
//   &7            7 is unsized, so at least 32 bits (1364 §3.5.1): its bits
//                 above bit 2 are 0, and the AND is 0 — where the sized
//                 &3'd7 above is 1. The width is part of the operand.
//   -8 >>> 1      signed: ...11111000 -> ...11111100 = -4
//   -8 >>> 40     signed, every position vacated, all sign bits = -1
//   8'b1000_0000 >>> 2   unsigned: zero-filled, 0010_0000 = 32
//   1 <<< 3       = 8, the same as 1 << 3
//
//! lrm 4.2.10
//! lrm 4.2.11
//! lrm 3.4
//! lrm 4.2.10:1000
//! lrm 4.2.11:1000
//! inherited IEEE 1364-2005 5.1.11
//! inherited IEEE 1364-2005 5.1.12
//! bias V(p) = 0.5
//! bias V(n) = 0
`include "check.vh"
module parameter_reduction_and_arithmetic_shift(p, n);
    inout p, n;
    electrical p, n;
    parameter integer r_and = &3'b111;
    parameter integer r_nand = ~&3'b111;
    parameter integer r_or = |3'b000;
    parameter integer r_nor = ~|3'b000;
    parameter integer r_xor = ^3'b101;
    parameter integer r_xnor = ~^3'b100;
    parameter integer r_wide = &7;
    parameter integer s_neg = -8 >>> 1;
    parameter integer s_all = -8 >>> 40;
    parameter integer s_uns = 8'b1000_0000 >>> 2;
    parameter integer s_left = 1 <<< 3;
    analog begin
        `CHECKI("&3'b111", r_and, 1);
        `CHECKI("~&3'b111", r_nand, 0);
        `CHECKI("|3'b000", r_or, 0);
        `CHECKI("~|3'b000", r_nor, 1);
        `CHECKI("^3'b101", r_xor, 0);
        `CHECKI("~^3'b100", r_xnor, 0);
        `CHECKI("&7 reduces all 32 bits", r_wide, 0);
        `CHECKI("-8 >>> 1 sign-fills", s_neg, -4);
        `CHECKI("-8 >>> 40 is all sign bits", s_all, -1);
        `CHECKI("an unsigned >>> zero-fills", s_uns, 32);
        `CHECKI("1 <<< 3", s_left, 8);
        I(p, n) <+ V(p, n);
    end
endmodule
