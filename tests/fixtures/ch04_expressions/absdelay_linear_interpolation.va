// LRM 4.5.7: the operator "will use linear interpolation as needed" at
// max(t - td, 0). Use td=2ns and nonuniform sample spacing, with a nonzero
// initial input and slopes that change sign. Independent hand derivation:
//
// t/ns       0   1   3   6   10   11
// input      3   5   9   3   11    0
// query/ns   0   0   1   4    8    9
// output     3   3   5   7    7    9
// At query 4: 9 + (3-9)*(4-3)/(6-3) = 7.
// At query 8: 3 + (11-3)*(8-6)/(10-6) = 7.
// At query 9: 3 + (11-3)*(9-6)/(10-6) = 9, using two already
// accepted samples rather than the current trial input at t=11ns.
// A previous-sample hold gives 9 and 3, nearest-sample selection gives 9
// at query 4, and a fixed-step history index cannot use these time intervals.
// This tests interpolation of sampled history, not adaptive host scheduling.
//! lrm 4.5.7
//! lrm 4.5.7:1002
//! bias V(n) = 0
//! wave V(p) = 3, 5, 9, 3, 11, 0
//! time 0, 1n, 3n, 6n, 10n, 11n
//! analysis tran
//! print none
`include "check.vh"
module audit_absdelay_linear_interpolation(p, n);
    inout p, n;
    electrical p, n;
    real want;
    analog begin
        want = $abstime < 2n ? 3.0 : ($abstime < 4n ? 5.0 : ($abstime < 10.5n ? 7.0 : 9.0));
        `CHECK("linear interpolation on nonuniform history", absdelay(V(p,n), 2n) - want, 0.0, 1e-12);
        I(p,n) <+ 0.0;
    end
endmodule
