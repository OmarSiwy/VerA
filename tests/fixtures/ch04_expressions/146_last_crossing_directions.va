// LRM 4.5.10, verbatim: "The optional direction indicator shall evaluate to an
// integer expression +1, -1, or 0. If it is set to 0, the last_crossing() will
// return the most recent time the input expression had either a rise or falling
// edge transition. If direction is +1 (-1), the last_crossing() will return the
// last time the input expression had a rising (falling) edge transition."
//
// 22_last_crossing.va queries +1 and nothing else, which a lowering that
// ignored the direction argument entirely would satisfy. These are the other
// two directions, on a waveform with exactly one edge and that edge rising:
// V(p,n) is held at -1 V through t = 1ns and steps to +1 V at t = 2ns.
//
//   direction -1  there is never a falling edge here, so the -1 query never
//                 leaves the state 4.5.10's last sentence describes — "Before
//                 the expression crosses zero (0) for the first time, the
//                 last_crossing() function returns a negative value" — and
//                 stays negative at every one of the five time points,
//                 including t = 4ns, where the +1 query has long since gone
//                 positive. This is the line that separates a real direction
//                 filter from an ignored argument.
//
//   direction  0  either edge counts and the only edge is the rising one, so
//                 the 0 query shall report the same crossing the +1 query does.
//                 4.5.10 fixes no digits for it — it "uses linear interpolation
//                 to estimate the time of the last crossing" and explicitly
//                 "does not control the timestep to get accurate results" — so
//                 the claim is an identity between two of the operator's own
//                 outputs and not a value.
//
//                 It is asserted only from t = 3ns on. At t = 0 and t = 1ns
//                 NEITHER query has crossed, and all 4.5.10 fixes about that
//                 state is that the result is "a negative value" — not which
//                 negative value, and not that two independent queries agree on
//                 one. Demanding equality there would over-specify a sentinel
//                 the LRM leaves open. t = 2ns is skipped for the reason
//                 22_last_crossing.va gives: §4.5.2 lets the history advance on
//                 the accepted step, so whether a crossing is visible in the
//                 step that created it is not fixed either.
//
// The bare `last_crossing(expr)` shape is deliberately not asserted: 4.5.10
// calls the indicator optional but never says which of the three it defaults
// to, so any value written here would over-specify.
//
// The gate is $abstime as an OPERAND and not a branch, so the assertions stay
// unconditional (§4.2.5 makes a comparison an integer) — the same shape
// 22_last_crossing.va uses. The -1 check needs no gate: 4.5.10 requires it to
// be negative at every one of the five points.
//
//! lrm 4.5.10
//! bias V(n) = 0
//! wave V(p) = -1, -1, 1, 1, 1
//! time 0, 1n, 2n, 3n, 4n
//! analysis tran
//! print none
//! xfail VerA's last_crossing ignores its direction argument for anything but +1: `last_crossing(V(p,n), -1)` and `last_crossing(V(p,n), 0)` both return a flat 0.0 at every time point, so the -1 query is not negative before its (never-occurring) first falling edge and the 0 query does not track the rising edge the +1 query reports
`include "check.vh"
module ch04_last_crossing_directions(p, n);
    inout p, n;
    electrical p, n;

    analog begin
        `CHECKI("direction -1 stays negative: this input never falls",
                last_crossing(V(p, n), -1) < 0.0, 1);
        `CHECKI("direction 0 reports the same edge when the only edge rises",
                ($abstime < 2.5e-9) ||
                (abs(last_crossing(V(p, n), 0) -
                     last_crossing(V(p, n), 1)) < 1e-15), 1);

        I(p, n) <+ last_crossing(V(p, n), 0);
    end
endmodule
