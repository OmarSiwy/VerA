// §4.7 "A user-defined function can be used to return a value (for an
// expression). All functions are defined within modules."
//
// The positive half of the clause. Every other §4.7 cite in the suite is a
// rejection (a digital function called from the analog block, a VPI routine
// name that is not a function); this one shows a function DEFINED IN THE MODULE
// returning a value INTO AN EXPRESSION.
//
// DERIVATION. With V(p) = 0.75 and V(n) = 0.25 (both dyadic), the call
// `sq_plus(V(p, n), 0.25)` returns 0.5 * 0.5 + 0.25 = 0.5, and the expression it
// sits in, `1.0 + sq_plus(...)`, is 1.5. Every step is exact in binary64.
//
//! lrm 4.7
//! lrm 4.7:1000
//! bias V(p) = 0.75, V(n) = 0.25
`include "check.vh"
module ch04_user_defined_function_returns_value(p, n);
  inout p, n;
  electrical p, n;

  analog function real sq_plus;
    input x, y;
    real x, y;
    begin
      sq_plus = x * x + y;
    end
  endfunction

  real r;
  analog begin
    r = 1.0 + sq_plus(V(p, n), 0.25);
    `CHECKX("§4.7 a module's analog function returns its value into an expression", r, 1.5);
    I(p, n) <+ V(p, n);
  end
endmodule
