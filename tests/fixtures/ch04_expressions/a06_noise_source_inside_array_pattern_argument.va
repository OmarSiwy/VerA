// §4.6.4: a noise function in a contribution statement declares a noise
// generator of the branch it is contributed to. §4.6.4.1 white_noise(pwr,
// name) is "a frequency-independent noise of power pwr". Nothing in §4.6.4
// asks where in the right-hand side the call sits, so a generator written as
// an element of an A.8.1 assignment pattern — the `input` array actual of a
// §4.7.2.3 function call — is as declared as one written bare.
//
// `first` returns element 0 of its array argument unchanged, so the branch
// (p,n) receives the generator's amplitude with coefficient 1: one thermal
// generator on (p,n), named "src", density 1e-20 A²/Hz — exactly `pwr`,
// which is exact in binary64 as the literal it is.
//
// VerA lost it: the walk that collects a contribution's generators did not
// look inside an assignment pattern, so the device exported no generator and
// `//! noise` found an empty table.
//
// The CHECKX is the weak companion a06_noise_coefficient_through_a_conditional.va
// explains: the generator stays out of the linearization, so ddx of the
// contributed current with respect to V(p) is the resistor's 1/1k, exact.
//
//! lrm 4.6.4
//! lrm 4.6.4.1
//! lrm 4.7.2.3
//! noise thermal(p,n)#0 name=src white=1e-20
//! analysis noise
//! bias V(p) = 0.0
//! bias V(n) = 0.0
`include "check.vh"
module a06_noise_source_inside_array_pattern(p, n);
    inout p, n;
    electrical p, n;
    analog function real first;
        input [0:1] a;
        real a[0:1];
        begin
            first = a[0];
        end
    endfunction

    analog begin
        `CHECKX("the generator stays out of the linearization", ddx(V(p, n) / 1k, V(p)), 1e-3);
        I(p, n) <+ V(p, n) / 1k + first('{white_noise(1e-20, "src"), 0.0});
    end
endmodule
