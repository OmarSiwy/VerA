// §4.3.2 Table 4-15: `cos(x)` is C `cos`, argument in RADIANS, for all x. The
// bias puts the argument at 0.5 rad, giving
// cos(0.5) = 0.87758256189037271612..., nearest double 0.8775825618903728.
// The second check is the Pythagorean identity sin^2 + cos^2 = 1, which fails
// if cos is confused with sin or shifted by a quadrant.
//
//! lrm 4.3.2
//! bias V(p) = 0.5
`include "check.vh"
module ch04_cos(p, n);
  inout p, n;
  electrical p, n;
  analog begin
    `CHECK("cos(0.5 rad)", cos(V(p, n)), 0.8775825618903728, 1e-15);
    `CHECK("sin^2 + cos^2 = 1",
           sin(V(p, n)) * sin(V(p, n)) + cos(V(p, n)) * cos(V(p, n)), 1.0, 1e-15);
    I(p, n) <+ cos(V(p, n));
  end
endmodule
