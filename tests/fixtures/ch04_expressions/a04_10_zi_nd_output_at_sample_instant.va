// §4.5.12.4 defines zi_nd by its numerator and denominator in z^-1.
// With n={1,0}, d={1,-0.5}, the transfer function is
// H(z)=1/(1-0.5*z^-1), giving y[k]=u[k]+0.5*y[k-1]. The n[0] term
// uses the current sample; there is no extra z^-1 transport factor.
// This recurrence is not a unity transfer function, so §4.5.12's separate
// unity-filter example is not the justification for these values.
//
// tau=0 makes each output transition abrupt (§4.5.12). The filter is
// observed as a real expression and is not directly assigned to a branch.
// T=1 ns and each listed point is a sampling instant. Input u[0]=0 makes
// both the zero-history (§4.5.15) and DC steady-state initial value zero;
// u[k]=1 thereafter. Substitution gives y=0,1,1.5,1.75,1.875.
// Equivalently y[k]=2*(1-0.5^k), derived from the recurrence below.
//
//! lrm 4.5.12
//! lrm 4.5.15
//! lrm 4.5.12.4
//! lrm 4.5.12.4:1000
//! bias V(n) = 0
//! wave V(in) = 0, 1
//! time 0, 1n, 2n, 3n, 4n
//! analysis tran
//! print none
`include "check.vh"
module a04_zi_sample_instant(in, n);
    inout in, n;
    electrical in, n;

    real y;

    analog begin
        // Bound once: `CHECK*` expands its GOT twice and the CHECKI puts it in
        // the operand of a `||`, so the operator is evaluated here,
        // unconditionally, and both checks read the variable.
        y = zi_nd(V(in, n), '{1, 0}, '{1, -0.5}, 1n, 0);
        `CHECKEQ("the sample taken at t = k*T is the output of that sample",
                 y, 2.0 * (1.0 - pow(0.5, $abstime * 1e9)), 1e-12);
        // Literal and row-invariant: the accumulator has already passed the
        // input by the second sample. A one-sample lag is still at 1.0 there,
        // and a pass-through never exceeds 1.0 at all.
        `CHECKI("the recurrence has accumulated past its input by t = 2T",
                y > 1.0 || $abstime < 2n, 1);

        I(in, n) <+ 0.0;
    end
endmodule
