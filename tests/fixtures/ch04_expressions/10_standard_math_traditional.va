// LRM 4.3.1 Table 4-14, the "traditional" (unprefixed) spellings of the standard
// math functions. The one that actually traps a reader is `log`: Table 4-14 maps
// `ln(x)` to C `log` ("Natural logarithm") and `log(x)` to C `log10` ("Decimal
// logarithm"). The two assertions below are what separate them.
//
// The bias fixes x = abs(V(p,n)) + 1.0 = abs(0.5) + 1.0 = 1.5, chosen so that
// min/max/floor/ceil all have something to do (x != 2.0, x not an integer):
//   ln(1.5)    = 0.4054651081081644
//   log(1.5)   = 0.17609125905568124   (base 10 -- natural would be 0.40546...)
//   exp(1.5)   = 4.4816890703380645
//   sqrt(1.5)  = 1.224744871391589
//   min(1.5,2) = 1.5      max(1.5,2) = 2.0      abs(-1.5) = 1.5
//   pow(1.5,2) = 2.25 exactly           floor(1.5) = 1    ceil(1.5) = 2
// Summed left to right in the source order: 16.537990308893498.
//
//! lrm 4.3.1
//! lrm 4.3
//! lrm 4.3:1000
//! bias V(p) = 0.5
`include "check.vh"
module ch04_standard_math_traditional(p, n);
    inout p, n;
    electrical p, n;
    real x, value;

    analog begin
        x = abs(V(p, n)) + 1.0;
        value = ln(x) + log(x) + exp(x) + sqrt(x) +
                min(x, 2.0) + max(x, 2.0) + abs(-x) +
                pow(x, 2.0) + floor(x) + ceil(x);
        `CHECKR("ln is the natural logarithm", ln(x), 0.4054651081081644, 1e-14);
        `CHECKR("log is the base-10 logarithm", log(x), 0.17609125905568124, 1e-14);
        `CHECKX("floor truncates toward -inf", floor(x), 1.0);
        `CHECKX("ceil truncates toward +inf", ceil(x), 2.0);
        `CHECKR("sum of the ten calls at x = 1.5", value, 16.537990308893498, 1e-14);
        I(p, n) <+ value;
    end
endmodule
