// §4.7.2.3 Output arguments: "If the output argument is defined as an array
// then the argument passed into the function must be an analog variable or an
// array assignment pattern of analog variables of equivalent size."
//
// `out` is the two-element array formal `[0:1]`; the call passes a THREE-element
// pattern, which is not of equivalent size. The legal call, `fill(V(p),
// '{a, b})`, is 108_function_array_output_pattern.va.
//
// VerA used to crash on this (a debug-build panic in the copy-out loop over two
// lists of different lengths) instead of diagnosing it.
//
//! lrm 4.7.2.3
//! lrm 4.7.2.3:2
//! reject-only E0511
//! neighbour 108_function_array_output_pattern.va
`include "disciplines.vams"
module ch04_fn_array_out_size(p);
  inout p;
  electrical p;
  real a, b, c, dummy;

  analog function real fill;
    input x;
    output [0:1] out;
    real x, out[0:1];
    begin
      out[0] = x;
      out[1] = 2.0 * x;
      fill = x;
    end
  endfunction

  analog begin
    dummy = fill(V(p), '{a, b, c});
    I(p) <+ dummy + a + b + c;
  end
endmodule
