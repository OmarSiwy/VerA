// §4.3.1 Table 4-14: traditional-style `log(x)` is the DECIMAL logarithm (C
// `log10`), domain x > 0; the natural log is spelled `ln(x)`. Two arguments pin
// the base from both directions: log(10) must be 1 (any other base is not),
// and log(2) = 0.30102999566398119521..., nearest double 0.3010299956639812,
// where a natural log would answer 0.69315.
//
//! lrm 4.3.1
//! bias V(p) = 9.0
`include "check.vh"
module ch04_log10(p, n);
  inout p, n;
  electrical p, n;
  analog begin
    `CHECK("log(10) = 1, so the base is ten", log(abs(V(p, n)) + 1.0), 1.0, 1e-15);
    `CHECK("log(2) is log10, not ln", log(2.0), 0.3010299956639812, 1e-15);
    I(p, n) <+ log(abs(V(p, n)) + 1.0);
  end
endmodule
