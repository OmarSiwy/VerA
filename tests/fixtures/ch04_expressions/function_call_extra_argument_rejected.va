// §4.7.3: "The argument expressions are assigned to the declared inputs,
// outputs, and inouts in the order of their declaration." Each argument
// expression goes to one declared formal, in order.
//
// `f` declares one formal, `a`, and the call below passes two expressions. The
// second has no declared input, output or inout to be assigned to. The legal
// call is 28_user_function.va.
//
//! lrm 4.7.3
//! lrm 4.7.3:1001
//! reject-only E0511
//! neighbour 28_user_function.va
`include "disciplines.vams"
module ch04_function_call_extra_argument(p, n);
  inout p, n; electrical p, n;
  analog function real f;
    input a;
    real a;
    f = a;
  endfunction
  analog I(p, n) <+ f(1.0, 2.0) * V(p, n);
endmodule
