// §4.2.4: "For the case of the modulus operator where either argument is real,
// the operation performed is
//     a % b = ((a/b) < 0) ? (a - ceil(a/b)*b) : (a - floor(a/b)*b);"
// and "the result of a modulus operation takes the sign of the first operand".
//
// At V(p,n) = 5.5, b = 2.0:  5.5/2.0 = 2.75 >= 0, so the result is
//     5.5 - floor(2.75)*2.0 = 5.5 - 4.0 = 1.5.
// Negating the first operand takes the other arm: -5.5/2.0 = -2.75 < 0, so
//     -5.5 - ceil(-2.75)*2.0 = -5.5 - (-2.0)*2.0 = -1.5,
// i.e. the sign follows a and NOT the C-truncation-free floor form, which would
// have given +0.5. Every value here is exact in IEEE 754 binary.
//
// Table 4-6 "Examples of modulus operations" hands over five worked rows, all
// distributed between this fixture and 118_modulo_negative_divisor.va:
//
//     11 % 3      2     11/3 yields a remainder of 2.
//     12 % 3      0     12/3 yields no remainder.
//    -10 % 3     -1     The result takes the sign of the first operand.
//     11 % -3     2     The result takes the sign of the first operand.
//     10 % 3.75   2.5   [10 - floor(10/3.75)*3.75] yields a remainder of 2.5.
//
// -10 % 3 == -1 is the load-bearing row here: the sign comes from the FIRST
// operand, so a floor-modulus or Euclidean lowering returns +2 and passes every
// other row in the table. Its mirror image, 11 % -3 == 2, lives in
// 118_modulo_negative_divisor.va. Its former negative-divisor compilation
// limitation is historical, not a current rejection requirement.
//
// 10 % 3.75 goes through the real formula: 10/3.75 = 2.666... >= 0, so
// 10 - floor(2.666...)*3.75 = 10 - 2*3.75 = 2.5, exact in binary.
//
//! lrm 4.2.4
//! lrm 4.2.4:1003
//! bias V(p) = 5.5
`include "check.vh"
module ch04_modulo(p, n);
    inout p, n;
    electrical p, n;
    analog begin
        `CHECKX("5.5 % 2.0", V(p, n) % 2.0, 1.5);
        `CHECKX("-5.5 % 2.0 takes the sign of the first operand", (-V(p, n)) % 2.0, -1.5);
        `CHECKI("Table 4-6: 11 % 3", 11 % 3, 2);
        `CHECKI("Table 4-6: 12 % 3 divides exactly", 12 % 3, 0);
        `CHECKI("Table 4-6: -10 % 3 takes the sign of the first operand", (-10) % 3, -1);
        `CHECKX("Table 4-6: 10 % 3.75", 10 % 3.75, 2.5);
        I(p, n) <+ V(p, n) % 2.0;
    end
endmodule
