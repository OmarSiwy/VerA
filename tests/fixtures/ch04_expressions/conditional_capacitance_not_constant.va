// §4.2.12: "If expression1 evaluates to false (0), then expression3 is
// evaluated and used as the result of the conditional expression. If
// expression1 evaluates to true (any value other than zero (0)), then
// expression2 is evaluated and used as the result."
//
// The charge is q = V(p, n) * (V(p) > -0.1 ? 1p : 2p), so dq/dV(p, n) is 1 pF
// or 2 pF depending on x. The device must not declare `constant.c`
// (tools/contract.zig `Constant`: "g/c promise that dF/dx and dQ/dx do not
// depend on x ... A wrong promise silently freezes the Jacobian"). The
// resistive part, V(p, n) / 1k, is linear, so `constant.g` may stand: only
// the reactive claim is under test. The arms are constants; x reaches the
// capacitance only through the condition (#78).
//
// The testbench's const_check gate evaluates a second bias,
// x' = 1.5 x - 0.25 - 0.125 i for unknown i, and compares the charge rows'
// Jacobian there when the device declares `constant.c`. At the bias below
// V(p) = 0 takes the 1p arm; at x' V(p) = -0.25 - 0.125 i <= -0.25 takes the
// 2p arm, whichever index p has, so a false claim fails the run.
//
// The check, by hand: V(p) = 0 > -0.1 is true, so the capacitance is 1p.
//! lrm 4.2.12
//! bias V(p) = 0.0, V(n) = 0.0
//! checks 1
`include "check.vh"
module conditional_capacitance_not_constant(p, n);
  inout p, n;
  electrical p, n;
  real cq;
  analog begin
    cq = V(p) > -0.1 ? 1p : 2p;
    `CHECKX("V(p) > -0.1 takes expression2", cq, 1e-12);
    I(p, n) <+ V(p, n) / 1k;
    I(p, n) <+ ddt(V(p, n) * cq);
  end
endmodule
