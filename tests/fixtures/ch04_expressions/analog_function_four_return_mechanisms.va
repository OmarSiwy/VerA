// LRM 4.7.2: "There are four ways to return a value from an analog user-defined
// function: using the implicit analog user-defined function identifier variable,
// using a return statement, using an output argument, or using an inout argument."
// This fixture demonstrates all four return mechanisms working correctly.
//
// Corrected 2026-10-08 (construct only, the wants are unchanged): the analog
// block declared `real dummy, ret;` without a name. A.6.3 lets only a named
// block declare (E0290), so the block is `begin : body`.
//
//! lrm 4.7.2
//! lrm 4.7.2:1000
//! bias V(p) = 0.5
`include "check.vh"
module ch04_function_return_four_ways(p, n);
    inout p, n;
    electrical p, n;

    // Method 1: implicit function identifier variable
    analog function real via_identifier;
        input x;
        real x;
        begin
            via_identifier = x * 2.0;
        end
    endfunction

    // Method 2: return statement
    analog function real via_return;
        input x;
        real x;
        begin
            return x * 3.0;
        end
    endfunction

    // Method 3: output argument
    analog function real via_output;
        input x;
        output y;
        real x, y;
        begin
            y = x * 4.0;
            via_output = 0.0;
        end
    endfunction

    // Method 4: inout argument
    analog function real via_inout;
        inout x;
        real x;
        begin
            x = x * 5.0;
            via_inout = x;
        end
    endfunction

    analog begin : body
        real dummy, ret;
        `CHECKX("return via implicit identifier", via_identifier(1.0), 2.0);
        `CHECKX("return via return statement", via_return(1.0), 3.0);
        // Methods 3 and 4 write through an argument, so the call is bound to a
        // variable before it is asserted on: check.vh expands GOT twice (once
        // for the transcript column, once for the verdict), which calls the
        // function twice and writes through the argument twice. Written inline
        // this read `got=5 want=5 ok=0` and left `dummy` at 25.
        dummy = 1.0;
        ret = via_output(1.0, dummy);
        `CHECKX("return via output argument", ret, 0.0);
        `CHECKX("output argument received the value", dummy, 4.0);
        dummy = 1.0;
        ret = via_inout(dummy);
        `CHECKX("return via inout argument", ret, 5.0);
        `CHECKX("inout argument was modified", dummy, 5.0);
        I(p, n) <+ via_identifier(V(p, n));
    end
endmodule
