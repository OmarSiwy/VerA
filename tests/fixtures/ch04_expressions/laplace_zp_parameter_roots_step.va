// §4.5.11.1 laplace_zp with its zeros and poles read from parameter ARRAYS,
// which §4.5.11 allows ("the vector may be represented as either a literal
// vector or a reference to a vector parameter"):
//
//   H(s) = ∏ (1 − s/ζ_k) / ∏ (1 − s/ρ_k),  ζ = −3, −4,  ρ = −1 ± j, −2 ± 3j.
//
// The card sets the imaginary parts, so VerA pairs the roots when the model
// is evaluated (specification/Vague_Decisions.md, `zRootSecs`) instead of at compile
// time; this fixture holds that pairing to the closed-form step response
// and to the same filter with literal roots.
//
// HAND DERIVATION. The pole pairs multiply out to 1 + s + s²/2 and
// 1 + (4/13)s + s²/13, so with K = 13/6
//   H(s) = K (s + 3)(s + 4) / ((s² + 2s + 2)(s² + 4s + 13)),  H(0) = 1.
// The step response is L⁻¹[H(s)/s]; the residue of H(s)/s at ρ is
// K(ρ+3)(ρ+4) / (ρ · q'(ρ) · q_other(ρ)):
//   at −1 + j:  −39/68 + (13/102)j,   at −2 + 3j:  5/68 + (61/612)j,
// and each conjugate pair gives 2·Re(r e^{ρt}), so
//   y(t) = 1 + e^{−t}(−39/34 cos t − 13/51 sin t)
//            + e^{−2t}(5/34 cos 3t − 61/306 sin 3t).
// Check: y(0) = 1 − 39/34 + 5/34 = 0, and y'(0) = 39/34 − 13/51 − 10/34
// − 61/102 = 0 (relative degree 2).
//
// THE DISCRETE STEP. The input is 0 at the operating point and 1 from the
// first step on, a 5 ms grid. The trapezoidal rule (§4.5.11's transient
// realisation, specification/Vague_Decisions.md) sees that as a ramp across the first
// step, whose response is y(t − dt/2) to O(dt²); with ρ up to |−2 + 3j| =
// 3.6 rad/s and t ≤ 4 s the trapezoidal phase error ω³·t·dt²/12 stays below
// 4e-4 of the 0.25 amplitude of the fast mode. Replaying that recurrence by
// hand over the 801 points puts its worst deviation from y(t − dt/2) at
// 7.0e-6, so the band is 2e-5 absolute.
//
// The closed form is asserted from 0.2 s on. Before that y is small (it
// starts as t², relative degree 2) and a 0.1% error in the want hides inside
// the band plus that deviation (the replay's last such point is 0.155 s), so
// a check there could not see one (`benchmark -- --perturb`). The literal-root
// agreement is asserted at every point: 761 + 801 = 1562 verdicts.
//
// The closed form is a function of $abstime, so it is a CHECKEQ: no finite
// list of digits states it at 801 points. Its coefficients are the hand
// residues above, written as literals. The literal-root filter is the same
// H(s) built by the compile-time pairing; the two agree to rounding, 1e-12.
//
//! lrm 4.5.11.1
//! bias V(n) = 0
//! checks 1562
//! time 0, 0.005, 0.01, 0.015, 0.02, 0.025, 0.03, 0.035, 0.04, 0.045, 0.05, 0.055, 0.06, 0.065, 0.07, 0.075, 0.08, 0.085, 0.09, 0.095, 0.1, 0.105, 0.11, 0.115, 0.12, 0.125, 0.13, 0.135, 0.14, 0.145, 0.15, 0.155, 0.16, 0.165, 0.17, 0.175, 0.18, 0.185, 0.19, 0.195, 0.2, 0.205, 0.21, 0.215, 0.22, 0.225, 0.23, 0.235, 0.24, 0.245, 0.25, 0.255, 0.26, 0.265, 0.27, 0.275, 0.28, 0.285, 0.29, 0.295, 0.3, 0.305, 0.31, 0.315, 0.32, 0.325, 0.33, 0.335, 0.34, 0.345, 0.35, 0.355, 0.36, 0.365, 0.37, 0.375, 0.38, 0.385, 0.39, 0.395, 0.4, 0.405, 0.41, 0.415, 0.42, 0.425, 0.43, 0.435, 0.44, 0.445, 0.45, 0.455, 0.46, 0.465, 0.47, 0.475, 0.48, 0.485, 0.49, 0.495, 0.5, 0.505, 0.51, 0.515, 0.52, 0.525, 0.53, 0.535, 0.54, 0.545, 0.55, 0.555, 0.56, 0.565, 0.57, 0.575, 0.58, 0.585, 0.59, 0.595, 0.6, 0.605, 0.61, 0.615, 0.62, 0.625, 0.63, 0.635, 0.64, 0.645, 0.65, 0.655, 0.66, 0.665, 0.67, 0.675, 0.68, 0.685, 0.69, 0.695, 0.7, 0.705, 0.71, 0.715, 0.72, 0.725, 0.73, 0.735, 0.74, 0.745, 0.75, 0.755, 0.76, 0.765, 0.77, 0.775, 0.78, 0.785, 0.79, 0.795, 0.8, 0.805, 0.81, 0.815, 0.82, 0.825, 0.83, 0.835, 0.84, 0.845, 0.85, 0.855, 0.86, 0.865, 0.87, 0.875, 0.88, 0.885, 0.89, 0.895, 0.9, 0.905, 0.91, 0.915, 0.92, 0.925, 0.93, 0.935, 0.94, 0.945, 0.95, 0.955, 0.96, 0.965, 0.97, 0.975, 0.98, 0.985, 0.99, 0.995, 1, 1.005, 1.01, 1.015, 1.02, 1.025, 1.03, 1.035, 1.04, 1.045, 1.05, 1.055, 1.06, 1.065, 1.07, 1.075, 1.08, 1.085, 1.09, 1.095, 1.1, 1.105, 1.11, 1.115, 1.12, 1.125, 1.13, 1.135, 1.14, 1.145, 1.15, 1.155, 1.16, 1.165, 1.17, 1.175, 1.18, 1.185, 1.19, 1.195, 1.2, 1.205, 1.21, 1.215, 1.22, 1.225, 1.23, 1.235, 1.24, 1.245, 1.25, 1.255, 1.26, 1.265, 1.27, 1.275, 1.28, 1.285, 1.29, 1.295, 1.3, 1.305, 1.31, 1.315, 1.32, 1.325, 1.33, 1.335, 1.34, 1.345, 1.35, 1.355, 1.36, 1.365, 1.37, 1.375, 1.38, 1.385, 1.39, 1.395, 1.4, 1.405, 1.41, 1.415, 1.42, 1.425, 1.43, 1.435, 1.44, 1.445, 1.45, 1.455, 1.46, 1.465, 1.47, 1.475, 1.48, 1.485, 1.49, 1.495, 1.5, 1.505, 1.51, 1.515, 1.52, 1.525, 1.53, 1.535, 1.54, 1.545, 1.55, 1.555, 1.56, 1.565, 1.57, 1.575, 1.58, 1.585, 1.59, 1.595, 1.6, 1.605, 1.61, 1.615, 1.62, 1.625, 1.63, 1.635, 1.64, 1.645, 1.65, 1.655, 1.66, 1.665, 1.67, 1.675, 1.68, 1.685, 1.69, 1.695, 1.7, 1.705, 1.71, 1.715, 1.72, 1.725, 1.73, 1.735, 1.74, 1.745, 1.75, 1.755, 1.76, 1.765, 1.77, 1.775, 1.78, 1.785, 1.79, 1.795, 1.8, 1.805, 1.81, 1.815, 1.82, 1.825, 1.83, 1.835, 1.84, 1.845, 1.85, 1.855, 1.86, 1.865, 1.87, 1.875, 1.88, 1.885, 1.89, 1.895, 1.9, 1.905, 1.91, 1.915, 1.92, 1.925, 1.93, 1.935, 1.94, 1.945, 1.95, 1.955, 1.96, 1.965, 1.97, 1.975, 1.98, 1.985, 1.99, 1.995, 2, 2.005, 2.01, 2.015, 2.02, 2.025, 2.03, 2.035, 2.04, 2.045, 2.05, 2.055, 2.06, 2.065, 2.07, 2.075, 2.08, 2.085, 2.09, 2.095, 2.1, 2.105, 2.11, 2.115, 2.12, 2.125, 2.13, 2.135, 2.14, 2.145, 2.15, 2.155, 2.16, 2.165, 2.17, 2.175, 2.18, 2.185, 2.19, 2.195, 2.2, 2.205, 2.21, 2.215, 2.22, 2.225, 2.23, 2.235, 2.24, 2.245, 2.25, 2.255, 2.26, 2.265, 2.27, 2.275, 2.28, 2.285, 2.29, 2.295, 2.3, 2.305, 2.31, 2.315, 2.32, 2.325, 2.33, 2.335, 2.34, 2.345, 2.35, 2.355, 2.36, 2.365, 2.37, 2.375, 2.38, 2.385, 2.39, 2.395, 2.4, 2.405, 2.41, 2.415, 2.42, 2.425, 2.43, 2.435, 2.44, 2.445, 2.45, 2.455, 2.46, 2.465, 2.47, 2.475, 2.48, 2.485, 2.49, 2.495, 2.5, 2.505, 2.51, 2.515, 2.52, 2.525, 2.53, 2.535, 2.54, 2.545, 2.55, 2.555, 2.56, 2.565, 2.57, 2.575, 2.58, 2.585, 2.59, 2.595, 2.6, 2.605, 2.61, 2.615, 2.62, 2.625, 2.63, 2.635, 2.64, 2.645, 2.65, 2.655, 2.66, 2.665, 2.67, 2.675, 2.68, 2.685, 2.69, 2.695, 2.7, 2.705, 2.71, 2.715, 2.72, 2.725, 2.73, 2.735, 2.74, 2.745, 2.75, 2.755, 2.76, 2.765, 2.77, 2.775, 2.78, 2.785, 2.79, 2.795, 2.8, 2.805, 2.81, 2.815, 2.82, 2.825, 2.83, 2.835, 2.84, 2.845, 2.85, 2.855, 2.86, 2.865, 2.87, 2.875, 2.88, 2.885, 2.89, 2.895, 2.9, 2.905, 2.91, 2.915, 2.92, 2.925, 2.93, 2.935, 2.94, 2.945, 2.95, 2.955, 2.96, 2.965, 2.97, 2.975, 2.98, 2.985, 2.99, 2.995, 3, 3.005, 3.01, 3.015, 3.02, 3.025, 3.03, 3.035, 3.04, 3.045, 3.05, 3.055, 3.06, 3.065, 3.07, 3.075, 3.08, 3.085, 3.09, 3.095, 3.1, 3.105, 3.11, 3.115, 3.12, 3.125, 3.13, 3.135, 3.14, 3.145, 3.15, 3.155, 3.16, 3.165, 3.17, 3.175, 3.18, 3.185, 3.19, 3.195, 3.2, 3.205, 3.21, 3.215, 3.22, 3.225, 3.23, 3.235, 3.24, 3.245, 3.25, 3.255, 3.26, 3.265, 3.27, 3.275, 3.28, 3.285, 3.29, 3.295, 3.3, 3.305, 3.31, 3.315, 3.32, 3.325, 3.33, 3.335, 3.34, 3.345, 3.35, 3.355, 3.36, 3.365, 3.37, 3.375, 3.38, 3.385, 3.39, 3.395, 3.4, 3.405, 3.41, 3.415, 3.42, 3.425, 3.43, 3.435, 3.44, 3.445, 3.45, 3.455, 3.46, 3.465, 3.47, 3.475, 3.48, 3.485, 3.49, 3.495, 3.5, 3.505, 3.51, 3.515, 3.52, 3.525, 3.53, 3.535, 3.54, 3.545, 3.55, 3.555, 3.56, 3.565, 3.57, 3.575, 3.58, 3.585, 3.59, 3.595, 3.6, 3.605, 3.61, 3.615, 3.62, 3.625, 3.63, 3.635, 3.64, 3.645, 3.65, 3.655, 3.66, 3.665, 3.67, 3.675, 3.68, 3.685, 3.69, 3.695, 3.7, 3.705, 3.71, 3.715, 3.72, 3.725, 3.73, 3.735, 3.74, 3.745, 3.75, 3.755, 3.76, 3.765, 3.77, 3.775, 3.78, 3.785, 3.79, 3.795, 3.8, 3.805, 3.81, 3.815, 3.82, 3.825, 3.83, 3.835, 3.84, 3.845, 3.85, 3.855, 3.86, 3.865, 3.87, 3.875, 3.88, 3.885, 3.89, 3.895, 3.9, 3.905, 3.91, 3.915, 3.92, 3.925, 3.93, 3.935, 3.94, 3.945, 3.95, 3.955, 3.96, 3.965, 3.97, 3.975, 3.98, 3.985, 3.99, 3.995, 4
//! analysis tran
//! print none
`include "check.vh"
module laplace_zp_parameter_roots_step(p, n);
  inout p, n;
  electrical p, n;
  parameter real z[0:3] = '{-3.0, 0.0, -4.0, 0.0};
  parameter real r[0:7] = '{-1.0, 1.0, -2.0, 3.0, -1.0, -1.0, -2.0, -3.0};
  real u, y, yl, tc;
  analog begin
    u = $abstime > 0.0 ? 1.0 : 0.0;
    y = laplace_zp(u, z, r);
    yl = laplace_zp(u, '{-3.0, 0.0, -4.0, 0.0}, '{-1.0, 1.0, -2.0, 3.0, -1.0, -1.0, -2.0, -3.0});
    tc = max($abstime - 0.0025, 0.0);
    if ($abstime > 0.1975)
      `CHECKEQ("the step response of the parameter-root filter",
             y, 1.0 + exp(-tc) * (-39.0/34.0 * cos(tc) - 13.0/51.0 * sin(tc))
                 + exp(-2.0 * tc) * (5.0/34.0 * cos(3.0 * tc) - 61.0/306.0 * sin(3.0 * tc)), 2e-5);
    `CHECKEQ("the same filter with literal roots", y, yl, 1e-12);
    I(p, n) <+ 0.0;
  end
endmodule
