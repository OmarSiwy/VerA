// §4.5.8, the two identities in "If td is not specified, it is taken to be
// zero (0.0). If only a positive rise_time value is specified, the simulator
// uses it for both rise and fall times."
//
//      transition(x)         == transition(x, 0)
//      transition(x, 0, 4n)  == transition(x, 0, 4n, 4n)
//
// A `default_transition 8n in force makes the second pair non-trivial: the
// absent fall time must come from the lone rise time (4n), not from the
// directive (8n). The input falls from 1 to 0 at t = 1n, so the fall time is
// the one in use; a lowering that filled the absent fall from the directive
// sits at 1 - d/8n where the explicit fall sits at 1 - d/4n once d > 0.
//
// CHECKEQ, because §4.5.8 states the identities and no digit: the ramps'
// digits cancel from both sides, and the same kernel fed the same numbers
// agrees exactly.
//
//! lrm 4.5.8
//! lrm 4.5.8:1001
//! analysis tran
//! time 0, 1n, 2n, 3n
//! wave V(in) = 1, 0
//! bias V(n) = 0
//! print none
`default_transition 8n
`include "check.vh"
module ch04_transition_default_td_and_fall(in, n);
  inout in, n;
  electrical in, n;
  analog begin
    `CHECKEQ("an absent td is td = 0",
             transition(V(in, n)), transition(V(in, n), 0), 0.0);
    `CHECKEQ("a lone rise time is the fall time too, whatever the directive says",
             transition(V(in, n), 0, 4n), transition(V(in, n), 0, 4n, 4n), 0.0);
    `CHECK("omitting td starts the default fall at the input change",
             transition(V(in, n)) - (1.0 - min(max($abstime / 1n - 1.0, 0.0) / 8.0, 1.0)),
             0.0, 1e-12);
    `CHECK("a lone positive rise time gives an independent four-ns falling ramp",
             transition(V(in, n), 0, 4n) - (1.0 - min(max($abstime / 1n - 1.0, 0.0) / 4.0, 1.0)),
             0.0, 1e-12);
    I(in, n) <+ 0.0;
  end
endmodule
