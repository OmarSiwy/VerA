// §4.6 small-signal source functions: "When not active, the small-signal source
// functions return zero (0)." A dc analysis is not a small-signal analysis, so
// all four noise sources contribute EXACTLY zero here — not their power
// argument, not its square root, not a random draw. That is the property the
// operating point depends on: a resistor's thermal noise must not perturb its
// own dc bias.
//
// $temperature is pinned too (§9.10, kelvin), because the thermal-noise power
// 4kT/R is written in terms of it one line below.
//
// The four calls also declare four INDEPENDENT generators on one branch
// (§4.6.4.6: "each noise function generates noise which is uncorrelated with
// the noise generated by other functions"), which the `//! noise` lines assert
// — the zero above is the same for all four, so nothing else here can tell them
// apart. §4.6.4.3/.4 export one `table` kind between them; which of the two
// interpolations applies is the table's own mode, not the row's tag.
//
//! lrm 4.6
//! lrm 4.6.4
//! lrm 4.6:1000
//! lrm 4.6.4:1000
//! noise thermal(p,n)#0
//! noise flicker(p,n)#1
//! noise table(p,n)#2
//! noise table(p,n)#3
//! analysis dc
//! temp 300.15
//! bias V(p) = 1.0
`include "check.vh"
module ch04_noise_sources(p, n);
    inout p, n;
    electrical p, n;
    parameter real resistance = 1000.0 from (0:inf);
    real thermal, flicker, tbl, tbl_log;

    analog begin
        thermal = white_noise(4.0 * 1.380649e-23 * $temperature / resistance, "thermal");
        flicker = flicker_noise(1e-20, 1.0, "flicker");
        tbl     = noise_table('{1.0, 1e-18, 1e6, 1e-24}, "linear-table");
        tbl_log = noise_table_log('{1.0, 1e-18, 1e6, 1e-24}, "log-table");

        `CHECKX("$temperature is the declared ambient in kelvin", $temperature, 300.15);
        `CHECKX("white_noise is inactive outside a small-signal analysis", thermal, 0.0);
        `CHECKX("flicker_noise is inactive outside a small-signal analysis", flicker, 0.0);
        `CHECKX("noise_table is inactive outside a small-signal analysis", tbl, 0.0);
        `CHECKX("noise_table_log is inactive outside a small-signal analysis", tbl_log, 0.0);

        I(p, n) <+ thermal;
        I(p, n) <+ flicker;
        I(p, n) <+ tbl;
        I(p, n) <+ tbl_log;
    end
endmodule
