// Device for flicker_psd_frequency.sp. The live noise sweep observes the
// frequency dependence; this device fixture observes its exported coefficient.
//! lrm 4.6.4.2
//! noise flicker(p,n)#0 name=flick flicker=1e-18 ef=2
//! bias V(p) = 1.0, V(n) = 0.0
`include "check.vh"
module flicker_psd_frequency(p,n);
    inout p,n;
    electrical p,n;
    analog begin
        `CHECK("the deterministic conductance is one millisiemens",
               ddx(V(p,n)/1000.0, V(p)), 0.001, 1e-15);
        I(p,n) <+ V(p,n)/1000.0 + flicker_noise(1e-18, 2.0, "flick");
    end
endmodule
