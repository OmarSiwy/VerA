// LRM 4.7.3: an analog user-defined function "shall not call itself directly or
// indirectly, i.e., recursive functions are not permitted". `recurse` names
// itself in its own body, which is the direct case, so the module is illegal
// however the ?: guard is written -- the ban is on the call graph, not on
// whether a base case exists.
//! reject E0510
module ch4_fn_direct(p); inout p; electrical p; analog function real recurse; input x; real x; recurse=(x>0.0)?recurse(x-1.0):0.0; endfunction analog I(p)<+V(p); endmodule
