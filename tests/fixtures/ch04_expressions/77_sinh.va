// sinh() (LRM 4.3.2 Table 4-15): hyperbolic sine, (e^x - e^-x) / 2, all x.
`include "check.vh"
//! lrm 4.3.2
//! bias V(p) = 1.0
module ch04_sinh(p, n);
  inout p, n; electrical p, n;
  analog begin
    I(p, n) <+ sinh(V(p, n));
    // (e - 1/e) / 2 = (2.718281828459045 - 0.36787944117144233) / 2.
    `CHECK("sinh(1)", sinh(V(p, n)), 1.1752011936438014, 1e-15);
    // Odd function: sinh(0) = 0 and sinh(-1) = -sinh(1).
    `CHECKX("sinh(0) = 0", sinh(0.0), 0.0);
    `CHECK("sinh(-1)", sinh(-1.0), -1.1752011936438014, 1e-15);
  end
endmodule
