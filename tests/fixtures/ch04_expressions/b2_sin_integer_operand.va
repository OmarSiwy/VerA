// §4.3.2 Transcendental functions: "All operands shall be numeric (integer or
// real) and are converted to real if necessary."
//
// The integer 1 is converted to 1.0 before the function is applied:
// sin(1) = 0.84147098480789650665..., nearest double 0.8414709848078965.
// An integer-valued sin would answer 0 (or 1).
//
// The legal neighbour of b2_sin_string_operand_rejected.va: the two differ
// only in the operand's declared type (integer here, string there).
//
//! lrm 4.3.2
//! lrm 4.3.2:1
//! bias V(p) = 0.5
//! bias V(n) = 0.0
//! checks 1
`include "check.vh"
module b2_sin_integer_operand(p, n);
    inout p, n;
    electrical p, n;
    integer s;
    real x;

    analog begin
        s = 1;
        x = sin(s);
        `CHECK("sin of the integer 1 is sin(1.0)", x, 0.8414709848078965, 1e-15);
        I(p, n) <+ x * V(p, n);
    end
endmodule
