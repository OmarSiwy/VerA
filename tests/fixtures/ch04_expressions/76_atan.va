// atan() (LRM 4.3.2 Table 4-15): arc-tangent, defined for all x, result in
// radians (4.3.2 makes the return value of the inverse trig functions radians).
`include "check.vh"
//! lrm 4.3.2
//! bias V(p) = 1.0
module ch04_atan(p, n);
  inout p, n; electrical p, n;
  analog begin
    I(p, n) <+ atan(V(p, n));
    // tan(pi/4) = 1, so atan(1) = pi/4 = 0.7853981633974483 rad.
    `CHECK("atan(1) = pi/4", atan(V(p, n)), 0.7853981633974483, 1e-15);
    // atan is odd and passes through the origin.
    `CHECKX("atan(0) = 0", atan(0.0), 0.0);
    `CHECK("atan(-1) = -pi/4", atan(-1.0), -0.7853981633974483, 1e-15);
  end
endmodule
