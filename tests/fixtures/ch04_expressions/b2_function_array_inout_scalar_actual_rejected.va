// §4.7.2.4 Inout arguments: "If the inout argument is defined as an array then
// the argument passed into the function must be an analog variable or an array
// assignment pattern of analog variables of equivalent size."
//
// `a` is the two-element inout formal [0:1]; the call passes the scalar `u`,
// which is neither a two-element array variable nor a two-element pattern.
// The legal neighbour, b2_function_array_inout_pattern_actual.va, passes
// '{u, v} and differs only in that.
//
//! lrm 4.7.2.4
//! lrm 4.7.2.4:2
//! reject-only E0511
//! neighbour b2_function_array_inout_pattern_actual.va
`include "disciplines.vams"
module b2_function_array_inout_scalar_actual_rejected(p);
    inout p;
    electrical p;
    real u, v, w, y, z, dummy;

    analog function real arrayadd;
        inout [0:1] a;
        input [0:1] b;
        real a[0:1], b[0:1];
        integer i;
        begin
            for (i = 0; i < 2; i = i + 1) begin
                a[i] = a[i] + b[i];
            end
        end
    endfunction

    analog begin
        u = 5; v = 10; w = 0; y = 3; z = 6;
        dummy = arrayadd(u, '{y, z});
        I(p) <+ (u + v + w + dummy) * V(p);
    end
endmodule
