// LRM 4.7.2.2, verbatim: "The return statement shall OVERRIDE any value
// assigned to the function name."
//
// The sentence only says something if there IS a value assigned to the function
// name for the return to beat. So `choose` assigns its identifier variable a
// deliberately wrong -99.0 first, on the line before the return: the wants
// below are reachable only through the override, and a compiler that took the
// last assignment to the identifier variable — 4.7.2.1's rule, which is the
// right rule in the absence of a return — reads -99.0 for both.
//
//     choose(0.75,  0.0) = 0.75   (first > second)
//     choose(-2.5, -1.5) = -1.5   (second > first, and the answer is negative,
//                                  so a "max with 0" mis-lowering cannot pass)
//
// 4.7.2.1 is the other half and gets its own function: "This internal variable
// is initialized to zero (0) if the inherited type is numerical ... If this
// internal variable is not assigned during the execution of the analog
// user-defined function, then the analog user-defined function will return the
// variable's default initial value." `untouched` assigns nothing and returns
// nothing, so it is 0.0 — not the argument it was handed, and not garbage.
//
// (4.7.2 lists "using a return statement" as one of the four ways to return a
// value from an analog user-defined function, and 4.7.2.2 prints the statement
// itself — `return (n1 > n2) ? n1 : n2;`. This file used to be named
// `_rejected` and apologise for it in its header; the source is legal and
// always was. function_bare_return_rejected.va is the return statement
// being used illegally.)
//
// Formals carry a direction and a separate type declaration: A.2.1.2's
// `input_declaration` has no `real` slot, so `input real first;` is not
// Verilog-AMS.
//
//! lrm 4.7.2.1
//! lrm 4.7.2.1:1001
//! lrm 4.7.2.2
//! lrm 4.7.2.2:1
//! bias V(p) = 0.75
`include "check.vh"
module ch04_function_return(p, n);
    inout p, n;
    electrical p, n;

    analog function real choose;
        input first, second;
        real first, second;
        begin
            choose = -99.0;
            return first > second ? first : second;
        end
    endfunction

    analog function real untouched;
        input ignored;
        real ignored;
        begin
        end
    endfunction

    analog function string untouched_string;
        input ignored;
        real ignored;
        begin
        end
    endfunction

    analog function real last_assignment;
        input x;
        real x;
        begin
            last_assignment = -99.0;
            last_assignment = x;
        end
    endfunction

    analog begin
        `CHECKX("return overrides the value assigned to the function name",
                choose(V(p, n), 0.0), 0.75);
        `CHECKX("and it overrides it in the second arm too",
                choose(-2.5, -1.5), -1.5);
        `CHECKX("an unassigned identifier variable returns the numeric default",
                untouched(7.0), 0.0);
        `CHECKI("an unassigned string identifier variable returns the empty string",
                untouched_string(7.0) == "", 1);
        `CHECKX("without return the last identifier assignment wins",
                last_assignment(2.5), 2.5);
        I(p, n) <+ choose(V(p, n), 0.0);
    end
endmodule
