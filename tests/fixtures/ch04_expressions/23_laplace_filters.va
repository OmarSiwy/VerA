// §4.5.11 the four Laplace filter forms. A DC operating point pins H(0), which
// each form spells differently — that is the whole reason there are four of
// them, and a compiler that confused two of the argument lists reads the wrong
// one.
//
//   laplace_zp(x, '{-1,0}, '{-1,-1,-1,1})   §4.5.11.1
//     H(s) = (1 - s/(-1)) / ((1 - s/(-1-j))(1 - s/(-1+j)))
//     every (1 - s/r) factor is 1 at s=0, so H(0) = 1.
//
//   laplace_zd(x, '{-1,0}, '{1,2})          §4.5.11.2
//     H(s) = (1 + s) / (1 + 2s), so H(0) = 1/1 = 1.
//
//   laplace_np(x, '{0,1}, '{-1,0})          §4.5.11.3
//     H(s) = (0 + 1*s) / (1 + s). The numerator is a COEFFICIENT vector, not a
//     root vector, so its constant term is 0 and H(0) = 0.
//
//   laplace_nd(x, '{0,1}, '{1,2,1})         §4.5.11.4
//     H(s) = s / (1 + 2s + s^2), so H(0) = 0/1 = 0.
//
// With V(p,n) = 1 V the outputs are therefore 1, 1, 0, 0. The two zeros are
// what bites: a filter lowered as a pass-through, or one that read '{0,1} as a
// pair of roots instead of coefficients, reads 1 there.
//
//! bias V(p) = 1.0
//! bias V(n) = 0.0
`include "check.vh"
module ch04_laplace_filters(p, n);
    inout p, n;
    electrical p, n;
    real y_zp, y_zd, y_np, y_nd;

    analog begin
        y_zp = laplace_zp(V(p, n), '{-1.0, 0.0}, '{-1.0, -1.0, -1.0, 1.0});
        y_zd = laplace_zd(V(p, n), '{-1.0, 0.0}, '{1.0, 2.0});
        y_np = laplace_np(V(p, n), '{0.0, 1.0}, '{-1.0, 0.0});
        y_nd = laplace_nd(V(p, n), '{0.0, 1.0}, '{1.0, 2.0, 1.0});

        `CHECK("laplace_zp DC gain is every root factor at s=0", y_zp, 1.0, 1e-12);
        `CHECK("laplace_zd DC gain is 1/d0", y_zd, 1.0, 1e-12);
        `CHECK("laplace_np DC gain is n0, which is zero here", y_np, 0.0, 1e-12);
        `CHECK("laplace_nd DC gain is n0/d0, and n0 is zero here", y_nd, 0.0, 1e-12);

        I(p, n) <+ y_zp;
        I(p, n) <+ y_zd;
        I(p, n) <+ y_np;
        I(p, n) <+ y_nd;
    end
endmodule
