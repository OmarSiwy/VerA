// §4.5.6 ddx inside a §4.6.4.1 noise power: the small-signal conductance a
// SPICE channel-noise formula reads (4kT·(2/3)·gm), here without the
// constants so the power is the derivative itself.
//
// i = 0.5·V(p,n)², so ddx(i, V(p)) = V(p,n). At V(p) = 2, V(n) = 0 that is
// 2.0, in `eval` (the CHECKR) and in the noise power alike: §4.6.4.1's
// white_noise(pwr) "generates white noise with a power of pwr", and pwr is
// this ddx. Before #32 the noise core ran on value-only inputs and read 0.
//
// BY HAND: white = |ddx(0.5·V², V(p))| at V(p,n) = 2 is 2.0 A²/Hz.
//
// THE COUNT, from tb/runner.zig: one CHECKR, then the runner's noise lines
// for one `//! noise` entry: the table count, the row's topology, its name
// and its white density. 1 + 4 = 5.
//
//! lrm 4.5.6
//! lrm 4.6.4.1
//! noise thermal(p,n)#0 name=g white=2.0
//! analysis noise
//! bias V(p) = 2.0, V(n) = 0.0
//! checks 5
`include "check.vh"
module ddx_in_noise_power(p, n);
  inout p, n; electrical p, n;
  real i;
  analog begin
    i = 0.5 * V(p, n) * V(p, n);
    `CHECKR("ddx(0.5 V^2, V(p)) in eval is V(p,n) = 2", ddx(i, V(p)), 2.0, 1e-14);
    I(p, n) <+ i;
    I(p, n) <+ white_noise(abs(ddx(i, V(p))), "g");
  end
endmodule
