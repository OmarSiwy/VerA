// LRM 5.2.1/4.7.2: analog operators are forbidden inside an analog function.
//! reject E0422
module ch4_op_function(p); inout p; electrical p; analog function real stateful; input x; real x; stateful=ddt(x); endfunction analog I(p)<+stateful(V(p)); endmodule
