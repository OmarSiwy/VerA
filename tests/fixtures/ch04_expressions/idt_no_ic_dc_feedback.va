// §4.5.4 an idt() with NO initial condition, inside a negative feedback loop:
// its DC value is whatever the loop settles on, not zero.
//
//   "When used in DC or IC analyses, idt() returns the initial condition (ic)
//    if specified. If not specified, the idt operator must be contained within
//    a negative feedback loop that forces its argument to zero."
//
//   Table 4-18, idt(expr): "c is the initial starting point as determined by
//   the simulator and is generally the DC value (the value that makes expr
//   equal to zero)."
//
// The clause's own opamp example (`V(out) <+ idt(V(pin,nin))`) says the same:
// "the initial condition for the integrator is found by the simulator,
// generally the DC operating point is used."
//
// THE HAND DERIVATION. The output drives its own input, V(o) <+ idt(V(i) - V(o)).
// At DC the loop forces the argument to zero, V(i) - V(o) = 0, so with V(i)
// biased at 0.75 the output is 0.75. An implementation that answers a no-ic
// idt with 0 in DC reads V(o) = 0 and leaves the argument at 0.75 — the loop
// the clause requires is then not closed.
//
// `//! solve` frees V(o) and the source's branch current, so the value is the
// solution of the device's own equations, not a harness write.
//
//! lrm 4.5.4
//! bias V(i) = 0.75
//! solve
//! print none
//! xfail C1: a no-ic idt answers 0 at DC instead of the value its feedback loop forces
`include "check.vh"
module idt_no_ic_dc_feedback(i, o);
    inout i, o;
    electrical i, o;

    analog begin
        V(o) <+ idt(V(i) - V(o));
        `CHECK("the feedback loop drives the no-ic integrator to V(i)", V(o), 0.75, 1e-12);
        `CHECK("and the argument it integrates to zero", V(i) - V(o), 0.0, 1e-12);
    end
endmodule
