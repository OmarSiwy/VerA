// §4.7.2.4 Inout arguments: "If the inout argument is defined as an array then
// the argument passed into the function must be an analog variable or an array
// assignment pattern of analog variables of equivalent size. ... At the end of
// the execution of the analog user-defined function, the last value assigned to
// the inout argument is then assigned to the corresponding analog variable
// reference that was passed into the function."
//
// 109_function_array_inout_pattern.va passes an array VARIABLE to the inout
// formal. This file passes the other legal form: a two-element assignment
// pattern of analog variables, '{u, v}, to the two-element inout `a`.
//
// HAND DERIVATION. arrayadd is §4.7.1 Example 3 verbatim: a[i] = a[i] + b[i].
// u = 5, v = 10 copy in through the pattern, b = '{y, z} = '{3, 6}, and the
// copy-out writes a[0] = 8 back to u and a[1] = 16 back to v. y and z feed
// an input formal and are not written. arrayadd never assigns arrayadd, so
// §4.7.2.1's zero-initialized function variable makes dummy 0.
//
// The legal neighbour of b2_function_array_inout_pattern_size_rejected.va and
// b2_function_array_inout_scalar_actual_rejected.va.
//
//! lrm 4.7.2.4
//! lrm 4.7.2.4:2
//! checks 5
`include "check.vh"
module b2_function_array_inout_pattern_actual(p);
    inout p;
    electrical p;
    real u, v, w, y, z, dummy;

    analog function real arrayadd;
        inout [0:1] a;
        input [0:1] b;
        real a[0:1], b[0:1];
        integer i;
        begin
            for (i = 0; i < 2; i = i + 1) begin
                a[i] = a[i] + b[i];
            end
        end
    endfunction

    analog begin
        u = 5; v = 10; w = 0; y = 3; z = 6;
        dummy = arrayadd('{u, v}, '{y, z});
        `CHECKX("the pattern's first variable gets a[0] = 5 + 3", u, 8.0);
        `CHECKX("the pattern's second variable gets a[1] = 10 + 6", v, 16.0);
        `CHECKX("the input pattern is not written back: y", y, 3.0);
        `CHECKX("the input pattern is not written back: z", z, 6.0);
        `CHECKX("an unassigned function identifier variable returns zero", dummy, 0.0);
        I(p) <+ (u + v + w + dummy) * V(p);
    end
endmodule
