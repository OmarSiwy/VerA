// §4.5.11.2 laplace_zd — the zero-DENOMINATOR form. Its zeros are given as
// real/imaginary pairs like `laplace_zp`'s, and its denominator as polynomial
// COEFFICIENTS like `laplace_nd`'s, which is the whole reason the clause exists
// as a form of its own.
//
//     H(s) = ∏(k=0..M-1) (1 - s/(ζkr + j·ζki)) / Σ(k=0..N-1) dk·s^k
//
// At s = 0 every factor of the product is (1 - 0) = 1 and every term of the sum
// but the constant one vanishes, so H(0) = 1/d0 exactly — the zeros cannot
// affect it, whatever they are. That is what makes it a digit a reader derives
// from the clause instead of from a simulation: with d = {4.0, 1.0}, H(0) is
// 1/4, and the zero at -2 is there precisely to prove it does not move it.
//
// `//! analysis dc` is what puts the filter at s = 0: dt is zero in a static
// analysis, and the discretization short-circuits to the DC gain rather than
// integrating toward it. So this is exact, not a settled approximation — and
// `CHECKX` says so.
//
// Corrected 2026-10-08 (construct only, the wants are unchanged): the
// coefficient vectors were VAMS 2.x concatenations, `{...}`. A.8.2's
// analog_filter_function_arg is a parameter, a part of one or a `'{...}`
// assignment pattern (annex G: "Add apostrophe before opening { in list of
// values"), and a concatenation there is E0572
// (reject_4_5_11_concatenation_coefficients.va), so each is now `'{...}`.
// The empty `{}` zeros are now the null argument, which §4.5.11 gives the
// same meaning: "The zeros argument may be represented as a null argument".
//
//! lrm 4.5.11.2
//! lrm 4.5.11
//! lrm 4.5.11:1
//! analysis dc
//! bias V(in) = 1.0
//! bias V(n) = 0.0
`include "check.vh"
module ch04_laplace_zd_dc_gain(in, n);
    inout in, n;
    electrical in, n;
    real y, y_no_zero;

    analog begin
        y = laplace_zd(V(in, n), '{-2.0, 0.0}, '{4.0, 1.0});
        // The same denominator with NO zeros at all. §4.5.11.2's product over
        // an empty vector is 1, so this must land on the identical number, and
        // a lowering that folded a zero into the DC term would separate them.
        y_no_zero = laplace_zd(V(in, n), , '{4.0, 1.0});
        `CHECKX("H(0) = 1/d0 with one zero", y, 0.25);
        `CHECKX("H(0) = 1/d0 with no zeros — a zero cannot move it", y_no_zero, 0.25);
        I(in, n) <+ 0.0;
    end
endmodule
