// §4.5 "Analog operators are functions which operate on more than just the
// current value of their arguments. Instead, they maintain their internal state
// and their output is a function of both the input and the internal state."
//
// The positive statement of the clause, which its only other cite (185, the
// limexp constant-expression rejection) does not reach. The operand below is
// the SAME constant, 1e9, at every time point — so a function of "just the
// current value" of its argument would return the same number every time. The
// time integral does not: its internal state accumulates.
//
// DERIVATION. idt(1e9, 0.0) with initial condition 0 is the exact integral
// 1e9 * t of a constant, which every integration formula reproduces (the
// trapezoidal rule and backward Euler both integrate a constant exactly):
//
//     t      0     1n    2n    3n
//     idt    0.0   1.0   2.0   3.0
//
// The check pins that value against a closed form in $abstime alone, at every
// point. Since the operand is the same 1e9 at all four points and the output
// runs 0, 1, 2, 3, the output is not a function of the operand's current value:
// the clause's point, with no second assertion needed. (A "did the value change
// since last evaluation" check was considered and dropped: §4.2.1 keeps a
// variable across Newton ITERATIONS as well as time points, so on a second
// iteration at one time point it would compare the output with itself, and a
// conforming implementation that iterates twice would fail it.)
//
//! lrm 4.5
//! lrm 4.5.4
//! lrm 4.5:1000
//! analysis tran
//! time 0, 1n, 2n, 3n
//! print none
`include "check.vh"
module ch04_analog_operator_keeps_internal_state(p, n);
    inout p, n;
    electrical p, n;
    real y;

    analog begin
        y = idt(1e9, 0.0);
        `CHECK("§4.5 idt of a constant is the accumulated 1e9*t", y - 1e9 * $abstime, 0.0, 1e-9);
        I(p, n) <+ V(p, n);
    end
endmodule
