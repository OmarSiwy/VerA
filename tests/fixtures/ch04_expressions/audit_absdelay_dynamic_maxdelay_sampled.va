// AMS4.5.14 printedp86: dynamic expressions passed to constant slots take
// their analysis-start value; later changes are ignored. Table4-20 identifies
// absdelay maxdelay as such a slot. 4.5.7 substitutes maxdelay when td exceeds it.
// Here td=2ns, maxdelay initially1ns, later4ns. Sampling freezes maxdelay1ns,
// hence Output(t)=Input(max(t-1ns,0)) for input=t/ns. Expected at 0..4ns:
// 0,0,1,2,3. Incorrectly resampling maxdelay gives 0 at2ns instead of1.
// This is not the separate rule freezing td when maxdelay is omitted.
//! lrm 4.5.14
//! lrm 4.5.7
//! checks 5
//! xfail Dynamic maxdelay in a constant slot is rejected E0515 instead of sampled at analysis start
//! bias V(n) = 0
//! wave V(d) = 1, 1, 4, 4, 4
//! time 0, 1n, 2n, 3n, 4n
//! analysis tran
//! print none
`include "check.vh"
module audit_absdelay_dynamic_maxdelay_sampled(d, n);
    inout d, n;
    electrical d, n;
    analog begin
        `CHECK("maxdelay sampled at analysis start", absdelay($abstime * 1e9, 2n, V(d,n)*1n) - max($abstime*1e9-1.0, 0.0), 0.0, 1e-12);
        I(d,n) <+ 0.0;
    end
endmodule
