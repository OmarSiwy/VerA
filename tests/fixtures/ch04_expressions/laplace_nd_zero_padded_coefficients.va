// §4.5.11.4 a laplace_nd whose coefficient vectors are PARAMETER ARRAYS
// longer than the polynomial they hold, the tail filled with zeros. This is
// how a port of HSPICE LAPLACE writes a fixed-size coefficient table.
//
//   §4.5.11.4: "H(s) = (Σk=0..M-1 nk s^k) / (Σk=0..N-1 dk s^k) where nk is
//    the coefficient of the k th power of s in the numerator and dk is the
//    coefficient of the k th power of s in the denominator."
//   §4.5.11: "For arguments that require a vector, the vector may be
//    represented as either a literal vector or a reference to a vector
//    parameter."
//
// A zero coefficient of s^k contributes 0·s^k to the sum, so the padded and
// unpadded vectors below are the SAME H(s), and a conforming filter returns
// the same waveform for both. Both are written out in the module.
//
//   n = '{1}                 npad[0:15] = '{1, 0, ..., 0}
//   d = '{1, 2tau, tau^2}    dpad[0:15] = '{1, 2tau, tau^2, 0, ..., 0}
//
//   H(s) = 1 / (1 + 2 tau s + tau^2 s^2) = 1 / (1 + s tau)^2,   tau = 10 ns
//
// a critically damped second-order low-pass.
//
// THE HAND DERIVATION. Driven from rest by the unit ramp u(t) = t/1ns
// (written $abstime*1e9, so the oracle shares no probe with the operator),
// with a = 1/tau,
//
//   Y(s) = a^2 / (s^2 (s + a)^2)
//        = 1/s^2 - 2tau/s + 1/(s + a)^2 + 2tau/(s + a)
//
// (the four residues: s^2 Y at 0 is 1; d/ds of it at 0 is -2/a; (s+a)^2 Y at
// -a is 1; d/ds of that at -a is 2/a). Inverting, in ns:
//
//   y(t) = tns - 20 + (tns + 20) exp(-tns/10)
//
// Sample values: y(10ns) = 1.0363832, y(20ns) = 5.4134113, y(60ns) = 40.0173512.
//
// THE TOLERANCE, DERIVED. Uniform grid dt = 0.5 ns = tau/20, as
// a04_11_laplace_nd_ramp_response.va. VerA realises the filter with the
// trapezoidal (bilinear) transform; replaying that recurrence by hand over
// these 121 points (degree 2, history at rest) puts its worst deviation from
// the closed form at 6.44e-4 (t = 26 ns). The asserted tolerance is 1e-3.
//
// WHY THIS FIXTURE EXISTS. Discretising the padded section at its DECLARED
// degree 15 clears both sides by (1+z^-1)^15 instead of (1+z^-1)^2: thirteen
// cancelling poles sit on z = -1, the Nyquist frequency, and roundoff moves
// them off it. Replaying that untrimmed recurrence on this grid leaves the
// 1e-3 band at t = 21 ns, reads 49.09 against 29.99 at 49.5 ns, and is out by
// 770 at 60 ns. Trimmed to the effective degree the two vectors take the same
// arithmetic, so they agree to roundoff (1e-12) at every point.
//
// The closed-form check is made from 10.5 ns on: before that the response is
// small enough that a 0.1% error in its want hides inside the band plus the
// discretisation error (the same replay: the last such point is 9.5 ns), so a
// check there could not see one (`benchmark -- --perturb`). The padded/unpadded
// agreement is asserted at every point.
//
// 121 + 100 = 221 verdicts.
//
//! lrm 4.5.11.4
//! lrm 4.5.11
//! lrm 4.5.11:2
//! bias V(p) = 0
//! bias V(n) = 0
//! time 0, 0.5n, 1n, 1.5n, 2n, 2.5n, 3n, 3.5n, 4n, 4.5n, 5n, 5.5n, 6n, 6.5n, 7n, 7.5n, 8n, 8.5n, 9n, 9.5n, 10n, 10.5n, 11n, 11.5n, 12n, 12.5n, 13n, 13.5n, 14n, 14.5n, 15n, 15.5n, 16n, 16.5n, 17n, 17.5n, 18n, 18.5n, 19n, 19.5n, 20n, 20.5n, 21n, 21.5n, 22n, 22.5n, 23n, 23.5n, 24n, 24.5n, 25n, 25.5n, 26n, 26.5n, 27n, 27.5n, 28n, 28.5n, 29n, 29.5n, 30n, 30.5n, 31n, 31.5n, 32n, 32.5n, 33n, 33.5n, 34n, 34.5n, 35n, 35.5n, 36n, 36.5n, 37n, 37.5n, 38n, 38.5n, 39n, 39.5n, 40n, 40.5n, 41n, 41.5n, 42n, 42.5n, 43n, 43.5n, 44n, 44.5n, 45n, 45.5n, 46n, 46.5n, 47n, 47.5n, 48n, 48.5n, 49n, 49.5n, 50n, 50.5n, 51n, 51.5n, 52n, 52.5n, 53n, 53.5n, 54n, 54.5n, 55n, 55.5n, 56n, 56.5n, 57n, 57.5n, 58n, 58.5n, 59n, 59.5n, 60n
//! analysis tran
//! print none
//! checks 221
`include "check.vh"
module laplace_nd_zero_padded_coefficients(p, n);
    inout p, n;
    electrical p, n;
    parameter real tau = 1e-8;
    parameter real nlit[0:0] = '{1.0};
    parameter real dlit[0:2] = '{1.0, 2.0 * tau, tau * tau};
    parameter real npad[0:15] = '{1.0, 0.0, 0.0, 0.0, 0.0, 0.0, 0.0, 0.0,
                                  0.0, 0.0, 0.0, 0.0, 0.0, 0.0, 0.0, 0.0};
    parameter real dpad[0:15] = '{1.0, 2.0 * tau, tau * tau, 0.0, 0.0, 0.0, 0.0, 0.0,
                                  0.0, 0.0, 0.0, 0.0, 0.0, 0.0, 0.0, 0.0};
    real tns, ylit, ypad;

    analog begin
        tns = $abstime * 1e9;
        ylit = laplace_nd(tns, nlit, dlit);
        ypad = laplace_nd(tns, npad, dpad);
        `CHECKEQ("zero-padded coefficient vectors give the unpadded filter's output",
                 ypad, ylit, 1e-12);
        if (tns > 10.25)
            `CHECKEQ("the padded filter follows the ramp response of 1/(1+s*tau)^2",
                     ypad, tns - 20.0 + (tns + 20.0) * exp(-tns / 10.0), 1e-3);
        I(p, n) <+ 0.0;
    end
endmodule
