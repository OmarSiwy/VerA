// §4.6.2: "The analysis("nodeset") function call shall return true only during
// the phase of an operating point analysis in which nodeset values are
// applied; that phase may occur in a single-point dc analysis or the first
// point of a multipoint dc sweep analysis, but does not occur for subsequent
// points of a dc sweep."
//
// "May occur" leaves the first point open, so nothing is asserted about it.
// What is fixed is the rest: at points 2 and 3 of one sweep, no evaluation may
// see analysis("nodeset") true.
//
// The record is a running maximum over the evaluations that saw "nodeset":
// `if (analysis("nodeset") && v > ns_max) ns_max = v;`, carried from point to
// point (§4.6.2, b2_dc_sweep_variables_carry_to_next_point.va). The sweep is
// V(p) = 0.25, 0.5, 0.75, so a nodeset phase at the first point can leave at
// most 0.25 behind, and one at a later point leaves 0.5 or 0.75. The check
// is ns_max <= 0.25 at every point, an integer 1 (§4.2.5). An implementation
// that answered "nodeset" at every dc point fails it at points 2 and 3.
//
//! lrm 4.6.2
//! lrm 4.6.2:2
//! analysis dc
//! sweep V(p) = 0.25, 0.5, 0.75
//! bias V(n) = 0.0
//! checks 3
`include "check.vh"
module b2_dc_sweep_nodeset_only_first_point(p, n);
    inout p, n;
    electrical p, n;
    real ns_max;

    analog begin
        if (analysis("nodeset") && V(p, n) > ns_max)
            ns_max = V(p, n);
        `CHECKI("no nodeset phase after the first point of the sweep", ns_max <= 0.25, 1);
        I(p, n) <+ V(p, n);
    end
endmodule
