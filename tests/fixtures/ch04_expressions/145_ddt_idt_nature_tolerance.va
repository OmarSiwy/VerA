// LRM 4.5.3 Table 4-17 and 4.5.4 Table 4-18 each end with a NATURE form:
//
//     ddt(expr, nature)                 "Same as above, except nature is
//                                        specified explicitly."
//     idt(expr, ic, assert, nature)     "Same as above, except the absolute
//                                        tolerance used to control the error in
//                                        the numerical integration process is
//                                        taken from the specified nature."
//
// A nature — 3.6.1 — carries an `abstol`, and naming one here is how a model
// says "resolve this integral to the precision of a charge" without writing the
// number. The alternative spelling, the bare abstol, is pinned by 14_ddt.va and
// 15_idt.va; this is the half where the tolerance comes from annex D's
// disciplines.vams instead of a literal.
//
// The tolerance changes no value — 4.5.3: it "is the largest signal level that
// is considered negligible" — so the wants are the same ones the two siblings
// assert: 4.5.3's "In DC analysis, ddt() returns zero (0)", and 4.5.4's "When
// used in DC or IC analyses, idt() returns the initial condition (ic) if
// specified". The claim being made is that the SHAPE is accepted.
//
//! lrm 4.5.3
//! lrm 4.5.4
//! xfail VerA does not resolve a nature identifier as an analog operator argument: `ddt(V(p,n), Current)` and `idt(I(p,n), 5.0, 0, Charge)` both raise E0314 "unknown identifier", with or without an explicit `include "disciplines.vams"
//! print none
`include "disciplines.vams"
`include "check.vh"
module ch04_ddt_idt_nature_tolerance(p, n);
    inout p, n;
    electrical p, n;

    analog begin
        `CHECKX("ddt(expr, nature) still returns zero in DC", ddt(V(p, n), Current), 0.0);
        `CHECKX("idt(expr, ic, assert, nature) still returns ic in DC",
                idt(I(p, n), 5.0, 0, Charge), 5.0);
        I(p, n) <+ V(p, n);
    end
endmodule
