// §4.6.2: "Verilog-AMS supports a single-point dc analysis and also a
// multipoint dc sweep analysis in which multiple dc points are computed over a
// sweep of parameter values. ... The analysis("dc") and analysis("static")
// function calls shall return true for a single-point dc analysis and also for
// every dc point in a sweep analysis."
//
// 26_analysis.va pins the single-point half. This is the sweep half: three dc
// points of ONE sweep (`//! sweep` with no `//! time` line makes the points the
// steps of one dc sweep, not three analyses), and at every one of them both
// calls must answer 1 and the calls naming the other analyses 0 (Table 4-22's
// "DC Sweep" d1/d2/dN columns: "tran", "ac", "noise" and "ic" are 0 at every
// point). A runner that treated only the first point as dc — the one where the
// clause's nodeset phase occurs — fails the second and third.
//
// §4.6.2's other two duties — carrying variable values from one sweep point to
// the next, and NOT carrying them between two independent sweeps — are the
// simulator's; the one-sweep runner cannot run two sweeps, so they are not
// claimed here (tests/fixtures/ch04_expressions/CLAUSES.tsv says why no source
// can break them).
//
//! lrm 4.6.2
//! lrm 4.6.2:1
//! lrm 4.6.1
//! analysis dc
//! sweep V(p) = 0.2, 0.4, 0.6
//! bias V(n) = 0.0
`include "check.vh"
module ch04_dc_sweep_every_point_is_dc_and_static(p, n);
    inout p, n;
    electrical p, n;

    analog begin
        `CHECKI("analysis(\"dc\") at this point of the dc sweep", analysis("dc"), 1);
        `CHECKI("analysis(\"static\") at this point of the dc sweep", analysis("static"), 1);
        `CHECKI("analysis(\"tran\") at this point of the dc sweep", analysis("tran"), 0);
        `CHECKI("analysis(\"ac\") at this point of the dc sweep", analysis("ac"), 0);
        `CHECKI("analysis(\"noise\") at this point of the dc sweep", analysis("noise"), 0);
        `CHECKI("analysis(\"ic\") at this point of the dc sweep", analysis("ic"), 0);

        I(p, n) <+ V(p, n);
    end
endmodule
