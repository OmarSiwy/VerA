// §4.3.1 Standard mathematical functions: "The operands shall be numeric
// (integer or real)."
//
// `s` is a §3.3 string VARIABLE. Table 3-3 gives strings comparison,
// concatenation and replication and no arithmetic or numeric conversion, so
// `ln(s)` has a non-numeric operand. (A string LITERAL operand is a different
// case: §2.7 treats it as an unsigned integer constant, so ln("abc") is not
// what this file refuses.)
//
// The legal neighbour, b2_ln_integer_operand.va, differs only in s's type.
//
//! lrm 4.3.1
//! lrm 4.3.1:1
//! reject-only E0321
//! neighbour b2_ln_integer_operand.va
`include "disciplines.vams"
module b2_ln_string_operand_rejected(p, n);
    inout p, n;
    electrical p, n;
    string s;
    real x;

    analog begin
        s = "abc";
        x = ln(s);
        I(p, n) <+ x * V(p, n);
    end
endmodule
