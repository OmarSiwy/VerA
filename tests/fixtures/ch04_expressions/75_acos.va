// acos() is defined only for -1 <= x <= 1 (LRM 4.3.2 Table 4-15); a node
// voltage is unbounded, so the call is guarded into that domain.
`include "check.vh"
//! lrm 4.3.2
//! bias V(p) = 0.5
module ch04_acos(p, n);
  inout p, n; electrical p, n;
  analog begin
    if (V(p, n) >= -1.0)
      if (V(p, n) <= 1.0)
        I(p, n) <+ acos(V(p, n));
    // cos(pi/3) = 1/2, so acos(1/2) = pi/3 = 1.0471975511965979 rad.
    `CHECK("acos(0.5) = pi/3", acos(V(p, n)), 1.0471975511965979, 1e-15);
    // The two domain endpoints of Table 4-15: cos(0) = 1, cos(pi) = -1.
    `CHECKX("acos(1) = 0", acos(1.0), 0.0);
    `CHECK("acos(-1) = pi", acos(-1.0), 3.141592653589793, 1e-15);
  end
endmodule
