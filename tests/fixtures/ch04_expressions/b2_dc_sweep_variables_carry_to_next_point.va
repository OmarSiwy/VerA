// §4.6.2: "During a dc sweep analysis, the values of variables at the
// conclusion of the operating point analysis for one dc point shall be used as
// the starting values for those variables for the next dc point."
//
// `//! sweep` with no `//! time` line is ONE dc sweep of three points
// (dc_sweep_every_point_is_dc_and_static.va says why), V(p) = 0.75, 0.25, 0.5.
//
// The observed variables are running maxima, `if (v > peak) peak = v;`. A
// maximum is idempotent, so its value at the conclusion of a point does not
// depend on how many Newton iterations the point took or which iterate an
// implementation keeps: it is the largest bias seen so far, provided the
// value is carried from point to point.
//
// HAND DERIVATION.
//   point 1: V = 0.75, peak starts at 0 (§4.6.2 re-initialization), ends 0.75
//   point 2: V = 0.25, peak STARTS at 0.75 (carried), 0.25 < 0.75, stays 0.75
//   point 3: V = 0.5,  peak starts at 0.75, stays 0.75
// so peak = 0.75 at every point; a simulator that restarted each dc point from
// zero reads 0.75, 0.25, 0.5. The integer `ipeak` runs the same maximum over
// level = V * 4 (§4.2.1.1 rounds 3.0, 1.0, 2.0 to 3, 1, 2): 3 at every point.
// Both exact, so CHECKX/CHECKI. Two checks at each of three points.
//
//! lrm 4.6.2
//! lrm 4.6.2:3
//! analysis dc
//! sweep V(p) = 0.75, 0.25, 0.5
//! bias V(n) = 0.0
//! checks 6
`include "check.vh"
module b2_dc_sweep_variables_carry_to_next_point(p, n);
    inout p, n;
    electrical p, n;
    real peak;
    integer level, ipeak;

    analog begin
        if (V(p, n) > peak)
            peak = V(p, n);
        level = V(p, n) * 4.0;
        if (level > ipeak)
            ipeak = level;
        `CHECKX("a real carried from point to point: the largest bias so far", peak, 0.75);
        `CHECKI("an integer carried from point to point: the largest level so far", ipeak, 3);
        I(p, n) <+ V(p, n);
    end
endmodule
