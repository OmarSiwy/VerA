// §9.11 Conversion System Functions, in full:
//
//   "Verilog AMS HDL extends the conversion functions defined in IEEE Std 1364
//    Verilog so that $bitstoreal and $realtobits,$rtoi and $itor can be used in
//    the analog context."
//
// FOUR NAMES, and Table 9-8 — under §9.2, the heading that owns every Table
// 9-1..9-20 — gives the whole family its two columns:
//
//   $bitstoreal   digital Yes   analog Yes
//   $itor         digital Yes   analog Yes
//   $signed       digital Yes   analog No
//   $realtobits   digital Yes   analog Yes
//   $rtoi         digital Yes   analog Yes
//   $unsigned     digital Yes   analog No
//
// Exactly TWO of the six analog cells are "No", and the suite already pins both
// from the refusing side:
// tests/fixtures/ch09_system_tasks/134_signed_analog_rejected.va and
// 135_unsigned_analog_rejected.va. $rtoi is not one of them. §9.11 names it and
// §9.2's table grants it — and until this file nothing in the suite said so,
// because the two fixtures that used to stand here asserted the opposite and
// have been withdrawn. DO NOT take 134's header as the text of §9.11: it still
// quotes the pre-2023 sentence in which only $bitstoreal and $realtobits cross
// the boundary. The clause has said four names since 2023.
//
// Annex G records the change and misspells the function while doing it —
// item 7920 reads "Add support for $roi() and $itor() in the analog context",
// clause column "9-8, 9.11". `$roi` is a typo in the change table; §9.11 is the
// normative text and it says `$rtoi`.
//
// WHAT $rtoi DOES WITH ITS ARGUMENT. §1.1 is what imports the function at all:
// "Verilog-AMS HDL consists of the complete IEEE Std 1364 Verilog specification
// ... and extensions to both". IEEE Std 1364-2005 §17.8 defines $rtoi to
// convert a real to an integer BY TRUNCATING, i.e. toward zero.
//
// THE RULE IT IS NOT. §4.2.1.1 is the conversion this suite uses everywhere
// else, and it is the opposite rule, in its own words:
//
//   "Real numbers are converted to integers by rounding the real number to the
//    nearest integer, rather than by truncating it. Implicit conversion takes
//    place when a real number is assigned to an integer. If the fractional part
//    of the real number is exactly 0.5, it shall be rounded away from zero.
//    Examples: The real numbers 35.7 and 35.5 both become 36 when converted to
//    an integer and 35.2 becomes 35. Converting -1.5 to integer yields -2,
//    converting 1.5 to integer yields 2."
//
// Lowering $rtoi onto the implicit conversion the compiler already has is the
// cheapest imaginable implementation and it is wrong at every fractional
// argument and at every sign. Two of the six assertions below are §4.2.1.1's
// OWN worked examples, 1.5 and -1.5, with the answers that clause does not give
// — so the cheap mistake fails on the clause it was borrowed from.
//
// HAND DERIVATION. §3.2: "The real variables are stored as 64-bit quantities,
// as described by IEEE Std 754, an IEEE standard for double precision floating
// point numbers." So every argument below is the nearest double, not the
// decimal a reader sees.
//
//   `//! bias V(p) = 1.7` against the grounded `n` row puts V(p,n) at the
//   double nearest 1.7, which is not 1.7:
//
//     1.7  ->  0x3FFB333333333333
//          =   1.6999999999999999555910790149937383830547332763671875
//
//   Truncation toward zero drops everything after the point:
//
//     $rtoi(V(p, n))        ->  1     (want 1)
//     $rtoi(0.0 - V(p, n))  ->  -1    (want -1)
//
//   0.0 - x is exact for a representable x, so the second argument is exactly
//   -1.6999999999999999555910790149937383830547332763671875. Truncation toward
//   zero gives -1; FLOOR gives -2; §4.2.1.1 gives -2. The negative half is the
//   one that separates the three rules, and it is the one a sign-blind `trunc`
//   gets wrong, so it is worth two of the six lines.
//
//     $rtoi(1.5)   ->  1    (§4.2.1.1's own example says 2)
//     $rtoi(-1.5)  ->  -1   (§4.2.1.1's own example says -2)
//     $rtoi(3.0)   ->  3    an exact integer, where all four candidate rules
//                           agree. It is here to pin that nothing is ADDED
//                           before the truncation, i.e. that the rule is not
//                           floor(x + 0.5), which is the other cheap spelling.
//
//   The sixth argument is the one whose real representation is inexact, and it
//   is also a boundary case. 2.0e-16 is not representable:
//
//     2.0e-16  ->  0x1.cd2b297d889bcp-53
//              =   2028240960365167 / 10141204801825835211973625643008
//
//   and 1.0 minus it lands on no double at all. The exact difference,
//   10141204801825833183732665277841 / 10141204801825835211973625643008, lies
//   between 1 - 2**-53 and 1 - 2**-52 and is nearer the latter, so
//
//     1.0 - 2.0e-16  ->  0x3FEFFFFFFFFFFFFE = 1 - 2**-52
//                    =   0.9999999999999997779553950749686919152736663818359375
//
//   two ulps under 1.0. $rtoi gives 0; rounding to nearest gives 1; so does any
//   implementation that compares against an epsilon instead of truncating. It
//   is also the only argument here that is not a literal, which makes it the
//   line that pins the conversion as operating on the value the expression
//   actually has rather than on a decimal re-reading of its source text.
//
// WHY IT CANNOT PASS BY ACCIDENT. Four candidate rules, four answer vectors:
//
//   rule                  1.7  -1.7  1.5  -1.5  3.0  0.9999999999999998
//   truncate toward zero   1    -1    1    -1    3    0     <- wanted
//   §4.2.1.1 nearest       2    -2    2    -2    3    1
//   floor                  1    -2    1    -2    3    0
//   floor(x + 0.5)         2    -2    2    -1    3    1
//
// None of the three wrong vectors matches the wanted one, and the wanted one is
// not producible by any mix of them, so a green run is evidence for truncation
// rather than for a coincidence.
//
// STATUS. VerA refuses all six today with
//
//   error[E0806]: system task is not supported in the analog context: `$rtoi`
//     = note: LRM 9.2
//
// i.e. it applies Table 9-8's analog "No" column to a row whose analog cell
// reads "Yes". The E0806 explain text names the same wrong set ("Table 9-8 —
// $itor, $rtoi, $signed and $unsigned"), so the compiler's own justification is
// the pre-2023 reading of §9.11 and not a decision about $rtoi. That is the
// implementation's error and not the fixture's. **THIS FIXTURE FAILS TODAY**, which is
// why it lives here: the compiler refuses a legal call site.

//! lrm 9.2
//! lrm 9.11
//! lrm 4.2.1.1
//! lrm 4.2.1.1:1
//! lrm G.1
//! lrm 9.2:1000
//! lrm 9.11:1000
//! bias V(p) = 1.7
//! print none
`include "check.vh"
module a01_rtoi_truncates_toward_zero(p, n);
  inout p, n;
  electrical p, n;

  analog begin
    `CHECKI("$rtoi truncates a positive real toward zero", $rtoi(V(p, n)), 1);
    `CHECKI("and a negative one toward zero, not down", $rtoi(0.0 - V(p, n)), -1);
    `CHECKI("$rtoi(1.5) is 1, where 4.2.1.1 says 2", $rtoi(1.5), 1);
    `CHECKI("$rtoi(-1.5) is -1, where 4.2.1.1 says -2", $rtoi(-1.5), -1);
    `CHECKI("an exact integer is unchanged, so nothing is added first", $rtoi(3.0), 3);
    `CHECKI("an argument two ulps under 1.0 still truncates to 0", $rtoi(1.0 - 2.0e-16), 0);

    I(p, n) <+ V(p, n);
  end
endmodule
