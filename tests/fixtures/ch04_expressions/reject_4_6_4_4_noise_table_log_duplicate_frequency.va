// §4.6.4.4 (noise_table_log): "The argument input can either be a vector or a
// string indicating a filename; in either case, the meaning and restrictions
// on the input are the same as for noise_table()."
//
// One of those restrictions, from §4.6.4.3: "Each frequency value must be
// unique." The vector '{1.0, 1e-20, 1.0, 2e-20} gives frequency 1 Hz twice
// (with two different powers), so the table is invalid for noise_table_log
// exactly as it is for noise_table. With the second frequency changed to 10.0
// the same call compiles (probed).
//
// 183_noise_table_duplicate_frequency_rejected.va pins the §4.6.4.3 sentence
// for noise_table itself; this file is the logarithmic form, which inherits it.
//
//! lrm 4.6.4.4
//! lrm 4.6.4.4:1001
//! reject-only E0519
//! neighbour a06_noisetables_a06_ntab.assets_a06_ntab_log.va
//! reject appears twice
`include "disciplines.vams"
module ch4_noise_table_log_duplicate(p, n);
  inout p, n;
  electrical p, n;

  analog I(p, n) <+ noise_table_log('{1.0, 1e-20, 1.0, 2e-20});
endmodule
