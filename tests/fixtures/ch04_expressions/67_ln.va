// §4.3.1 Table 4-14: traditional-style `ln(x)` is the NATURAL logarithm (C
// `log`), domain x > 0 — not the decimal one, which Table 4-14 spells `log(x)`.
// The bias makes abs(V(p,n)) + 1.0 = 2.0 exactly, so the result is
// ln(2) = 0.69314718055994530942..., nearest double 0.6931471805599453. A
// log10 implementation would answer 0.30103, so this pins the base.
//
//! lrm 4.3.1
//! bias V(p) = -1.0
`include "check.vh"
module ch04_ln(p, n);
  inout p, n;
  electrical p, n;
  analog begin
    `CHECK("ln(2) is the natural log, not log10",
           ln(abs(V(p, n)) + 1.0), 0.6931471805599453, 1e-15);
    I(p, n) <+ ln(abs(V(p, n)) + 1.0);
  end
endmodule
