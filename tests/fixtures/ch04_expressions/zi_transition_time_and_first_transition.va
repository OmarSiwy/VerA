// §4.5.12: "All Z-transform filters share three common arguments: T, τ, and
// t0. ... If the transition time is specified and is non-zero, the timestep
// is controlled to accurately resolve both the leading and trailing corner of
// the transition. ... If the transition time is specified as zero (0), then
// the output is abruptly discontinuous. ... Finally t0 specifies the time of
// the first transition".
//
// Both filters are unity sample-and-holds (H(z) = 1, "samples every T seconds
// and exhibits no delay") with T = 2n and t0 = 1n, so samples fall at 1n, 3n,
// 5n, ...; `ramp` has τ = 1n, `step` has τ = 0. The input is 1 until 1n, 2 from
// 1n, 4 from 3n. Before the first transition the output holds the operating
// point's value, H(1) * 1 = 1 (VerA's reading: the clause gives no value
// before t0, and the DC solve's is the one the output already has). Each
// sample starts a transition from wherever the output is:
//
//   t      0    0.5n  1n   1.5n  2n   2.5n  3n   3.5n  4n
//   in     1    1     2    2     2    2     4    4     4
//   ramp   1    1     1    1.5   2    2     2    3     4     (linear over 1n)
//   step   1    1     2    2     2    2     4    4     4     (at the sample)
//
// At 1n `ramp` has just begun its 1 -> 2 transition (0 of 1n elapsed) and
// at 1.5n it is halfway, 1.5; it ends at 2n. At 3n the 2 -> 4 transition
// begins, halfway (3) at 3.5n. Without t0 the samples would fall at 0, 2n,
// 4n and `step` would still read 1 at 1n and 1.5n; without τ `ramp` would
// equal `step`.
// The fixed-grid testbench evaluates exactly the declared points, so every
// value above is read at its own point.
//
// The refusal neighbour is zi_negative_transition_time_rejected.va (τ < 0);
// 24_z_transform_filters.va is the τ/t0-free form.
//
// Corrected 2026-10-08 (construct only, the wants are unchanged): the
// coefficient vectors were VAMS 2.x concatenations, `{...}`. A.8.2's
// analog_filter_function_arg is a parameter, a part of one or a `'{...}`
// assignment pattern (annex G: "Add apostrophe before opening { in list of
// values"), and a concatenation there is E0572
// (reject_4_5_11_concatenation_coefficients.va), so each is now `'{...}`.
//
//! lrm 4.5.12
//! analysis tran
//! time 0, 0.5n, 1n, 1.5n, 2n, 2.5n, 3n, 3.5n, 4n
//! wave V(in) = 1, 1, 2, 2, 2, 2, 4, 4, 4
//! bias V(n) = 0
//! checks 18
`include "check.vh"
module zi_transition_time_and_first_transition(in, n);
  inout in, n; electrical in, n;
  real ramp, step;
  analog begin
    ramp = zi_nd(V(in, n), '{1.0}, '{1.0}, 2n, 1n, 1n);
    step = zi_nd(V(in, n), '{1.0}, '{1.0}, 2n, 0, 1n);
    `CHECK("tau = 1n: a linear transition from each sample",
           ramp - (($abstime > 3.75n) ? 4.0 : ($abstime > 3.25n) ? 3.0 : ($abstime > 1.75n) ? 2.0 : ($abstime > 1.25n) ? 1.5 : 1.0),
           0.0, 1e-9);
    `CHECK("tau = 0: abrupt at the samples t0 + k*T",
           step - (($abstime > 2.75n) ? 4.0 : ($abstime > 0.75n) ? 2.0 : 1.0),
           0.0, 1e-9);
    I(in, n) <+ 0.0;
  end
endmodule
