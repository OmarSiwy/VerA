// LRM 4.2.3 lists THREE short-circuiting operators: "Some operators (&&, ||,
// and ?:) shall use short-circuit evaluation ... When short circuiting occurs,
// any side effects or runtime errors that would have occurred due to evaluation
// of the short-circuited operand expression shall not occur."
//
// `?:` is the third, and 4.2.12 says the same thing from the value side: "If
// expression1 evaluates to false (0), then expression3 is evaluated and used as
// the result" — expression2 is not mentioned, because it is not evaluated.
//
// `bump` adds 1 to the inout counter it is handed and returns 1, so each
// counter's final value IS the number of times its arm was evaluated. With a
// constant-false and a constant-true condition, exactly one arm of each pair
// runs: `taken` ends at 1 and `skipped` at 0. A compiler that evaluates both
// arms and then selects leaves both at 1.
//
// This is 123_short_circuit_side_effects.va's missing third operator, split out
// only so that VerA failing it does not take the ten `&&`/`||`/`&`
// assertions there down with it.
//
//! lrm 4.2.3
//! lrm 4.2.12
//! xfail VerA evaluates both arms of `?:` and selects afterwards, so a call in the unselected arm still runs its side effect: `0 ? bump(e) : 0` leaves e at 1 instead of 0
`include "check.vh"
module ch04_short_circuit_ternary(p, n);
    inout p, n;
    electrical p, n;
    integer skipped, taken, result;

    analog function integer bump;
        inout counter;
        integer counter;
        begin
            counter = counter + 1;
            bump = 1;
        end
    endfunction

    analog begin
        skipped = 0;
        taken = 0;

        result = 0 ? bump(skipped) : bump(taken);

        `CHECKI("?: does not evaluate the unselected arm", skipped, 0);
        `CHECKI("?: does evaluate the selected arm", taken, 1);
        `CHECKI("and the result is the selected arm's value", result, 1);

        I(p, n) <+ V(p, n);
    end
endmodule
