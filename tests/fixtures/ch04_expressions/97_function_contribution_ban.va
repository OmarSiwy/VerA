// LRM 5.2.1/4.7.2: contribution statements are forbidden inside an analog
// function.
//! reject E0405
module ch4_fn_contrib(p); inout p; electrical p; analog function real drive; input x; real x; begin I(p)<+x; drive=x; end endfunction analog I(p)<+drive(V(p)); endmodule
