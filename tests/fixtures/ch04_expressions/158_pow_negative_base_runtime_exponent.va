// LRM 4.3.1 Table 4-14, pow(x, y) = x**y, and the domain column verbatim:
// "if x < 0, all integer y; if x = 0, all y > 0" — a NEGATIVE base with an
// integer exponent is inside the function's own stated domain.
//
// The exponent here is a solve quantity (a probe), which is the one shape a
// compiler cannot reduce to pow-with-constant at build time. Lowering it as
// exp(y*ln(x)) is NaN over the whole x < 0 half of the legal domain — value,
// residual and Jacobian together — which is the bug this pins. With
// V(p) = -2 and V(q) = 3:
//
//   pow(-2, 3)   = -8      (sign carried by the odd integer exponent)
//   pow(-2, 6)   = 64      (even exponent, 2*V(q) evaluated at solve time)
//   d/dx x^y     = y*x^(y-1) = 3*4 = 12   (valid for integer y, either sign of x)
//   d/dy x^y     = 0 for x < 0            (y moves in integer steps there; no
//                                          continuous derivative exists)
//   d/dy |x|^y   = |x|^y * ln|x| = 8*ln 2  for the x > 0 companion, so the
//                                          x > 0 arm keeps its exact slope
//
// All values except 8*ln2 are dyadic and exact in libm pow, so CHECKX; the
// logarithm case is CHECKR at 1e-15.
//
//! lrm 4.3.1
//! bias V(p) = -2.0, V(q) = 3.0
`include "check.vh"
module ch04_pow_negative_base(p, q);
    inout p, q;
    electrical p, q;

    analog begin
        `CHECKX("pow(-2, 3): negative base, odd integer exponent", pow(V(p), V(q)), -8.0);
        `CHECKX("pow(-2, 6): negative base, even integer exponent", pow(V(p), 2.0 * V(q)), 64.0);
        `CHECKX("d/dx = y*x^(y-1) survives the negative base", ddx(pow(V(p), V(q)), V(p)), 12.0);
        `CHECKX("d/dy is 0 for x < 0 (integer steps only)", ddx(pow(V(p), V(q)), V(q)), 0.0);
        `CHECKR("d/dy = x^y*ln(x) on the x > 0 side", ddx(pow(abs(V(p)), V(q)), V(q)),
                5.545177444479562, 1e-15);
        I(p, q) <+ pow(V(p), V(q)) * 1.0e-3;
    end
endmodule
