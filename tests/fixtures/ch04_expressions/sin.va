// §4.3.2 Table 4-15: `sin(x)` is C `sin` and its argument is in RADIANS, for
// all x. The bias puts the argument at 0.5 rad, giving
// sin(0.5) = 0.47942553860420300538..., nearest double 0.479425538604203. A
// degree-based implementation would answer 0.0087, so the unit is pinned too.
//
//! lrm 4.3.2
//! lrm 4.3.2:1001
//! bias V(p) = 0.5
`include "check.vh"
module ch04_sin(p, n);
  inout p, n;
  electrical p, n;
  analog begin
    `CHECK("sin(0.5 rad)", sin(V(p, n)), 0.479425538604203, 1e-15);
    `CHECK("cos(0.5 rad)", cos(V(p, n)), 0.8775825618903728, 1e-15);
    `CHECK("tan(0.5 rad)", tan(V(p, n)), 0.5463024898437905, 1e-15);
    `CHECK("asin returns radians", asin(V(p, n)), 0.5235987755982989, 1e-15);
    `CHECK("acos returns radians", acos(V(p, n)), 1.0471975511965979, 1e-15);
    `CHECK("atan returns radians", atan(V(p, n)), 0.4636476090008061, 1e-15);
    `CHECK("atan2 returns radians", atan2(V(p, n), 0.5), 0.7853981633974483, 1e-15);
    I(p, n) <+ sin(V(p, n));
  end
endmodule
