// LRM 4.2.7: the equality operators "compare the value of the operands. [...]
// the result shall be zero (0) if comparison fails, one (1) if it succeeds."
// So `==` yields a 0/1 INTEGER, never the operand and never a bare boolean.
//
// Biased at V(p)=1.0, V(n)=0 the branch potential is exactly 1.0, so the two
// comparisons below straddle the rule: one succeeds (1), one fails (0).
//
//! lrm 4.2.7
//! lrm 4.2.7:1
//! bias V(p) = 1.0
`include "check.vh"
module ch04_logical_equal(p, n);
    inout p, n;
    electrical p, n;

    analog begin
        `CHECKI("1.0 == 1.0 succeeds -> 1", (V(p, n) == 1.0), 1);
        `CHECKI("1.0 == 2.0 fails -> 0", (V(p, n) == 2.0), 0);
        I(p, n) <+ (V(p, n) == 1.0);
    end
endmodule
