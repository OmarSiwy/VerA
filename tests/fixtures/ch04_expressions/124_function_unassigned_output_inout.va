// The one semantic difference between an `output` and an `inout` formal, in the
// LRM's own words.
//
// 4.7.2.3: "All output arguments of an analog user-defined function are
// initialized, zero (0) if numeric, empty string ("") if a string, which in
// turn means that the argument passed to it is reset to zero (0) or the empty
// string ("") accordingly."
//
// 4.7.2.4: "The inout arguments of an analog user-defined function do not get
// initialized like those defined as output ... If a value was not assigned to
// the inout argument during the execution of the analog user-defined function,
// then the corresponding analog variable reference is left untouched."
//
// `passive` assigns NEITHER formal, which is the only state in which the two
// directions can be told apart — 39_function_output_inout.va assigns both, so
// its copy-out path hides the distinction. Both actuals are pre-set to a
// non-zero value before the call:
//
//     out_actual = 5.0   ->  reset to 0.0 by the output rule
//     io_actual  = 7.0   ->  left at 7.0 by the inout rule
//
// A compiler that treats the two alike fails exactly one of the two wants,
// whichever way it errs, and 5.0 vs 7.0 keeps a copy-out that swapped the two
// slots from passing either.
//
//! lrm 4.7.2.3
//! lrm 4.7.2.1:1001
//! lrm 4.7.2.3:1001
//! lrm 4.7.2.4:1001
//! lrm 4.7.2.4
`include "check.vh"
module ch04_function_unassigned_output_inout(p, n);
    inout p, n;
    electrical p, n;
    real out_actual, io_actual, returned;

    analog function real passive;
        input seed;
        output out_arg;
        inout io_arg;
        real seed, out_arg, io_arg;
        begin
            passive = seed;
        end
    endfunction

    analog begin
        out_actual = 5.0;
        io_actual = 7.0;
        returned = passive(1.0, out_actual, io_actual);

        `CHECKX("an unassigned output argument resets the actual to zero", out_actual, 0.0);
        `CHECKX("an unassigned inout argument leaves the actual untouched", io_actual, 7.0);
        `CHECKX("4.7.2.1: the identifier variable still carries the return", returned, 1.0);

        I(p, n) <+ V(p, n);
    end
endmodule
