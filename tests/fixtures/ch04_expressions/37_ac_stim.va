// LRM 4.6.3 AC stimulus, verbatim: "The AC stimulus function returns zero (0)
// during large-signal analyses (such as DC and transient) as well as on all
// small-signal analyses using names which do not match analysis_name."
//
// The operating point below is a dc analysis (4.6.1 Table 4-21, ".OP or .DC"),
// which is a large-signal analysis, so the clause hands over the literal: this
// call is exactly 0.0, whatever mag and phase say. The second check separates
// the two halves of the sentence — "ac" is the analysis_name that WOULD match a
// small-signal ac analysis, "notanalysis" matches nothing at all, and in dc
// both are zero, so a tool that returned mag when the name matched fails the
// first and passes the second.
//
// 4.6 states the same rule for the family: "When not active, the small-signal
// source functions return zero (0)."
//
// This file used to be `//! reject GeneratedCompileError`, which is a harness
// phase label meaning the emitted Zig did not compile — it pinned a VerA
// codegen crash as the expected behaviour of a normative function.
//
//! lrm 4.6.3
//! analysis dc
//! bias V(p) = 0.5
//! bias V(n) = 0.0
//! xfail VerA codegen emits @compileError for ac_stim (GeneratedCompileError); the small-signal source functions of 4.6 have no lowering
`include "check.vh"
module ch04_ac_stim(p, n);
    inout p, n;
    electrical p, n;

    analog begin
        `CHECKX("ac_stim is zero in a large-signal dc analysis", ac_stim("ac", 1.0, 0.0), 0.0);
        `CHECKX("ac_stim is zero when the analysis name matches nothing", ac_stim("notanalysis", 1.0, 0.0), 0.0);
        I(p, n) <+ ac_stim("ac", 1.0, 0.0);
    end
endmodule
