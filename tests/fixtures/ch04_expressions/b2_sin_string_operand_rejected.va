// §4.3.2 Transcendental functions: "All operands shall be numeric (integer or
// real) and are converted to real if necessary."
//
// `s` is a §3.3 string VARIABLE: Table 3-3 gives strings no arithmetic and no
// numeric conversion, so `sin(s)` has a non-numeric operand. (A string
// LITERAL operand is §2.7's unsigned integer constant, a different case.)
//
// The legal neighbour, b2_sin_integer_operand.va, differs only in s's type.
//
//! lrm 4.3.2
//! lrm 4.3.2:1
//! reject-only E0321
//! neighbour b2_sin_integer_operand.va
`include "disciplines.vams"
module b2_sin_string_operand_rejected(p, n);
    inout p, n;
    electrical p, n;
    string s;
    real x;

    analog begin
        s = "abc";
        x = sin(s);
        I(p, n) <+ x * V(p, n);
    end
endmodule
