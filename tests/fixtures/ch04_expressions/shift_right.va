// LRM 4.2.11: `>>` shifts its left operand right by the number of bit positions
// given by the right operand, filling the vacated positions with zeroes. Bits
// shifted off the bottom are DISCARDED, not rounded.
//
//   8 >> 2 = 1000 shifted two places = 0010 = 2
//
// The second line is the LRM's own worked example verbatim: "start = 3;
// result = (start >> 1)" is "assigned the binary value 0001", i.e. 1 — so the
// dropped low bit is truncated, not rounded up to 2.
//
// The third line is what separates `>>` from `>>>`. 4.2.11: "Both the << and >>
// shift operators fill the vacated bit positions with zeroes (0). The right
// operand is always treated as an unsigned number and has no effect on the
// signedness of the result." LRM 3.2 fixes `integer` at 32 bits two's
// complement, so -8 is 0xFFFFFFF8 and a ZERO-filled one-place right shift is
// 0x7FFFFFFC = 2147483644. An arithmetic, sign-extending lowering — which is
// what a host `>>` on a signed int gives in C and in Zig — returns -4, and
// 8>>2 and 3>>1 cannot tell the two apart because both operands are
// non-negative. 05 and 117 are the `>>>`/`<<<` ban that makes this the only
// right shift the analog subset has.
//
//! lrm 4.2.11
//! lrm 4.2.11:1000
`include "check.vh"
module ch04_shift_right(p, n);
    inout p, n;
    electrical p, n;
    integer a;

    analog begin
        a = 8 >> 2;
        `CHECKI("8 >> 2 = 0010", a, 2);
        `CHECKI("LRM 4.2.11 example: 3 >> 1 = 0001, truncated", (3 >> 1), 1);
        `CHECKI("-8 >> 1 zero-fills 0xFFFFFFF8, it does not sign-extend", (-8) >> 1, 2147483644);
        I(p, n) <+ a;
    end
endmodule
