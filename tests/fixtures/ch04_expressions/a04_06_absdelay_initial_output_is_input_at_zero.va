// §4.5.7 INITIALIZATION of the delay line: what the output is before enough
// time has elapsed to have anything delayed.
//
//   "Output(t) = Input(max(t − td, 0))"
//   "In DC and operating point analyses, absdelay() returns the value of its
//    input."
//
// The floor is max(t − td, 0), NOT "zero output until t reaches td". For t < td
// the operator shall answer Input(0) — the operating-point value of its own
// input — and that is only distinguishable from a zero-filled history when the
// input is NONZERO at t = 0. Every absdelay fixture in tests/fixtures drives a
// ramp that starts at 0, where the two answers coincide; this one does not.
//
// THE HAND DERIVATION. Input is 3 + t/1ns (so Input(0) = 3), td = 2ns:
//
//   t/ns    0    1    2    3    4
//   in      3    4    5    6    7
//   out     3    3    3    4    5      = 3 + max(t/1ns - 2, 0)
//
// t = 0 is the DC point, where the quoted sentence makes the operator the
// identity, so 3 twice over. t = 1ns and t = 2ns are the clause's floor: the
// output is still Input(0) = 3, not 0 and not 1. t = 3ns and t = 4ns are the
// ordinary transport region, and they are what stops this fixture from being
// satisfied by a constant.
//
// §4.5.15 is the other half of the rule and agrees: "All analog operators are
// considered to have no state history prior to time t == 0" — there is no
// history before 0 to read, so max(t − td, 0) clamps the query onto the
// operating point rather than onto an invented zero.
//
//! lrm 4.5.7
//! lrm 4.5.15
//! lrm 4.5.15:1002
//! bias V(n) = 0
//! time 0, 1n, 2n, 3n, 4n
//! analysis tran
//! print none
`include "check.vh"
module a04_absdelay_initial(p, n);
    inout p, n;
    electrical p, n;

    analog begin
        `CHECK("before t = td the output is Input(0), not zero",
               absdelay(3.0 + $abstime * 1e9, 2n)
                 - (3.0 + max($abstime * 1e9 - 2.0, 0.0)), 0.0, 1e-12);
        // Literal and row-invariant: a zero-initialised history answers 0 at
        // the first two transient points, and 3 is never 0.
        `CHECKI("the delay line never reports a value its input never had",
                absdelay(3.0 + $abstime * 1e9, 2n) >= 3.0, 1);

        I(p, n) <+ 0.0;
    end
endmodule
