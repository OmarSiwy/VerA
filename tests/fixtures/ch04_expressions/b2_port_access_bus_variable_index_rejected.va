// §4.4: "For port access functions, the expression list is a single port of
// the module. The port identifier shall be scalar or resolve to a constant net
// of a bus port accessed by a genvar expression."
//
// `g` below is an `integer` VARIABLE, so `I(<pb[g]>)` indexes the bus port
// with a variable, not a genvar expression. The legal neighbour,
// b2_port_access_bus_genvar_index.va, differs only in `g` being declared
// `genvar`.
//
//! lrm 4.4
//! lrm 4.4:6
//! reject-only E0352
//! neighbour b2_port_access_bus_genvar_index.va
`include "disciplines.vams"
module b2_port_access_bus_variable_index_rejected(pb);
    inout [0:1] pb;
    electrical [0:1] pb;
    integer g;
    real s;

    analog begin
        s = 0.0;
        for (g = 0; g < 2; g = g + 1)
            s = s + (g + 1) * I(<pb[g]>);
        I(pb[0]) <+ I(<pb[0]>);
        I(pb[1]) <+ I(<pb[1]>);
    end
endmodule
