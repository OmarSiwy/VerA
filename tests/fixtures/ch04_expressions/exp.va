// §4.3.1 Table 4-14: `exp(x)` is C `exp`, defined for all x. The bias puts the
// argument at exactly 1.0, so the result is e = 2.71828182845904523536...,
// whose nearest double is 2.718281828459045. Checked relatively because the
// point of an exponential is its magnitude.
//
//! lrm 4.3.1
//! bias V(p) = 1.0
`include "check.vh"
module ch04_exp(p, n);
  inout p, n;
  electrical p, n;
  analog begin
    `CHECKR("exp(1) = e", exp(V(p, n)), 2.718281828459045, 1e-15);
    I(p, n) <+ exp(V(p, n));
  end
endmodule
