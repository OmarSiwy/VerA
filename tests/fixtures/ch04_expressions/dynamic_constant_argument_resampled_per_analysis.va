// §4.5.14: "If a dynamic expression is passed as an argument which expects a
// constant expression, the value of the dynamic expression at the start of
// the analysis defaults to the constant value of the argument. Any further
// change in value of that expression is ignored during the iterative
// analysis." Table 4-20 lists `absdelay`'s maxdelay as a constant slot.
//
// audit_absdelay_dynamic_maxdelay_sampled.va pins the second sentence inside
// one analysis. This fixture pins "at the start of THE analysis": a second
// analysis starts over and samples again. With `//! time`, each `//! sweep`
// point is its own transient analysis (a fresh state, `initial_step` at its
// first point; lib/backend/tb/runner.zig), so the two sweep points below are
// two analyses run one after the other, i.e. an analysis restart.
//
// maxdelay = (V(s) + V(w)) * 1 ns, with V(s) the swept start value and V(w)
// a wave that rises by 5 after the start of every analysis:
//
//   analysis 1, V(s) = 1: sampled maxdelay = (1 + 0) ns = 1 ns. td = 2 ns
//     exceeds it, so §4.5.7 delays by maxdelay: out(t) = in(t - 1 ns) with
//     in = t/ns clamped at 0, i.e. 0, 0, 1, 2, 3 at t = 0..4 ns. (The later
//     6 ns is ignored; using it would give out(2 ns) = 0, not 1.)
//   analysis 2, V(s) = 4: sampled maxdelay = (4 + 0) ns = 4 ns >= td, so the
//     delay is td = 2 ns: 0, 0, 0, 1, 2. A tool that kept analysis 1's
//     sample (1 ns) would print 0, 0, 1, 2, 3 again.
//
// One CHECK per point of out minus that hand-derived delayed input, want 0:
// the delay is 1 ns in the analysis whose V(s) < 2 and 2 ns in the other.
// Two analyses of five points: ten checks.
//
//! lrm 4.5.14
//! lrm 4.5.14:1001
//! lrm 4.5.7
//! sweep V(s) = 1, 4
//! wave V(w) = 0, 0, 5, 5, 5
//! time 0, 1n, 2n, 3n, 4n
//! analysis tran
//! bias V(n) = 0
//! print none
//! checks 10
`include "check.vh"
module dynamic_constant_argument_resampled_per_analysis(s, w, n);
    inout s, w, n;
    electrical s, w, n;
    analog begin
        `CHECK("maxdelay is sampled at the start of each analysis",
            absdelay($abstime * 1e9, 2n, (V(s, n) + V(w, n)) * 1n)
                - max($abstime * 1e9 - ((V(s, n) < 2.0) ? 1.0 : 2.0), 0.0),
            0.0, 1e-12);
        I(s, n) <+ 0.0;
        I(w, n) <+ 0.0;
    end
endmodule
