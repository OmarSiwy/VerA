// §4.5.11 a Laplace filter RESPONDING IN TIME. Every laplace_* fixture in
// tests/fixtures evaluates at a DC point and pins H(0); none of them has ever
// let one of these filters take a second timestep, so the pole — the only part
// of the transfer function that is not visible at s = 0 — is unpinned.
//
//   §4.5.11.4 laplace_nd: "H(s) = (Σk=0..M-1 nk sk) / (Σk=0..N-1 dk sk)"
//   §4.5.11: "The Laplace transform filters implement lumped linear
//    continuous-time filters."
//
// LUMPED LINEAR CONTINUOUS-TIME is the whole specification of the time-domain
// behaviour: the operator is the LTI system whose transfer function is H(s),
// so its output is the exact convolution of its input with that system's
// impulse response, and the numerical method a simulator picks to get there is
// its own business. That is what makes an analytic want legitimate here and
// what fixes the tolerance.
//
// THE HAND DERIVATION. With numerator '{1, 0} and denominator '{1, 1e-8},
//
//     H(s) = 1 / (1 + s·tau),   tau = 10ns
//
// a first-order lag. Driven from rest by the unit ramp u(t) = t/1ns (written
// as $abstime*1e9, so the oracle does not share a probe with the operator),
// the exact response of that system is the textbook ramp response
//
//     y(t) = t/1ns − (tau/1ns)·(1 − exp(−t/tau))
//          = tns − 10·(1 − exp(−tns/10))
//
// which is what the check writes. Sample values: y(5ns) = 1.0653066,
// y(10ns) = 3.6787944, y(20ns) = 11.3533528. The input is CONTINUOUS and
// starts at the operating point, so there is no step discontinuity for a
// one-step integration rule to smear — which is what makes the tolerance below
// small enough to mean something.
//
// THE TOLERANCE, DERIVED. The grid is uniform at dt = 0.5ns = tau/20. VerA's
// realisation is the trapezoidal (bilinear) transform (`filter_kernels.zBilin`
// + `zSec`), whose local error on a smooth input is O(dt²); replaying that
// recurrence by hand over these 41 points gives a worst-case deviation from
// the closed form above of 7.67e-4, at t = 10ns. The asserted tolerance is
// 1e-3 — above the discretisation error of a correct second-order method, and
// far below every way of getting the filter wrong: a DC-gain-only reading
// (y = u) is out by 8.6 at t = 20ns, a filter with tau = 9ns is out by 0.09,
// and an uninitialised one is out by the whole response.
//
// WHERE IT IS ASSERTED. The comparison runs from 7ns on. Before that the
// response is small enough that a 0.1% error in the want hides inside the
// band plus the discretisation error (the same replay: the last such point is
// 6ns), so a check there could not see one (`benchmark -- --perturb`). The
// early points are still held by the CHECKI below.
//
//! lrm 4.5.11
//! lrm 4.5.11.4
//! lrm 4.5.11.4:1000
//! bias V(p) = 0
//! bias V(n) = 0
//! time 0, 0.5n, 1n, 1.5n, 2n, 2.5n, 3n, 3.5n, 4n, 4.5n, 5n, 5.5n, 6n, 6.5n, 7n, 7.5n, 8n, 8.5n, 9n, 9.5n, 10n, 10.5n, 11n, 11.5n, 12n, 12.5n, 13n, 13.5n, 14n, 14.5n, 15n, 15.5n, 16n, 16.5n, 17n, 17.5n, 18n, 18.5n, 19n, 19.5n, 20n
//! analysis tran
//! print none
`include "check.vh"
module a04_laplace_ramp_response(p, n);
    inout p, n;
    electrical p, n;
    real tns, y;

    analog begin
        tns = $abstime * 1e9;
        y = laplace_nd(tns, '{1, 0}, '{1, 1e-8});
        if (tns > 6.75)
            `CHECKEQ("a one-pole laplace_nd follows the exact ramp response of 1/(1+s*tau)",
                     y, tns - 10.0 * (1.0 - exp(-tns / 10.0)), 1e-3);
        // Row-invariant and literal: the lag never leads its input and never
        // exceeds it. A filter that answered its DC gain at every point (the
        // behaviour the existing DC-only fixtures cannot distinguish) sits
        // exactly ON the input instead, so the strict inequality is the claim.
        `CHECKI("the lag trails its input at every transient point",
                laplace_nd(tns, '{1, 0}, '{1, 1e-8}) < tns || $abstime <= 0.0, 1);

        I(p, n) <+ 0.0;
    end
endmodule
