// §4.5.6 ddx — the symbolic partial derivative, in the shape §4.5.6's own diode
// example uses it: the small-signal conductance of an exponential current.
//
// §4.5.13 makes limexp(x) equal exp(x) at the converged solution (the limiting
// only bounds the step during iteration), and 0.5 is nowhere near any limit, so
// at the 0.5 V bias
//
//   current_value = exp(0.5) - 1 = 0.6487212707001282
//   d/dV(p) of exp(V(p)-V(n)) = exp(0.5) = 1.6487212707001282
//   d/dV(n) of the same       = -exp(0.5)   (the branch is p MINUS n)
//
// and §4.5.6's last sentence on the matter — "If the expression does not depend
// explicitly on the unknown, then ddx() returns zero (0)" — is the fourth check.
//
//! lrm 4.5.6
//! lrm 4.5.6:1001
//! bias V(p) = 0.5
//! bias V(n) = 0
//! print none
`include "check.vh"
module ch04_ddx(p, n);
    inout p, n;
    electrical p, n;
    real current_value, conductance;

    analog begin
        current_value = limexp(V(p, n)) - 1.0;
        conductance = ddx(current_value, V(p));

        `CHECKR("limexp(0.5) - 1", current_value, 0.6487212707001282, 1e-14);
        `CHECKR("d/dV(p) of the exponential current", conductance, 1.6487212707001282, 1e-14);
        `CHECKR("d/dV(n) is the same with the sign flipped",
                ddx(limexp(V(p, n)) - 1.0, V(n)), -1.6487212707001282, 1e-14);
        `CHECK("ddx of an expression free of the unknown is zero",
               ddx(2.0, V(p)), 0.0, 0.0);

        I(p, n) <+ current_value + conductance;
    end
endmodule
