// §4.6.4.3 noise_table — PIECEWISE LINEAR in (frequency, power).
//
//     noise_table ( input [ , name ] )
//
//     "The noise_table() function interpolates a set of values to model a
//      process where the spectral density of the noise varies as a piecewise
//      linear function of frequency."
//
//     "noise_table() performs piecewise linear interpolation to compute the
//      power spectral density generated by the function at each frequency
//      between the lowest and highest frequency in the set of values. For
//      frequencies lower than the lowest frequency in the value set,
//      noise_table() returns the power specified for the lowest frequency, and
//      for frequencies higher than the highest frequency, noise_table()
//      returns the power specified for the highest frequency."
//
// THE TABLE, in ascending frequency (the vector is written ascending here only
// for readability; §4.6.4.3 lets it be written in any order and makes sorting
// the compiler's job — tests/fixtures/ch04_expressions/181_noise_table_
// topology.va already pins that half):
//
//     f [Hz]     S_I(f) [A^2/Hz]
//       1000       1.0e-18
//       5000       9.0e-18
//       9000       4.0e-18
//
// The knots are deliberately NOT monotone: the first segment rises and the
// second falls. A host that interpolates with an unsigned slope, or that
// clamps to the maximum instead of to the endpoint, gets the second segment
// wrong and passes the first.
//
// Powers are perfect squares (1, 4, 9 times 1e-18) so that the reported
// V/sqrt(Hz) column has short exact decimals — see tests/fixtures/ch04_expressions/a06_noisetables_SPEC.md at 8b1514d4.
//
// The conductance term is what makes the node solvable and sets the transfer
// impedance; it declares no noise of its own, so S_I above is the WHOLE
// spectrum of this device.
//
// WHAT THIS FILE ASSERTS ON ITS OWN, i.e. without the deck and its oracle.
//
// The `//! noise` line carries the TABLE: the three knots as the device exports
// them, sorted, with `interp=linear` — §4.6.4.3 and not §4.6.4.4, which is the
// distinction Figure 4-14 is about.
//
// The two `CHECK`s carry the two sentences that say what a noise generator is
// NOT, both of which are readable inside the analog block:
//
//   §4.6.4, on every one of the four functions: "The noise functions are only
//   active in small-signal noise analyses and return zero (0) otherwise." This
//   run is the default dc analysis, so `noise_table()` reads exactly 0.0 — an
//   exact want, because the clause gives a literal zero and not a small number.
//
//   §4.5.6: "If the expression does not depend explicitly on the unknown, then
//   ddx() returns zero (0)." The tabulated density is a constant vector, so it
//   contributes nothing to the branch linearization and the conductance is the
//   resistor's alone, 1/R = 1.0e-3 S exactly at the declared default. A
//   lowering that let the generator reach an unknown — the same mistake that
//   would make its density bias-dependent when the model never asked — moves
//   that number, and the band is 1e-18 S against 1e-3 S.
//
// The call is bound to a variable first, as check.vh's own warning requires: a
// macro expands its operands twice and a noise call is a generator-creating
// site, not a pure expression.
//
//! lrm 4.6.4
//! lrm 4.6.4.3
//! lrm 4.5.6
//! lrm 4.6.4.3:6
//! noise table(p,n)#0 name=tbl_lin interp=linear points=1000.0:1e-18,5000.0:9e-18,9000.0:4e-18
//! bias V(p) = 1.0
//! bias V(n) = 0.0
`include "check.vh"
module a06_ntab_lin(p, n);
    inout p, n;
    electrical p, n;

    parameter real R = 1000.0 from (0:inf);
    real ntab;

    analog begin
        ntab = noise_table('{1000.0, 1.0e-18, 5000.0, 9.0e-18, 9000.0, 4.0e-18}, "tbl_lin");

        `CHECKX("a noise function is inactive outside a small-signal noise analysis",
            ntab, 0.0);
        `CHECK("the tabulated generator is outside the branch linearization",
            ddx(V(p, n) / R + ntab, V(p)), 1.0e-3, 1e-18);

        I(p, n) <+ V(p, n) / R + ntab;
    end
endmodule
