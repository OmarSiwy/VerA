// §4.6.4.3 noise_table — PIECEWISE LINEAR in (frequency, power).
//
//     noise_table ( input [ , name ] )
//
//     "The noise_table() function interpolates a set of values to model a
//      process where the spectral density of the noise varies as a piecewise
//      linear function of frequency."
//
//     "noise_table() performs piecewise linear interpolation to compute the
//      power spectral density generated by the function at each frequency
//      between the lowest and highest frequency in the set of values. For
//      frequencies lower than the lowest frequency in the value set,
//      noise_table() returns the power specified for the lowest frequency, and
//      for frequencies higher than the highest frequency, noise_table()
//      returns the power specified for the highest frequency."
//
// THE TABLE, in ascending frequency (the vector is written ascending here only
// for readability; §4.6.4.3 lets it be written in any order and makes sorting
// the compiler's job — tests/fixtures/ch04_expressions/181_noise_table_
// topology.va already pins that half):
//
//     f [Hz]     S_I(f) [A^2/Hz]
//       1000       1.0e-18
//       5000       9.0e-18
//       9000       4.0e-18
//
// The knots are deliberately NOT monotone: the first segment rises and the
// second falls. A host that interpolates with an unsigned slope, or that
// clamps to the maximum instead of to the endpoint, gets the second segment
// wrong and passes the first.
//
// Powers are perfect squares (1, 4, 9 times 1e-18) so that the reported
// V/sqrt(Hz) column has short exact decimals — see SPEC.md.
//
// The conductance term is what makes the node solvable and sets the transfer
// impedance; it declares no noise of its own, so S_I above is the WHOLE
// spectrum of this device.
//
//! lrm 4.6.4.3
//! noise table(p,n)#0
`include "disciplines.vams"
module a06_ntab_lin(p, n);
    inout p, n;
    electrical p, n;

    parameter real R = 1000.0 from (0:inf);

    analog
        I(p, n) <+ V(p, n) / R +
            noise_table('{1000.0, 1.0e-18, 5000.0, 9.0e-18, 9000.0, 4.0e-18}, "tbl_lin");
endmodule
