// abs() (LRM 4.3.1 Table 4-14): "abs(x) is equivalent to (x > 0) x : -x",
// all x. 4.3.1 also fixes the result type: an integer operand gives an integer
// result, otherwise the result is real.
`include "check.vh"
//! lrm 4.3.1
//! bias V(p) = -2.5
module ch04_abs(p, n);
  inout p, n; electrical p, n;
  analog begin
    I(p, n) <+ abs(V(p, n));
    // V(p,n) = -2.5, so the negated arm is taken.
    `CHECKX("abs of a negative", abs(V(p, n)), 2.5);
    // The positive arm leaves the operand alone.
    `CHECKX("abs of a positive", abs(-V(p, n)), 2.5);
    // x = 0 sits on the discontinuity; (x > 0) is false, so -0 is returned,
    // which compares equal to 0.
    `CHECKX("abs(0) = 0", abs(0.0), 0.0);
    // An integer operand keeps an integer result.
    `CHECKI("abs of an integer is integer", abs(-7), 7);
  end
endmodule
