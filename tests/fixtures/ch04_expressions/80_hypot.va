// hypot() (LRM 4.3.2 Table 4-15): sqrt(x^2 + y^2), all x, all y.
`include "check.vh"
//! lrm 4.3.2
//! bias V(p) = 0.75
module ch04_hypot(p, n);
  inout p, n; electrical p, n;
  analog begin
    I(p, n) <+ hypot(V(p, n), 1.0);
    // 3-4-5 triangle scaled by 1/4: sqrt(0.5625 + 1) = sqrt(1.5625) = 1.25,
    // and every term here is exact in binary floating point.
    `CHECKX("hypot(0.75, 1)", hypot(V(p, n), 1.0), 1.25);
    // Sign-independent, and degenerates to abs() when one leg is zero.
    `CHECKX("hypot(-0.75, 1)", hypot(-V(p, n), 1.0), 1.25);
    `CHECKX("hypot(-3, 0)", hypot(-3.0, 0.0), 3.0);
  end
endmodule
