// The device under test for a04_idt_hold_revert_host.zig beside it: an
// assert-form idt whose offset latch (`<n>__off`) is device history that a
// rejected step must put back.
//
//   §4.5.4 "When specified with both initial conditions and assert, idt()
//   returns the initial conditions during DC and IC analyses, and whenever
//   assert is nonzero. Once assert becomes zero, idt() returns the integral of
//   the argument starting from the last instant where assert was nonzero."
//
// The integrand is the constant 1e9, so the integral gains exactly 1.0 per
// nanosecond; ic = 7.0. assert (node a) is 1 at the DC point and 0 after, so
// ta = 0 and the value is 7 + t/1ns:
//
//   t/ns     0     1     2
//   assert   1     0     0
//   idt      7     8     9
//
// The contribution is scaled by 1e-3 so the host reads the operator from one
// residual row: f[a] = 1e-3 · idt. The rollback itself (eval, updateState,
// stateCtl(.revert), eval again) is a sequence of host calls the `//!`
// directive language cannot express; it is in the host driver. This file
// asserts the accepted-step half that host's table rests on.
//
//! lrm 4.5.4
//! time 0, 1n, 2n
//! wave V(a) = 1, 0, 0
//! bias V(n) = 0
//! analysis tran
`include "check.vh"
module a04_idt_hold_revert(a, n);
    inout a, n;
    electrical a, n;

    real out;

    analog begin
        out = idt(1e9, 7.0, V(a, n));

        `CHECK("integration runs from the last instant assert was nonzero",
            out, 7.0 + $abstime * 1e9, 1e-12);

        I(a, n) <+ 1e-3 * out;
    end
endmodule
