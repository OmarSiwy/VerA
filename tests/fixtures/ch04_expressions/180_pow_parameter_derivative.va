// Parameter exponents keep the zero-base slope; voltage exponents keep d/dy.
//
// §4.3.1: "abs(x) is equivalent to (x > 0) x : -x", so at V(p, n) = 0 abs
// takes the -x arm: its value is -0 (equal to 0) and its slope is -1. The
// zero-base slope of pow(u, 1) is 1 * pow(0, 0) = 1, so by the chain rule
// d a / d V(p) = 1 * (-1) = -1.
`include "check.vh"
//! lrm 4.3.1
//! bias V(p) = 0
//! bias V(x) = 1
//! bias V(y) = 3
module ch04_pow_parameter_derivative(p, x, y, n);
    inout p, x, y, n;
    electrical p, x, y, n;
    parameter real power = 1.0 from (0:inf);
    real a, b;
    analog begin
        a = pow(abs(V(p, n)), power);
        b = pow(abs(V(x, n)) + 1.0, V(y, n));
        I(p, n) <+ a + b;
        `CHECKX("zero-base value", a, 0.0);
        `CHECKX("zero-base slope at exponent one", ddx(a, V(p)), -1.0);
        `CHECKX("variable-exponent value", b, 8.0);
        `CHECKX("variable-exponent base slope", ddx(b, V(x)), 12.0);
        `CHECKR("variable-exponent slope", ddx(b, V(y)), 5.545177444479562, 1e-14);
    end
endmodule
