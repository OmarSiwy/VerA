// pow(x, y) (LRM 4.3.1 Table 4-14): x raised to the y. The domain is
// "if x > 0, all y; if x = 0, y > 0; if x < 0, all integer y", so the base is
// kept positive here by abs() + 1.
`include "check.vh"
//! lrm 4.3.1
//! bias V(p) = -1.5
module ch04_pow(p, n);
  inout p, n; electrical p, n;
  analog begin
    I(p, n) <+ pow(abs(V(p, n)) + 1.0, 2.0);
    // abs(-1.5) + 1 = 2.5, and 2.5^2 = 6.25 — exact in binary floating point.
    `CHECKX("pow(2.5, 2) = 6.25", pow(abs(V(p, n)) + 1.0, 2.0), 6.25);
    // The x < 0 arm of the domain: a negative base with an integer exponent.
    `CHECKX("pow(-2, 3) = -8", pow(-2.0, 3.0), -8.0);
    // The x = 0, y > 0 arm.
    `CHECKX("pow(0, 2) = 0", pow(0.0, 2.0), 0.0);
    // A fractional exponent is a root: 2.5^0.5 = sqrt(2.5).
    `CHECK("pow(2.5, 0.5) = sqrt(2.5)", pow(2.5, 0.5), 1.5811388300841898, 1e-15);
  end
endmodule
