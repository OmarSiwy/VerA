// §4.3.1 Table 4-14: `sqrt(x)` is C `sqrt` with domain x >= 0, and `abs(x)` is
// C `fabs`. The bias drives V(p,n) NEGATIVE (-2.0), so abs() is what puts the
// argument into sqrt's domain. sqrt(2) = 1.41421356237309504880..., whose
// nearest double is 1.4142135623730951. IEEE 754 requires sqrt to be CORRECTLY
// ROUNDED, so a conforming implementation returns that double bit for bit; the
// 1e-16 tolerance is below one ulp (2.2e-16) and therefore admits nothing else.
//
//! lrm 4.3.1
//! bias V(p) = -2.0
`include "check.vh"
module ch04_sqrt(p, n);
  inout p, n;
  electrical p, n;
  analog begin
    `CHECKX("abs() folds the negative probe", abs(V(p, n)), 2.0);
    `CHECK("sqrt(2)", sqrt(abs(V(p, n))), 1.4142135623730951, 1e-16);
    I(p, n) <+ sqrt(abs(V(p, n)));
  end
endmodule
