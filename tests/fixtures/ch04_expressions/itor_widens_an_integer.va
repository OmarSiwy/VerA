// The other half of §9.11: `$itor`. The clause, in full:
//
//   "Verilog AMS HDL extends the conversion functions defined in IEEE Std 1364
//    Verilog so that $bitstoreal and $realtobits,$rtoi and $itor can be used in
//    the analog context."
//
// Table 9-8 gives `$itor  digital Yes  analog Yes`. Annex G item 7920 records
// the change as "Add support for $roi() and $itor() in the analog context" —
// `$roi` is the change table's own typo for `$rtoi`; §9.11 is normative and
// names both.
//
// 09_rtoi_truncates_toward_zero.va is the sibling. This file is the direction
// that has no rule to get wrong — integer to real is exact — so the thing it
// actually pins is the RETURN TYPE, and §4.2.1.3 supplies the contrast in its
// own words:
//
//   "For operands, a common data type for each operand is determined before the
//    operator is applied. If either operand is real, the other operand is
//    converted to real. ...
//
//    b = 1 / 2;
//    The above is integer division and the result is 0."
//
// `$itor(3) / 2` is 1.5 if $itor hands back a real and 1 if it hands back an
// integer — §4.2.1.3's `b = 1 / 2` is the integer case, spelled in the LRM, so
// that assertion separates the two implementations on the clause's own example.
// §4.2.1.2 is the conversion itself, and it is thin:
//
//   "Implicit conversion shall take place when an expression is assigned to a
//    real. Individual bits that are x or z in the net or the variable shall be
//    an error (see 7.3.2)."
//
// It states no precision, so the accuracy of the widening comes from §3.2 and
// not from this subclause. §3.2 fixes both ends:
//
//   "An integer declaration declares one or more variables of type integer.
//    These variables can hold values ranging from -2**31 to 2**31-1."
//   "The real variables are stored as 64-bit quantities, as described by IEEE
//    Std 754, an IEEE standard for double precision floating point numbers."
//
// Every 32-bit integer is exactly representable in IEEE 754 binary64, so the
// widening is exact for the whole declared range of the source type — which is
// what makes `CHECKX` the right macro rather than a tolerance.
//
// HAND DERIVATION.
//
//   `//! bias V(p) = 0.5` against the grounded `n` row gives V(p,n) = 0.5, and
//   §4.2.1 makes `V(p, n) > 0.0` the integer 1. So
//
//     k = 4 + (V(p, n) > 0.0) = 4 + 1 = 5
//
//   and k does not fold, because it depends on the probe. `$itor(k)` is the one
//   line here whose argument is a runtime value rather than a literal.
//
//   $itor(3)         ->  3.0         binary-exact in both types
//   $itor(-7)        ->  -7.0        the sign survives; a tool that widened
//                                    through an unsigned intermediate fails
//   $itor(16777217)  ->  16777217.0  see below
//   $itor(3) / 2     ->  1.5         §4.2.1.3, the return-type line
//   $itor(k)         ->  5.0
//
//   WHY 16777217. It is 2**24 + 1, the smallest positive integer a binary32
//   cannot represent (it rounds to 2**24). §3.2's two sentences put it inside
//   `integer`'s range and inside binary64's exact range and OUTSIDE binary32's,
//   so the single line separates a conforming real from a float-backed one. A
//   compiler that promoted through a 32-bit float reads 16777216.0 and fails
//   this assertion and no other.
//
//   WHY `$itor(3) / 2` IS NOT WRITTEN `$itor(3 / 2)`. §4.2.1.3 evaluates the
//   argument first: `3 / 2` is integer division and is 1, so the parenthesised
//   spelling would assert 1.0 or 1.5 depending on where the conversion sits,
//   which is a different claim. The unparenthesised form asks exactly one
//   question — is the value $itor returns a real? — and §4.2.1.3's `b = 1 / 2`
//   is the answer it must not give.
//
// STATUS. VerA refuses `$itor` in the analog context today with
//
//   error[E0806]: system task is not supported in the analog context: `$itor`
//     = note: LRM 9.2
//
// the same wrong-column reading of Table 9-8 that 09 documents. Note that only
// the literal arguments are refused: the diagnostic is at the call site and the
// compiler never reaches the arithmetic, so nothing here is evidence about
// VerA's integer-to-real conversion, only about its membership test. The
// fixture **FAILS TODAY** for that reason and not because the values
// are in doubt.

//! lrm 9.2
//! lrm 9.11
//! lrm 4.2.1.2
//! lrm 4.2.1.2:1
//! lrm 4.2.1.3
//! lrm G.1
//! lrm 9.2:1000
//! lrm 9.11:1000
//! bias V(p) = 0.5
//! print none
`include "check.vh"
module a01_itor_widens_an_integer(p, n);
  inout p, n;
  electrical p, n;
  integer k;

  analog begin
    k = 4 + (V(p, n) > 0.0);

    `CHECKX("$itor widens a positive integer exactly", $itor(3), 3.0);
    `CHECKX("and a negative one, sign included", $itor(-7), -7.0);
    `CHECKX("2**24+1 is exact in a 64-bit real and not in a 32-bit one",
            $itor(16777217), 16777217.0);
    `CHECKX("the result is a real: 3/2 is 1.5, not 4.2.1.3's integer 0",
            $itor(3) / 2, 1.5);
    `CHECKX("and a runtime integer widens the same way", $itor(k), 5.0);

    I(p, n) <+ V(p, n);
  end
endmodule
