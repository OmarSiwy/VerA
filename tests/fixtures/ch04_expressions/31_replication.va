// §4.2.13 replication: "An operator that can be applied only to concatenations
// is replication, which is expressed by a concatenation preceded by a
// non-negative, non-x and non-z constant expression, called a replication
// constant, enclosed together within brace characters, and which indicates a
// joining together of that many copies of the concatenation."
//
// This is LEGAL Verilog-AMS and the clause works two of the three cases below
// out in its own text. The file it replaces, 31_replication_rejected.va,
// demanded VerA's parser error instead — an inverted fixture that a conforming
// compiler fails and only VerA passes. The requirement is written the way the
// LRM writes it; it was carried as an `xfail` until the parser grew the rule,
// and it now runs green.
//
// Three replication value cases, with the widths worked out. A
// concatenation joins BITS, so every count below is the sum of the operand
// widths and every value is read off the bit string:
//
//   {4{2'b10}}
//     4.2.13, "{4{w}} // This yields the same value as {w, w, w, w}". Four
//     copies of a 2-bit operand is 8 bits, 10_10_10_10 = 8'b10101010 = 170.
//     A lowering that replicated the VALUE rather than the bits answers 8
//     (2+2+2+2) or 2 (the last copy); neither is 170.
//
//   {1'b0, {3{1'b1, 1'b0}}}
//     4.2.13's nested example spelled out: "{b, {3{a, b}}} // This yields the
//     same value as {b, a, b, a, b, a, b}", with a = 1'b1 and b = 1'b0. Seven
//     bits, 0_10_10_10 = 7'b0101010 = 42. The replication is INSIDE the outer
//     concatenation and the inner {a, b} is itself a concatenation, so this
//     pins the nesting as well as the count.
//
//   {{0{1'b1}}, 4'b0101}
//     4.2.13: "A replication with a zero replication constant is considered to
//     have a size of zero and is ignored. Such a replication shall appear only
//     within a concatenation in which at least one of the operands of the
//     concatenation has a positive size." The 4-bit operand supplies that
//     positive size, so this form is the legal one, and the result is the
//     4'b0101 alone = 5. Rejection of this legal form fails the fixture, but an
//     erroneous extra leading zero bit could still give the same integer value.
//     The former width-proof claim moves to open EXPR-018 in
//     docs/conformance-expressions.md at 8b1514d4; this observes value, not width.
//     audit_replication_zero_width.va now supplies the middle-bit discriminator.
//
// Not pinned here: 4.2.13's rule, "the operands shall be evaluated
// exactly once, even if the replication constant is zero" — the LRM's own
// example needs a function call with an observable evaluation count, which
// 4.7.1 analog functions cannot express without an output argument.
// audit_replication_zero_effect.va uses an inout counter and records the
// zero-count evaluation independently of these value cases.
//
//! lrm 4.2.13
//! lrm 4.2.13:1001
//! lrm 4.2.13:1002
//! lrm 4.2.13:4
//! bias V(p) = 0.0
`include "check.vh"
module ch04_replication(p, n);
    inout p, n;
    electrical p, n;
    integer replicated, nested, zero_replicated;

    analog begin
        replicated = {4{2'b10}};
        nested = {1'b0, {3{1'b1, 1'b0}}};
        zero_replicated = {{0{1'b1}}, 4'b0101};

        `CHECKI("{4{2'b10}} is 8 bits of 10101010", replicated, 170);
        `CHECKI("{b, {3{a, b}}} is {b, a, b, a, b, a, b}", nested, 42);
        `CHECKI("a zero replication has size zero and is ignored", zero_replicated, 5);

        I(p, n) <+ replicated + nested + zero_replicated;
    end
endmodule
