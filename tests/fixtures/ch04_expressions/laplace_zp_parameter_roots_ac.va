// §4.5.11.1 laplace_zp with zeros and poles from parameter ARRAYS (§4.5.11:
// "a reference to a vector parameter"), in a small-signal analysis. A linear
// filter's response at ω is H(jω) (laplace_ac_response.va says why), read
// through `acDyn` as `//! acdyn (row,col)`.
//
//   H(s) = (1 + s/3)(1 + s/4) / ((1 + s + s²/2)(1 + (4/13)s + s²/13))
//
// from ζ = −3, −4 and ρ = −1 ± j, −2 ± 3j (each pole pair multiplied out:
// (1 − s/ρ)(1 − s/ρ*) = 1 − 2Re(ρ)/|ρ|² s + s²/|ρ|²). The card sets the
// imaginary parts, so VerA pairs the roots at run time (`zRootSecs`).
//
// HAND DERIVATION, exact rationals:
//   ω = 1:  numerator (1 + j/3)(1 + j/4) = 11/12 + (7/12)j;
//           denominators (1/2 + j)(12/13 + (4/13)j) = 2/13 + (14/13)j;
//           H = (13/12)(11 + 7j)/(2 + 14j) = (13/12)(120 − 140j)/200
//             = 13/20 − (91/120)j = (0.65, −0.7583333333333333)
//   ω = 2:  numerator (1 + 2j/3)(1 + j/2) = 2/3 + (7/6)j;
//           denominators (−1 + 2j)(9/13 + (8/13)j) = −25/13 + (10/13)j;
//           H = (13/6)(4 + 7j)/(−25 + 10j) = (13/6)(−30 − 215j)/725
//             = −13/145 − (559/870)j = (−0.0896551724137931, −0.6425287356321839)
//   f = 0:  H(0) = 1, exactly (the operating-point gain).
// The same filter with literal roots (row b) reads the same numbers.
//
//! lrm 4.5.11.1
//! bias V(in) = 0.5
//! print none
//! acdyn (a,in) f=0 re=1 im=0 tol=0
//! acdyn (a,in) f=0.15915494309189535 re=0.65 im=-0.7583333333333333
//! acdyn (a,in) f=0.3183098861837907 re=-0.0896551724137931 im=-0.6425287356321839
//! acdyn (b,in) f=0.15915494309189535 re=0.65 im=-0.7583333333333333
//! acdyn (b,in) f=0.3183098861837907 re=-0.0896551724137931 im=-0.6425287356321839
`include "check.vh"
module laplace_zp_parameter_roots_ac(in, a, b);
  inout in, a, b;
  electrical in, a, b;
  parameter real z[0:3] = '{-3.0, 0.0, -4.0, 0.0};
  parameter real r[0:7] = '{-1.0, 1.0, -2.0, 3.0, -1.0, -1.0, -2.0, -3.0};
  analog begin
    `CHECK("the parameter-root filter at the operating point is H(0)·V(in)",
           laplace_zp(V(in), z, r), 0.5, 1e-12);
    I(a) <+ laplace_zp(V(in), z, r);
    I(b) <+ laplace_zp(V(in), '{-3.0, 0.0, -4.0, 0.0}, '{-1.0, 1.0, -2.0, 3.0, -1.0, -1.0, -2.0, -3.0});
  end
endmodule
