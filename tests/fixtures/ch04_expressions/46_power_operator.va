// §4.2.4 Table 4-4: `a ** b` is "a to power of b", the same operation §4.3.1
// spells pow(x,y). At V(p,n) = 1.5 the base is 1.5 + 1.0 = 2.5 and the exponent
// is 2.0, so the value is 2.5*2.5 = 6.25 — exact in IEEE 754 binary, and
// distinct from every plausible mis-lowering (2.5*2.0 = 5.0, 2.5+2.0 = 4.5).
//
//! lrm 4.2.4
//! bias V(p) = 1.5
`include "check.vh"
module ch04_power_operator(p, n);
    inout p, n;
    electrical p, n;
    analog begin
        `CHECKX("2.5 ** 2.0", (V(p, n) + 1.0) ** 2.0, 6.25);
        I(p, n) <+ (V(p, n) + 1.0) ** 2.0;
    end
endmodule
