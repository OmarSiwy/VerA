// Two kernels the LRM defines by naming their C library forms, pinned where a
// textbook re-composition breaks and the C form does not.
//
// LRM 4.3.2 Table 4-15 hypot(x, y) = sqrt(x^2 + y^2): the C function is
// overflow-free, while literally squaring overflows binary64 once a leg
// passes ~1.34e154 — hypot(3e200, 4e200) computed as sqrt(9e400 + 1.6e401)
// is inf, the true 5e200 nowhere near the format's ceiling. The derivative
// rides along: d/dV hypot(3e200*V, 4e200*V) = 0.6*3e200 + 0.8*4e200 = 5e200.
// CHECKR at 1e-15 — libm hypot is a correctly-rounded-to-a-few-ulp value, not
// a dyadic identity.
//
// LRM 4.2.4: "The modulus operator ... operates similarly to the modulus
// operator in ... C", i.e. fmod, which is EXACT for reals. The re-composition
// a - b*trunc(a/b) loses the entire remainder to the subtraction's rounding
// once |a| is ~2^53*|b|: at a = 2^60 the quotient's unit of rounding is 64,
// so the recomposed answer is off by hundreds while the true remainder is
//
//   2^60 mod 3 = (2^2)^30 mod 3 = 1^30 mod 3 = 1     (and -2^60 % 3 = -1,
//                                                     "the sign of the first
//                                                     operand", Table 4-6)
//
// exact in binary64, so CHECKX. The derivative of a % 3 in a is 1 almost
// everywhere, so d/dV of (2^60*V) % 3 is 2^60 itself — also exact.
//
// Every extreme operand is multiplied by V(p, n) = 1 to keep it a solve
// quantity: a constant fold would answer these in the compiler, and the thing
// under test is the compiled kernel.
//
//! lrm 4.3.2
//! lrm 4.2.4
//! bias V(p) = 1.0, V(n) = 0
`include "check.vh"
module ch04_hypot_fmod_extreme(p, n);
    inout p, n;
    electrical p, n;

    analog begin
        `CHECKR("hypot with ~1e200 legs does not overflow",
                hypot(3.0e200 * V(p, n), 4.0e200 * V(p, n)), 5.0e200, 1e-15);
        `CHECKR("d/dV hypot = (a*da + b*db)/h at the same scale",
                ddx(hypot(3.0e200 * V(p, n), 4.0e200 * V(p, n)), V(p)), 5.0e200, 1e-15);
        `CHECKX("2^60 % 3 is the exact fmod remainder",
                (1152921504606846976.0 * V(p, n)) % 3.0, 1.0);
        `CHECKX("-2^60 % 3 keeps the sign of the first operand",
                (-1152921504606846976.0 * V(p, n)) % 3.0, -1.0);
        `CHECKX("d/dV of (2^60*V) % 3 is 2^60 a.e.",
                ddx((1152921504606846976.0 * V(p, n)) % 3.0, V(p)), 1152921504606846976.0);
        I(p, n) <+ V(p, n) * 1.0e-3;
    end
endmodule
