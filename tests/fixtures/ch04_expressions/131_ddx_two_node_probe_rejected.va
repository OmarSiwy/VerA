// LRM 4.5.6, verbatim: "The second argument shall be the potential of a scalar
// net or port or the flow through a branch, because these are the unknown
// variables in the system of equations for the analog solver."
//
// `V(p, n)` is neither. It is the DIFFERENCE of two unknowns, not an unknown,
// and the sentence says why that matters: ddx() "returns the partial derivative
// of its first argument with respect to the unknown indicated by the second
// argument, HOLDING ALL OTHER UNKNOWNS FIXED". There is no way to hold the
// others fixed while varying V(p)-V(n), so the request has no answer — d/dV(p)
// and -d/dV(n) are both defensible readings and they differ.
//
// 4.5.6's own vccs example makes the legal form explicit: it writes
// `vin = V(pin,nin); one = ddx(vin, V(pin));` — the two-node probe goes in the
// EXPRESSION, and the single-node probe is what the derivative is taken with
// respect to. 18_ddx.va is that legal side; 132 is the second argument being
// no probe at all.
//
//! lrm 4.5.6
//! reject ddx
//! xfail VerA's E0504 check only asks whether the second argument is an access function call; `ddx(expr, V(p,n))` with two nets passes it and compiles with only W0650
module ch04_ddx_two_node_probe_rejected(p, n);
    inout p, n;
    electrical p, n;
    real slope;

    analog begin
        slope = ddx(V(p, n) * 2.0, V(p, n));
        I(p, n) <+ slope;
    end
endmodule
