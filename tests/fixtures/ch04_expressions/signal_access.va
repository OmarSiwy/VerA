// §4.4 Table 4-16 — branch access functions. `V(b1)` accesses the voltage
// across branch b1, and a branch declared `branch (p, n)` IS the p-n pair, so
// the probe through the name and the probe through the node pair are one value.
//
// The bias holds that pair at 2 V, which is what the first check writes down;
// without it the identity below would be 0 == 0 and would pass in a compiler
// that resolved `named_path` to nothing at all.
//
//! lrm 4.4
//! lrm 4.4:1
//! bias V(p) = 2.0
//! bias V(n) = 0
//! print none
`include "check.vh"
module ch04_signal_access(p, n);
    inout p, n;
    electrical p, n;
    branch (p, n) named_path;

    analog begin
        // The named branch spans p and n, so at this bias it reads 2 V.
        `CHECK("V(named_path) at a 2 V bias", V(named_path), 2.0, 1e-15);
        // Table 4-16 states this as an identity with no value of its own: the
        // two spellings name the same branch, so they must not diverge at ANY
        // operating point. Relational on purpose.
        `CHECKEQ("V(b1) is V(p,n)", V(named_path), V(p, n), 0.0);

        I(named_path) <+ V(named_path) / 10.0;
        I(p, n) <+ V(p, n);
    end
endmodule
