// §4.3.2 Table 4-15 gives hypot one row: `$hypot(x,y)` / `hypot(x,y)`,
// "√(x² + y²)", domain "All x, all y". Two operands; the function is the
// Euclidean norm of a pair and has no one-argument form.
//
// The call below passes one. The legal call is 159_hypot_fmod_extreme_magnitude.va.
//
//! lrm 4.3.2
//! reject-only E0506
//! neighbour 159_hypot_fmod_extreme_magnitude.va
`include "disciplines.vams"
module ch04_hypot_takes_two_arguments(p, n);
  inout p, n; electrical p, n;
  analog I(p, n) <+ hypot(V(p, n));
endmodule
