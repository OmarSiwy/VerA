// tanh() (LRM 4.3.2 Table 4-15): hyperbolic tangent, sinh(x)/cosh(x), all x.
`include "check.vh"
//! lrm 4.3.2
//! bias V(p) = 0.5
module ch04_tanh(p, n);
  inout p, n; electrical p, n;
  analog begin
    I(p, n) <+ tanh(V(p, n));
    // tanh(1/2) = (e - 1) / (e + 1) = 1.718281828459045 / 3.718281828459045.
    `CHECK("tanh(0.5)", tanh(V(p, n)), 0.46211715726000974, 1e-15);
    // Odd, through the origin, and asymptotic to +/-1.
    `CHECKX("tanh(0) = 0", tanh(0.0), 0.0);
    `CHECK("tanh(-0.5)", tanh(-0.5), -0.46211715726000974, 1e-15);
  end
endmodule
