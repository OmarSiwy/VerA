// §4.6.4.2 flicker_noise — the three-argument form, and the export that says a
// PINK generator was declared rather than a white one.
//
//     flicker_noise ( pwr , exp [ , name ] )
//
// "generates pink noise with a power of pwr at 1Hz which varies in proportion
// to 1/f^exp". Every word of that is about frequency, and a dc point has none:
// §4.6 makes the source read zero here, so the only thing the model's own text
// can assert is that it does. What distinguishes this clause from §4.6.4.1 —
// that the generator is 1/f^exp shaped and not flat — survives into the
// device's §4.6.4 table as the generator's KIND, and nowhere else. `//! noise`
// is what reads it.
//
// The exponent is 1.0 and not the `pwr`-only default of §4.6.4.1 deliberately:
// `exp` is a REQUIRED argument here (the optional one is `name`), so a fixture
// that omitted it would be testing the arity rule and not this clause.
//
// The distinction is worth pinning from the export side because it is exactly
// what a host cannot recover on its own: a §4.6.4.1 thermal PSD is 4kT·g and a
// host can read `g` off the Jacobian it already built, but §4.6.4.2's
// kf·I^af / f^ef is in no Jacobian. A `flicker` row is therefore topology the
// device tells the host about and a PSD the host has to decline until a
// `noisePsd` hook exists — so if the KIND were lost, the host would silently
// substitute the thermal answer for a source that is not thermal.
//
//! lrm 4.6.4.2
//! lrm 4.6.2
//! noise flicker(d,s)#0
//! analysis dc
//! bias V(d) = 0.7
//! bias V(s) = 0.0
`include "check.vh"
module ch04_flicker_noise_topology(d, s);
    inout d, s;
    electrical d, s;
    parameter real R = 700.0 from (0:inf);

    analog begin
        I(d, s) <+ V(d, s)/R + flicker_noise(1e-20, 1.0, "flick");
        `CHECKX("the dc current is the resistive term alone", V(d,s)/R, 1e-3);
        `CHECKX("flicker_noise is inactive outside a small-signal analysis", flicker_noise(1e-20, 1.0), 0.0);
    end
endmodule
