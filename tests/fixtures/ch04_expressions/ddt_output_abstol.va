// Full operator behavior is observed by tests/host.py;
// these local value/Jacobian checks alone do not prove the live tolerance or AC rule.
// §4.5.3 the tolerance argument of ddt() belongs to its OUTPUT, and the device
// publishes it as that output's absolute tolerance.
//
//   "The absolute tolerance, abstol or derived from nature, applies to the
//    output of the ddt operator and is the largest signal level that is
//    considered negligible."
//
//   §4.5.2: "Occasionally, analog operators require new equations and new
//   unknowns be introduced by the simulator ... Alternatively, these operators
//   can be used to specify tolerances."
//
// A ddt() off a contribution's spine is one new unknown, the derivative itself
// (ddt_in_expression_is_a_charge_site.va), so "the output of the ddt operator"
// IS that unknown, and its §3.6.1.2 tolerance in `u_abstol` is the number the
// call names. The unknowns are `ddt$0` and `ddt$1`, in source order.
//
//   ddt(V(p), 1e-3)          ddt$0   1e-3, written out
//   ddt(1p*V(p), Current)    ddt$1   1e-12, annex D's `Current` abstol
//                                    (disciplines.vams, CURRENT_ABSTOL unset)
//
// The values are §4.5.3's DC zero; the tolerance changes no value.
//
//! lrm 4.5.3
//! lrm 4.5.2
//! lrm 4.5.2:1
//! bias V(p) = 1.0
//! print none
//! abstol ddt$0 = 1e-3
//! abstol ddt$1 = 1e-12
`include "disciplines.vams"
`include "check.vh"
module ddt_output_abstol(p);
    inout p;
    electrical p;
    real x, y;

    analog begin
        x = ddt(V(p), 1e-3);
        y = ddt(1p * V(p), Current);
        I(p) <+ x * x + y * y;
        `CHECKX("ddt(expr, abstol) is zero in DC", x, 0.0);
        `CHECKX("ddt(expr, nature) is zero in DC", y, 0.0);
    end
endmodule
