// §4.2.1.2 Integer to real conversion: "Implicit conversion shall take place
// when an expression is assigned to a real."
//
// No $itor below (a01_10_itor_widens_an_integer.va is the explicit §9.11
// form). Every conversion here is the assignment itself.
//
// HAND DERIVATION. `//! bias V(p) = 0.5` with n grounded, so §4.2.5 makes
// `V(p, n) > 0.0` the integer 1 and k = 6 + 1 = 7 (an integer expression the
// folder cannot see through, read from the operating point).
//
//   r = k            the integer 7 assigned to a real: r = 7.0.
//   h = r / 2        r is now real, so §4.2.1.3 makes this real division:
//                    7.0 / 2 = 3.5. Had r kept the integer's bits or type,
//                    this would be the integer 3 (or garbage), not 3.5.
//   q = k / 2        the RIGHT side is all integer, so the division is integer
//                    division (§4.2.4 truncates toward zero): 3; the
//                    conversion happens at the assignment, giving 3.0, not 3.5.
//   kmax = 2147483646 + 1 = 2**31-1 and kmin = -kmax - 1 = -2**31, the §3.2
//                    range ends ("-2**31 to 2**31-1"). Every integer in that
//                    range is exact in IEEE 754 binary64, so the assigned
//                    reals are exactly 2147483647.0 and -2147483648.0.
//
// Every want is exact in binary64, so the checks are CHECKX.
//
//! lrm 4.2.1.2
//! lrm 4.2.1.2:1
//! bias V(p) = 0.5
//! bias V(n) = 0.0
//! checks 5
`include "check.vh"
module b2_implicit_conversion_to_real(p, n);
    inout p, n;
    electrical p, n;
    integer k, kmin, kmax;
    real r, h, q, lo, hi;

    analog begin
        k = 6 + (V(p, n) > 0.0);
        r = k;
        h = r / 2;
        q = k / 2;
        kmax = 2147483646 + (V(p, n) > 0.0);
        kmin = -kmax - 1;
        lo = kmin;
        hi = kmax;
        `CHECKX("the integer 7 assigned to a real is 7.0", r, 7.0);
        `CHECKX("the assigned real divides as a real: 7.0 / 2", h, 3.5);
        `CHECKX("integer division first, then conversion at the assignment", q, 3.0);
        `CHECKX("-2**31 converts exactly", lo, -2147483648.0);
        `CHECKX("2**31-1 converts exactly", hi, 2147483647.0);
        I(p, n) <+ 1e-3 * (r + h + q) * V(p, n);
    end
endmodule
