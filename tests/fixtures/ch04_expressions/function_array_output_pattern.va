// LRM 4.7.2.3 Output arguments, verbatim: "If the output argument is defined as
// an array then the argument passed into the function must be an analog
// variable or an array assignment pattern of analog variables of equivalent
// size", and "At the end of the execution of the analog user-defined function,
// the last value assigned to the output argument is then assigned to the
// corresponding analog variable reference that was passed into the function."
//
// So `fill(V(p), '{a,b})` is the form the clause mandates, not a syntax error:
// the two-element pattern is the actual for the `output [0:1] out` formal, and
// on return `a` holds out[0] and `b` holds out[1], in declaration order.
//
// The digits come from the bias. V(p) = 0.75 is a dyadic rational, so
//   out[0] = x        = 0.75
//   out[1] = 2.0 * x  = 1.5
//   fill   = x        = 0.75      (4.7.2.1, the last value assigned)
// are all exact in IEEE 754 and CHECKX is the right macro. 4.7.2.3 also fixes
// the copy-out direction: `a` and `b` are ZERO before the call ("All output
// arguments ... are initialized, zero (0) if numeric, which in turn means that
// the argument passed to it is reset to zero"), so a tool that dropped the
// copy-out leaves 0.0 in both and fails.
//
// This file used to be `//! reject ParseError`, which locked VerA's parser gap
// in as the correct behaviour: a conforming compiler accepts the module and so
// FAILED the fixture. The requirement is now stated the way the LRM states it.
//
//! lrm 4.7.2.3
//! lrm 4.7.2.3:2
//! bias V(p) = 0.75
`include "check.vh"
module ch4_fn_array_out(p);
  inout p;
  electrical p;
  real a, b, dummy;
  real whole[0:1];

  analog function real fill;
    input x;
    output [0:1] out;
    real x, out[0:1];
    begin
      out[0] = x;
      out[1] = 2.0 * x;
      fill = x;
    end
  endfunction

  analog begin
    dummy = fill(V(p), '{a, b});
    `CHECKX("output pattern element 0 receives out[0]", a, 0.75);
    `CHECKX("output pattern element 1 receives out[1]", b, 1.5);
    `CHECKX("the function identifier variable still returns", dummy, 0.75);
    dummy = fill(-0.5, whole);
    `CHECKX("a whole array output receives its first element", whole[0], -0.5);
    `CHECKX("a whole array output receives its second element", whole[1], -1.0);
    I(p) <+ dummy + a + b;
  end
endmodule
