// §4.6.4.3: "When the input is a vector it contains pairs of real numbers:
// the first number in each pair is the frequency in Hertz and the second is
// the power. The vector can either be specified as an array parameter or an
// array assignment pattern." A.8.2 spells the array parameter two ways:
//
//     noise_table_input_arg ::=
//           parameter_identifier
//         | parameter_identifier [ msb_constant_expression : lsb_constant_expression ]
//         | ...
//
// This is the second: a part select of an array parameter. The array holds
// a leading and a trailing pair the table must NOT see:
//
//     tbl[0:9] = '{9.0, 9e-9,  1.0, 1e-18,  1e3, 1e-21,  1e6, 1e-24,  7.0, 7e-7}
//
// and tbl[2:7] is its elements 2..7, in that order: the three knots
// (1 Hz, 1e-18), (1 kHz, 1e-21), (1 MHz, 1e-24), a linear table (§4.6.4.3,
// not .4). A tool that passed the whole array would publish five knots,
// one that dropped the select would publish none. The same select in a
// filter's coefficient slot (A.8.2 `analog_filter_function_arg` has the same
// production) is laplace_nd(V(p,n), k[0:0], k[1:2]) with k = '{2, 1, 0, 9}:
// numerator 2, denominator 1 + 0*s, so the dc gain is 2 and, at V(p,n) = 1,
// the filter's output is 2.0 exactly.
//
// Invalid neighbour: noise_table_part_select_out_of_range_rejected.va (E0310).
// Whole-array neighbour: a06_noise_table_array_parameter.va.
//! lrm 4.6.4.3
//! lrm 4.5.11
//! noise table(p,n)#0 name=tbl interp=linear points=1.0:1e-18,1000.0:1e-21,1000000.0:1e-24
//! analysis noise
//! bias V(p) = 1.0
//! bias V(n) = 0.0
//! checks 7
`include "check.vh"
module noise_table_parameter_part_select(p, n);
    inout p, n;
    electrical p, n;
    parameter real R = 1000.0 from (0:inf);
    parameter real tbl[0:9] = '{9.0, 9e-9, 1.0, 1e-18, 1e3, 1e-21, 1e6, 1e-24, 7.0, 7e-7};
    parameter real k[0:3] = '{2.0, 1.0, 0.0, 9.0};
    real y;

    analog begin
        y = laplace_nd(V(p, n), k[0:0], k[1:2]);
        `CHECKX("a filter coefficient slot takes the same select", y, 2.0);
        `CHECKR("the dc current is the resistive term alone", V(p, n) / R, 1e-3, 1e-15);
        I(p, n) <+ V(p, n) / R + noise_table(tbl[2:7], "tbl");
    end
endmodule
