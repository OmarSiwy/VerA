// §4.2.9: "When one or both operands are unsigned, the expression shall be
// interpreted as a comparison between unsigned values. If the operands are of
// unequal bit lengths, the smaller operand shall be zero-extended to the size of
// the larger operand." And "When both operands are signed ... the smaller
// operand shall be sign-extended to the size of the larger operand."
//
// In an analog block an integer operand is §3.2's 32 bits, evaluated at that
// width (§4.2.11's shifts included), and the sentence extends the operand's
// VALUE. So `a` at -1 is 32'hFFFF_FFFF, zero-extended against a 40-bit literal
// to 40'h00_FFFF_FFFF, never 40'hFF_FFFF_FFFF. (IEEE 1364 §5.4's
// context-determined widths are the digital context's rule, not this one.)
//
// By hand, a = -1, n = 0, k = 4:
//
//   a == 40'hFF_FFFF_FFFF         40'h00_FFFF_FFFF vs 40'hFF_FFFF_FFFF  -> 0
//   a == 40'h00_FFFF_FFFF         equal                                 -> 1
//   (a >> n) > 40'h1              32'hFFFF_FFFF >> 0, extended; > 1     -> 1
//   (a >> n) == 40'hFF_FFFF_FFFF  the shift's 32 bits, extended         -> 0
//   (a >> k) == 40'h00_0FFF_FFFF  32'h0FFF_FFFF                         -> 1
//   (a << k) == 40'h00_FFFF_FFF0  32'hFFFF_FFF0 (bits past 32 are gone) -> 1
//   a > 128'h1                    2^32 - 1 > 1                          -> 1
//   (a << 28) > 64'h1             32'hF000_0000 = 4026531840 > 1        -> 1
//   s < 40'sh0                    both signed: -1 sign-extended, < 0    -> 1
//
// A compiler that masks both operands to the wider width reads the first two
// rows as 1 and 0; one that refuses the shift rows (E0364) compiles nothing.
// `a` and `n` are read from parameters, so nothing folds at compile time;
// wide_unsigned_compare_extends_each_operand_folded.va is the folded twin.
//
//! lrm 4.2.9
//! lrm 4.2.9:2
//! lrm 4.2.9:4
//! lrm 4.2.11
//! lrm 4.2.9:1
//! lrm 4.2.9:3
`include "check.vh"
module ch04_wide_unsigned_compare(p);
  inout p; electrical p;
  parameter integer pa = -1;
  parameter integer pn = 0;
  parameter integer pk = 4;
  integer a, n, k, s;
  analog begin
    a = pa; n = pn; k = pk; s = pa;
    `CHECKI("a == 40'hFF_FFFF_FFFF", a == 40'hFF_FFFF_FFFF, 0);
    `CHECKI("a == 40'h00_FFFF_FFFF", a == 40'h00_FFFF_FFFF, 1);
    `CHECKI("(a >> n) > 40'h1", (a >> n) > 40'h1, 1);
    `CHECKI("(a >> n) == 40'hFF_FFFF_FFFF", (a >> n) == 40'hFF_FFFF_FFFF, 0);
    `CHECKI("(a >> k) == 40'h00_0FFF_FFFF", (a >> k) == 40'h00_0FFF_FFFF, 1);
    `CHECKI("(a << k) == 40'h00_FFFF_FFF0", (a << k) == 40'h00_FFFF_FFF0, 1);
    `CHECKI("a > 128'h1", a > 128'h1, 1);
    `CHECKI("(a << 28) > 64'h1", (a << 28) > 64'h1, 1);
    `CHECKI("s < 40'sh0", s < 40'sh0, 1);
    I(p) <+ V(p);
  end
endmodule
