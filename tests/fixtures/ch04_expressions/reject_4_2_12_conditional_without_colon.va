// §4.2.12: the conditional operator "shall be constructed using three operands
// separated by two operators", and A.8.3 spells it
//
//     conditional_expression ::= expression1 ? { attribute_instance } expression2 : expression3
//
// `(y > 0) ? 1.0` has the `?` and two operands but no `:` and no third
// operand, so it is not a conditional expression and not derivable from
// anything else. The full `(y > 0) ? 1.0 : 0.0` is the legal form.
//
// VerA reports E0207 "unexpected token: found `;`" at the point where the `:`
// is required.
//
//! lrm 4.2.12
//! lrm A.8.3
//! lrm 4.2.12:1
//! lrm A.8.3:1000
//! reject-only E0207
//! neighbour 08_conditional_operator.va
`include "disciplines.vams"
module ch4_conditional_without_colon(p, n);
  inout p, n;
  electrical p, n;
  real x, y;

  analog begin
    y = 1.0;
    x = (y > 0) ? 1.0;      // illegal: missing `: expression3`
    I(p, n) <+ x;
  end
endmodule
