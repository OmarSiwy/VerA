// §3.2 Integer and real data types:
//
//   "Arrays of integers can be declared using a range which defines the upper
//    and lower indices of the array. BOTH INDICES SHALL BE CONSTANT EXPRESSIONS
//    and shall evaluate to a positive integer, a negative integer, or zero (0)."
//
// A `constant_expression` is not a literal. §3.4 Parameters makes a parameter's
// value a property of the INSTANCE, verbatim:
//
//   "Parameters represent constants, hence it is illegal to modify their value
//    at runtime. However, PARAMETERS CAN BE MODIFIED AT COMPILATION TIME TO
//    HAVE VALUES WHICH ARE DIFFERENT FROM THOSE SPECIFIED IN THE DECLARATION
//    ASSIGNMENT. This allows customization of module instances. A parameter can
//    be modified with the defparam statement or in the module_instantiation
//    statement."
//
// (Corrected after review: an earlier draft of this header printed a paraphrase
// of that sentence — "compile time", "a value which is different from the one
// specified" — inside quotation marks. The clause and the conclusion are
// unchanged; only the quotation is now the LRM's own words.)
//
// So a dimension written `[0:N]` is a constant expression whose value is
// whatever the model card says N is, and the array has that many elements in
// that instance. The parameter's declared default is what an instance gets when
// the card is silent; it is not the shape of the type.
//
// THE DERIVATION, by hand.
//
//   parameter integer N = 3;   // the DEFAULT
//   real b[0:N];               // so a default instance holds 4 elements
//
//   The card below overrides N to 5, so this instance holds SIX elements,
//   b[0] .. b[5]. The loop writes b[i] = 2*i for i = 0 .. N:
//
//     b[0]=0  b[1]=2  b[2]=4  b[3]=6  b[4]=8  b[5]=10
//
//   Every one of those is a small even integer, exact in IEEE 754, so the
//   asserted values carry no rounding argument at all.
//
//   top = b[N] must be 10.0 — the last element, the one that exists ONLY
//   because the override widened the array. On a device built to the default
//   shape there is no such element.
//
//   mid = b[N-2] must be 6.0 — 6, not 10 and not 0: it pins that the override
//   moved the whole index arithmetic and not just the upper bound. If N were
//   still 3 this expression would read b[1] and give 2.0.
//
//   b[0] must be 0.0 — the low end is unaffected by the override, which is the
//   guard against "widen the array by shifting it".
//
// WHY IT FAILS TODAY, and how loudly. VerA scalarizes an array into one
// variable per cell at COMPILE time, and folds the dimension bounds with the
// parameter's DEFAULT, so the emitted device carries four cells:
//
//   switch (...) { 0 => h[0], 1 => h[1], 2 => h[2], 3 => h[3],
//                  else => S.con(0.0) }
//
// while the index arithmetic in the very same expression reads `model.N`, which
// the card has set to 5. The two disagree by construction. Re-observed
// 2026-09-23: `top` reads got=0 want=10 ok=0; `mid` (b[3], inside the default
// shape) and b[0] pass. An earlier revision panicked on the out-of-range read;
// it now takes the out-of-range answer 0, which is quieter and still wrong.
// The writes to b[4] and b[5] are silently dropped first (the masked-write path
// in `assignRuntimeIndex` treats an index past the folded bound as invalid).
// This is the plan's "independently overridden structural dimensions" in one
// file.
//
// WHY IT IS NOT REFUSED INSTEAD. Nothing in §3.2, §3.4 or §6.3 lets an
// implementation reject an override of a parameter because a dimension reads
// it, and §3.4.4 says outright that "the array size may be changed by
// overriding the appropriate parameters". So the fixture is right. The fix is
// an array whose extent is a function of the model card, which means storage
// the device sizes at card time rather than cells scalarized at compile time.
// An instance-line override (`#(.N(5))`) already works, because it is folded
// at elaboration (ch06 h01_11). Only the host card is a runtime value.
//
//! lrm 3.2
//! lrm 3.4
//! param N = 5
//! bias V(p) = 0.5
//! print none
`include "check.vh"
module a01_parameterized_dimension_override(p, n);
  inout p, n;
  electrical p, n;
  parameter integer N = 3;
  real b[0:N];
  integer i;
  real top, mid;

  analog begin
    for (i = 0; i <= N; i = i + 1) b[i] = 2.0 * i;

    top = b[N];
    mid = b[N - 2];

    `CHECKX("the top element exists because the card widened the array", top, 10.0);
    `CHECKX("the override moved the whole index range, not just its end", mid, 6.0);
    `CHECKX("the low end is where it always was", b[0], 0.0);

    I(p, n) <+ V(p, n);
  end
endmodule
