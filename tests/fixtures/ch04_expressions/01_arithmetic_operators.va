// LRM 4.2.4 arithmetic operators, one term per row of Table 4-4 (binary) and
// Table 4-5 (unary), in a single expression so 4.2.2 Table 4-3 precedence has
// to hold for the total to land.
//
//   value = +7.0 + -2.0 * 3.0 - 8.0 / 4.0 + 11 % 3 + 2 ** 3
//
// ** binds tightest, then the unary signs, then * / %, then binary + -, so the
// terms are 7.0, -6.0, -2.0, 2 and 8:  7 - 6 - 2 + 2 + 8 = 9.
// Every term is a dyadic rational, so the sum is exact in IEEE 754 (3.2).
//
// 11 % 3 is 2 by 4.2.4: the modulus is the remainder of a truncating integer
// division, and it takes the sign of the FIRST operand.
//! lrm 4.2.4
//! lrm 4.2.2
`include "check.vh"
module ch04_arithmetic_operators(p, n);
    inout p, n;
    electrical p, n;
    real value;

    analog begin
        value = +7.0 + -2.0 * 3.0 - 8.0 / 4.0 + 11 % 3 + 2 ** 3;
        `CHECKI("11 % 3 is the truncating remainder", 11 % 3, 2);
        `CHECKI("2 ** 3 with two integer operands", 2 ** 3, 8);
        `CHECKX("mixed arithmetic total", value, 9.0);
        I(p, n) <+ value;
    end
endmodule
