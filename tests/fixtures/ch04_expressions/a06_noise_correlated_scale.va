// §4.6.4.6 Example 1, and the half of it no fixture asserts today: the
// COEFFICIENT.
//
// The clause, verbatim: "Perfectly correlated noise is generated by using the
// output of one noise function for more than one noise source.
//
//     n = white_noise(pwr);
//     V(a,b) <+ c1*n;
//     V(c,d) <+ c2*n;"
//
// `ch04_expressions/38_correlated_noise.va` pins the IDENTITY half — both rows
// carry one source id, so a host knows the two branches move together. That is
// not enough to compute anything. `n` is an amplitude and `c1*n` scales it, so
// the spectral density the branch (a,b) carries is c1²·pwr, and the one branch
// (c,d) carries is c2²·pwr; their cross-spectrum is c1·c2·pwr. A host handed
// "same source, density pwr on both rows" builds the wrong covariance matrix
// unless the scaling reaches it — and the sign matters too: c1 and c2 of
// opposite signs is anti-correlation, which no positive density can encode.
//
// THE NUMBERS. pwr = 1e-18 V²/Hz, c1 = 2.0, c2 = 3.0, both exact in f64:
//
//   branch (a,b):  c1²·pwr = 4.0 · 1e-18 = 4e-18 V²/Hz
//   branch (c,d):  c2²·pwr = 9.0 · 1e-18 = 9e-18 V²/Hz
//   cross:         c1·c2·pwr = 6e-18 V²/Hz, and 6e-18 = sqrt(4e-18 · 9e-18),
//                  which is the statement that the correlation is PERFECT
//                  (|ρ| = 1) — the clause's own words.
//
// The `white=` fields below are the per-branch densities; the shared `#0` is
// the identity that makes the cross term the geometric mean rather than zero.
// An implementation that instead exports the raw pwr plus a per-row coefficient
// satisfies this fixture only if the effective branch density it hands a host
// is still 4e-18 and 9e-18 — the assertion is about the spectrum, not about
// which field carries the factor.
//
// Today both rows export white = 1e-18: `tools/contract.zig`'s own NoiseGen
// comment says so ("Still not expressible: the per-use scaling coefficient
// (c1*n vs c2*n)"). So the output noise of this module is a factor of 4 (and 9)
// low, silently.
//
// Contributed as POTENTIAL sources, exactly as the clause writes them, so the
// units are V²/Hz and the rows are potential rows.
//
// WHERE THIS FIXTURE'S CLAIM LIVES. On the two `//! noise` lines, and nowhere
// else. §4.6.4.6 is a statement about what a host must be handed — one source
// id shared by two rows, each row scaled by its own coefficient — and §4.6.4
// gives an active noise function no deterministic scalar value a `CHECK` could
// read back. The fixture fails today at `//!` directive: BadSyntax
// (`validNoiseEntry`, lib/backend/tb.zig:341); once the directive lands it
// fails again on `white=4e-18` against the 1e-18 both rows actually export.
//
// An earlier draft padded that out with three `CHECK`s that cannot go red on
// any compiler: `c1*c1*pwr` against 4e-18, `c2*c2*pwr` against 9e-18, and
// `c1*c2*pwr` against `sqrt(4e-18*9e-18)`. Those are arithmetic over three
// parameters whose values are written five lines below them — 2·2·1e-18 = 4e-18
// is true of every compiler that multiplies. They restate this header's
// derivation instead of testing it, and they are gone. The derivation stays
// above, where a reviewer checks it against §4.6.4.6 rather than against a
// binary.
//
// WHAT REPLACES THEM is the one place a noise generator is observable inside
// the analog block: the linearization. §4.6.4.6's Example 1 contributes
// POTENTIALS, so the branch derivatives are §4.5.6's own `vccs` example —
// "one = ddx(vin, V(pin)); minusone = ddx(vin, V(nin))", whose names the LRM
// says "indicate the values of the partial derivatives: +1, -1, or 0". The
// shared generator, whose power is a constant parameter, must leave them at
// exactly ±1:
//
//   ddx(V(a,b) + c1*nz, V(a)) = +1      ddx(V(c,d) + c2*nz, V(d)) = −1
//   ddx(c1*nz, V(a))          =  0      (the same clause's zero case)
//
// The want is non-zero and exact, so a lowering that let `white_noise(pwr)`
// reach an unknown — or that folded the coefficient into a node-dependent path
// — moves it. That is a weaker claim than the two `//! noise` lines and is
// stated as one; it is here so the file is not a green no-op while the
// directive is blocked, not as a substitute for the amplitude assertion.
//
//! lrm 4.6.4.6
//! lrm 4.5.6
//! xfail the per-use coefficient does not reach the export: both rows report white = pwr = 1e-18 instead of c1²·pwr and c2²·pwr, so a host computes this module's output noise 4x (and 9x) low. tools/contract.zig:665 names the fix — a `coeff` on PsdTerm, evaluated by noisePsd because it may depend on the bias, with S_k(f) = coeff²·(white + flicker/f^ef) and the §4.6.4.6 cross term coeff_i·coeff_j·pwr. Delete this line and rewrite the two want values when it lands.
//! noise thermal(a,b)#0 name=shared white=4e-18
//! noise thermal(c,d)#0 name=shared white=9e-18
//! analysis noise
//! bias V(a) = 0.0
//! bias V(b) = 0.0
//! bias V(c) = 0.0
//! bias V(d) = 0.0
`include "check.vh"
module a06_noise_correlated_scale(a, b, c, d);
    inout a, b, c, d;
    electrical a, b, c, d;
    parameter real pwr = 1e-18 from [0:inf);
    parameter real c1 = 2.0;
    parameter real c2 = 3.0;
    real nz;

    analog begin
        nz = white_noise(pwr, "shared");

        // §4.5.6's vccs example: ddx(V(pin,nin), V(pin)) is +1 and
        // ddx(..., V(nin)) is -1. A constant-power shared generator must not
        // move either.
        `CHECKX("the shared generator is outside branch (a,b)'s linearization",
            ddx(V(a, b) + c1 * nz, V(a)), 1.0);
        `CHECKX("and outside branch (c,d)'s, from the negative terminal",
            ddx(V(c, d) + c2 * nz, V(d)), -1.0);
        `CHECKX("on its own it has no derivative at all (the clause's zero case)",
            ddx(c1 * nz, V(a)) + ddx(c2 * nz, V(c)), 0.0);

        V(a, b) <+ c1 * nz;
        V(c, d) <+ c2 * nz;
    end
endmodule
