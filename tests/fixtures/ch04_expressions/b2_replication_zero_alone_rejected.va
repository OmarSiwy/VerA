// §4.2.13: "A replication with a zero replication constant is considered to
// have a size of zero and is ignored. Such a replication shall appear only
// within a concatenation in which at least one of the operands of the
// concatenation has a positive size."
//
// `{ {0{1'b1}} }` is a concatenation whose only operand is a zero
// replication: no operand has a positive size, so the rule is broken. The
// legal neighbour, b2_replication_zero_beside_sized_operand.va, differs only
// in the 4'b0101 operand beside the replication.
//
//! lrm 4.2.13
//! lrm 4.2.13:5
//! reject-only E0326
//! neighbour b2_replication_zero_beside_sized_operand.va
`include "disciplines.vams"
module b2_replication_zero_alone_rejected(p, n);
    inout p, n;
    electrical p, n;
    integer k;

    analog begin
        k = { {0{1'b1}} };
        I(p, n) <+ k * V(p, n);
    end
endmodule
