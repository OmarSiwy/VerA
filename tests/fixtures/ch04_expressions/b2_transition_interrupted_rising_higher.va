// §4.5.8, the second of the four interrupted-transition cases (Figure 4-8):
//
//   "If the original transition was rising and the new destination value is
//    above the value at the interruption, then the original transition's
//    origin shall be used to compute the new origin. ... Then the original
//    transition's origin (v1) shall be used along with the new rise time
//    (tr3), to calculate the slope: (v3-v1)/tr3. This slope will be applied
//    from the point of interruption (ti,vi), and the readjusted transition's
//    expected end time (t3) is then calculated using this slope, along with
//    the time and value level at the point of the interruption:
//    t3 = ti + (v3-vi)/slope."
//
// a04_02_transition_interrupted_rising.va is the rising-then-LOWER case.
//
// HAND DERIVATION. transition(V(p, n), 0, 4n, 2n): td = 0, rise 4ns, fall 2ns.
// The input is piecewise constant: 0, then 4 from t = 1ns, then 8 from 3ns.
//
//   Original rise: (t1,v1) = (1ns, 0) to (t2,v2) = (5ns, 4), slope 1 V/ns.
//   At ti = 3ns the output is vi = 2 and the input becomes v3 = 8 > vi.
//   tr3 = 4ns (the rise time). slope = (v3 - v1)/tr3 = (8 - 0)/4ns = 2 V/ns,
//   from (3ns, 2); t3 = ti + (v3 - vi)/slope = 3 + 6/2 = 6ns.
//
//   t/ns   0   1   2   3   4   5   5.5   6   7
//   out    0   0   1   2   4   6   7     8   8
//
// The wrong readings differ at 4, 5, 5.5 and 6ns: a fresh rise from (ti,vi)
// over tr3, slope (v3-vi)/tr3 = 1.5 V/ns, reads 3.5, 5, 5.75, 6.5; keeping
// the destination v2 as origin, (v3-v2)/tr3 = 1 V/ns, reads 3, 4, 4.5, 5.
// (python3 check of the table: piecewise-linear through (1,0), (3,2), (6,8).)
//
//! lrm 4.5.8
//! lrm 4.5.8:6
//! lrm 4.5.8:7
//! lrm 4.5.8:9
//! analysis tran
//! bias V(n) = 0
//! wave V(p) = 0, 4, 4, 8
//! time 0, 1n, 2n, 3n, 4n, 5n, 5.5n, 6n, 7n
//! print none
//! checks 9
`include "check.vh"
module b2_transition_interrupted_rising_higher(p, n);
    inout p, n;
    electrical p, n;
    real tns, y;

    analog begin
        tns = $abstime * 1e9;
        y = transition(V(p, n), 0, 4n, 2n);
        if (tns < 0.5)
            `CHECK("rising, interrupted upward: at t = 0", y, 0.0, 1e-9);
        else if (tns < 1.5)
            `CHECK("rising, interrupted upward: at t = 1ns", y, 0.0, 1e-9);
        else if (tns < 2.5)
            `CHECK("rising, interrupted upward: at t = 2ns", y, 1.0, 1e-9);
        else if (tns < 3.5)
            `CHECK("rising, interrupted upward: at t = 3ns (ti, vi)", y, 2.0, 1e-9);
        else if (tns < 4.5)
            `CHECK("rising, interrupted upward: at t = 4ns", y, 4.0, 1e-9);
        else if (tns < 5.25)
            `CHECK("rising, interrupted upward: at t = 5ns", y, 6.0, 1e-9);
        else if (tns < 5.75)
            `CHECK("rising, interrupted upward: at t = 5.5ns", y, 7.0, 1e-9);
        else if (tns < 6.5)
            `CHECK("rising, interrupted upward: at t = 6ns = t3", y, 8.0, 1e-9);
        else
            `CHECK("rising, interrupted upward: at t = 7ns", y, 8.0, 1e-9);
        I(p, n) <+ 1e-3 * y;
    end
endmodule
