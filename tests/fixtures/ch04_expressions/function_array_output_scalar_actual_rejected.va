// §4.7.2.3 Output arguments: "If the output argument is defined as an array
// then the argument passed into the function must be an analog variable or an
// array assignment pattern of analog variables of equivalent size."
//
// `out` is the two-element array formal `[0:1]`; the call passes the scalar
// `a`, which is neither an array variable of two elements nor a two-element
// pattern. The legal call, `fill(V(p), '{a, b})`, is
// 108_function_array_output_pattern.va.
//
// VerA used to accept this and copy nothing back: `a` silently kept its old
// value, as if the output argument did not exist.
//
//! lrm 4.7.2.3
//! lrm 4.7.2.3:2
//! reject-only E0511
//! neighbour 108_function_array_output_pattern.va
`include "disciplines.vams"
module ch04_fn_array_out_scalar(p);
  inout p;
  electrical p;
  real a, dummy;

  analog function real fill;
    input x;
    output [0:1] out;
    real x, out[0:1];
    begin
      out[0] = x;
      out[1] = 2.0 * x;
      fill = x;
    end
  endfunction

  analog begin
    dummy = fill(V(p), a);
    I(p) <+ dummy + a;
  end
endmodule
