// §4.3.2: "Input values outside of the valid range for the operator shall
// report an error." Table 4-14: `ln1p(x)`, C `log1p(x)`, "Natural logarithm
// of 1 plus x", domain "x > -1" (#59). The constant ln1p(-2.0) is E0603 at
// compile time (ln1p_domain_rejected.va).
//
//   point 0, V(p) = 0:  ln1p(0) = 0 exactly (C99 F.10.3.9), so CHECKX 0.
//   point 1, V(p) = -1: x = -1 is the bound itself, outside the OPEN "x > -1"
//                       (IEEE gives -inf, silently, before #59). The run
//                       reports E0603 and exits 1.
//
//! lrm 4.3.1
//! lrm 4.3.2
//! lrm 4.3.2:2
//! sweep V(p) = 0, -1
//! reject-run E0603
//! neighbour runtime_domain_legal_neighbour.va
//! checks 1
//! print none
`include "check.vh"
module runtime_ln1p_domain(p, n);
  inout p, n; electrical p, n;
  real r;
  analog begin
    r = ln1p(V(p, n));
    `CHECKX("ln1p(0) is 0, at the in-domain point only", r, 0.0);
    I(p, n) <+ V(p, n);
  end
endmodule
