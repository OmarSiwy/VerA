// AMS 4.3 and 4.3.1 Table4-14 permit both function styles. Integer min/max/abs
// return integer, hence result3 divided by integer2 truncates to1 (4.2.4).
// Observe before integer assignment can erase the type distinction. The legal
// traditional and mixed-real neighbors are in audit_math_result_type_division.va.
// A real operand instead gives real result3 and real quotient1.5, in either
// binary argument position. Keep these neighbors beside the integer oracle.
//! lrm 4.3.1
//! lrm 4.2.4
//! checks 8
`include "check.vh"
module audit_system_math_result_type_division(p);
    inout p;
    electrical p;
    analog begin
        `CHECKX("system integer min quotient", $min(3, 5) / 2, 1.0);
        `CHECKX("system integer max quotient", $max(1, 3) / 2, 1.0);
        `CHECKX("system integer abs quotient", $abs(-3) / 2, 1.0);
        `CHECKX("system mixed min quotient", $min(3, 5.0) / 2, 1.5);
        `CHECKX("system reverse mixed min quotient", $min(3.0, 5) / 2, 1.5);
        `CHECKX("system mixed max quotient", $max(1.0, 3) / 2, 1.5);
        `CHECKX("system reverse mixed max quotient", $max(1, 3.0) / 2, 1.5);
        `CHECKX("system real abs quotient", $abs(-3.0) / 2, 1.5);
        I(p) <+ V(p);
    end
endmodule
