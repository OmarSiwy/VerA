// §5.9 "The following restrictions are applied to looping statements (repeat,
// while and for) except for analog_for statements: - Analog filter functions are
// not allowed". No analysis_or_constant carve-out here, unlike §5.8.1 — and an
// event body is conditionally executed by definition.
//
// This fixture used to assert the opposite — that the illegal form COMPILES.
//! reject E0514
// §5.10.3.1: `cross()` "maintains its internal state and has the same
// restrictions as analog operators" — an event body runs only when the event
// fires, so `ddt` inside one misses every other step. Rejected as E0514.
module ch4_op_event(p); inout p; electrical p; real x; analog begin @(cross(V(p),1)) x=ddt(V(p)); I(p)<+x; end endmodule
