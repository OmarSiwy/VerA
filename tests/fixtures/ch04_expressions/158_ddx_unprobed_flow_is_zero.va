// LRM 4.5.6, closing sentence on the unknowns: "If the expression does not
// depend explicitly on the unknown, then ddx() returns zero (0)."
//
// Here the named flow I(p,n) is not an unknown of the system AT ALL: nothing
// probes it and the branch is driven as a flow source, so the solver's vector
// holds the two node potentials and nothing else. An expression can only
// depend on a branch current through an I() read, and there is none — so the
// derivative is the clause's plain 0, and asking for it must not CHANGE the
// system it is asked about:
//
//   - minting a solver unknown for the target would add a variable no
//     equation pins (an all-zero Jacobian row — structurally singular, the
//     operating point below would not even solve), and
//   - recording a branch READ for the target would make (p,n) a flow-probe
//     branch, which §5.4.2 defines as a 0 V short — a topology change a
//     derivative query has no license to make; the dc current below would
//     become 1.5e-3 through a short instead of 1e-3 through the source.
//
// So the fixture pins all three at once: the 0, the solvable system (the
// bias converging IS the no-phantom-unknown check), and the undisturbed
// topology (the resistive current keeps its two-node value).
//
// 147_ddx_flow_unknown.va is the other half of the same sentence: the SAME
// probe shape where the flow IS an unknown, with the exact derivative.
//
//! lrm 4.5.6
//! bias V(p) = 1.5
//! bias V(n) = 0.0
`include "check.vh"
module ch04_ddx_unprobed_flow_is_zero(p, n);
    inout p, n;
    electrical p, n;
    real g;

    analog begin
        g = ddx(2.0 * V(p, n), I(p, n));
        `CHECKX("d/dI of an expression with no I() read is zero", g, 0.0);
        `CHECKX("and asking did not short the branch", V(p, n), 1.5);
        I(p, n) <+ V(p, n) * 1.0e-3;
    end
endmodule
