// §4.2.12: "If expression1 evaluates to false (0), then expression3 is
// evaluated and used as the result of the conditional expression. If
// expression1 evaluates to true (any value other than zero (0)), then
// expression2 is evaluated and used as the result."
//
// I(p, n) = V(p, n) * (V(p) > -0.1 ? 2.0 : 3.0), so dI/dV(p, n) is 2 where
// V(p) > -0.1 and 3 elsewhere: the Jacobian depends on x. The device must not
// declare `constant.g` (tools/contract.zig `Constant`: "g/c promise that
// dF/dx and dQ/dx do not depend on x ... A wrong promise silently freezes the
// Jacobian"). The arms are constants, so the select's own derivative is zero
// in every lane; only its condition reads x, which is what a claim built on
// the arms alone missed (#78).
//
// The testbench's const_check gate evaluates a second bias,
// x' = 1.5 x - 0.25 - 0.125 i for unknown i, and fails the run when a
// declared-constant Jacobian differs there. At the bias below V(p) = 0 takes
// the 2.0 arm; at x' V(p) = -0.25 - 0.125 i <= -0.25 takes the 3.0 arm,
// whichever index p has. A false `constant.g` therefore fails the run with
// `const_check FAIL`; a device that makes no such promise passes.
//
// The check, by hand: V(p) = 0 > -0.1 is true, so the conditional is 2.0.
//! lrm 4.2.12
//! bias V(p) = 0.0, V(n) = 0.0
//! checks 1
`include "check.vh"
module conditional_conductance_not_constant(p, n);
  inout p, n;
  electrical p, n;
  analog begin
    `CHECKX("V(p) > -0.1 takes expression2", V(p) > -0.1 ? 2.0 : 3.0, 2.0);
    I(p, n) <+ V(p, n) * (V(p) > -0.1 ? 2.0 : 3.0);
  end
endmodule
