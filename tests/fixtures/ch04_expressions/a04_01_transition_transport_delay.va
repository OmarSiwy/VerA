// §4.5.8 the TRANSPORT DELAY argument of transition(), which is the second
// argument and the one VerA never reads.
//
//   "The general form of the transition() filter is
//      transition ( expr [ , td [ , rise_time [ , fall_time [ , time_tol ] ] ] ] )
//    ... When applied, transition() forces all positive transitions of expr to
//    occur over rise_time and all negative transitions to occur in fall_time
//    (AFTER AN INITIAL DELAY OF td). Thus, td models transport delay and
//    rise_time and fall_time model inertial delay."
//
// So td shifts the whole ramp later in time; it does not stretch it. With
//
//     td = 2ns, rise_time = 2ns, fall_time = 2ns
//
// and a piecewise-constant input that steps 0 -> 1 at t = 1ns, the transition
// is created at t = 1ns (the instant the input changes), starts ramping at
// 1ns + td = 3ns, and reaches the new level one rise_time later at 5ns:
//
//   t/ns    0     1     2     3     4     5     6
//   in      0     1     1     1     1     1     1
//   out     0     0     0     0     0.5   1     1
//
// which is the closed form  clamp((t/1ns - 3) / 2, 0, 1)  written below in
// $abstime rather than in V(p,n), so an error common to the operator and to
// the oracle cannot cancel. out minus that closed form is one literal want,
// 0.0, at all seven points.
//
// WHY THIS FAILS TODAY. `Gen.transitionTimes` reads arguments 2 and 3 only
// (rise_time, fall_time); argument 1 is dropped on the floor, so every
// `transition(x, td, ...)` behaves as if td were 0 and the ramp begins at the
// previous accepted timepoint. That implementation answers 0.5 at t = 1ns,
// where this fixture demands 0 — a full rise_time early.
//
// The 0.5 at t = 4ns is the discriminator that a "delay by rounding to the
// next timepoint" shortcut cannot fake: it is a point strictly inside the
// delayed ramp.
//
// MEASURED, the RESIDUAL `out - want` printed by the CHECK below reads
// 0.5 / 1 / 1 / 0.5 / 0 at t = 1..5ns, i.e. the operator itself reads
// 0.5 / 1 / 1 / 1 / 1 against the want 0 / 0 / 0 / 0.5 / 1 — four of the seven
// points wrong. (The 0.5/1/1/0.5/0 sequence is the residual, not the output;
// they are easy to confuse because the want is zero over the first three
// points.) Two defects add up there and
// both are the same missing question "when did this excursion begin": td is
// dropped, and `zTransStep` arms the ramp origin at the PREVIOUS accepted
// timepoint rather than at the timepoint where the input changed, so even with
// td = 0 the ramp starts one step early. §4.5.8's "a transition is created when
// the input expression changes" and its requirement that the simulator "place
// time points at both corners of a transition" fix that origin at the change
// itself, which is what the want above is built from.
//
//! lrm 4.5.8
//! bias V(n) = 0
//! wave V(p) = 0, 1
//! time 0, 1n, 2n, 3n, 4n, 5n, 6n
//! analysis tran
//! print none
`include "check.vh"
module a04_transition_transport_delay(p, n);
    inout p, n;
    electrical p, n;

    analog begin
        `CHECK("transition(expr, td, tr, tf) starts its ramp td after the input changed",
               transition(V(p, n), 2n, 2n, 2n)
                 - min(max(($abstime * 1e9 - 3.0) / 2.0, 0.0), 1.0), 0.0, 1e-12);
        // td is a shift, not a stretch: the ramp still takes exactly
        // rise_time, so the output is still 0 one whole rise_time after the
        // input changed. A td folded into the rise time would read 0.25 here.
        `CHECKI("the output has not moved at all one rise_time after the input changed",
                transition(V(p, n), 2n, 2n, 2n) == 0.0 || $abstime > 3n, 1);

        I(p, n) <+ 1e-3 * transition(V(p, n), 2n, 2n, 2n);
    end
endmodule
