// §4.5.12.1 (zi_zp): "If a root (a pole or zero) is real, the imaginary part
// shall be specified as zero. If a root is complex, its conjugate shall also
// be present."
//
// The zero vector '{-0.5, 0.5} is one zero, -0.5 + 0.5j, with no -0.5 - 0.5j.
// The pole vector '{0.1, 0.0} is a single real pole with its imaginary part
// written as zero, as the first sentence requires, and T = 1u is a positive
// sampling period. The only error is the unpaired complex zero.
//
//! lrm 4.5.12.1
//! lrm 4.5.12.1:2
//! reject-only no conjugate partner
//! neighbour 24_z_transform_filters.va
`include "disciplines.vams"
module ch4_zi_zp_unpaired_zero(p, n);
  inout p, n;
  electrical p, n;

  analog I(p, n) <+ zi_zp(V(p, n), '{-0.5, 0.5}, '{0.1, 0.0}, 1u);
endmodule
