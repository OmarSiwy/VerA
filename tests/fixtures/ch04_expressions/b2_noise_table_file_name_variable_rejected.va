// §4.6.4.3: "The file name argument shall be constant and will be either a
// string literal or a string parameter." A.8.2 agrees:
//
//     noise_table_input_arg ::= parameter_identifier
//         | parameter_identifier [ msb_constant_expression : lsb_constant_expression ]
//         | string | constant_assignment_pattern
//
// `fname` below is a string VARIABLE: not constant, not a literal, not a
// parameter. The legal neighbour, b2_noise_table_file_name_parameter.va,
// differs only in `fname` being declared a parameter.
//
//! lrm 4.6.4.3
//! lrm 4.6.4.3:1
//! reject-only E0519
//! neighbour b2_noise_table_file_name_parameter.va
`include "disciplines.vams"
module b2_noise_table_file_name_variable_rejected(p, n);
    inout p, n;
    electrical p, n;
    string fname = "noise_table_input.tbl";
    real nt;

    analog begin
        nt = noise_table(fname, "file-input");
        I(p, n) <+ V(p, n) / 1000.0 + nt;
    end
endmodule
