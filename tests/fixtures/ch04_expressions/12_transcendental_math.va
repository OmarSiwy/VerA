// §4.3.2 Table 4-15 — the trigonometric and hyperbolic functions.
//
// The bias puts V(p,n) at 1 V, so x = 0.5*tanh(1) = 0.3807970779778824 — one
// value, well inside every domain in the table (asin/acos want [-1,1], atanh
// wants (-1,1), tan wants away from an odd multiple of pi/2), and the wants
// below are that argument put through the equivalent C function.
//
// The identity checks are there to LOCALIZE a failure: the summed `value` says
// something broke, sin^2+cos^2 and cosh^2-sinh^2 and asin+acos say which pair.
// They hold at every x, so they are claims about the functions rather than
// about this operating point.
//
//! lrm 4.3.2
//! bias V(p) = 1
//! bias V(n) = 0
//! print none
`include "check.vh"
module ch04_transcendental_math(p, n);
    inout p, n;
    electrical p, n;
    real x, value;

    analog begin
        // tanh maps the unbounded probe into [-1,1] (LRM 4.3.2), and the 0.5
        // scale puts x strictly inside every domain used below: tan's
        // pole-free central branch, asin/acos' [-1,1], atanh's (-1,1).
        x = 0.5 * tanh(V(p, n));
        value = sin(x) + cos(x) + tan(x) + asin(x) + acos(x) + atan(x) +
                atan2(x, 1.0) + hypot(x, 1.0) + sinh(x) + cosh(x) + tanh(x) +
                asinh(x) + acosh(abs(x) + 1.0) + atanh(x);

        // The operating point: tanh(1) = 0.7615941559557649, halved.
        `CHECKR("x = 0.5*tanh(1)", x, 0.3807970779778824, 1e-15);

        // Individual rows of Table 4-15 at that x.
        `CHECKR("tan(x)", tan(x), 0.4003372522293064, 1e-15);
        `CHECKR("hypot(x, 1)", hypot(x, 1.0), 1.0700497252915369, 1e-15);
        `CHECKR("asinh(x)", asinh(x), 0.3721473882243021, 1e-15);
        `CHECKR("acosh(1 + x)", acosh(abs(x) + 1.0), 0.8471347729815142, 1e-15);
        `CHECKR("atanh(x)", atanh(x), 0.40099158142700686, 1e-15);

        // Identities, true for every x in the domain.
        `CHECK("sin^2 + cos^2 == 1", sin(x)*sin(x) + cos(x)*cos(x), 1.0, 1e-15);
        `CHECK("cosh^2 - sinh^2 == 1", cosh(x)*cosh(x) - sinh(x)*sinh(x), 1.0, 1e-15);
        `CHECK("asin(x) + acos(x) == pi/2", asin(x) + acos(x), 1.5707963267948966, 1e-15);
        // Table 4-15 defines atan2(y,x) as the arc-tangent of y/x, so with
        // x = 1 it must agree with atan. The tolerance is 1e-15 — about 18 ulp
        // of atan(x) = 0.36384332848986, whose ulp is 5.55e-17. Table 4-15
        // names atan2 and atan as two SEPARATE C entry points, and neither it
        // nor C requires them to agree bit for bit; glibc happens to return an
        // exact 0.0 for this difference today. The previous 1e-16 was 1.8 ulp,
        // which a different libm would fail for a reason that is not a bug.
        //
        // Both sides are VerA expressions, so this is CHECKEQ and not a CHECK
        // against a literal 0.0: writing the difference on the left and 0.0 on
        // the right would route a relational claim past the macro that exists
        // to keep relational claims greppable. The three identities above are
        // CHECKs because their right side is a constant the LRM fixes (1, 1,
        // pi/2), not a second call into the same table. Contrast the
        // `expr - closed_form, 0.0` shape in 17/19/21, where the right side is
        // an independent $abstime oracle.
        `CHECKEQ("atan2(x, 1) == atan(x)", atan2(x, 1.0), atan(x), 1e-15);

        // All fourteen rows summed, left to right in source order. The double
        // is 8.516023054937422; the last digit is part of the value, not noise.
        `CHECKR("the whole table summed", value, 8.516023054937422, 1e-14);

        I(p, n) <+ value;
    end
endmodule
