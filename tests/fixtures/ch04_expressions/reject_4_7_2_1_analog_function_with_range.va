// §4.7.2.1: "An analog user-defined function shall always return a scalar
// value, either numeric or string based on the type specified for the analog
// user-defined function."
//
// A.2.6 makes that a grammar fact:
//
//     analog_function_declaration ::=
//             analog function [ analog_function_type ] analog_function_identifier ; ...
//     analog_function_type ::= integer | real | string
//
// There is no range in analog_function_type, so `analog function real [0:1] f`
// (a vector return) is not derivable. The same function declared
// `analog function real f;` compiles.
//
// VerA refuses at the `[`: E0208 "expected an identifier: found `[`" (the
// function name is what may follow the type). Later diagnostics are the
// parser recovering from that one error.
//
//! lrm 4.7.2.1
//! lrm 4.7.2.1:1
//! lrm A.2.6
//! lrm A.2.6:1000
//! reject E0208
`include "disciplines.vams"
module ch4_function_with_range(p, n);
  inout p, n;
  electrical p, n;

  analog function real [0:1] f;     // illegal: a function returns a scalar
    input x;
    real x;
    f = x;
  endfunction

  analog I(p, n) <+ f(V(p, n));
endmodule
