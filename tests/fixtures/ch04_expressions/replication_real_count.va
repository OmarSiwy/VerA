// §4.2.1: "If a real expression is used for the replication factor of a
// concatenation, the expression will first be converted to an integer value
// using the rules described in 4.2.1.1, before it is used as the replication
// factor for the concatenation."
//
// §4.2.1.1: "Real numbers are converted to integers by rounding the real number
// to the nearest integer, rather than by truncating it. ... If the fractional
// part of the real number is exactly 0.5, it shall be rounded away from zero."
//
// IEEE 1364-2005 §5.1.14 constrains the count only as "a non-negative, non-x
// and non-z constant expression". Every count below is a constant, and each is
// non-negative after conversion (a real is never x or z).
//
// §3.3 Table 3-3 says a STRING replication's "multiplier must be of integral
// type", but the same row says that when "Str is a literal and multiplier is
// constant, the expression behaves like numeric replication in Verilog" — the
// replication §4.2.1 converts. So a constant real count over a string literal is
// the §4.2.1 case, not the Table 3-3 nonconstant one.
//
// Hand derivation:
//   {2.0{"ab"}}        2.0 -> 2                   "abab"
//   {2.4{"ab"}}        2.4 -> 2 (nearest, not 3)  "abab"
//   {2.5{"ab"}}        2.5 -> 3 (tie, away from 0) "ababab"  (truncation says 2)
//   {1.0 + 1.5{"ab"}}  2.5 -> 3, the count folded rather than written as one
//                      literal                    "ababab"
//   {2.5{4'd3}}        three copies of 4'b0011 = 12'b0011_0011_0011
//                      = 0x333 = 819              (truncation says 0x33 = 51)
//
// The illegal neighbour, a real count that is negative after conversion, is
// replication_real_count_negative_rejected.va.
//
//! lrm 4.2.1
//! lrm 4.2.1:1002
//! lrm 4.2.1.1
//! lrm 4.2.1.1:1001
//! lrm 4.2.1.1:1
//! bias V(p) = 1.0
`include "check.vh"
module ch04_replication_real_count(p);
    inout p;
    electrical p;
    string a, b, c, d;
    integer k;

    analog begin
        a = {2.0{"ab"}};
        b = {2.4{"ab"}};
        c = {2.5{"ab"}};
        d = {1.0 + 1.5{"ab"}};
        k = {2.5{4'd3}};
        `CHECKI("2.0 copies is two", (a == "abab"), 1);
        `CHECKI("2.4 rounds to the nearest integer, two", (b == "abab"), 1);
        `CHECKI("2.5 rounds away from zero, three", (c == "ababab"), 1);
        `CHECKI("a folded 1.0 + 1.5 converts the same way", (d == "ababab"), 1);
        `CHECKI("numeric replication by 2.5 is three copies of 4'd3", k, 819);
        I(p) <+ 0.0 * V(p);
    end
endmodule
