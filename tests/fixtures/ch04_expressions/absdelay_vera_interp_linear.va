// The default twin of `absdelay_vera_interp_quadratic.va`: §4.5.7 "the
// absdelay() operator will use linear interpolation as needed", and VerA's
// `vera_interp` of 1 — written, or implied by §2.9's "If a value is not
// specifically assigned to the attribute, then its value shall be 1" — is
// that same linear reading.
//
// INPUT: V(p) = tn^2 at tn = $abstime/1ns = 0..5; td = 1.5 ns, so the query
// tn - 1.5 lies between two accepted samples a unit apart, and linear
// interpolation of a parabola there overshoots by h^2/4 = 0.25:
//   tn   query  linear
//   0    -      0 (DC: the input)
//   1    -0.5   0 (before history: Input(0))
//   2    0.5    0 + (1 - 0) * 0.5  = 0.5
//   3    1.5    1 + (4 - 1) * 0.5  = 2.5
//   4    2.5    4 + (9 - 4) * 0.5  = 6.5
//   5    3.5    9 + (16 - 9) * 0.5 = 12.5
// i.e. (tn - 1.5)^2 + 0.25 from tn = 2.
//! lrm 4.5.7
//! lrm 2.9
//! lrm 2.9:3
//! bias V(n) = 0
//! wave V(p) = 0, 1, 4, 9, 16, 25
//! time 0, 1n, 2n, 3n, 4n, 5n
//! analysis tran
//! print none
`include "check.vh"
module absdelay_vera_interp_linear(p, n);
    inout p, n;
    electrical p, n;
    real y0, y1, yb;
    analog begin
        y0 = absdelay(V(p, n), 1.5n);
        y1 = absdelay (* vera_interp = 1 *) (V(p, n), 1.5n);
        (* vera_interp *) yb = absdelay(V(p, n), 1.5n);
        `CHECK("no attribute", y0,
            $abstime < 0.5n ? 0.0 : ($abstime < 1.5n ? 0.0 : ($abstime < 2.5n ? 0.5 : ($abstime < 3.5n ? 2.5 : ($abstime < 4.5n ? 6.5 : 12.5)))), 1e-9);
        `CHECK("vera_interp = 1", y1,
            $abstime < 0.5n ? 0.0 : ($abstime < 1.5n ? 0.0 : ($abstime < 2.5n ? 0.5 : ($abstime < 3.5n ? 2.5 : ($abstime < 4.5n ? 6.5 : 12.5)))), 1e-9);
        `CHECK("bare vera_interp", yb,
            $abstime < 0.5n ? 0.0 : ($abstime < 1.5n ? 0.0 : ($abstime < 2.5n ? 0.5 : ($abstime < 3.5n ? 2.5 : ($abstime < 4.5n ? 6.5 : 12.5)))), 1e-9);
        I(p, n) <+ 0.0;
    end
endmodule
