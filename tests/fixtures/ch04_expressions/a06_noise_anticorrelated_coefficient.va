// §4.6.4.6: "Each noise function generates noise which is uncorrelated with
// the noise generated by other functions. Perfectly correlated noise is
// generated by using the output of one noise function for more than one noise
// source." Example 1:
//
//     n = white_noise(pwr);
//     V(a,b) <+ c1*n;
//     V(c,d) <+ c2*n;
//
// THE COEFFICIENT, by hand. Both contributions are scalings of ONE random
// process n of density pwr, so the spectra a host must build are
//
//     S_ab = c1² · pwr      S_cd = c2² · pwr      S_ab,cd = c1 · c2 · pwr
//
// and the correlation coefficient of the two branch noises is
//
//     ρ = S_ab,cd / sqrt(S_ab · S_cd) = c1·c2 / (|c1|·|c2|) = sign(c1·c2).
//
// Here c1 = 2 and the second branch is contributed as `-c2 * n` with c2 = 3,
// so its factor is -3 and ρ = (2·-3)/(2·3) = -1: ANTI-correlated, which no
// pair of positive densities can say, and which a host that drops the sign
// gets backwards (+1). The densities are 2²·1e-18 = 4e-18 and
// (-3)²·1e-18 = 9e-18, exact in f64 to the default rtol.
//
// A third branch takes m, a second `white_noise` call: "uncorrelated with the
// noise generated by other functions", so ρ = 0 against both rows of n. Its
// density is 2²·1e-18 = 4e-18.
//
// So the export is three rows: (a,b) and (c,d) share one source id (#0), (e,f)
// has its own (#1), and `corr=` states ρ between rows as a host computes it
// from the table (`coeff` signs on a shared source, `tb.NoiseWant.corrs`).
//
// The CHECKs pin the analysis the table was read in (§4.6.1: `analysis("noise")`
// is 1 during a noise analysis) and that the shared generator is outside the
// linearization (§4.6.4: noise is a small-signal source; d(c1*n)/dV(a) = 0).
//
//! lrm 4.6.4.6
//! lrm 4.6.4.6:1000
//! lrm 4.6.1
//! noise thermal(a,b)#0 name=shared white=4e-18 corr=1:-1 corr=2:0
//! noise thermal(c,d)#0 name=shared white=9e-18 corr=0:-1 corr=2:0
//! noise thermal(e,f)#1 name=other white=4e-18 corr=0:0
//! analysis noise
//! bias V(a) = 0.0, V(b) = 0.0, V(c) = 0.0, V(d) = 0.0, V(e) = 0.0, V(f) = 0.0
//! checks 17
`include "check.vh"
module a06_noise_anticorrelated_coefficient(a, b, c, d, e, f);
    inout a, b, c, d, e, f;
    electrical a, b, c, d, e, f;
    parameter real pwr = 1e-18 from [0:inf);
    parameter real c1 = 2.0;
    parameter real c2 = 3.0;
    real n, m;

    analog begin
        n = white_noise(pwr, "shared");
        m = white_noise(pwr, "other");
        `CHECKI("the table is read in a noise analysis", analysis("noise"), 1);
        `CHECKX("the shared generator is outside the linearization", ddx(c1 * n, V(a)), 0.0);
        I(a, b) <+ c1 * n;
        I(c, d) <+ -c2 * n;
        I(e, f) <+ c1 * m;
    end
endmodule
