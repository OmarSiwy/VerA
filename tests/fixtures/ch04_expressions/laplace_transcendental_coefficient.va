// §4.5.11 filter coefficients may be any constant expression, and Table 4-15's
// trigonometric functions are among the §4.3 functions a constant expression
// may call. So a root written `1e3*sin(w)` over a parameter `w` is as legal as
// one written `1e3*sqrt(w)`.
//
// §4.5.11.4 fixes the DC gain of the numerator-denominator form:
//
//     H(s) = Σ n_k s^k / Σ d_k s^k,  so H(0) = n_0 / d_0
//
// and §4.5.11.1's zero-pole form has H(0) = 1 whatever its roots (every factor
// (1 - s/ρ) is 1 at s = 0). `//! analysis dc` puts both filters at s = 0.
//
// THE NUMBERS. w = 0.5235987755982988 is π/6 to f64 precision, so
// sin(w) = 1/2 to within one ulp (sin(π/6) = 1/2 exactly; the literal is off
// π/6 by less than 1e-16). With n = {sin(w)}, d = {1.0} and V(in) = 1:
//   y = n_0/d_0 * 1 = 1/2                 (CHECK, 1e-15)
//   z = 1 * 1 = 1, for the conjugate pair -1e3 ± j·1e3·sin(w)  (exact)
//
// GROUND TRUTH before the shared constant kernel: "codegen refused a
// construct" (and, under `--check`, device Zig that did not compile). The
// emitter folds filter coefficients through
// `analysis.foldConst`, which knew sqrt/exp/ln/log/floor/ceil and nothing of
// Table 4-15 (audit R4, probe lzp_sin). It now folds every opcode through the
// `fold` column of lib/ir/opcode.zig.
//
// Corrected 2026-10-08 (construct only, the wants are unchanged): the
// coefficient vectors were VAMS 2.x concatenations, `{...}`. A.8.2's
// analog_filter_function_arg is a parameter, a part of one or a `'{...}`
// assignment pattern (annex G: "Add apostrophe before opening { in list of
// values"), and a concatenation there is E0572
// (reject_4_5_11_concatenation_coefficients.va), so each is now `'{...}`.
// The empty `{}` zeros are now the null argument, which §4.5.11 gives the
// same meaning: "The zeros argument may be represented as a null argument".
//
//! lrm 4.5.11.4
//! lrm 4.5.11.1
//! lrm 4.3.2
//! analysis dc
//! bias V(in) = 1.0
//! bias V(n) = 0.0
`include "check.vh"
module ch04_laplace_trig_coeff(in, n);
    inout in, n;
    electrical in, n;
    parameter real w = 0.5235987755982988;
    real y, z;

    analog begin
        y = laplace_nd(V(in, n), '{sin(w)}, '{1.0});
        z = laplace_zp(V(in, n), , '{-1e3, 1e3*sin(w), -1e3, -1e3*sin(w)});
        `CHECK("laplace_nd H(0) = n0/d0 = sin(pi/6) = 1/2", y, 0.5, 1e-15);
        `CHECKX("laplace_zp H(0) = 1 with sin() in its roots", z, 1.0);
        I(in, n) <+ 0.0;
    end
endmodule
