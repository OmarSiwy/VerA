// §4.2.5: "An expression using these relational operators yields the value zero
// (0) if the specified relation is false or the value one (1) if it is true."
// The bias sits exactly ON the boundary, which is where `<` and `<=` differ:
// 1.0 < 1.0 is FALSE, so the value is the integer 0, and the contribution is a
// zero current. Moving the operand off the boundary gives the 1.
//
//! lrm 4.2.5
//! lrm 4.2.5:1000
//! bias V(p) = 1.0
`include "check.vh"
module ch04_less_than(p, n);
    inout p, n;
    electrical p, n;
    analog begin
        `CHECKI("1.0 < 1.0 is false", V(p, n) < 1.0, 0);
        `CHECKI("0.5 < 1.0 is true", V(p, n) - 0.5 < 1.0, 1);
        I(p, n) <+ (V(p, n) < 1.0);
    end
endmodule
