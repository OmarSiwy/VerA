// LRM 4.2.8: `&&` is a logical connective whose result "can be one (1) (defined
// as true) or zero (0) (defined as false)" — it NORMALISES, it does not pass an
// operand through and it is not the bit-wise `&` of 4.2.9.
//
// Biased at V(p)=1.0, V(n)=0 the branch potential is 1.0, which is inside
// (0, 2) and outside (2, inf), so the two conjunctions below land on opposite
// sides of the truth table.
//
// The third line is the one that separates `&&` from `&`: 4 && 2 is 1 because
// both operands are non-zero, while the bit-wise 4 & 2 is 0 (0100 & 0010).
//
//! lrm 4.2.8
//! lrm 4.2.8:1000
//! bias V(p) = 1.0
`include "check.vh"
module ch04_logical_and(p, n);
    inout p, n;
    electrical p, n;

    analog begin
        `CHECKI("true && true -> 1", ((V(p, n) > 0.0) && (V(p, n) < 2.0)), 1);
        `CHECKI("true && false -> 0", ((V(p, n) > 0.0) && (V(p, n) > 2.0)), 0);
        `CHECKI("&& normalises to 1, unlike 4 & 2 = 0", (4 && 2), 1);
        I(p, n) <+ ((V(p, n) > 0.0) && (V(p, n) < 2.0));
    end
endmodule
