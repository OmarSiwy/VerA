// The all-constant twin of wide_unsigned_compare_extends_each_operand.va, so
// constant folding meets the same §4.2.9 rule: "If the operands are of unequal
// bit lengths, the smaller operand shall be zero-extended to the size of the
// larger operand." -1 is §3.2's 32 bits, 32'hFFFF_FFFF, extended to
// 40'h00_FFFF_FFFF:
//
//   -1 == 40'hFF_FFFF_FFFF         -> 0
//   (-1 >> 0) > 40'h1              -> 1
//   (-1 << 4) == 40'h00_FFFF_FFF0  -> 1
//   -1 > 128'h1                    2^32 - 1 > 1 -> 1
//
//! lrm 4.2.9
//! lrm 4.2.9:2
//! lrm 4.2.9:4
`include "check.vh"
module ch04_wide_unsigned_compare_folded(p);
  inout p; electrical p;
  localparam integer f1 = -1 == 40'hFF_FFFF_FFFF;
  localparam integer f2 = (-1 >> 0) > 40'h1;
  localparam integer f3 = (-1 << 4) == 40'h00_FFFF_FFF0;
  localparam integer f4 = -1 > 128'h1;
  analog begin
    `CHECKI("-1 == 40'hFF_FFFF_FFFF", f1, 0);
    `CHECKI("(-1 >> 0) > 40'h1", f2, 1);
    `CHECKI("(-1 << 4) == 40'h00_FFFF_FFF0", f3, 1);
    `CHECKI("-1 > 128'h1", f4, 1);
    I(p) <+ V(p);
  end
endmodule
