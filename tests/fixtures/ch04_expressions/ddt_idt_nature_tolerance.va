// LRM 4.5.3 Table 4-17 and 4.5.4 Table 4-18 each end with a NATURE form:
//
//     ddt(expr, nature)                 "Same as above, except nature is
//                                        specified explicitly."
//     idt(expr, ic, assert, nature)     "Same as above, except the absolute
//                                        tolerance used to control the error in
//                                        the numerical integration process is
//                                        taken from the specified nature."
//
// A nature — 3.6.1 — carries an `abstol`, and naming one here is how a model
// says "resolve this to the precision of an ampere" without writing the number.
// The alternative spelling, the bare abstol, is pinned by ddt.va and
// idt.va; this is the half where the tolerance comes from annex D's
// disciplines.vams instead of a literal.
//
// WHICH SIGNAL THE NATURE DESCRIBES IS NOT THE SAME FOR THE TWO OPERATORS, and
// the two calls below are written so that the units line up in each:
//
//   4.5.3: "The absolute tolerance, abstol or derived from nature, applies to
//   the OUTPUT of the ddt operator" — so the argument is `1p * V(p,n)`, a
//   capacitance times a voltage, i.e. a charge, whose time derivative is a
//   current. `Current` is then a tolerance on an ampere-valued output.
//   `ddt(V(p,n), Current)` would name an ampere tolerance for a volt-per-second
//   output, which a tool that checks nature units is entitled to reject for a
//   reason that has nothing to do with the shape this file pins.
//
//   4.5.4: "The absolute tolerance applies to the INPUT of the idt operator" —
//   the input is I(p,n), an ampere, so the nature is `Current` here too. It is
//   NOT `Charge`: coulombs are the units of idt's output.
//
// §4.5.2 is why the nature form exists at all, in its own words: "Occasionally,
// analog operators require new equations and new unknowns be introduced by the
// simulator to convert a module description into a set of first-order
// differential equations. In this case, the simulator attempts to determine
// from context which tolerance to associate with the new equation and new
// unknown. ALTERNATIVELY, THESE OPERATORS CAN BE USED TO SPECIFY TOLERANCES."
// The two calls below are that alternative: a `nature` argument is a model
// naming the tolerance for the equation the operator introduces, rather than
// leaving the simulator to infer one from context. A compiler that implemented
// only the literal-abstol spelling the sibling fixtures use would reject this
// file.
//
// Equation tolerance association is observed by the conditional host runner
// tests/host.py, not these local DC checks:
// "each equation, at a minimum, shall have a tolerance defined and associated
// with it" constrains the solver, not a model description, and the clause's
// closing sentence — "Specifying natures also directly enforces reusability and
// allows other signal attributes to be accessed by the simulator" — gives the
// rationale for the form rather than a second rule about it.
//
// The tolerance changes no value — 4.5.3: it "is the largest signal level that
// is considered negligible" — so the wants are the same ones the two siblings
// assert: 4.5.3's "In DC analysis, ddt() returns zero (0)", and 4.5.4's "When
// used in DC or IC analyses, idt() returns the initial condition (ic) if
// specified". The claim being made is that the SHAPE is accepted.
//
//! lrm 4.5.3
//! lrm 4.5.4
//! print none
`include "disciplines.vams"
`include "check.vh"
module ch04_ddt_idt_nature_tolerance(p, n);
    inout p, n;
    electrical p, n;

    analog begin
        `CHECKX("ddt(expr, nature) still returns zero in DC",
                ddt(1p * V(p, n), Current), 0.0);
        `CHECKX("idt(expr, ic, assert, nature) still returns ic in DC",
                idt(I(p, n), 5.0, 0, Current), 5.0);
        I(p, n) <+ V(p, n);
    end
endmodule
