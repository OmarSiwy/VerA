// A.8.4 lists what an analog_primary can be:
//
//     analog_primary ::= number | analog_concatenation | ... | variable_reference
//                      | net_reference | ... | branch_probe_function_call | ...
//                      | ( analog_expression )
//
// Only a reference to a named object (variable_reference, net_reference,
// parameter_reference) carries a `[ ... ]` select. A branch_probe_function_call
// is a complete primary with no select after it, and a probe's value is one
// real number with no elements to index. `V(p, n)[0]` has no derivation.
//
//! lrm A.8.4
//! lrm A.8.4:1000
//! reject-only E0330
`include "disciplines.vams"
module ch04_select_on_probe_call(p, n);
  inout p, n; electrical p, n;
  analog I(p, n) <+ V(p, n)[0];
endmodule
