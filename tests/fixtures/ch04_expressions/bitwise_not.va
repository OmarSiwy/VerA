// LRM 4.2.9 Table 4-13: unary `~` inverts every bit of its operand. LRM 3.2
// makes an integer a 32-bit 2's complement value, so the inversion runs over
// the full width and ~x is -(x+1):
//
//   5  = 0000...0101
//   ~5 = 1111...1010 = 0xFFFFFFFA = -6
//   ~0 = 1111...1111 = -1
//
// ~0 = -1 is the width-independent half: any 2's complement width gives it, and
// only an unsigned or truncated reading would not. Contrast the logical `!` of
// 4.2.8, for which !5 is 0 and !0 is 1.
//
//! lrm 4.2.9
//! lrm 4.2.9:1001
`include "check.vh"
module ch04_bitwise_not(p, n);
    inout p, n;
    electrical p, n;
    integer a;

    analog begin
        a = ~5;
        `CHECKI("~5 = -6 in 2's complement", a, -6);
        `CHECKI("~0 = all ones = -1, unlike !0 = 1", (~0), -1);
        I(p, n) <+ a;
    end
endmodule
