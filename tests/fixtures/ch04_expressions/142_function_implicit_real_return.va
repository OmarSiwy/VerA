// LRM 4.7.1, verbatim: "The analog_function_type specifies the return value of
// the function; its use is optional. type can be real, integer, or string; if
// unspecified, the default is real."
//
// Three clauses, and every other analog function in this chapter writes
// `analog function real`, so none of them is exercised. Two are here:
//
//   `analog function halve;`          no type, so the return type is real and
//                                     0.5 * 3.0 = 1.5 survives as a fraction.
//                                     A compiler that defaulted to integer —
//                                     the Verilog-1364 default for a digital
//                                     `function` — truncates it to 1.
//
//   `analog function integer trunc;`  the explicit integer form. 4.2.1.1 fixes
//                                     the conversion: "The real-to-integer
//                                     conversion of the return value ... shall
//                                     round to the nearest integer", so 2.7
//                                     assigned to the identifier variable of an
//                                     integer function reads back as 3, not 2.
//
// -2.5 pins the tie rule the same clause states: "if the fractional part is
// exactly 0.5, it shall be rounded away from zero", giving -3 and not -2.
//
// Every argument is a literal, so nothing here depends on an operating point.
// The string form is not asserted: 4.7.1 allows it, but nothing in chapter 4
// gives a string-returning analog function an observable value to pin.
//
//! lrm 4.7.1
//! lrm 4.7.1:2
//! lrm 4.2.1.1
//! lrm 4.2.1.1:1
`include "check.vh"
module ch04_function_implicit_real_return(p, n);
    inout p, n;
    electrical p, n;

    analog function halve;
        input x;
        real x;
        halve = 0.5 * x;
    endfunction

    analog function integer trunc;
        input x;
        real x;
        trunc = x;
    endfunction

    analog begin
        `CHECKX("an untyped analog function returns real, not integer", halve(3.0), 1.5);
        `CHECKI("an integer analog function rounds to nearest", trunc(2.7), 3);
        `CHECKI("and rounds a .5 tie away from zero", trunc(-2.5), -3);
        I(p, n) <+ V(p, n);
    end
endmodule
