// DEBT — this rejection is NOT conformance.
// The LRM permits what VerA refuses here. The substrings below record
// CURRENT behavior so the suite stays green on it; they do not claim it
// is right. `zig build ledger` counts this rule against VerA.
//
// VAMS-11.6.19-01  (ch11-vpi.html)
// For an operator whose type is vpiMultiConcat , the first operand shall be the multiplier expression.
// VAMS-4.2.13-03  (ch4-expressions.html)
// Unlike regular concatenations, expressions containing replications shall not appear on the left-hand side of an assignment.
// VAMS-4.2.13-05  (ch4-expressions.html)
// Such a replication shall appear only within a concatenation in which at least one of the operands of the concatenation has a positive size.
// VAMS-4.2.13-06  (ch4-expressions.html)
// When a replication expression is evaluated, the operands shall be evaluated exactly once, even if the replication constant is zero.
//
//! reject expected `}`
// EXPECT: error
module ch04_replication_rejected;
    integer replicated;
    analog replicated = {4{2'b10}};
endmodule
