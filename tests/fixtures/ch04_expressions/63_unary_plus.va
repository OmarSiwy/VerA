// §4.2 Table 4-1 / Table 4-2: unary `+` is legal on a real operand and is the
// identity — it must not round, clamp, or take a magnitude. The bias makes
// V(p,n) = 0.75 - 0.25 = 0.5; both operands and their difference are exact
// powers of two, so the identity is checkable to the last bit.
//
//! lrm 4.2.1
//! lrm 4.2.4
//! bias V(p) = 0.75
//! bias V(n) = 0.25
`include "check.vh"
module ch04_unary_plus(p, n);
  inout p, n;
  electrical p, n;
  analog begin
    `CHECKX("unary + on a real is the identity", +V(p, n), 0.5);
    I(p, n) <+ +V(p, n);
  end
endmodule
