// §4.6.4.3: "Although the user is encouraged to specify each noise pair in
// order of ascending frequency, the simulator shall internally sort the pairs
// into ascending frequency if required."
//
// The pairs below are written in the order (1e6, 1e-24), (1, 1e-18),
// (1e3, 1e-21): neither ascending nor descending. Sorted into ascending
// frequency they are
//
//     (1, 1e-18), (1e3, 1e-21), (1e6, 1e-24)
//
// and that is the table the device must publish, read by the `points=` field
// of the `//! noise` line (181_noise_table_topology.va asserts the row only,
// not its knots). Interpolation is §4.6.4.3's piecewise linear.
//
//! lrm 4.6.4.3
//! lrm 4.6.4.3:5
//! noise table(p,n)#0 name=tbl interp=linear points=1.0:1e-18,1000.0:1e-21,1000000.0:1e-24
//! analysis dc
//! bias V(p) = 1.0
//! bias V(n) = 0.0
`include "check.vh"
module b2_noise_table_sorts_pairs(p, n);
    inout p, n;
    electrical p, n;
    parameter real R = 1000.0 from (0:inf);

    analog begin
        I(p, n) <+ V(p, n) / R + noise_table('{1e6, 1e-24, 1.0, 1e-18, 1e3, 1e-21}, "tbl");
        `CHECKX("the dc current is the resistive term alone", V(p, n) / R, 1e-3);
    end
endmodule
