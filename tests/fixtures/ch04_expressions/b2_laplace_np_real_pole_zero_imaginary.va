// §4.5.11.3 laplace_np: "rho is a vector of N pairs of real numbers. Each pair
// represents a pole, the first number in the pair is the real part of the pole
// and the second is the imaginary part. ... If a pole is real, the imaginary
// part shall be specified as zero (0)."
//
//     H(s) = sum(k) n_k s^k / prod(k) (1 - s/(rho_kr + j rho_ki))
//
// Two REAL poles, each written as (real part, 0): '{-1.0, 0.0, -2.0, 0.0} is
// the poles -1 and -2, so
//
//     H(s) = 2 / ((1 + s)(1 + s/2)).
//
// HAND DERIVATION (exact rationals, python3-checked):
//   f = 0:         H(0) = 2; the operating point reads 2 * V(in) = 2 * 0.5 = 1.
//   w = 1 (f = 1/2pi): (1 + j)(1 + j/2) = 1/2 + (3/2)j,
//                      H = 2/(1/2 + 3j/2) = (1 - 3j)/(5/2) = 0.4 - 1.2j
//   w = 2 (f = 1/pi):  (1 + 2j)(1 + j) = -1 + 3j,
//                      H = 2/(-1 + 3j) = 2(-1 - 3j)/10 = -0.2 - 0.6j
// A reader that took the four numbers as four real poles (-1, 0, -2, 0) has
// two s factors and no finite H(0); one that dropped the minus in (1 - s/rho)
// reads 0.4 + 1.2j at w = 1.
//
// The row (a, in) of `acDyn` is H(jw) itself: I(a) is the KCL current into a
// (laplace_ac_response.va says why).
//
//! lrm 4.5.11.3
//! lrm 4.5.11.3:1
//! bias V(in) = 0.5
//! print none
//! checks 7
//! acdyn (a,in) f=0 re=2 im=0 tol=0
//! acdyn (a,in) f=0.15915494309189535 re=0.4 im=-1.2
//! acdyn (a,in) f=0.3183098861837907 re=-0.2 im=-0.6
`include "check.vh"
module b2_laplace_np_real_pole_zero_imaginary(in, a);
    inout in, a;
    electrical in, a;

    analog begin
        `CHECK("two real poles: H(0) * V(in) = 2 * 0.5",
               laplace_np(V(in), '{2.0}, '{-1.0, 0.0, -2.0, 0.0}), 1.0, 1e-12);
        I(a) <+ laplace_np(V(in), '{2.0}, '{-1.0, 0.0, -2.0, 0.0});
    end
endmodule
