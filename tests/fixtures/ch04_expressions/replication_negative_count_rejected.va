// §4.2.13: replication "is expressed by a concatenation preceded by a
// non-negative, non-x and non-z constant expression, called a replication
// constant". The count below is the constant -1, which is none of those. (Zero
// is non-negative, and legal.)
//
// The legal replications are 31_replication.va and audit_replication_zero_effect.va.
//
//! lrm 4.2.13
//! lrm 4.2.13:1001
//! reject-only E0327
//! neighbour 31_replication.va
//! neighbour audit_replication_zero_effect.va
`include "disciplines.vams"
module ch04_replication_negative_count(p, n);
  inout p, n; electrical p, n;
  integer k;
  analog begin
    k = {-1{4'd3}};
    I(p, n) <+ k * V(p, n);
  end
endmodule
