// AMS 4.5.14: "If a dynamic expression is passed as an argument which expects
// a constant expression, the value of the dynamic expression at the start of
// the analysis defaults to the constant value of the argument. Any further
// change in value of that expression is ignored during the iterative
// analysis." Table 4-20 lists zi_nd's numerator and denominator as constant
// expression arguments; the clause's editorial note says "a blanket rejection
// requirement must not be inferred from the column heading alone", so this
// rule has no invalid form and no refusal fixture.
//
// The denominator is {1, -V(k, n)}. V(k) is 0.5 at the analysis start (the
// static point, t = 0) and 0.9 after, so the sampled filter is a04_10's
// H(z) = 1 / (1 - 0.5·z^-1) (§4.5.12.4): y[k] = u[k] + 0.5·y[k-1]. T = 1ns,
// τ = 0, every listed point is a sample instant, and u is 0 at t = 0 and 1
// after, so y = 0, 1, 1.5, 1.75, 1.875 = 2·(1 - 0.5^k), exactly as a04_10
// derives it. Resampling the coefficient gives 1.9 at t = 2ns.
//
// Corrected 2026-10-08 (construct only, the wants are unchanged): the
// coefficient vectors were VAMS 2.x concatenations, `{...}`. A.8.2's
// analog_filter_function_arg is a parameter, a part of one or a `'{...}`
// assignment pattern (annex G: "Add apostrophe before opening { in list of
// values"), and a concatenation there is E0572
// (reject_4_5_11_concatenation_coefficients.va), so each is now `'{...}`.
//
//! lrm 4.5.14
//! lrm 4.5.12.4
//! checks 5
//! bias V(n) = 0
//! wave V(in) = 0, 1
//! wave V(k) = 0.5, 0.9
//! time 0, 1n, 2n, 3n, 4n
//! analysis tran
//! print none
`include "check.vh"
module zi_nd_dynamic_coefficient_sampled(in, k, n);
    inout in, k, n;
    electrical in, k, n;

    analog begin
        `CHECKEQ("the denominator is sampled at the analysis start",
                 zi_nd(V(in, n), '{1.0, 0.0}, '{1.0, -V(k, n)}, 1n, 0),
                 2.0 * (1.0 - pow(0.5, $abstime * 1e9)), 1e-12);
        I(in, n) <+ 0.0;
        I(k, n) <+ 0.0;
    end
endmodule
