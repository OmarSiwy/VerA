// §4.3.2: "Input values outside of the valid range for the operator shall
// report an error." Table 4-14 pow's zero-base row: "if x = 0, y > 0" (#59).
// The exponent is a literal, so the device takes its constant-exponent
// spelling (`zPowK`); runtime_pow_domain_rejected.va is the moving one.
//
//   point 0, V(p) = 2: pow(2, -1) = 0.5, exact (a power of two), so CHECKX.
//   point 1, V(p) = 0: a zero base under a negative exponent (+inf, silently,
//                      before #59): E0609, exit 1. VerA admits y = 0 at x = 0
//                      (IEEE pow(0, 0) = 1), as its prover does; y = -1 is
//                      outside either reading.
//
//! lrm 4.3.1
//! lrm 4.3.2
//! lrm 4.3.2:2
//! sweep V(p) = 2, 0
//! reject-run E0609
//! neighbour runtime_domain_legal_neighbour.va
//! checks 1
//! print none
`include "check.vh"
module runtime_pow_constant_exponent(p, n);
  inout p, n; electrical p, n;
  real r;
  analog begin
    r = pow(V(p, n), -1.0);
    `CHECKX("pow(2, -1) is 0.5, at the in-domain point only", r, 0.5);
    I(p, n) <+ V(p, n);
  end
endmodule
