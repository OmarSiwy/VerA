// §4.3.2: "Input values outside of the valid range for the operator shall
// report an error." Table 4-14: `log(x)`, C `log10(x)`, "Decimal logarithm",
// domain "x > 0". A different row and a different C function from `ln`
// (runtime_ln_domain_rejected.va), so it is checked on its own (#59).
//
//   point 0, V(p) = 100: log10(100) = 2 (mpmath: 2 exactly); RTOL 1e-15
//                        admits a faithful log10.
//   point 1, V(p) = -1:  outside "x > 0" (NaN, silently, before #59). The run
//                        reports E0602, as the prover does for a constant
//                        log(-1.0), and exits 1.
//
//! lrm 4.3.1
//! lrm 4.3.2
//! lrm 4.3.2:2
//! sweep V(p) = 100, -1
//! reject-run E0602
//! neighbour runtime_domain_legal_neighbour.va
//! checks 1
//! print none
`include "check.vh"
module runtime_log_domain(p, n);
  inout p, n; electrical p, n;
  real r;
  analog begin
    r = log(V(p, n));
    `CHECKR("log(100) is 2, at the in-domain point only", r, 2.0, 1e-15);
    I(p, n) <+ V(p, n);
  end
endmodule
