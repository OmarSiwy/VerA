// §4.3.1 Table 4-14: `pow(x, y)`, "Power (x^y)", domain "if x > 0, all y; if
// x = 0, y > 0; if x < 0, all integer y". §4.3.2: "Input values outside of the
// valid range for the operator shall report an error."
//
// pow(-2.0, 0.5) is a negative base with a non-integer exponent: sqrt(-2), with
// no real value. Both arguments are constants, so the violation is static.
// 158_pow_even_exponent_accepted.va is the legal negative-base case (an integer
// exponent), and 158_pow_negative_base_runtime_exponent.va the one that can
// only be decided at run time.
//
//! lrm 4.3.1
//! lrm 4.3.2
//! lrm 4.3.2:2
//! reject-only E0609
//! neighbour 158_pow_even_exponent_accepted.va
//! neighbour 158_pow_negative_base_runtime_exponent.va
`include "disciplines.vams"
module ch04_pow_negative_base_fractional_exponent(p, n);
  inout p, n; electrical p, n;
  analog I(p, n) <+ pow(-2.0, 0.5) * V(p, n);
endmodule
