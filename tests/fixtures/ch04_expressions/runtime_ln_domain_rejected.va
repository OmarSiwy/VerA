// §4.3.2: "Input values outside of the valid range for the operator shall
// report an error." Table 4-14: `ln(x)`, C `log(x)`, "Natural logarithm",
// domain "x > 0". VerA reads the sentence for Table 4-14's Domain column too
// (114_standard_math_domain_rejected.va refuses the constant ln(-1.0) with
// E0602); this is the half where the argument is a signal (#59).
//
//   point 0, V(p) = 1: ln(1) = 0 exactly (C99 F.10.3.7), so CHECKX 0.
//   point 1, V(p) = 0: zero is outside "x > 0" (IEEE gives -inf, silently, before
//                      #59). The run reports E0602, the code the prover gives
//                      the same argument, and exits 1; point 1 prints nothing.
//
// The exit status is VerA's reporting policy, not a number §4.3.2 states.
//
//! lrm 4.3.1
//! lrm 4.3.2
//! lrm 4.3.2:2
//! sweep V(p) = 1, 0
//! reject-run E0602
//! neighbour runtime_domain_legal_neighbour.va
//! checks 1
//! print none
`include "check.vh"
module runtime_ln_domain(p, n);
  inout p, n; electrical p, n;
  real r;
  analog begin
    r = ln(V(p, n));
    `CHECKX("ln(1) is 0, at the in-domain point only", r, 0.0);
    I(p, n) <+ V(p, n);
  end
endmodule
