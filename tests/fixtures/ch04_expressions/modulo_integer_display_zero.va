// AMS §4.2.4 requires a zero-divisor error even when an inlined function
// discards the remainder's value (§4.2.3 preserves runtime errors). This
// function is called only by a §9.4 display task: its error belongs to that
// task's accepted-point phase, and a solver device that drops display tasks
// must not acquire the check in eval. Codegen's artifact test pins that half.
// At d=3 the function returns 7 and one check prints; at d=0 it reports E0601
// and the executable exits 1. modulo_integer_short_circuit.va is the skipped
// operand neighbour; modulo_integer_dynamic.va supplies nonzero divisors.
//! lrm 4.2.3
//! lrm 4.2.4
//! lrm 9.4.1
//! lrm 4.2.4:1
//! sweep V(p) = 3, 0
//! exit 1
//! checks 1
//! print none
`include "check.vh"
module modulo_integer_display_zero(p, n);
  inout p, n; electrical p, n;
  analog function integer discard_remainder;
    input d;
    integer d, unused;
    begin
      unused = 11 % d;
      discard_remainder = 7;
    end
  endfunction
  analog begin
    `CHECKI("only the nonzero display point completes", discard_remainder($rtoi(V(p,n))), 7);
    I(p,n) <+ V(p,n);
  end
endmodule
