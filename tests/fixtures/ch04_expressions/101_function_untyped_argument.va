// LRM 4.7.1 bullet list, verbatim: "all formal arguments shall have an
// associated block item declaration specifying the data type of the argument".
// `untyped` gives `x` a direction with `input x;` and never a type, so a
// conforming tool diagnoses this module.
//
// 4.7.1's "if unspecified, the default is real" does NOT rescue it. That
// sentence is about `analog_function_type`, the FUNCTION's return type — "type
// can be real, integer, or string; if unspecified, the default is real" — and
// the bullet list grants no default for a formal, it requires the declaration.
// The header this file used to carry cited that default for the formal, which
// is the wrong thing defaulted.
//
// It also carried no `reject` and asserted CHECKX(untyped(V(p)), 0.75) instead.
// The pass-the-actual-through-the-formal rule it was pinning holds on a
// properly typed formal, where 28_user_function.va pins it.
//
//! lrm 4.7.1
//! reject formal
//! reject data type
//! xfail VerA silently types an undeclared formal as real, so `input x;` with no `real x;` compiles. No diag code covers the 4.7.1 block-item-declaration requirement
module ch4_fn_untyped(p);
  inout p;
  electrical p;
  analog function real untyped;
    input x;
    untyped = x;
  endfunction
  analog begin
    I(p) <+ untyped(V(p));
  end
endmodule
