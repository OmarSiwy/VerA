// §4.6.4.1 a solve-dependent white_noise power in a device that also keeps a
// history array across evaluations.
//
// §4.6.4.1: "white_noise ( pwr [ , name ] ) … generates white noise with a
// power of pwr." So the exported white density is pwr itself, evaluated at the
// operating point: pwr = kv * V(p,n)^2.
//
// §3.2 "Real variables are initialized to zero (0) at the start of a
// simulation", and a variable the analog block writes keeps what the previous
// evaluation left in it. `hist` is a four-slot ring: each evaluation reads the
// slot the previous one wrote, then stores V(p,n) into the next. The store is
// read by nothing this evaluation returns, only by the next evaluation.
//
// THE BUG THIS ROW PINS. A store only the next evaluation reads makes the
// core take a `comptime held: bool`. `noisePsd` reads the power off its own
// slice of the core, which renders no such store and so names the parameter
// `_`, but its call site passed no argument for it: the device did not compile
// once the testbench instantiated `noisePsd`.
//
// THE NUMBERS. Bias V(p) = 0.5, V(n) = 0, kv = 1e-20:
//
//   pwr = 1e-20 * 0.5^2 = 2.5e-21 A^2/Hz
//
// The previous evaluation ran at this same bias, or there was none and §3.2
// gives zero, so prev is 0 or 0.5 and prev * (prev - V(p,n)) = 0 either way.
//
//! lrm 4.6.4.1
//! lrm 3.2
//! noise thermal(p,n)#0 name=sq white=2.5e-21
//! analysis noise
//! bias V(p) = 0.5
//! bias V(n) = 0.0
`include "check.vh"
module a06_noise_psd_beside_a_held_history(p, n);
    inout p, n;
    electrical p, n;
    parameter real R = 1000.0 from (0:inf);
    parameter real kv = 1e-20 from [0:inf);
    real hist[0:3];
    integer nh;
    real prev;

    analog begin
        prev = hist[(nh + 3) % 4];
        `CHECKX("the history holds zero or the previous evaluation's V", prev * (prev - V(p, n)), 0.0);
        `CHECKR("the power at the bias", kv * V(p, n) * V(p, n), 2.5e-21, 1e-12);
        I(p, n) <+ V(p, n) / R + white_noise(kv * V(p, n) * V(p, n), "sq");
        hist[nh % 4] = V(p, n);
        nh = nh + 1;
    end
endmodule
