// §4.6.4.3: "noise_table() function interpolates a set of values... The argument
// input can either be a vector or a string indicating a filename." This pins the
// file-input mode with comments and newline-separated frequency/power pairs.
//
//! lrm 4.6.4.3
//! analysis dc
//! bias V(p) = 1.0
`include "check.vh"
module lrm_4_6_4_3_file_input(p, n);
    inout p, n;
    electrical p, n;

    analog begin
        // noise_table with file input: the file contains frequency/power pairs
        // separated by newlines, with comments starting with '#'. The file is
        // specified as a string literal. In DC analysis, noise_table returns 0.
        real tbl_file = noise_table("noise_table_input.tbl", "file-input");

        `CHECKX("noise_table with file input is inactive outside a small-signal analysis", tbl_file, 0.0);

        I(p, n) <+ tbl_file;
    end
endmodule
