// §4.6.4.3 a noise_table whose knots are MODEL PARAMETERS, set by the card
// (ESPice #9: a host must read the card's knots, per Model row).
//
// "When the input is a vector it contains pairs of real numbers: the first
// number in each pair is the frequency in Hertz and the second is the power."
// "Although the user is encouraged to specify each noise pair in order of
// ascending frequency, the simulator shall internally sort the pairs into
// ascending frequency if required." "noise_table() performs piecewise linear
// interpolation to compute the power spectral density generated by the
// function at each frequency between the lowest and highest frequency in the
// set of values. For frequencies lower than the lowest frequency in the value
// set, noise_table() returns the power specified for the lowest frequency, and
// for frequencies higher than the highest frequency, noise_table() returns the
// power specified for the highest frequency."
//
// The vector here is an assignment pattern of scalar parameters, so every
// knot is a model-card value: a card a host binds per Model row (VerA
// declares instance parameters as `Model` fields too, so an instance's own
// values are its own row). `f3` is DERIVED (§6.3.4), so the knots are only
// right if they are taken after `derive` has rewritten it.
//
// DECLARED DEFAULTS, already ascending:
//     (1e3, 1e-18)  (5e3, 9e-18)  (f2 + 4e3 = 9e3, 4e-18)
//
// THE CARD: f1 = 2e4, f2 = 2e3, s3 = 2.5e-17. Then f3 = 2e3 + 4e3 = 6e3, and
// the knots in source order are (2e4, 1e-18) (2e3, 9e-18) (6e3, 2.5e-17),
// which the clause's sort puts in the order the `points=` line states:
//     (2e3, 9e-18)  (6e3, 2.5e-17)  (2e4, 1e-18)
//
// THE SPECTRUM a host integrates from them (§4.6.4.3 linear in f), by hand:
//     f = 1e3   below the lowest knot: its power             9e-18
//     f = 2e3   a knot                                       9e-18
//     f = 4e3   9e-18 + (2.5e-17 - 9e-18)·(2000/4000)       1.7e-17
//     f = 1.3e4 2.5e-17 + (1e-18 - 2.5e-17)·(7000/14000)    1.3e-17
//     f = 1e5   above the highest knot: its power            1e-18
//
// Wrong implementations, and what they fail: a host reading `noise_tables`
// (the defaults) gets 1e-18, 7e-18, 4e-18 and 4e-18 at 1e3, 4e3, 1.3e4 and 1e5,
// and the default knots; one that keeps the card's order unsorted fails
// `points=`; one that reads the knots before `derive` rewrites `f3` has
// (9e3, 2.5e-17) for the middle knot and 1.357e-17 at 4e3. The CHECK pins the
// derived knot inside the device.
//
// No invalid form: a knot that is not a constant (E0519) and a repeated
// frequency (183_noise_table_duplicate_frequency_rejected.va) are refused
// elsewhere; a card cannot spell either one.
//
//! lrm 4.6.4.3
//! lrm 4.6.4.3:5
//! lrm 4.6.4.3:6
//! lrm 4.6.4.3:1001
//! param f1 = 2.0e4
//! param f2 = 2.0e3
//! param s3 = 2.5e-17
//! noise table(p,n)#0 name=card interp=linear points=2000.0:9e-18,6000.0:2.5e-17,20000.0:1e-18 psd=1000.0:9e-18,2000.0:9e-18,4000.0:1.7e-17,13000.0:1.3e-17,100000.0:1e-18
//! bias V(p) = 1.0
//! bias V(n) = 0.0
`include "check.vh"
module a06_noise_table_card_knots(p, n);
    inout p, n;
    electrical p, n;
    parameter real R = 1000.0 from (0:inf);
    parameter real f1 = 1.0e3 from (0:inf);
    parameter real s1 = 1.0e-18 from [0:inf);
    parameter real f2 = 5.0e3 from (0:inf);
    parameter real s2 = 9.0e-18 from [0:inf);
    parameter real f3 = f2 + 4.0e3;
    parameter real s3 = 4.0e-18 from [0:inf);
    real ntab;

    analog begin
        ntab = noise_table('{f1, s1, f2, s2, f3, s3}, "card");
        `CHECKX("the derived knot follows the card's f2", f3, 6000.0);
        I(p, n) <+ V(p, n) / R + ntab;
    end
endmodule
