// AMS §4.2.4: "It shall be an error to pass zero (0) as the second argument
// to the modulus operator." The sentence names no operand type, and Table 4-2
// admits real operands, so it covers a real divisor too
// (specification/Vague_Decisions.md VD-056). The divisor is probe-dependent: 2 at the
// first point, then 0. The first point prints 7.5 % 2 = 7.5 - 3*2 = 1.5 (the
// §4.2.4 real formula, exact in binary); the second reports E0601 before
// printing, as the integer path does (modulo_integer_dynamic_zero.va), rather
// than returning IEEE's NaN. Exit 1 is VerA's executable error policy, not a
// numeral §4.2.4 requires. Legal neighbour: modulo_integer_dynamic.va takes
// a real remainder by the probe-dependent divisor 3.75 (2.5);
// audit_real_modulus_zero_rejected.va is the compile-time zero.
//! lrm 4.2.4
//! lrm 4.2.4:1
//! sweep V(p) = 2, 0
//! exit 1
//! checks 1
//! print none
`include "check.vh"
module modulo_real_dynamic_zero(p, n);
  inout p, n; electrical p, n;
  real d, remainder;
  analog begin
    d = V(p,n);
    remainder = 7.5 % d;
    `CHECKX("only the nonzero point completes", remainder, 1.5);
    I(p,n) <+ remainder;
  end
endmodule
