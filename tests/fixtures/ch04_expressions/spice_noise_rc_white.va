// The device of spice_noise_dec_sweep.sp: a resistor r in parallel with a
// capacitor c, and one §4.6.4.1 white_noise current of a literal density
// pwr across them (no k, no T, so the deck's arithmetic carries no
// constant VerA and a reference might disagree on).
//
// WHAT THIS FILE ASSERTS ON ITS OWN. The `//! noise` line is the export
// claim: one thermal-kind row (§4.6.4.1's white_noise) on (p, n) of density
// 1e-20 A^2/Hz, its own generator (#0). The CHECK is the conductance the
// deck's transfer impedance uses: §4.5.6, d(V(p,n)/r)/dV(p) = 1/r = 1e-3 S.
//
//! lrm 4.6.4.1
//! lrm 4.5.6
//! noise thermal(p,n)#0 name=w white=1e-20
//! analysis noise
//! bias V(p) = 0.0, V(n) = 0.0
`include "check.vh"
module spice_noise_rc_white(p, n);
    inout p, n;
    electrical p, n;
    parameter real r = 1000.0 from (0:inf);
    parameter real c = 10e-9 from [0:inf);
    parameter real pwr = 1e-20 from [0:inf);

    analog begin
        `CHECK("the resistive half is 1/r", ddx(V(p, n) / r, V(p)), 1e-3, 1e-18);
        I(p, n) <+ V(p, n) / r + ddt(c * V(p, n));
        I(p, n) <+ white_noise(pwr, "w");
    end
endmodule
