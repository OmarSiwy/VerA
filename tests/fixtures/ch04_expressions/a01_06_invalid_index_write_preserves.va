// The anti-symmetric partner to 05_invalid_index_read_value.va, and the guard
// rail that stops it from being "fixed" by clamping.
//
// §5.7 Analog procedural assignments:
//
//   "The left-hand side of a procedural assignment shall be scalar, either an
//    integer, real, or string identifier OR AN ELEMENT of an integer, real or
//    string array."
//
// A subscript outside the declared range designates no element, so the
// assignment has no target and nothing in the array changes. No delegated rule
// and no default value is needed for that — it falls straight out of the
// sentence above, which is why this claim is stated separately from 05's.
//
// THE DERIVATION, by hand.
//
//   real a[0:2];  a[0] = 1.0, a[1] = 2.0, a[2] = 3.0.
//
//   bias V(p) = 0.5 against the grounded `n` row gives V(p,n) = 0.5, and §4.2.1
//   makes `V(p,n) > 0.0` the integer 1, so
//
//     hi =  5 * 1 = 5      lo =  0 - 1 = -1
//
//   neither of which folds. Then
//
//     a[hi] = 99.0;        a[lo] = -99.0;
//
//   and the array must still read { 1.0, 2.0, 3.0 }.
//
//   The three wants are the three spoilers, one each:
//     a[2] == 3.0  fails if the high write CLAMPED to the top element (99.0)
//                  or if it wrapped by modulus (5 mod 3 == 2, also 99.0);
//     a[0] == 1.0  fails if the low write clamped to the bottom element;
//     a[1] == 2.0  fails if either write scattered into the middle of the
//                  flat storage — the failure mode a scalarized array with an
//                  unchecked offset actually has.
//
//   1.0, 2.0, 3.0, 99.0 and -99.0 are all exact in IEEE 754, so `CHECKX` is
//   exact equality and no tolerance argument is involved.
//
// STATUS: THIS ONE PASSES (re-run 2026-10-04 at ae9633f1 with AGENTS.md
// §6's `vera --emit-exe` command), deliberately. `assignRuntimeIndex`
// (`lib/ir/lower.zig`) lowers a runtime-indexed write to one masked write per
// cell, `select(index == k, value, old)`, over a flat index that
// `runtimeArrayIndex` forces to -1 when any subscript is out of its dimension —
// so every cell keeps `old` and the clause holds. It is kept because the read
// side (05) fails, and the cheapest way to make 05 pass is to clamp the index,
// which would turn this file red. Wire the two together or neither.
//
//! lrm 5.7
//! lrm 4.2.1
//! bias V(p) = 0.5
//! print none
`include "check.vh"
module a01_invalid_index_write_preserves(p, n);
  inout p, n;
  electrical p, n;
  real a[0:2];
  integer hi, lo;

  analog begin
    a[0] = 1.0; a[1] = 2.0; a[2] = 3.0;

    hi = 5 * (V(p, n) > 0.0);
    lo = 0 - (V(p, n) > 0.0);

    a[hi] = 99.0;
    a[lo] = -99.0;

    `CHECKX("a write past the top changes no element", a[2], 3.0);
    `CHECKX("a write below the bottom changes no element", a[0], 1.0);
    `CHECKX("and neither scatters into the middle of the array", a[1], 2.0);

    I(p, n) <+ V(p, n);
  end
endmodule
