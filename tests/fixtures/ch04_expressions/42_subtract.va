// §4.2.4 Table 4-4: `a - b` is "a minus b", and the operands do not commute —
// at V(p,n) = 3.0 the result is 3.0 - 2.0 = 1.0, not 2.0 - 3.0 = -1.0. Every
// value here is exact in IEEE 754 binary.
//
//! lrm 4.2.4
//! bias V(p) = 3.0
`include "check.vh"
module ch04_subtract(p, n);
    inout p, n;
    electrical p, n;
    analog begin
        `CHECKX("3.0 - 2.0", V(p, n) - 2.0, 1.0);
        I(p, n) <+ V(p, n) - 2.0;
    end
endmodule
