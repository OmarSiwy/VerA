// tan() has poles at odd multiples of pi/2 (LRM 4.3.2 Table 4-15). A node
// voltage is unbounded, so the call is guarded into the pole-free central
// branch (-pi/2, pi/2).
//
// The bias sits at 1.0 rad, inside that branch, where
// tan(1) = 1.55740772465490223050..., nearest double 1.5574077246549023. The
// second check is tan = sin/cos, the definition Table 4-15 inherits from C.
// Both checks are OUTSIDE the guard: §9.4.6 display tasks must be
// unconditional or VerA drops them with W0851.
//
//! lrm 4.3.2
//! bias V(p) = 1.0
`include "check.vh"
module ch04_tan(p, n);
  inout p, n; electrical p, n;
  analog begin
    `CHECK("tan(1 rad)", tan(V(p, n)), 1.5574077246549023, 1e-15);
    `CHECKEQ("tan is sin over cos", tan(V(p, n)), sin(V(p, n)) / cos(V(p, n)), 1e-15);
    if (V(p, n) > -1.5)
      if (V(p, n) < 1.5)
        I(p, n) <+ tan(V(p, n));
  end
endmodule
