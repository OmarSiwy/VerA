// §4.6.4.5 "The noise of a junction diode could be modeled as shown in the
// following example." This fixture pins that the three noise sources
// (exp term, white_noise, flicker_noise) compile and run together in a
// diode model, each contributing zero in dc analysis where they are inactive.
//
//! lrm 4.6.4.5
//! analysis dc
//! bias V(a) = 0.6
//! bias V(c) = 0.0
`include "check.vh"
module ch04_diode_noise_model(a, c);
    inout a, c;
    electrical a, c;
    parameter real is = 1e-14 from (0:inf);
    parameter real n = 1.0 from (0:inf);
    parameter real kf = 1e-20 from (0:inf);
    parameter real af = 1.0 from (0:inf);
    parameter real ef = 1.0 from (0:inf);

    analog begin
        // The example from 4.6.4.5: diode current with shot noise (white_noise)
        // and flicker noise (flicker_noise).
        I(a, c) <+ is * (exp(V(a, c) / (n * $vt)) - 1) +
                         white_noise(2 * `P_Q * I(a), "shot") +
                         flicker_noise(kf * pow(abs(I(a)), af), ef, "1/f");

        // In dc analysis, noise sources are inactive and return zero.
        // The current through the diode is resistive only.
        `CHECKX("white_noise is inactive outside a small-signal analysis", white_noise(1.0), 0.0);
        `CHECKX("flicker_noise is inactive outside a small-signal analysis", flicker_noise(1.0, 1.0), 0.0);
    end
endmodule
