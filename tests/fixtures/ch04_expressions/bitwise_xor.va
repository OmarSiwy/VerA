// LRM 4.2.9 Table 4-11: `^` is the bit-wise exclusive or — a result bit is 1
// exactly when the two source bits differ.
//
//   5 = ...0101
//   3 = ...0011
//   ^ = ...0110 = 6
//
// The second line pins xor against or, which they differ on wherever two set
// bits meet: 6 ^ 3 = 0110 ^ 0011 = 0101 = 5, whereas 6 | 3 would be 7.
//
//! lrm 4.2.9
//! lrm 4.2.9:1001
`include "check.vh"
module ch04_bitwise_xor(p, n);
    inout p, n;
    electrical p, n;
    integer a;

    analog begin
        a = 5 ^ 3;
        `CHECKI("0101 ^ 0011 = 0110", a, 6);
        `CHECKI("0110 ^ 0011 = 0101, unlike 6 | 3 = 7", (6 ^ 3), 5);
        I(p, n) <+ a;
    end
endmodule
