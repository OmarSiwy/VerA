// §4.6.4 correlated noise: one white_noise() call assigned to a variable and
// used twice makes the two branch noise sources fully correlated, because they
// are literally the same source scaled by 1 and by 2.
//
// Outside a small-signal analysis §4.6 pins the value: "When not active, the
// small-signal source functions return zero (0)." So in this dc point the
// shared source is exactly 0.0 — not sqrt(1e-18) = 1e-9, and not a random
// draw — and both branches carry exactly nothing. That is what keeps a noisy
// device's operating point equal to its noiseless one, and it is checked on the
// variable AND on the scaled use so a lowering that re-evaluated the source per
// use is still pinned.
//
// The CORRELATION is §4.6.4.6 Example 1 — "Perfectly correlated noise is
// generated by using the output of one noise function for more than one noise
// source" — and it is a property of the export, not of any value the model can
// read: the `//! noise` lines below assert TWO rows on two branches sharing
// ONE `#0` source id, which is how the device tells a host the branches carry
// the same physical generator rather than two independent ones. The scaled use
// (`2.0 * shared_noise`) must not break the sharing.
//
//! lrm 4.6.4.6
//! lrm 4.6.4.6:1000
//! noise thermal(a,b)#0
//! noise thermal(b,c)#0
//! analysis dc
//! bias V(a) = 1.0
//! bias V(b) = 0.5
//! bias V(c) = 0.0
`include "check.vh"
module ch04_correlated_noise(a, b, c);
    inout a, b, c;
    electrical a, b, c;
    real shared_noise;

    analog begin
        shared_noise = white_noise(1e-18, "shared");
        `CHECKX("a shared white_noise source is inactive in a dc analysis", shared_noise, 0.0);
        `CHECKX("and so is the branch that scales it", 2.0 * shared_noise, 0.0);
        I(a, b) <+ shared_noise;
        I(b, c) <+ 2.0 * shared_noise;
    end
endmodule
