// §4.6.2: "However, variable values shall not be carried over between two
// independent dc sweep analyses (from the last dc point of one analysis to the
// first dc point of the next analysis)."
//
// A `//! sweep` line with no `//! time` is ONE dc sweep: its points are steps
// of the same analysis and keep variables, which is
// b2_dc_sweep_variables_carry_to_next_point.va's side. With a `//! time` grid
// the runner makes each sweep block its own analysis: `per_block =
// d.times.len > 1`, and `pointUnknowns(..., per_block or n == 0)` starts each
// block's `State` fresh (lib/exe/tb/runner.zig). `//! analysis dc` keeps the
// kind dc instead of the transient a bare time grid selects, so the two sweep
// blocks below are two independent dc analyses, not one dc sweep.
//
// The observed variables are running maxima, `if (v > peak) peak = v;`, which
// is idempotent: their value cannot depend on Newton iteration counts. Within a
// block they carry across its time points (the bias is constant, so they do not
// move); between the two analyses they must reset, or the second analysis
// starts from the last dc point of the first (0.5).
//
// HAND DERIVATION.
//   analysis 1: V = 0.5, peak starts 0, ends 0.5; level = 4*0.5 = 2, ipeak 2.
//   analysis 2: V = 0.25, peak starts 0 (reset), ends 0.25; level = 1, ipeak 1.
// So peak equals this analysis's own bias and ipeak its own level at both points
// of both analyses. A simulator that carried analysis 1's variables into
// analysis 2 reads peak - V = 0.25 and ipeak - level = 1 there.
//
//! lrm 4.6.2
//! lrm 4.6.2:4
//! analysis dc
//! sweep V(p) = 0.5, 0.25
//! time 0, 1n
//! bias V(n) = 0.0
//! checks 8
`include "check.vh"
module b2_two_independent_dc_sweeps_reinitialize_variables(p, n);
    inout p, n;
    electrical p, n;
    real peak;
    integer level, ipeak;

    analog begin
        if (V(p, n) > peak)
            peak = V(p, n);
        level = V(p, n) * 4.0;
        if (level > ipeak)
            ipeak = level;
        `CHECKX("a real restarts at zero in each independent dc analysis",
                peak - V(p, n), 0.0);
        `CHECKI("an integer restarts at zero in each independent dc analysis",
                ipeak - level, 0);
        I(p, n) <+ V(p, n);
    end
endmodule
