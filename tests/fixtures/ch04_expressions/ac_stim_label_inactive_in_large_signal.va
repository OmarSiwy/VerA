// §4.6.3 a host's analysis label never activates `ac_stim` in a LARGE-signal
// analysis, and neither does a large-signal kind's own spelling.
//
// "The AC stimulus function returns zero (0) during large-signal analyses
// (such as DC and transient) as well as on all small-signal analyses using
// names which do not match analysis_name."
//
// The first half of that sentence answers on its own here, whatever the
// name: this is a transient analysis (Table 4-21 "tran"), which the host
// labels "tran1" (Table 9-28 "analysis_name", e.g. "tran1"; the second word
// of `//! analysis`, published through `contract.host_strings`). So:
//     ac_stim("tran1", 2.5)   the label matches, the analysis is large-signal  0.0
//     ac_stim("tran", 2.5)    the kind's spelling, still large-signal          0.0
//     ac_stim("ac", 2.5)      not this analysis at all                         0.0
// and the label itself does reach the device, so the zeros above are the
// large-signal rule and not a missing label:
//     $simparam$str("analysis_name") == "tran1"                               1
//
// Neighbour: simparam_str_analysis_name_host_table.va, the same label rule in
// a small-signal analysis, where ac_stim("myac") is active.
//
// Wrong implementations: matching a name against the analysis's kind with
// Table 4-22's `analysis()` rule (where "tran" is true during a transient)
// makes the second check 2.5; matching against the label in any analysis
// makes the first 2.5.
//
//! lrm 4.6.3
//! lrm 4.6.3:1001
//! analysis tran tran1
//! bias V(p) = 0.5
//! bias V(n) = 0.0
`include "check.vh"
module ac_stim_label_inactive_in_large_signal(p, n);
    inout p, n;
    electrical p, n;
    parameter real R = 1000.0 from (0:inf);
    string an;

    analog begin
        an = $simparam$str("analysis_name");
        `CHECKX("the host's label does not wake ac_stim in a transient", ac_stim("tran1", 2.5), 0.0);
        `CHECKX("nor does the large-signal kind's own spelling", ac_stim("tran", 2.5), 0.0);
        `CHECKX("nor the default small-signal name", ac_stim("ac", 2.5), 0.0);
        `CHECKI("the label did reach the device", an == "tran1", 1);
        I(p, n) <+ V(p, n) / R + ac_stim("tran1", 2.5);
    end
endmodule
