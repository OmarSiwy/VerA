// §4.6.4.3: "When the input is a file name, the indicated file will contain the
// frequency / power pairs. The file name argument shall be constant and will be
// either a string literal or a string parameter."
//
// The string PARAMETER form. `fname` names noise_table_input.tbl beside this
// file (the clause's example file), so the device publishes its seven pairs,
// transcribed from the file:
//
//     1e0 1.65758e-23   1e1 3.31516e-23   1e2 6.63632e-23   1e3 1.326064e-22
//     1e4 2.652128e-22  1e5 5.304256e-22  1e6 1.060851e-21
//
// (a06_noise_table_file_input.va discusses the clause's own digits.) Outside a
// small-signal analysis the source reads 0 (§4.6.4), so the dc current is the
// resistor's alone.
//
// The legal neighbour of b2_noise_table_file_name_variable_rejected.va: the two
// differ only in `fname` being a parameter here and a variable there.
//
//! lrm 4.6.4.3
//! lrm 4.6.4.3:1
//! noise table(p,n)#0 name=file-input interp=linear points=1.0:1.65758e-23,10.0:3.31516e-23,100.0:6.63632e-23,1000.0:1.326064e-22,10000.0:2.652128e-22,100000.0:5.304256e-22,1000000.0:1.060851e-21
//! analysis dc
//! bias V(p) = 1.0
//! bias V(n) = 0.0
`include "check.vh"
module b2_noise_table_file_name_parameter(p, n);
    inout p, n;
    electrical p, n;
    parameter string fname = "noise_table_input.tbl";
    real nt;

    analog begin
        nt = noise_table(fname, "file-input");
        `CHECKX("noise_table is 0 outside a small-signal analysis", nt, 0.0);
        I(p, n) <+ V(p, n) / 1000.0 + nt;
    end
endmodule
