// LRM 4.5.12, verbatim: "If the transition time is specified as zero (0), then
// the output is abruptly discontinuous. A Z-filter with zero (0) transition
// time shall not be directly assigned to a branch."
//
// The two sentences are one rule: a zero tau is legal — 4.5.12 says tau "is
// optional, and shall be nonnegative" — and it is legal to READ its abruptly
// discontinuous output into a variable. What is banned is putting that
// discontinuity straight into the equation system, where a branch quantity
// stepping instantaneously has no derivative for Newton-Raphson to work with
// and the solver has nothing to converge on.
//
// So the contribution below is the violation and the tau is not. That is what
// makes this fixture worth writing: a compiler that rejected tau = 0 outright
// would break the legal reading, and a compiler that allowed the direct
// contribution breaks the solver.
//
//! lrm 4.5.12
//! reject shall not be directly assigned to a branch
//! xfail VerA refuses the whole optional tau/t0 tail of a zi_* filter in codegen ("VerA does not implement the optional t / t0 arguments of a zi_* filter"), so the legal non-zero tau is rejected too and the 4.5.12 rule that distinguishes them is never reached
module ch04_z_filter_zero_transition_branch_rejected(p, n);
    inout p, n;
    electrical p, n;

    analog I(p, n) <+ zi_zp(V(p, n), '{0.0, 0.0}, '{0.5, 0.0}, 1u, 0.0);
endmodule
