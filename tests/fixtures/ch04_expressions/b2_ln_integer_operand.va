// §4.3.1 Standard mathematical functions: "The operands shall be numeric
// (integer or real)." An integer operand is numeric, so ln(k) is legal, and
// the real-valued function of Table 4-14 sees the integer 2 as 2.0:
// ln(2) = 0.69314718055994530942..., nearest double 0.6931471805599453.
// An integer-valued ln would answer 0.
//
// The legal neighbour of b2_ln_string_operand_rejected.va: the two differ
// only in the operand's declared type (integer here, string there).
//
//! lrm 4.3.1
//! bias V(p) = 0.5
//! bias V(n) = 0.0
//! checks 1
`include "check.vh"
module b2_ln_integer_operand(p, n);
    inout p, n;
    electrical p, n;
    integer s;
    real x;

    analog begin
        s = 2;
        x = ln(s);
        `CHECK("ln of the integer 2 is ln(2.0)", x, 0.6931471805599453, 1e-15);
        I(p, n) <+ x * V(p, n);
    end
endmodule
