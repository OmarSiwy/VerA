// LRM 4.2.7: `!=` is the other half of Table 4-8 and obeys the same rule as
// `==` — zero (0) if the comparison fails, one (1) if it succeeds.
//
// Biased at V(p)=1.0, V(n)=0 the branch potential is exactly 1.0, so `!= 1.0`
// must be 0 and `!= 2.0` must be 1: the exact mirror of 51_logical_equal.
//
//! lrm 4.2.7
//! lrm 4.2.7:1
//! bias V(p) = 1.0
`include "check.vh"
module ch04_logical_unequal(p, n);
    inout p, n;
    electrical p, n;

    analog begin
        `CHECKI("1.0 != 1.0 fails -> 0", (V(p, n) != 1.0), 0);
        `CHECKI("1.0 != 2.0 succeeds -> 1", (V(p, n) != 2.0), 1);
        I(p, n) <+ (V(p, n) != 1.0);
    end
endmodule
