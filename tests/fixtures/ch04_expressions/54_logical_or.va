// LRM 4.2.8: `||` is the other logical connective, and its result is likewise
// one (1) or zero (0) — never an operand, and never the bit-wise `|` of 4.2.9.
//
// Biased at V(p)=1.0, V(n)=0 the branch potential is 1.0: neither `< 0` nor
// `> 2` holds, so the first disjunction is false; swapping the second arm for
// `> 0.5` makes it true.
//
// The third line separates `||` from `|`: 4 || 2 is 1, while the bit-wise
// 4 | 2 is 6 (0100 | 0010).
//
//! lrm 4.2.8
//! lrm 4.2.8:1000
//! bias V(p) = 1.0
`include "check.vh"
module ch04_logical_or(p, n);
    inout p, n;
    electrical p, n;

    analog begin
        `CHECKI("false || false -> 0", ((V(p, n) < 0.0) || (V(p, n) > 2.0)), 0);
        `CHECKI("false || true -> 1", ((V(p, n) < 0.0) || (V(p, n) > 0.5)), 1);
        `CHECKI("|| normalises to 1, unlike 4 | 2 = 6", (4 || 2), 1);
        I(p, n) <+ ((V(p, n) < 0.0) || (V(p, n) > 2.0));
    end
endmodule
