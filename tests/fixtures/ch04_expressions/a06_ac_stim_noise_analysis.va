// §4.6.3 AC stimulus during a NOISE analysis — the other small-signal analysis,
// and the one where the name test earns its keep.
//
// §4.6.3, verbatim: "The AC stimulus function returns zero (0) during
// large-signal analyses (such as DC and transient) as well as on all
// small-signal analyses using names which do not match analysis_name. The name
// of a small-signal analysis is implementation dependent, although the expected
// name (of the equivalent of a SPICE AC analysis) is 'ac', which is the default
// value of analysis_name. When the name of the small-signal analysis matches
// analysis_name, the source becomes active…"
//
// Table 4-21 names this analysis: "noise" — ".NOISE analysis". So the two
// halves of that sentence fall on opposite sides here, and the numbers are
// forced:
//
//   ac_stim()            default name "ac" ≠ "noise" → 0.0
//   ac_stim("ac", 2.5)   spelled "ac"      ≠ "noise" → 0.0
//   ac_stim("noise", 2.5)  matches the analysis in force, phase defaults to 0,
//                          so the phasor is the real number             → +2.5
//
// The first two are the assertion that matters and they are NOT the same claim
// as `ch04_expressions/37_ac_stim.va`'s: that fixture is in a LARGE-signal
// analysis, where the first clause of the sentence answers on its own. Here the
// analysis IS small-signal, and only the name comparison keeps the source off.
// A compiler that activated `ac_stim` in "any small-signal analysis" passes
// fixture 37 and fails the first line below.
//
// Table 4-22's NOISE column is asserted beside it: "noise" is true, "ac" is
// false, and "static" is false during the noise sweep (it is true only in the
// operating point that precedes it, a separate pass).
//
// §4.6.4's zero is NOT asserted here on purpose. In a noise analysis the noise
// functions ARE active, and what an active generator contributes is a spectral
// density and not a deterministic number a `CHECK` could hold — the LRM defines
// no scalar value for it. Its export is what
// `a06_psd_white_flicker_export.va` pins.
//
//! lrm 4.6.3
//! lrm 4.6.3:1
//! lrm 4.6.1
//! lrm 4.6.1:1
//! analysis noise
//! bias V(p) = 0.5
//! bias V(n) = 0.0
`include "check.vh"
module a06_ac_stim_noise_analysis(p, n);
    inout p, n;
    electrical p, n;
    parameter real R = 1000.0 from (0:inf);

    analog begin
        `CHECKX("the default name \"ac\" does not match a noise analysis", ac_stim(), 0.0);
        `CHECKX("an explicit \"ac\" does not match a noise analysis", ac_stim("ac", 2.5), 0.0);
        `CHECKX("\"noise\" is the name of this small-signal analysis (Table 4-21)",
            ac_stim("noise", 2.5), 2.5);
        `CHECKX("and phase pi negates it there too", ac_stim("noise", 2.5, `M_PI), -2.5);

        `CHECKI("Table 4-22: \"noise\" matches a noise analysis", analysis("noise"), 1);
        `CHECKI("Table 4-22: \"ac\" is false in a noise analysis", analysis("ac"), 0);
        `CHECKI("Table 4-22: \"static\" is false during the noise sweep", analysis("static"), 0);
        `CHECKI("Table 4-22: \"dc\" is false in a noise analysis", analysis("dc"), 0);

        I(p, n) <+ V(p, n) / R + ac_stim("noise", 2.5, 0.0);
    end
endmodule
