// AMS 4.5.14: "If a dynamic expression is passed as an argument which expects
// a constant expression, the value of the dynamic expression at the start of
// the analysis defaults to the constant value of the argument. Any further
// change in value of that expression is ignored during the iterative
// analysis." Table 4-20 lists laplace_zp's zeros and poles as constant
// expression arguments; the clause's editorial note says "a blanket rejection
// requirement must not be inferred from the column heading alone", so this
// rule has no invalid form and no refusal fixture.
//
// audit_laplace_dynamic_coefficient_sampled.va pins a coefficient-form
// numerator through a zero-order filter; this is a root-form pole with state.
// The pole is ρ = -1/(V(k, n)·1ns). V(k) is 10 at the analysis start (the
// static point, t = 0) and 1 after, so the sampled pole is -1e8 and
// §4.5.11.1 gives H(s) = 1 / (1 - s/ρ) = 1 / (1 + s·τ), τ = 10ns, for the
// whole transient. Driven from rest by the ramp u = t/1ns, the exact
// response of that lumped linear system is (as in a04_11)
//
//     y(t) = tns - 10·(1 - exp(-tns/10))
//
// y(5ns) = 1.0653066, y(10ns) = 3.6787944. The grid is a04_11's dt = 0.5ns =
// τ/20, whose worst trapezoidal discretisation error over 0..10ns is 7.67e-4
// at 10ns (a04_11's derivation), so the tolerance is 1e-3. As in a04_11 the
// check is made from 7ns on, where it can see a 0.1% error in its want
// (`benchmark -- --perturb`): seven points. Resampling the pole gives τ = 1ns
// from t = 0.5ns on, and y(10ns) near 9: out by 5.
//
// Corrected 2026-10-08 (construct only, the wants are unchanged): the
// coefficient vectors were VAMS 2.x concatenations, `{...}`. A.8.2's
// analog_filter_function_arg is a parameter, a part of one or a `'{...}`
// assignment pattern (annex G: "Add apostrophe before opening { in list of
// values"), and a concatenation there is E0572
// (reject_4_5_11_concatenation_coefficients.va), so each is now `'{...}`.
//
//! lrm 4.5.14
//! lrm 4.5.11.1
//! checks 7
//! bias V(n) = 0
//! wave V(k) = 10, 1
//! time 0, 0.5n, 1n, 1.5n, 2n, 2.5n, 3n, 3.5n, 4n, 4.5n, 5n, 5.5n, 6n, 6.5n, 7n, 7.5n, 8n, 8.5n, 9n, 9.5n, 10n
//! analysis tran
//! print none
`include "check.vh"
module laplace_zp_dynamic_pole_sampled(k, n);
    inout k, n;
    electrical k, n;
    real tns, y;

    analog begin
        tns = $abstime * 1e9;
        y = laplace_zp(tns, , '{-1.0 / (V(k, n) * 1n), 0.0});
        if (tns > 6.75)
            `CHECKEQ("the pole is sampled at the analysis start",
                     y, tns - 10.0 * (1.0 - exp(-tns / 10.0)), 1e-3);
        I(k, n) <+ 0.0;
    end
endmodule
