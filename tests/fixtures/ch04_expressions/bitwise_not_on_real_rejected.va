// §4.2.1: "The operators shown in Table 4-2 are legal when applied to real
// operands. All other operators are considered illegal when used with real
// operands." Table 4-2 lists unary + and -, the arithmetic operators, %, the
// relational and logical-equality operators, ! && || and ?:. The §4.2.9
// bitwise operators are not in it: they combine "a bit in one operand with its
// corresponding bit in the other operand", and a real has no bits in the
// language.
//
// `~x` below applies unary bitwise negation to a real variable. The legal side,
// the bitwise operators on integers, is 05_bitwise_shift.va. (A BINARY bitwise
// operator with a real operand is E0322, a separate code.)
//
//! lrm 4.2.1
//! lrm 4.2.1:1
//! lrm 4.2.9
//! reject-only E0318
`include "disciplines.vams"
module ch04_bitwise_not_on_real(p, n);
  inout p, n; electrical p, n;
  real x;
  analog begin
    x = 1.5;
    I(p, n) <+ (~x) * V(p, n);
  end
endmodule
