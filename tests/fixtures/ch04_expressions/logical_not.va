// LRM 4.2.8: the unary logical negation `!` "converts a non-zero or true
// operand into zero (0) and a zero or false operand into one (1)".
//
// Biased at V(p)=1.0, V(n)=0 the branch potential is 1.0, so `V == 0.0` is
// false and its negation is 1, while `V == 1.0` is true and its negation is 0.
//
// The third line separates `!` from the bit-wise `~` of 4.2.9: `!5` is 0
// because 5 is non-zero, whereas `~5` is -6 in 2's complement (3.2).
//
//! lrm 4.2.8
//! lrm 4.2.8:1000
//! bias V(p) = 1.0
`include "check.vh"
module ch04_logical_not(p, n);
    inout p, n;
    electrical p, n;

    analog begin
        `CHECKI("!(1.0 == 0.0) -> 1", (!(V(p, n) == 0.0)), 1);
        `CHECKI("!(1.0 == 1.0) -> 0", (!(V(p, n) == 1.0)), 0);
        `CHECKI("!5 is 0, unlike ~5 = -6", (!5), 0);
        I(p, n) <+ !(V(p, n) == 0.0);
    end
endmodule
