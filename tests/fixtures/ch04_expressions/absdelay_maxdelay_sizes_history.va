// §4.5.7 absdelay(input, td, maxdelay): "If td becomes greater than maxdelay,
// maxdelay will be used as a substitute for td", so maxdelay bounds every
// lookback the site can make. VerA sizes the site's history ring from it:
// ceil(maxdelay / 1ps) + 2 samples, at least 1024 and at most 16384
// (specification/Vague_Decisions.md, `codegen.hist_min_step`). This is the transmission
// line case: td = 1.5ns resolved at a 1ps step.
//
// HAND DERIVATION. The input is the ramp $abstime*1e12 (1 per ps), td =
// maxdelay = 1.5ns, on a uniform 1ps grid 0 .. 1600ps (1601 accepted points).
// Output(t) = Input(max(t - td, 0)) = max(t/1ps - 1500, 0): 0 through 1500ps,
// then 1 .. 100. Every query lands on a grid point, so linear interpolation is
// exact. At t = 1600ps the query t - td = 100ps is 1500 accepted samples old.
//
// THE LEGAL NEIGHBOUR is the refusal: the same delay WITHOUT maxdelay keeps
// the 1024-sample ring and ends the run with E1012 at the 1025th point
// (absdelay_history_underrun_is_fatal.va pins that exit on a 1ns grid). A ring
// that did not grow would do that here too, before t = 1600ps.
//
//! lrm 4.5.7
//! bias V(n) = 0
//! checks 1601
//! time 0p, 1p, 2p, 3p, 4p, 5p, 6p, 7p, 8p, 9p, 10p, 11p, 12p, 13p, 14p, 15p, 16p, 17p, 18p, 19p, 20p, 21p, 22p, 23p, 24p, 25p, 26p, 27p, 28p, 29p, 30p, 31p, 32p, 33p, 34p, 35p, 36p, 37p, 38p, 39p, 40p, 41p, 42p, 43p, 44p, 45p, 46p, 47p, 48p, 49p, 50p, 51p, 52p, 53p, 54p, 55p, 56p, 57p, 58p, 59p, 60p, 61p, 62p, 63p, 64p, 65p, 66p, 67p, 68p, 69p, 70p, 71p, 72p, 73p, 74p, 75p, 76p, 77p, 78p, 79p, 80p, 81p, 82p, 83p, 84p, 85p, 86p, 87p, 88p, 89p, 90p, 91p, 92p, 93p, 94p, 95p, 96p, 97p, 98p, 99p, 100p, 101p, 102p, 103p, 104p, 105p, 106p, 107p, 108p, 109p, 110p, 111p, 112p, 113p, 114p, 115p, 116p, 117p, 118p, 119p, 120p, 121p, 122p, 123p, 124p, 125p, 126p, 127p, 128p, 129p, 130p, 131p, 132p, 133p, 134p, 135p, 136p, 137p, 138p, 139p, 140p, 141p, 142p, 143p, 144p, 145p, 146p, 147p, 148p, 149p, 150p, 151p, 152p, 153p, 154p, 155p, 156p, 157p, 158p, 159p, 160p, 161p, 162p, 163p, 164p, 165p, 166p, 167p, 168p, 169p, 170p, 171p, 172p, 173p, 174p, 175p, 176p, 177p, 178p, 179p, 180p, 181p, 182p, 183p, 184p, 185p, 186p, 187p, 188p, 189p, 190p, 191p, 192p, 193p, 194p, 195p, 196p, 197p, 198p, 199p, 200p, 201p, 202p, 203p, 204p, 205p, 206p, 207p, 208p, 209p, 210p, 211p, 212p, 213p, 214p, 215p, 216p, 217p, 218p, 219p, 220p, 221p, 222p, 223p, 224p, 225p, 226p, 227p, 228p, 229p, 230p, 231p, 232p, 233p, 234p, 235p, 236p, 237p, 238p, 239p, 240p, 241p, 242p, 243p, 244p, 245p, 246p, 247p, 248p, 249p, 250p, 251p, 252p, 253p, 254p, 255p, 256p, 257p, 258p, 259p, 260p, 261p, 262p, 263p, 264p, 265p, 266p, 267p, 268p, 269p, 270p, 271p, 272p, 273p, 274p, 275p, 276p, 277p, 278p, 279p, 280p, 281p, 282p, 283p, 284p, 285p, 286p, 287p, 288p, 289p, 290p, 291p, 292p, 293p, 294p, 295p, 296p, 297p, 298p, 299p, 300p, 301p, 302p, 303p, 304p, 305p, 306p, 307p, 308p, 309p, 310p, 311p, 312p, 313p, 314p, 315p, 316p, 317p, 318p, 319p, 320p, 321p, 322p, 323p, 324p, 325p, 326p, 327p, 328p, 329p, 330p, 331p, 332p, 333p, 334p, 335p, 336p, 337p, 338p, 339p, 340p, 341p, 342p, 343p, 344p, 345p, 346p, 347p, 348p, 349p, 350p, 351p, 352p, 353p, 354p, 355p, 356p, 357p, 358p, 359p, 360p, 361p, 362p, 363p, 364p, 365p, 366p, 367p, 368p, 369p, 370p, 371p, 372p, 373p, 374p, 375p, 376p, 377p, 378p, 379p, 380p, 381p, 382p, 383p, 384p, 385p, 386p, 387p, 388p, 389p, 390p, 391p, 392p, 393p, 394p, 395p, 396p, 397p, 398p, 399p, 400p, 401p, 402p, 403p, 404p, 405p, 406p, 407p, 408p, 409p, 410p, 411p, 412p, 413p, 414p, 415p, 416p, 417p, 418p, 419p, 420p, 421p, 422p, 423p, 424p, 425p, 426p, 427p, 428p, 429p, 430p, 431p, 432p, 433p, 434p, 435p, 436p, 437p, 438p, 439p, 440p, 441p, 442p, 443p, 444p, 445p, 446p, 447p, 448p, 449p, 450p, 451p, 452p, 453p, 454p, 455p, 456p, 457p, 458p, 459p, 460p, 461p, 462p, 463p, 464p, 465p, 466p, 467p, 468p, 469p, 470p, 471p, 472p, 473p, 474p, 475p, 476p, 477p, 478p, 479p, 480p, 481p, 482p, 483p, 484p, 485p, 486p, 487p, 488p, 489p, 490p, 491p, 492p, 493p, 494p, 495p, 496p, 497p, 498p, 499p, 500p, 501p, 502p, 503p, 504p, 505p, 506p, 507p, 508p, 509p, 510p, 511p, 512p, 513p, 514p, 515p, 516p, 517p, 518p, 519p, 520p, 521p, 522p, 523p, 524p, 525p, 526p, 527p, 528p, 529p, 530p, 531p, 532p, 533p, 534p, 535p, 536p, 537p, 538p, 539p, 540p, 541p, 542p, 543p, 544p, 545p, 546p, 547p, 548p, 549p, 550p, 551p, 552p, 553p, 554p, 555p, 556p, 557p, 558p, 559p, 560p, 561p, 562p, 563p, 564p, 565p, 566p, 567p, 568p, 569p, 570p, 571p, 572p, 573p, 574p, 575p, 576p, 577p, 578p, 579p, 580p, 581p, 582p, 583p, 584p, 585p, 586p, 587p, 588p, 589p, 590p, 591p, 592p, 593p, 594p, 595p, 596p, 597p, 598p, 599p, 600p, 601p, 602p, 603p, 604p, 605p, 606p, 607p, 608p, 609p, 610p, 611p, 612p, 613p, 614p, 615p, 616p, 617p, 618p, 619p, 620p, 621p, 622p, 623p, 624p, 625p, 626p, 627p, 628p, 629p, 630p, 631p, 632p, 633p, 634p, 635p, 636p, 637p, 638p, 639p, 640p, 641p, 642p, 643p, 644p, 645p, 646p, 647p, 648p, 649p, 650p, 651p, 652p, 653p, 654p, 655p, 656p, 657p, 658p, 659p, 660p, 661p, 662p, 663p, 664p, 665p, 666p, 667p, 668p, 669p, 670p, 671p, 672p, 673p, 674p, 675p, 676p, 677p, 678p, 679p, 680p, 681p, 682p, 683p, 684p, 685p, 686p, 687p, 688p, 689p, 690p, 691p, 692p, 693p, 694p, 695p, 696p, 697p, 698p, 699p, 700p, 701p, 702p, 703p, 704p, 705p, 706p, 707p, 708p, 709p, 710p, 711p, 712p, 713p, 714p, 715p, 716p, 717p, 718p, 719p, 720p, 721p, 722p, 723p, 724p, 725p, 726p, 727p, 728p, 729p, 730p, 731p, 732p, 733p, 734p, 735p, 736p, 737p, 738p, 739p, 740p, 741p, 742p, 743p, 744p, 745p, 746p, 747p, 748p, 749p, 750p, 751p, 752p, 753p, 754p, 755p, 756p, 757p, 758p, 759p, 760p, 761p, 762p, 763p, 764p, 765p, 766p, 767p, 768p, 769p, 770p, 771p, 772p, 773p, 774p, 775p, 776p, 777p, 778p, 779p, 780p, 781p, 782p, 783p, 784p, 785p, 786p, 787p, 788p, 789p, 790p, 791p, 792p, 793p, 794p, 795p, 796p, 797p, 798p, 799p, 800p, 801p, 802p, 803p, 804p, 805p, 806p, 807p, 808p, 809p, 810p, 811p, 812p, 813p, 814p, 815p, 816p, 817p, 818p, 819p, 820p, 821p, 822p, 823p, 824p, 825p, 826p, 827p, 828p, 829p, 830p, 831p, 832p, 833p, 834p, 835p, 836p, 837p, 838p, 839p, 840p, 841p, 842p, 843p, 844p, 845p, 846p, 847p, 848p, 849p, 850p, 851p, 852p, 853p, 854p, 855p, 856p, 857p, 858p, 859p, 860p, 861p, 862p, 863p, 864p, 865p, 866p, 867p, 868p, 869p, 870p, 871p, 872p, 873p, 874p, 875p, 876p, 877p, 878p, 879p, 880p, 881p, 882p, 883p, 884p, 885p, 886p, 887p, 888p, 889p, 890p, 891p, 892p, 893p, 894p, 895p, 896p, 897p, 898p, 899p, 900p, 901p, 902p, 903p, 904p, 905p, 906p, 907p, 908p, 909p, 910p, 911p, 912p, 913p, 914p, 915p, 916p, 917p, 918p, 919p, 920p, 921p, 922p, 923p, 924p, 925p, 926p, 927p, 928p, 929p, 930p, 931p, 932p, 933p, 934p, 935p, 936p, 937p, 938p, 939p, 940p, 941p, 942p, 943p, 944p, 945p, 946p, 947p, 948p, 949p, 950p, 951p, 952p, 953p, 954p, 955p, 956p, 957p, 958p, 959p, 960p, 961p, 962p, 963p, 964p, 965p, 966p, 967p, 968p, 969p, 970p, 971p, 972p, 973p, 974p, 975p, 976p, 977p, 978p, 979p, 980p, 981p, 982p, 983p, 984p, 985p, 986p, 987p, 988p, 989p, 990p, 991p, 992p, 993p, 994p, 995p, 996p, 997p, 998p, 999p, 1000p, 1001p, 1002p, 1003p, 1004p, 1005p, 1006p, 1007p, 1008p, 1009p, 1010p, 1011p, 1012p, 1013p, 1014p, 1015p, 1016p, 1017p, 1018p, 1019p, 1020p, 1021p, 1022p, 1023p, 1024p, 1025p, 1026p, 1027p, 1028p, 1029p, 1030p, 1031p, 1032p, 1033p, 1034p, 1035p, 1036p, 1037p, 1038p, 1039p, 1040p, 1041p, 1042p, 1043p, 1044p, 1045p, 1046p, 1047p, 1048p, 1049p, 1050p, 1051p, 1052p, 1053p, 1054p, 1055p, 1056p, 1057p, 1058p, 1059p, 1060p, 1061p, 1062p, 1063p, 1064p, 1065p, 1066p, 1067p, 1068p, 1069p, 1070p, 1071p, 1072p, 1073p, 1074p, 1075p, 1076p, 1077p, 1078p, 1079p, 1080p, 1081p, 1082p, 1083p, 1084p, 1085p, 1086p, 1087p, 1088p, 1089p, 1090p, 1091p, 1092p, 1093p, 1094p, 1095p, 1096p, 1097p, 1098p, 1099p, 1100p, 1101p, 1102p, 1103p, 1104p, 1105p, 1106p, 1107p, 1108p, 1109p, 1110p, 1111p, 1112p, 1113p, 1114p, 1115p, 1116p, 1117p, 1118p, 1119p, 1120p, 1121p, 1122p, 1123p, 1124p, 1125p, 1126p, 1127p, 1128p, 1129p, 1130p, 1131p, 1132p, 1133p, 1134p, 1135p, 1136p, 1137p, 1138p, 1139p, 1140p, 1141p, 1142p, 1143p, 1144p, 1145p, 1146p, 1147p, 1148p, 1149p, 1150p, 1151p, 1152p, 1153p, 1154p, 1155p, 1156p, 1157p, 1158p, 1159p, 1160p, 1161p, 1162p, 1163p, 1164p, 1165p, 1166p, 1167p, 1168p, 1169p, 1170p, 1171p, 1172p, 1173p, 1174p, 1175p, 1176p, 1177p, 1178p, 1179p, 1180p, 1181p, 1182p, 1183p, 1184p, 1185p, 1186p, 1187p, 1188p, 1189p, 1190p, 1191p, 1192p, 1193p, 1194p, 1195p, 1196p, 1197p, 1198p, 1199p, 1200p, 1201p, 1202p, 1203p, 1204p, 1205p, 1206p, 1207p, 1208p, 1209p, 1210p, 1211p, 1212p, 1213p, 1214p, 1215p, 1216p, 1217p, 1218p, 1219p, 1220p, 1221p, 1222p, 1223p, 1224p, 1225p, 1226p, 1227p, 1228p, 1229p, 1230p, 1231p, 1232p, 1233p, 1234p, 1235p, 1236p, 1237p, 1238p, 1239p, 1240p, 1241p, 1242p, 1243p, 1244p, 1245p, 1246p, 1247p, 1248p, 1249p, 1250p, 1251p, 1252p, 1253p, 1254p, 1255p, 1256p, 1257p, 1258p, 1259p, 1260p, 1261p, 1262p, 1263p, 1264p, 1265p, 1266p, 1267p, 1268p, 1269p, 1270p, 1271p, 1272p, 1273p, 1274p, 1275p, 1276p, 1277p, 1278p, 1279p, 1280p, 1281p, 1282p, 1283p, 1284p, 1285p, 1286p, 1287p, 1288p, 1289p, 1290p, 1291p, 1292p, 1293p, 1294p, 1295p, 1296p, 1297p, 1298p, 1299p, 1300p, 1301p, 1302p, 1303p, 1304p, 1305p, 1306p, 1307p, 1308p, 1309p, 1310p, 1311p, 1312p, 1313p, 1314p, 1315p, 1316p, 1317p, 1318p, 1319p, 1320p, 1321p, 1322p, 1323p, 1324p, 1325p, 1326p, 1327p, 1328p, 1329p, 1330p, 1331p, 1332p, 1333p, 1334p, 1335p, 1336p, 1337p, 1338p, 1339p, 1340p, 1341p, 1342p, 1343p, 1344p, 1345p, 1346p, 1347p, 1348p, 1349p, 1350p, 1351p, 1352p, 1353p, 1354p, 1355p, 1356p, 1357p, 1358p, 1359p, 1360p, 1361p, 1362p, 1363p, 1364p, 1365p, 1366p, 1367p, 1368p, 1369p, 1370p, 1371p, 1372p, 1373p, 1374p, 1375p, 1376p, 1377p, 1378p, 1379p, 1380p, 1381p, 1382p, 1383p, 1384p, 1385p, 1386p, 1387p, 1388p, 1389p, 1390p, 1391p, 1392p, 1393p, 1394p, 1395p, 1396p, 1397p, 1398p, 1399p, 1400p, 1401p, 1402p, 1403p, 1404p, 1405p, 1406p, 1407p, 1408p, 1409p, 1410p, 1411p, 1412p, 1413p, 1414p, 1415p, 1416p, 1417p, 1418p, 1419p, 1420p, 1421p, 1422p, 1423p, 1424p, 1425p, 1426p, 1427p, 1428p, 1429p, 1430p, 1431p, 1432p, 1433p, 1434p, 1435p, 1436p, 1437p, 1438p, 1439p, 1440p, 1441p, 1442p, 1443p, 1444p, 1445p, 1446p, 1447p, 1448p, 1449p, 1450p, 1451p, 1452p, 1453p, 1454p, 1455p, 1456p, 1457p, 1458p, 1459p, 1460p, 1461p, 1462p, 1463p, 1464p, 1465p, 1466p, 1467p, 1468p, 1469p, 1470p, 1471p, 1472p, 1473p, 1474p, 1475p, 1476p, 1477p, 1478p, 1479p, 1480p, 1481p, 1482p, 1483p, 1484p, 1485p, 1486p, 1487p, 1488p, 1489p, 1490p, 1491p, 1492p, 1493p, 1494p, 1495p, 1496p, 1497p, 1498p, 1499p, 1500p, 1501p, 1502p, 1503p, 1504p, 1505p, 1506p, 1507p, 1508p, 1509p, 1510p, 1511p, 1512p, 1513p, 1514p, 1515p, 1516p, 1517p, 1518p, 1519p, 1520p, 1521p, 1522p, 1523p, 1524p, 1525p, 1526p, 1527p, 1528p, 1529p, 1530p, 1531p, 1532p, 1533p, 1534p, 1535p, 1536p, 1537p, 1538p, 1539p, 1540p, 1541p, 1542p, 1543p, 1544p, 1545p, 1546p, 1547p, 1548p, 1549p, 1550p, 1551p, 1552p, 1553p, 1554p, 1555p, 1556p, 1557p, 1558p, 1559p, 1560p, 1561p, 1562p, 1563p, 1564p, 1565p, 1566p, 1567p, 1568p, 1569p, 1570p, 1571p, 1572p, 1573p, 1574p, 1575p, 1576p, 1577p, 1578p, 1579p, 1580p, 1581p, 1582p, 1583p, 1584p, 1585p, 1586p, 1587p, 1588p, 1589p, 1590p, 1591p, 1592p, 1593p, 1594p, 1595p, 1596p, 1597p, 1598p, 1599p, 1600p
//! analysis tran
//! print none
`include "check.vh"
module absdelay_maxdelay_sizes_history(p, n);
  inout p, n; electrical p, n;
  analog begin
    `CHECK("a 1500-sample lookback within maxdelay is the delay",
           absdelay($abstime * 1e12, 1.5n, 1.5n) - max($abstime * 1e12 - 1500.0, 0.0), 0.0, 1e-6);
    I(p, n) <+ 0.0;
  end
endmodule
