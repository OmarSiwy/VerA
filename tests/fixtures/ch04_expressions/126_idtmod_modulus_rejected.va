// LRM 4.5.5, verbatim: "The modulus shall be an expression which evaluates to a
// positive value."
//
// The bound is not decoration. 4.5.5 defines the operator's whole contract in
// terms of it — "The output of the idtmod() function shall remain in the range
// offset <= idtmod < offset+modulus" — and with a negative modulus that range
// is empty, so no return value satisfies the specification. Zero is the same
// hole with the interval collapsed to a point.
//
// Both offending values are written, because a guard spelled `modulus != 0`
// admits the negative one and a guard spelled `modulus >= 0` admits zero. Both
// are constants, so the check is static and the fixture needs no operating
// point. 17_idtmod.va is the legal side with modulus 2.0.
//
//! lrm 4.5.5
//! reject modulus
//! xfail VerA validates none of Table 4-19's argument bounds: idtmod(x, 0.0, -2.0, 0.0) and idtmod(x, 0.0, 0.0, 0.0) both compile with only W0650, and src/diag_code.zig has no code for a non-positive modulus
module ch04_idtmod_modulus_rejected(p, n);
    inout p, n;
    electrical p, n;
    real negative_modulus, zero_modulus;

    analog begin
        negative_modulus = idtmod(V(p, n), 0.0, -2.0, 0.0);
        zero_modulus = idtmod(V(p, n), 0.0, 0.0, 0.0);
        I(p, n) <+ negative_modulus + zero_modulus;
    end
endmodule
