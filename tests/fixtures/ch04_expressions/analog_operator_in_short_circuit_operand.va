// §4.5.15 — TWO SIBLING OPERATOR SITES, ONE IN EACH OPERAND OF A `||`, SHALL
// AGREE. This fixture is the re-homed third check of
// 09_slew_small_signal_transfer.va: that check failed, but for a reason that
// has nothing to do with §4.5.9's transfer function, so it was moved here and
// re-cited rather than dropped.
//
//   §4.5.15: "Analog operators are subject to several important restrictions
//    because they maintain their internal state. IT IS IMPORTANT TO ENSURE
//    THAT ALL ANALOG OPERATORS ARE EVALUATED EVERY ITERATION OF A SIMULATION
//    TO ENSURE THAT THE INTERNAL STATE IS MAINTAINED. The analog operator
//    ddx() is the only exception to this rule as it does not require an
//    internal state to be maintained. ...
//    Analog operators shall not be used inside conditional (if, case, or ?:)
//    statements unless the conditional expression controlling the statement
//    consists of terms which can not change their value during the course of a
//    simulation. ...
//    These restrictions help prevent usage which could cause the internal
//    state to be corrupted or become out-of-date, which results in anomalous
//    behavior."
//
// WHY THIS IS A POSITIVE FIXTURE AND NOT A REFUSAL. The restriction paragraph
// names exactly three constructs — `if`, `case` and `?:`. `||` is none of
// them, and §4.5.15 lists no other spelling; nothing in the clause makes an
// analog operator in the right operand of a `||` illegal. So the clause does
// not authorise a diagnostic here. What it DOES require, in the sentence
// quoted in capitals, is that every analog operator be evaluated every
// iteration — which is precisely the guarantee a short-circuit lowering of
// `||` breaks. The requirement is therefore stated as a value, not a refusal.
//
// THE HAND DERIVATION. Two `slew()` sites with identical arguments: site A,
// written unconditionally into `lhs`, and site B, written syntactically inside
// the RIGHT operand of a `||`. §4.5.15 makes both of them live every
// iteration, and two operators with the same arguments and the same history
// are the same number, so
//
//     |B − A| == 0
//
// at every timepoint, whatever the rate limiter is doing. That is an IDENTITY
// the clause states with no value to write down — the two sides are VerA
// expressions compared against each other, not against digits — so the band is
// 1e-15, which admits nothing but agreement to the last place or two.
//
// The left operand is `$abstime < 3n`: pure time, evaluated unconditionally,
// and TRUE for the first three timepoints. That is what sets the trap. On a
// 1ns grid with a +-3e8 V/s limit the output moves 0.3 V per step, so
//
//   t/ns          0     1     2     3     4     5
//   V(in)         0     1     1     1     1     1
//   site A        0   0.3   0.6   0.9     1     1
//   left operand  T     T     T     F     F     F
//
// A short-circuiting lowering skips site B on the three steps where the left
// operand is already true, so B's history is stranded at 0. From t = 3ns the
// left operand is false, B is evaluated for real, and it starts its ramp three
// steps late: 0.3, 0.6, 0.9 where A reads 0.9, 1, 1. The identity separates at
// all three of those points and the fixture fails 3 of its 6. A lowering that
// evaluates both sites unconditionally keeps them equal and passes all 6.
//
// The first three points assert the identity trivially (the escape is true
// there) and are kept deliberately: they are the steps during which the damage
// is done, and asserting nothing about them is the honest reading — the clause
// requires the operator to be EVALUATED there, and evaluation is only
// observable in its later output.
//
// WHY IT FAILS TODAY. VerA lowers the right operand of `||` into the `else`
// arm of a short-circuit branch and `updateState` then feeds that operator site
// the branch-local input — 0.0 on every step where the left operand was true.
// The right-hand `slew` therefore carries prev = 0 forward, reports itself as
// still slewing, and reads a different number from its twin. That is the
// "internal state ... corrupted or become out-of-date" that §4.5.15's closing
// sentence names. It is also what made the third check of fixture 09 fail
// there, where it looked like a §4.5.9 defect and was not one.
//
//! lrm 4.5.15
//! lrm 4.5.15:1
//! bias V(n) = 0
//! wave V(in) = 0, 1
//! time 0, 1n, 2n, 3n, 4n, 5n
//! analysis tran
//! print none
`include "check.vh"
module a04_operator_in_short_circuit(in, n);
    inout in, n;
    electrical in, n;
    real lhs;

    analog begin
        // Site A, evaluated unconditionally by construction. Its own value is
        // pinned against the hand-derived rate limit so the identity below is
        // anchored to a known number and not to two equally-wrong sides.
        lhs = slew(V(in, n), 3e8, -3e8);
        `CHECKEQ("site A tracks the 0.3 V-per-step rate limit",
                 lhs, min(1.0, 0.3 * ($abstime * 1e9)), 1e-12);
        // Site B, syntactically inside the RIGHT operand of a `||`. The left
        // operand is a pure-$abstime test, so it is safe to evaluate and it is
        // what decides whether a short-circuiting lowering reaches site B.
        // §4.5.15 requires B to be evaluated every iteration regardless, hence
        // to equal A.
        `CHECKI("a slew() site inside the right operand of a || reads the same number as its twin",
                $abstime < 3n
                  || abs(slew(V(in, n), 3e8, -3e8) - lhs) <= 1e-15, 1);

        I(in, n) <+ 0.0;
    end
endmodule
