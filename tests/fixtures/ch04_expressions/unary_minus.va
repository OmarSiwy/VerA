// §4.2 Table 4-1 / Table 4-2: unary `-` on a real operand negates it. The bias
// makes V(p,n) = 0.75 - 0.25 = 0.5 exactly (powers of two), so the negation is
// checkable to the last bit: -0.5, not 0.5 and not the probe left unchanged.
//
//! lrm 4.2.1
//! lrm 4.2.4
//! bias V(p) = 0.75
//! bias V(n) = 0.25
`include "check.vh"
module ch04_unary_minus(p, n);
  inout p, n;
  electrical p, n;
  analog begin
    `CHECKX("unary - negates a real probe", -V(p, n), -0.5);
    I(p, n) <+ -V(p, n);
  end
endmodule
