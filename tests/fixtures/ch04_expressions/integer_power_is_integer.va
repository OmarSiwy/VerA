// §4.2.1.3 Arithmetic conversion: "For operands, a common data type for each
// operand is determined before the operator is applied. If either operand is
// real, the other operand is converted to real." `**` is in Table 4-4 with the
// other arithmetic operators, so with NEITHER operand real the operation is an
// integer one — the rule's own `b = 1 / 2;` "is integer division and the
// result is 0" applies to `**` as it does to `/`. (§4.3.1's `pow()` is a
// different thing: a FUNCTION whose Table 4-14 row is real-valued.)
//
// VAMS gives no integer value table for `**`; IEEE 1364-2005 §5.1.5 does, and
// VAMS inherits it: "If neither operand of the power operator is real, then the
// result type shall be determined as outlined in 5.4.1 and 5.5.1 ... The result
// value is 1 if the second operand is zero", and Table 5-6 for a negative
// exponent: op1 > 1 or op1 < -1 gives 0, op1 = 1 gives 1, op1 = -1 gives -1
// for an odd and 1 for an even op2 (op1 = 0 is 'bx, which no analog integer
// can hold, so this file does not write it). The width is §3.2's: an integer
// holds -2**31 .. 2**31-1, two's complement.
//
// THE NUMBERS. `k` is 1 at the bias below (V(p) = 0, so `V(p) > 5.0` is 0), so
// nothing is folded away at compile time — every operand is a runtime value.
//
//   d = 2 ** k            = 2
//   7 / d                 = 3      integer division truncates (§4.2.4); a real
//                                  `**` made this 7 / 2.0 = 3.5
//   (-3) ** (k + 2)       = -27
//   2 ** (0 - k)          = 0      Table 5-6, op1 > 1, op2 negative
//   (-1) ** (0 - k)       = -1     Table 5-6, op1 = -1, op2 odd
//   (-1) ** (0 - 2*k)     = 1      op2 even
//   1 ** (0 - k)          = 1
//   0 ** (k - 1)          = 1      "1 if the second operand is zero"
//   2 ** (k + 30)         = -2147483648   2**31 in §3.2's 32 bits
//   2.0 ** k              = 2.0    one real operand: real
//   2 ** (0.0 - k)        = 0.5    likewise (a real exponent keeps the half)
//
// And in a constant expression, which must agree:
//   parameter integer q  = n ** 2,  n = 3      = 9
//   parameter real   rq  = 2 ** -1             = 0 (integer 0, then §4.2.1.2
//                                                 converts it to 0.0)
//   localparam integer h = 7 / (2 ** 1)        = 3
//
// The `d != 0` guard restricts the quotient assertion to nonzero divisors.
// A negative integer exponent could make `2 ** k` zero, although the stated
// bias selects k=1. This fixture makes no claim about division by zero;
// VerA's guarded integer-division policy is documented under E0601/W0653.
//
//! lrm 4.2.1.3
//! lrm 4.2.4
//! lrm 3.2
//! lrm 4.2.1.3:1000
//! inherited IEEE 1364-2005 5.1.5
//! bias V(p) = 0.0
`include "check.vh"
module integer_power_is_integer(p);
  inout p; electrical p;
  parameter integer n = 3;
  parameter integer q = n ** 2;
  parameter real rq = 2 ** -1;
  localparam integer h = 7 / (2 ** 1);
  integer k, d;

  analog begin
    k = 1 + (V(p) > 5.0);
    d = 2 ** k;
    `CHECKI("2 ** k", d, 2);
    `CHECKI("7 / (2 ** k) divides two integers", (d != 0) ? 7 / d : -1, 3);
    `CHECKI("(-3) ** 3", (-3) ** (k + 2), -27);
    `CHECKI("2 ** -1 truncates to 0", 2 ** (0 - k), 0);
    `CHECKI("(-1) ** -1", (-1) ** (0 - k), -1);
    `CHECKI("(-1) ** -2", (-1) ** (0 - 2 * k), 1);
    `CHECKI("1 ** -1", 1 ** (0 - k), 1);
    `CHECKI("0 ** 0", 0 ** (k - 1), 1);
    `CHECKI("2 ** 31 wraps at 32 bits", 2 ** (k + 30), -2147483648);
    `CHECKX("a real base keeps ** real", 2.0 ** k, 2.0);
    `CHECKX("a real exponent keeps ** real", 2 ** (0.0 - k), 0.5);
    `CHECKI("constant n ** 2", q, 9);
    `CHECKX("constant 2 ** -1 is integer 0", rq, 0.0);
    `CHECKI("constant 7 / (2 ** 1)", h, 3);
    I(p) <+ V(p) / 1k;
  end
endmodule
