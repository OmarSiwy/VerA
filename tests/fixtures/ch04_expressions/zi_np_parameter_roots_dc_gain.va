// §4.5.12.3 zi_np with its poles from a parameter ARRAY, so VerA pairs them
// as the model is evaluated (`zRootSecs`, the §4.5.12 z⁻¹ form):
//
//   H(z) = 1 / ((1 − z⁻¹ρ)(1 − z⁻¹ρ*)),  ρ = 0.5 + 0.25j.
//
// HAND DERIVATION. The pair multiplies out to 1 − 2·Re(ρ)z⁻¹ + |ρ|²z⁻²
// = 1 − z⁻¹ + 0.3125z⁻². A static analysis is z = 1 (155_zi_dc_gains.va says
// why), so H(1) = 1/(1 − 1 + 0.3125) = 3.2, and V(in) = 1 reads 3.2.
//
//! lrm 4.5.12.3
//! lrm 4.5.12
//! lrm 4.5.12:4
//! bias V(in) = 1
//! bias V(n) = 0
//! checks 1
`include "check.vh"
module zi_np_parameter_roots_dc_gain(in, n);
  inout in, n;
  electrical in, n;
  parameter real r[0:3] = '{0.5, 0.25, 0.5, -0.25};
  analog begin
    `CHECK("zi_np with parameter-array poles is H(1) = 3.2 at DC",
           zi_np(V(in, n), '{1.0}, r, 1e-9), 3.2, 1e-12);
    I(in, n) <+ 0.0;
  end
endmodule
