// §4.5.11.4 laplace_nd — both sides as polynomial coefficients.
//
//     H(s) = Σ(k=0..M-1) nk·s^k / Σ(k=0..N-1) dk·s^k
//
// At s = 0 that is n0/d0 exactly. With n = {6.0} and d = {3.0, 1n} it is 2 —
// and the 1 ns coefficient is on s^1, so it is the filter's time constant and
// contributes nothing to the DC gain. A discretization that folded the
// timestep into the constant term would move this number.
//
// `exhaustive/066_laplace_dc_gain.va` runs the same transfer function through a
// TRANSIENT and asserts it settles to the same gain from a step. This one is
// the static half: `//! analysis dc` makes dt zero, so the answer is the gain
// itself and not something converging to it, and the two together say the
// discretization agrees with the clause at both ends.
//
// Corrected 2026-10-08 (construct only, the wants are unchanged): the
// coefficient vectors were VAMS 2.x concatenations, `{...}`. A.8.2's
// analog_filter_function_arg is a parameter, a part of one or a `'{...}`
// assignment pattern (annex G: "Add apostrophe before opening { in list of
// values"), and a concatenation there is E0572
// (reject_4_5_11_concatenation_coefficients.va), so each is now `'{...}`.
//
//! lrm 4.5.11.4
//! lrm 4.5.11
//! analysis dc
//! bias V(in) = 1.0
//! bias V(n) = 0.0
`include "check.vh"
module ch04_laplace_nd_dc_gain(in, n);
    inout in, n;
    electrical in, n;
    real y, y_second_order;

    analog begin
        y = laplace_nd(V(in, n), '{6.0}, '{3.0, 1n});
        // Second order, and a numerator with s^1 and s^2 terms that must all
        // drop out: H(0) is still n0/d0 = 6/3.
        y_second_order = laplace_nd(V(in, n), '{6.0, 2n, 1e-18}, '{3.0, 1n, 1e-18});
        `CHECKX("H(0) = n0/d0, first order", y, 2.0);
        `CHECKX("H(0) = n0/d0, second order — the s^k>0 terms drop out", y_second_order, 2.0);
        I(in, n) <+ 0.0;
    end
endmodule
