// §4.6.4.6: "Perfectly correlated noise is generated by using the output of
// one noise function for more than one noise source", and the clause's own
// spelling holds that output in a variable: `n = white_noise(pwr);`. A
// declaration initializer is the same assignment made at the declaration
// (`real w = white_noise(pwr, "dec");`), so the variable must carry the
// generator the same way and the device must export it.
//
// The block declares w with an initializer and assigns u the assignment way,
// with powers 4e-21 and 2e-21 and labels "dec" and "asg"; both reach branch
// (p,n). §4.6.4.1 white noise of power pwr has PSD pwr, so the generator
// table holds two thermal rows on (p,n): #0 "dec" 4e-21 and #1 "asg" 2e-21,
// in source order. A tool that dropped the initializer's generator exports
// only "asg". §4.6: "When not active, the small-signal source functions
// return zero (0).", so at the operating point I(p,n) is the
// resistive V(p,n)/1000 = 1e-3 alone. There is no invalid input: a noise
// function is legal in any analog expression that §4.6.4 allows (the
// refusals of a noise function in a disallowed place are other fixtures).
//! lrm 4.6.4.1
//! lrm 4.6.4.6
//! noise thermal(p,n)#0 name=dec white=4e-21
//! noise thermal(p,n)#1 name=asg white=2e-21
//! analysis noise
//! bias V(p) = 1.0
//! bias V(n) = 0.0
//! checks 9
`include "check.vh"
module white_noise_declaration_initializer(p, n);
  inout p, n;
  electrical p, n;
  analog begin : b
    real w = white_noise(4e-21, "dec");
    real u;
    u = white_noise(2e-21, "asg");
    `CHECKX("the noise terms are zero at the operating point", w + u, 0.0);
    `CHECKR("the dc current is the resistive term alone", V(p, n) / 1000.0, 1e-3, 1e-15);
    I(p, n) <+ V(p, n) / 1000.0 + w + u;
  end
endmodule
