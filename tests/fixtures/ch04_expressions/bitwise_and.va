// LRM 4.2.9 Table 4-9: `&` combines each bit of one operand with the
// corresponding bit of the other.
//
//   5 = ...0101
//   3 = ...0011
//   & = ...0001 = 1
//
// The second line is what keeps `&` from being read as `&&`: 4 & 2 is
// 0100 & 0010 = 0, while the logical 4 && 2 would be 1.
//
//! lrm 4.2.9
//! lrm 4.2.9:1001
`include "check.vh"
module ch04_bitwise_and(p, n);
    inout p, n;
    electrical p, n;
    integer a;

    analog begin
        a = 5 & 3;
        `CHECKI("0101 & 0011 = 0001", a, 1);
        `CHECKI("0100 & 0010 = 0, unlike 4 && 2 = 1", (4 & 2), 0);
        I(p, n) <+ a;
    end
endmodule
