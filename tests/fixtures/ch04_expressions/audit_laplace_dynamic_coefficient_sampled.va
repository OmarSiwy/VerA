// AMS 4.5.14: "If a dynamic expression is passed as an argument which expects
// a constant expression, the value of the dynamic expression at the start of
// the analysis defaults to the constant value of the argument. Any further
// change in value of that expression is ignored during the iterative
// analysis." Table 4-20 lists laplace_nd's numerator and denominator as
// constant expression arguments. The clause's editorial note adds that "a
// blanket rejection requirement must not be inferred from the column heading
// alone".
//
// audit_absdelay_dynamic_maxdelay_sampled.va pins absdelay's maxdelay slot;
// this is a filter-coefficient slot. The numerator is the probe V(k, n),
// whose wave is 2 V at the first two points and 5 V after. Sampled at the
// analysis start, the filter is the constant gain H(s) = 2 / 1 = 2, and with
// the constant input 1.0 its output is 2.0 at every point (a zero-order
// filter has no state to settle, so the DC and transient values agree).
// Resampling the coefficient gives 5.0 at the last two points.
//
// Corrected 2026-10-08 (construct only, the wants are unchanged): the
// coefficient vectors were VAMS 2.x concatenations, `{...}`. A.8.2's
// analog_filter_function_arg is a parameter, a part of one or a `'{...}`
// assignment pattern (annex G: "Add apostrophe before opening { in list of
// values"), and a concatenation there is E0572
// (reject_4_5_11_concatenation_coefficients.va), so each is now `'{...}`.
//
//! lrm 4.5.14
//! lrm 4.5.11.4
//! checks 4
//! bias V(n) = 0
//! wave V(k) = 2, 2, 5, 5
//! time 0, 1n, 2n, 3n
//! analysis tran
`include "check.vh"
module audit_laplace_dynamic_coefficient_sampled(k, n);
    inout k, n;
    electrical k, n;
    analog begin
        `CHECK("numerator sampled at the analysis start", laplace_nd(1.0, '{V(k, n)}, '{1.0}), 2.0, 1e-12);
        I(k, n) <+ 0.0;
    end
endmodule
