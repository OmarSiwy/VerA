// §4.2: "The symbols for the Verilog-AMS HDL operators are similar to those in
// the C programming language. Table 4-1 lists these operators." This file
// applies every row of Table 4-1 that an analog block may use once, to integer
// operands, and checks each result against a value worked out by hand. The
// individual rows have their own clauses and fixtures (§4.2.4-§4.2.13); this is
// the table as a whole, so a row that stopped parsing or started meaning a
// neighbouring row fails here.
//
// Two groups of rows are left out ON PURPOSE, because the LRM excludes them
// from this context: §4.2.10 "The reduction operators can not be used inside
// the analog block", and §4.2.11 "The arithmetic shift operators can not be
// used in an analog block". Both are refused here (E0348, E0324), and their
// own clauses' reject fixtures pin that.
//
// a = 12 = 1100b, b = 10 = 1010b, both 32-bit signed `integer`s (§3.2).
//
//   {} {{}}   {2'b11, 2'b01} = 1101b = 13      {2{2'b10}} = 1010b = 10
//   unary     +a = 12    -a = -12
//   arith     a+b = 22   a-b = 2   a*b = 120   a/b = 1 (§4.2.4 truncation)
//             a**2 = 144
//   %         a%b = 2
//   relat.    a>b = 1  a>=b = 1  a<b = 0  a<=b = 0
//   logical   !a = 0   a&&0 = 0   a||0 = 1
//   equality  a==b = 0   a!=b = 1   a===12 = 1   a!==b = 1
//   bitwise   ~a = -13 (two's complement)   a&b = 1000b = 8   a|b = 1110b = 14
//             a^b = 0110b = 6   a^~b = ~6 = -7
//   shifts    a<<2 = 48   a>>2 = 3
//   ?:        (a > b) ? 7 : 9 = 7
//
// Every value is an integer, so CHECKI (exact) throughout.
//
//! lrm 4.2
//! lrm 4.2:1000
//! bias V(p) = 1.0
`include "check.vh"
module ch04_table_4_1_every_operator(p, n);
    inout p, n;
    electrical p, n;
    integer a, b, c, r;

    analog begin
        a = 12;
        b = 10;
        c = {2'b11, 2'b01};
        r = {2{2'b10}};
        `CHECKI("{} concatenation", c, 13);
        `CHECKI("{{}} replication", r, 10);
        `CHECKI("unary +", +a, 12);
        `CHECKI("unary -", -a, -12);
        `CHECKI("+", a + b, 22);
        `CHECKI("-", a - b, 2);
        `CHECKI("*", a * b, 120);
        `CHECKI("/ truncates", a / b, 1);
        `CHECKI("**", a ** 2, 144);
        `CHECKI("%", a % b, 2);
        `CHECKI(">", a > b, 1);
        `CHECKI(">=", a >= b, 1);
        `CHECKI("<", a < b, 0);
        `CHECKI("<=", a <= b, 0);
        `CHECKI("!", !a, 0);
        `CHECKI("&&", a && 0, 0);
        `CHECKI("||", a || 0, 1);
        `CHECKI("==", a == b, 0);
        `CHECKI("!=", a != b, 1);
        `CHECKI("===", a === 12, 1);
        `CHECKI("!==", a !== b, 1);
        `CHECKI("~", ~a, -13);
        `CHECKI("& bitwise", a & b, 8);
        `CHECKI("| bitwise", a | b, 14);
        `CHECKI("^ bitwise", a ^ b, 6);
        `CHECKI("^~ bitwise", a ^~ b, -7);
        `CHECKI("<<", a << 2, 48);
        `CHECKI(">>", a >> 2, 3);
        `CHECKI("?:", (a > b) ? 7 : 9, 7);
        I(p, n) <+ V(p, n) * 1.0e-3;
    end
endmodule
