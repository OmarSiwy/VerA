// A.8.1 spells the replication form of an assignment pattern as
//
//     assignment_pattern ::= '{ constant_expression { expression { , expression } } }
//
// and §4.2.14's example `'{ 5{0.0} }` writes the count as a literal, but the
// production says constant_expression, and §3.4 makes a parameter one ("an
// expression containing only constant numbers and previously defined
// parameters"). So the count may be written over a localparam.
//
// N = 2 and M = N + 1 = 3, both folded by hand:
//
//   steps = '{M{1.25}}              -> [1.25, 1.25, 1.25]
//   grid  = '{N{V(p,n), 0.5}}       -> [0.75, 0.5, 0.75, 0.5]   (V(p,n) = 0.75)
//   sq    = '{N{ '{M{2.5}} }}       -> two rows of three 2.5s
//
// The LAST element of each is checked, because a count applied once instead of
// N or M times leaves it at §3.2's default 0.0; grid's order also tells the
// group [V, 0.5] repeated apart from each element repeated in place.
// assignment_pattern_replication_count_variable_rejected.va is the illegal
// neighbour, a count read from a variable.
//
//! lrm 4.2.14
//! lrm A.8.1
//! lrm 4.2.14:1000
//! lrm A.8.1:1000
//! bias V(p) = 0.75
//! bias V(n) = 0.0
`include "check.vh"
module ch04_pattern_repl_count_over_parameter(p, n);
    inout p, n;
    electrical p, n;
    localparam integer N = 2;
    localparam integer M = N + 1;
    parameter real steps[0:2] = '{M{1.25}};
    real grid[0:3];
    real sq[0:1][0:2] = '{N{ '{M{2.5}} }};

    analog begin
        grid = '{N{V(p, n), 0.5}};
        `CHECKX("'{M{1.25}} fills the first element", steps[0], 1.25);
        `CHECKX("and the M-th, M = N + 1 = 3", steps[2], 1.25);
        `CHECKX("'{N{V, 0.5}} repeats the group: element 0", grid[0], 0.75);
        `CHECKX("element 1", grid[1], 0.5);
        `CHECKX("the second copy of the group: element 2", grid[2], 0.75);
        `CHECKX("element 3, the last", grid[3], 0.5);
        `CHECKX("nested: the first row", sq[0][0], 2.5);
        `CHECKX("nested: the last cell of the last row", sq[1][2], 2.5);
        I(p, n) <+ steps[0] * V(p, n);
    end
endmodule
