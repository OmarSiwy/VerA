// LRM 4.2.14 prints this example itself:
//
//     parameter real data2[0:4] = '{ 5{0.0} };
//
// with the explanation "The example also uses a replication operator to repeat
// 0.0 five times so that every element of data2 is assigned to 0.0."
//
// This is the ASSIGNMENT-PATTERN replication and not the concatenation
// replication of 4.2.13 that 31_replication.va covers: `'{ 5{x} }` repeats an
// element of an array initializer, `{5{x}}` repeats a bit pattern. 4.2.13 is
// explicit that the two braces mean different things — the assignment pattern
// "should not be confused with" a concatenation — so a parser that routed one
// through the other's rule is exactly what this catches.
//
// The wants are 4.2.14's own: every element of the array is 0.0, and the
// declared range [0:4] means there are five of them, so both ends read 0.0. A
// non-zero second array is declared alongside so that a lowering which zeroed
// everything cannot pass on that alone.
//
//! lrm 4.2.14
//! xfail VerA's parser has no replication inside an assignment pattern: `'{5{0.0}}` stops at E0207 "unexpected token: found `{`", the same gap 31_replication.va records for the concatenation form
`include "check.vh"
module ch04_assignment_pattern_replication(p, n);
    inout p, n;
    electrical p, n;
    parameter real data2[0:4] = '{ 5{0.0} };
    parameter real data3[0:2] = '{ 3{2.5} };

    analog begin
        `CHECKX("LRM 4.2.14: '{5{0.0}} fills the first element", data2[0], 0.0);
        `CHECKX("LRM 4.2.14: '{5{0.0}} fills the last element too", data2[4], 0.0);
        `CHECKX("a replication of a non-zero element", data3[1], 2.5);
        I(p, n) <+ data2[0] + data3[2];
    end
endmodule
