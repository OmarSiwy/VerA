// LRM 4.3.1 Table 4-14 pow(x,y) with a sign-spanning base and an even integer
// exponent: over x from [-2:2], pow(x, 2.0) ranges over [0, 4] — the minimum
// sits at the INTERIOR point x = 0, not at a range corner (both corners give
// 4). A compiler that evaluates only corners concludes pow(x,2) == 4 exactly
// and, from that fabrication, REJECTED ln(2.0 - pow(x, 2.0)) as a 4.3.2 domain
// error ("known range [-2:-2]") — refusing every legal card: any |x| < sqrt(2)
// keeps the argument in ln's x > 0 domain, x = 1.0 below giving ln(1).
//
// The truth is undecidable at compile time (cards with |x| > sqrt(2) do put
// the argument out of domain), and 4.3.2 obliges an error only for a value
// that IS out of range — so the conforming verdict is to accept and evaluate.
//
// The default x = 1.0 makes every step exact in IEEE 754 binary:
//   pow(1.0, 2.0) = 1.0,  2.0 - 1.0 = 1.0,  ln(1.0) = 0.0
// so the want is the exact-equality kind. 85_pow.va owns the in-domain corner
// arithmetic of pow; this fixture owns the interior-minimum acceptance.
//
//! lrm 4.3.1
//! lrm 4.3.2
`include "check.vh"
module ch04_pow_even_exponent_accepted(p, n);
    inout p, n;
    electrical p, n;
    parameter real x = 1.0 from [-2:2];

    analog begin
        `CHECKX("ln(2 - pow(x,2)) at the card default is ln(1) = 0", ln(2.0 - pow(x, 2.0)), 0.0);
        I(p, n) <+ ln(2.0 - pow(x, 2.0)) * V(p, n);
    end
endmodule
