// §9.17.1 $discontinuity:
//
//   "$discontinuity(i) implies a discontinuity in the i'th derivative of the
//    constitutive equation with respect to either a signal value or time WHERE
//    i MUST BE A NON-NEGATIVE INTEGER."
//
// §3.3 String data type, on what may and may not become one:
//
//   "A string literal can be assigned to a string or an integral type. ...
//    A STRING CANNOT BE ASSIGNED TO AN INTEGRAL TYPE."
//
// The two sentences of §3.3 are deliberately not the same rule, and this
// fixture sits on the second one. A string LITERAL is still a Verilog packed
// bit vector — `$discontinuity("two")` would convert to the integer 0x74776F
// and is a legal, if useless, degree — so the literal spelling is NOT a
// rejection and is not what is written below. A `string`-typed operand is a
// different object with no integral conversion at all, so `deg` cannot be the
// non-negative integer §9.17.1 requires and the call has no meaning.
//
// §3.4.6 makes a string parameter a constant expression, so this passes
// §9.17.1's `constant_expression` requirement and fails only on the type —
// which is the point: the diagnostic has to be about the TYPE, not about
// constness (E0805 already covers a non-constant degree in
// tests/fixtures/ch09_system_tasks/139_discontinuity_nonconstant_rejected.va).
//
// WHAT HAPPENS TODAY: it compiles, silently, as degree 0. `Const.asInt`
// (`lib/ir/lower.zig:800`) has the arm
//
//   .str => 0,
//
// and `lowerKernelCtl` takes that 0 as the announced degree. A model that names
// its discontinuity degree through a mistyped parameter therefore gets the most
// severe announcement there is, with no warning, and the author never learns
// the argument was ignored. Reproduced: `vera --emit-zig` exits 0 and emits a
// device.
//
// THE TAG. It used to be `//! reject $discontinuity`, which any diagnostic
// quoting this module's one statement satisfies. The refusal owed is §9.17.1's
// degree rule, which already has a code: E0820 "$discontinuity degree must be
// nonnegative or -1". A string is not a nonnegative integer.
//
//! lrm 9.17.1
//! lrm 3.3
//! lrm 3.4.6
//! reject E0820
//! xfail VerA accepts a `string` parameter as the degree of $discontinuity and lowers it to 0 (Const.asInt has a `.str => 0` arm), so §9.17.1's "i must be a non-negative integer" and §3.3's "A string cannot be assigned to an integral type" are both unchecked and the model gets the most severe announcement there is, silently
module a01_discontinuity_string_degree_rejected(p, n);
  inout p, n;
  electrical p, n;
  parameter string deg = "two";

  analog begin
    $discontinuity(deg);
    I(p, n) <+ V(p, n);
  end
endmodule
