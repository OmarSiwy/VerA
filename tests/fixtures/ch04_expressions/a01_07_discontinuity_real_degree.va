// §9.17.1 $discontinuity, argument conversion.
//
//   "$discontinuity [ ( constant_expression ) ] ;
//    where constant_expression indicates the degree of the discontinuity if the
//    argument to $discontinuity is non-negative, i.e. $discontinuity(i) implies
//    a discontinuity in the i'th derivative of the constitutive equation ...
//    A special form of the $discontinuity task, $discontinuity(-1), is used with
//    the $limit() function so -1 is also a valid argument of $discontinuity."
//
// The clause says `constant_expression`, not `constant_integer_expression`, and
// §4.2.1.1 is the rule that turns one into the other:
//
//   "Real numbers are converted to integers by rounding the real number to the
//    nearest integer, rather than by truncating it."
//
// -1.0 is exactly representable in IEEE 754 and its nearest integer is -1 with
// no rounding involved at all, so `$discontinuity(-1.0)` IS the -1 form, and
// §9.17.3's rule for it applies unchanged:
//
//   "the user-defined function shall call $discontinuity(-1) ... when its
//    return value is not sufficiently close to the value of its first argument"
//
// i.e. the current Newton iterate is vetoed and another iteration is run.
//
// THE DERIVATION, by hand.
//
//   The device contributes I(p,n) = V(p,n) - 1e-10 with `//! solve`, so the one
//   free unknown settles where the current is zero: V(p,n) = 1e-10 exactly, in
//   a single Newton step from the harness's zero start (the residual is affine,
//   so the first correction is exact).
//
//   The guard `$simparam("iteration") == 1 && V(p,n) > 0.0` therefore fires on
//   the FIRST iteration and on no other. It calls $discontinuity(-1.0), which
//   vetoes that iterate; iteration 2 runs, the guard is false, nothing vetoes,
//   and the point is accepted. So `$simparam("iteration")` reads exactly 2 in
//   the accepted solution — not 1 (the conversion was dropped and the veto
//   never happened) and not 3 or more (the veto repeated).
//
//   The unconditional `$discontinuity(2.0)` above it is the non-negative half
//   of the same conversion rule: 2.0 converts to the degree 2, an ordinary
//   hint. §9.17.1 says a hint "does not directly specify the behavior of the
//   module", so it must NOT veto — and if it did, it would veto on every
//   iteration and the solve would run to its iteration limit instead of
//   stopping at 2. That is what makes the `iteration == 2` want sensitive to
//   both halves at once.
//
//   The tolerance on the iteration count is 0.0: it is a count, and `CHECK`
//   with a zero tolerance is exact equality on a value $simparam returns as a
//   real. The voltage is checked to 1e-18, twelve orders below a value that is
//   itself reached exactly, so the tolerance decides nothing.
//
// WHAT THIS FIXTURE DOES NOT PIN. The degree of a NON-negative $discontinuity
// is not observable from a .va file: VerA lowers it to `inst.discontinuity_order`
// and neither `lib/backend/tb.zig` nor ARPice reads that field back, so
// `$discontinuity(2.0)` and `$discontinuity(0)` are indistinguishable here. The
// assertion above pins that 2.0 is ACCEPTED and is not a veto, which is as far
// as the source language can see.
//
// STATUS: THIS ONE PASSES (re-run 2026-10-04 at ae9633f1 with AGENTS.md
// §6's `vera --emit-exe` command). `Const.asInt`
// (`lib/frontend/constfold.zig`) applies
// §4.2.1.1 with `@intFromFloat(@round(r))` and the -1 arm of `lowerKernelCtl`
// then takes over, so the conversion is already right for a finite, in-range
// real. It is written down because nothing in tests/fixtures/ says so — every
// existing $discontinuity fixture passes an integer literal — and because the
// two reject fixtures in this row (90, 91) are about the arguments that same
// line gets WRONG, so the line needs a positive pin before it is touched.
//
//! lrm 9.17.1
//! lrm 4.2.1.1
//! lrm 9.17.3
//! solve
//! bias V(n) = 0
//! print none
`include "check.vh"
module a01_discontinuity_real_degree(p, n);
  inout p, n;
  electrical p, n;

  analog begin
    // Non-negative half: 2.0 -> degree 2, a hint, never a veto.
    $discontinuity(2.0);
    // -1 half, spelled as a real: the §9.17.3 iteration veto.
    if ($simparam("iteration") == 1 && V(p, n) > 0.0)
      $discontinuity(-1.0);

    I(p, n) <+ V(p, n) - 1e-10;

    `CHECK("$discontinuity(-1.0) converts to -1 and vetoes exactly one iteration",
           $simparam("iteration"), 2.0, 0.0);
    `CHECK("and the vetoed solve still lands on the same operating point",
           V(p, n), 1e-10, 1e-18);
  end
endmodule
