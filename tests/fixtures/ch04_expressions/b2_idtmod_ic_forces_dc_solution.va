// §4.5.5 idtmod: "The initial condition is optional. If the initial condition
// is not specified, it defaults to zero (0). Regardless, the initial condition
// shall force the DC solution to the system."
//
// The integrand V(p, n) = 0.7 is NONZERO here, so a DC answer cannot come from
// "the value that makes expr equal to zero" (Table 4-19's one-argument case,
// not used here: 4.5.5:1 is in doubt). The ic forces the DC value.
//
// HAND DERIVATION. In DC the integral from t0 to t0 is 0, so Table 4-19's
// "integral + c = n * modulus + k" has integral + c = ic, and k is ic reduced
// into [offset, offset + modulus), the range §4.5.5 says the output "shall
// remain in".
//   idtmod(x, 0.25, 1.0)        ic in range        -> 0.25
//   idtmod(x, 0.25)             no modulus: §4.5.5 "shall behave like idt()",
//                               no limit            -> 0.25
//   idtmod(x, 1.25, 1.0)        1.25 = 1 * 1.0 + 0.25 -> 0.25
//   idtmod(x, -0.75, 1.0, -0.5) k in [-0.5, 0.5): -0.75 = -1 * 1.0 + 0.25 -> 0.25
// All exact in binary64, so CHECKX.
//
//! lrm 4.5.5
//! lrm 4.5.5:2
//! lrm 4.5.5:1
//! analysis dc
//! bias V(p) = 0.7
//! bias V(n) = 0.0
//! checks 4
`include "check.vh"
module b2_idtmod_ic_forces_dc_solution(p, n);
    inout p, n;
    electrical p, n;
    real y1, y2, y3, y4;

    analog begin
        y1 = idtmod(V(p, n), 0.25, 1.0);
        y2 = idtmod(V(p, n), 0.25);
        y3 = idtmod(V(p, n), 1.25, 1.0);
        y4 = idtmod(V(p, n), -0.75, 1.0, -0.5);
        `CHECKX("idtmod(x, 0.25, 1.0) in DC is the ic", y1, 0.25);
        `CHECKX("idtmod(x, 0.25) in DC is the ic", y2, 0.25);
        `CHECKX("idtmod(x, 1.25, 1.0) in DC is the ic reduced modulo 1", y3, 0.25);
        `CHECKX("idtmod(x, -0.75, 1.0, -0.5) in DC is the ic reduced into [-0.5, 0.5)", y4, 0.25);
        I(p, n) <+ 1e-3 * (y1 + y2 + y3 + y4) * V(p, n);
    end
endmodule
