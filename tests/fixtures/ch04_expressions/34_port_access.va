// §4.4 Table 4-16, last row: `I(<p1>)` "accesses the current flow into the
// module through port p1". It is a DIFFERENT quantity from every other row of
// that table — in particular from `V(p)` (the potential of the port relative to
// ground) and from `I(p)` (the flow in the unnamed branch from p to ground).
// §3.12.1 says the same thing structurally: the port branch is the branch
// between the upper and lower connections of the port, so it carries its own
// unknown. §5.4.3 adds that a port access function is read-only — it may not
// appear on the left of `<+`, which is why the contribution below drives `I(p)`
// and merely reads `I(<p>)`.
//
// The operating point imposes the two quantities separately: the port branch
// flow at 0.375 A and the port potential at 0.25 V. Both are exact in IEEE 754
// (3/8 and 1/4), so exact equality is the right claim, and picking two
// different values is the whole point — an implementation that resolved
// `I(<p>)` to the node potential, or to a fresh zero unknown, fails the first
// check rather than agreeing with itself.
//
//! lrm 4.4
//! lrm 4.4:1
//! bias flowZ28Z3cpZ3eZ29 = 0.375
//! bias V(p) = 0.25
`include "check.vh"
module ch04_port_access(p);
    inout p;
    electrical p;

    analog begin
        `CHECKX("I(<p>) is the flow into the module through port p", I(<p>), 0.375);
        `CHECKX("V(p) is a different row of Table 4-16", V(p), 0.25);
        I(p) <+ I(<p>);
    end
endmodule
