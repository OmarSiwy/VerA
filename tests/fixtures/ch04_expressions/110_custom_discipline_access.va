// LRM 4.4, the legal half of the rule 87_wrong_discipline_access.va pins the
// violation of: "The name of the access function for a signal is taken from the
// discipline of the net, port, or branch", and "If the signal or port access
// function is used in an expression, the access function returns the value of
// the signal."
//
// `p` is `ch4_custom_d`, whose potential nature declares `access = CustomV` and
// whose flow nature declares `access = CustomI` (3.6.2.1). Renaming the access
// function changes its NAME and nothing else: `CustomV(p)` is still the
// potential of p relative to ground, so at the bias below it is 0.7 — the same
// number `V(p)` would have read on an electrical net.
//
// 0.7 is not a dyadic rational, but the value is the same double all the way
// through (literal -> bias -> probe), so exact equality is the right claim: a
// tool that routed a custom access function through a conversion would fail it.
//
// The `V(p)` on the bias line is NOT the source-level access function — the
// whole point of this file is that p does not have one called `V`. `//!`
// directives are harness notation (lib/backend/tb.zig), where `V(name)` and
// `I(name)` are the fixed spellings for "the potential of" and "the flow
// through" whatever the net's discipline calls them.
//
//! lrm 4.4
//! lrm 4.4:1002
//! bias V(p) = 0.7
`include "check.vh"
nature ch4_c110_p; units="V"; access=CustomV; abstol=1u; endnature
nature ch4_c110_f; units="A"; access=CustomI; abstol=1p; endnature
discipline ch4_c110_d; potential ch4_c110_p; flow ch4_c110_f; enddiscipline
module ch4_custom_discipline_access(p);
  inout p;
  ch4_c110_d p;
  analog begin
    `CHECKX("CustomV(p) reads p's potential relative to ground", CustomV(p), 0.7);
    CustomI(p) <+ 1.0m;
  end
endmodule
