// §4.6.4.6's coefficient when the scaled generator passes through a §5.8 `if`
// or a §4.2.12 `?:`. The clause's Example 1:
//
//     n = white_noise(pwr);
//     V(a,b) <+ c1*n;
//     V(c,d) <+ c2*n;
//
// "Perfectly correlated noise is generated by using the output of one noise
// function for more than one noise source." A noise function's output is an
// AMPLITUDE and `c1*n` scales it, so the branch density is c1²·pwr — the rule
// a06_noise_correlated_scale.va pins for a factor written on the contribution.
// Nothing in §4.6.4 or §5.8 lets the factor stop being a factor because the
// statement that applied it sat under a condition: §5.8's `if` executes one
// arm, and whichever arm executed is the one whose factor the branch carries.
// §4.2.12's `?:` likewise evaluates to one of its two operands.
//
// THE NUMBERS. pwr = 1e-18 A²/Hz, sel = 1, r = 4.0; every factor is exact in
// binary64.
//
//   (a,b)  if (sel > 0) y = 3.0*n1; else y = 5.0*n1;   sel > 0: y = 3·n1
//          density 3² · 1e-18 = 9e-18
//   (c,d)  z = (sel < 0 ? 3.0 : 5.0) * n2;             sel < 0 false: 5·n2
//          density 5² · 1e-18 = 2.5e-17
//   (e,f)  if (sel > 0) w = n3 / r; else w = n3;       sel > 0: n3/4
//          density (1/4)² · 1e-18 = 0.0625 · 1e-18 = 6.25e-20
//
// Each is a different wrong answer away from the right one. A coefficient
// that falls back to 1 when the generator passes through a join — what VerA
// exported before — gives 1e-18 on all three rows (9x, 25x and 16x off). A
// coefficient taken from the wrong arm gives 2.5e-17, 9e-18 and 1e-18.
// The third row is the arm whose coefficient 1/r has to be COMPUTED, not read
// off a literal.
//
// `sel` is a parameter, not a literal, so no reading of §5.8 lets a compiler
// drop the untaken arm at elaboration: the host may override it.
//
// The generators get separate names and so separate identities (#0..#2): the
// rows are not correlated with each other, and each carries its own factor.
//
// The claim lives on the three `//! noise` lines. The three `CHECKX`s are the
// weaker companion a06_noise_correlated_scale.va explains: §4.5.6's ddx of each
// contributed current with respect to its own node is the resistor's 1/1k and
// nothing else, so a lowering that let a generator through a join into the
// linearization moves them. 1.0/1000.0 and the literal 1e-3 are the same
// binary64 value (both are the correctly rounded 0.001), so they are exact.
//
//! lrm 4.6.4.6
//! lrm 4.6.4.1
//! lrm 5.8
//! lrm 4.2.12
//! noise thermal(a,b)#0 name=n1 white=9e-18
//! noise thermal(c,d)#1 name=n2 white=2.5e-17
//! noise thermal(e,f)#2 name=n3 white=6.25e-20
//! analysis noise
//! bias V(a) = 0.0
//! bias V(b) = 0.0
//! bias V(c) = 0.0
//! bias V(d) = 0.0
//! bias V(e) = 0.0
//! bias V(f) = 0.0
`include "check.vh"
module a06_noise_coefficient_through_a_conditional(a, b, c, d, e, f);
    inout a, b, c, d, e, f;
    electrical a, b, c, d, e, f;
    parameter real pwr = 1e-18 from [0:inf);
    parameter integer sel = 1;
    parameter real r = 4.0 from (0:inf);
    real n1, n2, n3, y, z, w;

    analog begin
        n1 = white_noise(pwr, "n1");
        n2 = white_noise(pwr, "n2");
        n3 = white_noise(pwr, "n3");

        if (sel > 0) y = 3.0 * n1; else y = 5.0 * n1;
        z = (sel < 0 ? 3.0 : 5.0) * n2;
        if (sel > 0) w = n3 / r; else w = n3;

        `CHECKX("the if-scaled generator stays out of (a,b)'s linearization", ddx(V(a, b) / 1k + y, V(a)), 1e-3);
        `CHECKX("the ?:-scaled one out of (c,d)'s", ddx(V(c, d) / 1k + z, V(c)), 1e-3);
        `CHECKX("the arm-computed one out of (e,f)'s", ddx(V(e, f) / 1k + w, V(e)), 1e-3);

        I(a, b) <+ V(a, b) / 1k + y;
        I(c, d) <+ V(c, d) / 1k + z;
        I(e, f) <+ V(e, f) / 1k + w;
    end
endmodule
