// §4.6.3 PHASE — the half of the AC stimulus that no scalar can hold.
//
// "When the name of the small-signal analysis matches analysis_name, the source
// becomes active and models a source with magnitude mag and phase phase. The
// default magnitude is one (1) and the default phase is zero (0). phase is
// given in radians."
//
// A small-signal source is a phasor, mag·e^(j·phase), and only phase 0 and
// phase π land on the real axis. `a06_ac_stim_ac_analysis.va` pins those two
// because a `CHECK` can hold them; everything else has an imaginary part, and
// an imaginary part cannot survive a real-valued read. So this fixture asserts
// the EXPORT — the (magnitude, phase) pair the device hands the host that
// solves the complex system — and asserts nothing about any value the model can
// read back, on purpose: blessing the real part as "the value of ac_stim" is
// precisely the error under test.
//
// THE NUMBERS. Two stimuli, on two branches:
//
//   (p,n)   mag 2.0, phase π/3 = 1.0471975511965976 rad = 60°
//             real = 2·cos(60°) = 1.0
//             imag = 2·sin(60°) = √3 = 1.7320508075688772
//   (q,n)   mag 1.0, phase π/2 = 1.5707963267948966 rad = 90°
//             real = 0.0
//             imag = 1.0
//
// The second is the sharp one: a pure quadrature source. Its real part is zero,
// so a device that transfers only the real part transfers NOTHING — the source
// disappears from the analysis and the branch's ac response is identically zero
// instead of being in quadrature with the first branch's. That is not a
// rounding error; it is a missing excitation.
//
// The 60° case separates "phase dropped" from "phase truncated to its cosine":
// dropping the phase gives (2.0, 0.0), truncating gives (1.0, 0.0), and the
// clause requires (1.0, 1.7320508075688772). All three are distinguishable.
//
// TODAY. `lib/backend/codegen.zig` lowers `ac_stim` to `mag * @cos(phase)` and
// says so in its own comment: "the residual is REAL, so a matching analysis
// contributes the phasor's real part, mag·cos(phase). The quadrature component
// is dropped … Upgrade path is an `ac_gens` export beside `noise_gens`, carrying
// (mag, phase) for a host that solves a complex system." There is no such
// export, so this fixture has nothing to read and fails today at
// `//!` directive: UnknownDirective on the two `//! acstim` lines.
//
// WHERE THIS FIXTURE'S CLAIM LIVES, AND WHY NO `CHECK` HOLDS IT.
// An earlier draft carried three `CHECK`s — `2*cos(π/3)`, `2*sin(π/3)`,
// `cos(π/2)` — and its own header said they "do not touch `ac_stim`" (and
// miscounted them as two). That was accurate and disqualifying: arithmetic over
// literals is true of every compiler, so not one of those lines could go red
// for a §4.6.3 reason. They are gone.
//
// They are NOT replaced by a `CHECK` on `ac_stim` at a quadrature phase. The
// only real number such a check could name is `mag*cos(phase)` — which is
// precisely the lowering under test — so writing it down would bless the defect
// as the specification and hand an implementer a green test for discarding the
// imaginary part. §4.6.3 defines a phasor; an f64 is not one.
//
// So the (mag, phase) claim is the two `//! acstim` lines and nothing else. It
// becomes assertable as a `CHECK` only when the `ac_gens` export (row, col,
// mag, phase) exists beside `noise_gens` and `tb.zig` learns the directive —
// tests/fixtures/ch04_expressions/a06_SPEC.md at 8b1514d4's "Infrastructure these need" is where that is specified.
//
// WHAT THE REMAINING `CHECK`s DO ASSERT, and why they are not more literal
// arithmetic. They are §4.5.6's, not §4.6.3's. §4.6.3 says `ac_stim` "models a
// source with magnitude mag and phase phase" — an INDEPENDENT source — and
// §4.5.6 says "If the expression does not depend explicitly on the unknown,
// then ddx() returns zero (0)". So a stimulus contributes nothing to the
// conductance matrix AT EVERY PHASE, and the branch's derivative is the
// resistor's alone:
//
//   ddx(V(p,n)/R + s60, V(p)) = 1/R = 1e-3 S, and not 1e-3 ± anything
//
// That is the check with teeth, because its want is a NON-ZERO number a wrong
// lowering perturbs: a stimulus reached through a node-dependent path, or
// folded into the linearization the way a `mag·something(x)` lowering invites,
// moves it. `a06_small_signal_linearization.va` makes the same claim at phase
// 0, where `cos(0)` is 1 and a lowering can be right by accident; here the
// phases are π/3 and π/2, where `mag*cos(phase)` is 1.0 and 6.1e-17.
//
// The bare `ddx(s, V(...)) = 0` companions are the weaker half of the same
// clause and are kept only because they name which term is supposed to vanish.
//
//! lrm 4.6.3
//! lrm 4.5.6
//! acstim (p,n) name=ac mag=2.0 phase=1.0471975511965976
//! acstim (q,n) name=ac mag=1.0 phase=1.5707963267948966
//! analysis ac
//! bias V(p) = 0.0
//! bias V(q) = 0.0
//! bias V(n) = 0.0
`include "check.vh"
module a06_ac_stim_quadrature(p, q, n);
    inout p, q, n;
    electrical p, q, n;
    parameter real R = 1000.0 from (0:inf);
    real s60, s90;

    analog begin
        s60 = ac_stim("ac", 2.0, 1.0471975511965976);
        s90 = ac_stim("ac", 1.0, 1.5707963267948966);

        // §4.5.6: ddx() of an expression that does not depend explicitly on the
        // unknown is zero (0). §4.6.3 makes ac_stim an independent source, so
        // this holds at a quadrature phase exactly as it does at phase 0.
        `CHECKX("a 60-degree stimulus adds nothing to the conductance matrix",
            ddx(s60, V(p)), 0.0);
        `CHECKX("neither does a pure quadrature stimulus",
            ddx(s90, V(q)), 0.0);
        // The non-zero want: the branch derivative is the resistor's alone.
        `CHECKEQ("a 60-degree stimulus does not contaminate the linearization",
            ddx(V(p, n) / R + s60, V(p)), 1.0 / R, 1e-18);
        `CHECKEQ("nor does a quadrature one",
            ddx(V(q, n) / R + s90, V(q)), 1.0 / R, 1e-18);

        I(p, n) <+ V(p, n) / R + s60;
        I(q, n) <+ V(q, n) / R + s90;
    end
endmodule
