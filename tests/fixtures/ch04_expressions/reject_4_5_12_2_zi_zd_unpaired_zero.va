// §4.5.12.2 (zi_zd): "If a zero is real, the imaginary part shall be
// specified as zero (0). If a zero is complex, its conjugate shall also be
// present."
//
// The zero vector '{-0.5, 0.5} is one zero, -0.5 + 0.5j, with no conjugate.
// The denominator '{1.0, 0.5} is a legal coefficient vector (zi_zd's
// denominator is coefficients, not roots, so no pairing rule applies to it),
// and T = 1u is positive. The only error is the unpaired complex zero.
//
//! lrm 4.5.12.2
//! lrm 4.5.12.2:2
//! reject-only no conjugate partner
//! neighbour 24_z_transform_filters.va
`include "disciplines.vams"
module ch4_zi_zd_unpaired_zero(p, n);
  inout p, n;
  electrical p, n;

  analog I(p, n) <+ zi_zd(V(p, n), '{-0.5, 0.5}, '{1.0, 0.5}, 1u);
endmodule
