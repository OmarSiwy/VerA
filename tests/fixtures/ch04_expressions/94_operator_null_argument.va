// LRM 4.5.14: an analog operator argument may be omitted — "The null argument
// is characterized by two adjacent commas (,,) in the argument list" — but only
// where the operator defines a default for that position.
//
// `ddt` takes the expression to differentiate as its FIRST argument and has no
// default for it: there is nothing to differentiate. Table 4-20 lists no
// optional first argument for any analog operator, so `ddt(, 1.0)` is not the
// abbreviation of anything.
//
// 141_filter_null_zeros_argument.va is the legal side of the same sentence,
// where the omitted argument does have a defined meaning.
//
// E0502 is the per-operator form of E0505 and names `ddt` in its message, so it
// pins WHICH argument slot had no default rather than only that one did not.
//
//! lrm 4.5.14
//! reject E0502
module ch04_operator_null_argument(p, n);
    inout p, n;
    electrical p, n;

    analog I(p, n) <+ ddt(, 1.0);
endmodule
