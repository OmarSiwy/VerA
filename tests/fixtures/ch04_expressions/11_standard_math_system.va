// §4.3.1 Table 4-14 — the `$`-prefixed spelling of the standard math functions.
// The table gives each row an equivalent C function, so every want below is
// that C function evaluated at x = 1.5 (IEEE-754 double). Five of them are
// pinned bit for bit: §4.3.1 spells min and max out as `(x < y) ? x : y` and
// `(x > y) ? x : y` (the same prose covers abs, which 10_standard_math_
// traditional.va pins), and pow/floor/ceil happen to be exact at these
// arguments — 1.5*1.5 = 2.25 is exact in binary and the two rounding functions
// return integers. Exactness for those three is a property of the inputs, not
// a guarantee §4.3.1 makes for all of them.
//
// The bias is NEGATIVE so `$abs` has something to do: x = |-0.5| + 1 = 1.5.
//
//! lrm 4.3
//! lrm 4.3.1
//! lrm 4.3:1000
//! bias V(p) = -0.5
//! bias V(n) = 0
//! print none
`include "check.vh"
module ch04_standard_math_system(p, n);
    inout p, n;
    electrical p, n;
    real x, value;

    analog begin
        x = $abs(V(p, n)) + 1.0;
        value = $ln(x) + $log10(x) + $exp(x) + $sqrt(x) +
                $min(x, 2.0) + $max(x, 2.0) + $pow(x, 2.0) +
                $floor(x) + $ceil(x);

        // The operating point, so nothing below is vacuous: $abs(-0.5) is 0.5
        // exactly (a sign flip, not a rounding), so x is exactly 1.5.
        `CHECKX("x = $abs(-0.5) + 1", x, 1.5);

        // Table 4-14, the rows whose value is a transcendental.
        `CHECKR("$ln(1.5)", $ln(x), 0.4054651081081644, 1e-15);
        `CHECKR("$log10(1.5)", $log10(x), 0.17609125905568124, 1e-15);
        `CHECKR("$exp(1.5)", $exp(x), 4.4816890703380645, 1e-15);
        `CHECKR("$sqrt(1.5)", $sqrt(x), 1.224744871391589, 1e-15);

        // Table 4-14, the rows the LRM defines to the last bit. §4.3.1 spells
        // min/max out as `(x < y) ? x : y` and `(x > y) ? x : y`, and 1.5*1.5
        // is exact in binary, so these admit no tolerance at all.
        `CHECKX("$min(1.5, 2.0)", $min(x, 2.0), 1.5);
        `CHECKX("$max(1.5, 2.0)", $max(x, 2.0), 2.0);
        `CHECKX("$pow(1.5, 2.0)", $pow(x, 2.0), 2.25);
        `CHECKX("$floor(1.5)", $floor(x), 1.0);
        `CHECKX("$ceil(1.5)", $ceil(x), 2.0);

        // The sum of the nine rows `value` is built from, added left to right
        // in source order. Not the whole of Table 4-14: $abs, $ln1p and $expm1
        // are the other three rows and are not in this sum ($abs is pinned on
        // its own above; ln1p/expm1 are 33_ln1p_expm1.va).
        `CHECKR("the nine summed rows", value, 15.0379903088935, 1e-14);

        // Table 4-14 gives every row TWO spellings — `$ln(x)` and `ln(x)` are
        // the same function, not two implementations. No value to write down,
        // so this is the relational form.
        `CHECKEQ("$ln and ln name one function", $ln(x), ln(x), 0.0);

        I(p, n) <+ value;
    end
endmodule
