// The legal neighbour of the runtime_*_domain_rejected.va fixtures (#59).
// §4.3.2: "Input values outside of the valid range for the operator shall
// report an error" — and only those: every argument here is inside Table 4-14's
// or Table 4-15's Domain column, most of them ON its edge, so a run-time check
// that is one comparison too strict reports here and fails the run. Every
// argument is `z + c` with z = V(p) = 0, so it is computed at run time, never
// folded.
//
//   sqrt(0)       = 0           "x >= 0": the closed edge
//   sqrt(2.25)    = 1.5         exact
//   ln(1)         = 0           "x > 0"
//   log(1000)     = 3           mpmath 3 exactly; RTOL 1e-15
//   ln1p(-0.5)    = ln(0.5) = -0.6931471805599453 (mpmath -0.693147180559945309...)
//   pow(0, 2)     = 0           "if x = 0, y > 0"
//   pow(0, 0)     = 1           y = 0 at x = 0: admitted, IEEE pow(0, 0) = 1, as
//                               the prover admits it (E0609's leniency)
//   pow(-2, 3)    = -8          "if x < 0, all integer y", constant exponent
//   pow(-2, z + 3) = -8         the same, with an exponent that moves with the solve
//   asin(1)       = pi/2 = 1.5707963267948966   "-1 <= x <= 1": the closed edge
//   acosh(1)      = 0           "x >= 1": the closed edge
//
// All are exact or correctly rounded in IEEE 754, so CHECKX, except log and
// ln1p and asin, which a faithful (<= 1 ulp) library may round either way:
// RTOL 1e-15 there (one ulp is 2.2e-16 relative or less).
//
//! lrm 4.3.1
//! lrm 4.3.2
//! lrm 4.3.2:2
//! bias V(p) = 0, V(n) = 0
//! checks 11
//! print none
`include "check.vh"
module runtime_domain_legal_neighbour(p, n);
  inout p, n; electrical p, n;
  real z;
  analog begin
    z = V(p, n);
    `CHECKX("sqrt(0)", sqrt(z), 0.0);
    `CHECKX("sqrt(2.25)", sqrt(z + 2.25), 1.5);
    `CHECKX("ln(1)", ln(z + 1.0), 0.0);
    `CHECKR("log(1000)", log(z + 1000.0), 3.0, 1e-15);
    `CHECKR("ln1p(-0.5)", ln1p(z - 0.5), -0.6931471805599453, 1e-15);
    `CHECKX("pow(0, 2)", pow(z, 2.0), 0.0);
    `CHECKX("pow(0, 0)", pow(z, 0.0), 1.0);
    `CHECKX("pow(-2, 3)", pow(z - 2.0, 3.0), -8.0);
    `CHECKX("pow(-2, z + 3)", pow(z - 2.0, z + 3.0), -8.0);
    `CHECKR("asin(1)", asin(z + 1.0), 1.5707963267948966, 1e-15);
    `CHECKX("acosh(1)", acosh(z + 1.0), 0.0);
    I(p, n) <+ V(p, n);
  end
endmodule
