// LRM 4.7.2.4 Inout arguments, worked end to end by the LRM itself. 4.7.1
// Example 3 defines `arrayadd`, reproduced below verbatim:
//
//     analog function real arrayadd;
//       inout [0:1]a;
//       input [0:1]b;
//       real a[0:1], b[0:1];
//       integer i;
//       begin
//         for(i = 0; i < 2; i = i + 1) begin
//           a[i] = a[i] + b[i];
//         end
//       end
//     endfunction
//
// and 4.7.3 calls it, also verbatim:
//
//     x[0] = 5; x[1] = 10; y = 3; z = 6; dummy = arrayadd(x,'{y,z});
//
// with the answer written out in the same paragraph: "the result of calling the
// arrayinit function will update the vector variable x with values x[0] = 8 and
// x[1] = 16". That is the LRM handing over the literals — 5+3 and 10+6 — so
// they are what the CHECKX wants below say, with no bias and no arithmetic of
// mine in between. All four inputs are small integers, exact in IEEE 754.
//
// `dummy` is 0.0 and that is normative too, not an accident: 4.7.2.1 declares
// the function-identifier variable "initialized to zero (0) if the inherited
// type is numerical", and `arrayadd` never assigns to `arrayadd`.
//
// 4.7.2.4 also fixes that the inout copy-in happened: `'{y,z}` feeds 3 and 6
// INTO b (unlike an `output` array, whose actual is reset to zero on entry —
// 4.7.2.3), so y and z are unchanged on return and a tool that zeroed the inout
// actual on entry gets x[0] = 5, x[1] = 10 and fails.
//
// This file used to be `//! reject ParseError` on the LRM's own worked example,
// which made a conforming compiler fail it and only VerA pass.
//
//! lrm 4.7.2.4
//! lrm 4.7.3
//! lrm 4.7.2.4:2
`include "check.vh"
module ch4_fn_array_inout(p);
  inout p;
  electrical p;
  real x[0:1];
  real y, z, dummy;

  analog function real arrayadd;
    inout [0:1]a;
    input [0:1]b;
    real a[0:1], b[0:1];
    integer i;
    begin
      for(i = 0; i < 2; i = i + 1) begin
        a[i] = a[i] + b[i];
      end
    end
  endfunction

  analog begin
    x[0] = 5; x[1] = 10; y = 3; z = 6;
    dummy = arrayadd(x, '{y, z});
    `CHECKX("arrayadd copies out x[0] = 5 + 3", x[0], 8.0);
    `CHECKX("arrayadd copies out x[1] = 10 + 6", x[1], 16.0);
    `CHECKX("the input pattern is not written back: y", y, 3.0);
    `CHECKX("the input pattern is not written back: z", z, 6.0);
    `CHECKX("an unassigned function identifier variable returns zero", dummy, 0.0);
    dummy = arrayadd('{y, z}, '{1.0, 2.0});
    `CHECKX("an inout pattern copies its first changed element back", y, 4.0);
    `CHECKX("an inout pattern copies its second changed element back", z, 8.0);
    `CHECKX("a different inout actual leaves the previous array intact", x[1], 16.0);
    I(p) <+ x[0] + x[1] + dummy;
  end
endmodule
