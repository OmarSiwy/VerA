// A.8.2:
//
//     laplace_filter_name ( analog_expression , [ analog_filter_function_arg ] ,
//             [ analog_filter_function_arg ] [ , constant_expression ] )
//     analog_filter_function_arg ::= parameter_identifier
//             | parameter_identifier [ msb_constant_expression : lsb_constant_expression ]
//             | constant_assignment_pattern_or_null
//
// A coefficient vector is a parameter array, a part of one, or an assignment
// pattern `'{...}`. VAMS 2.x wrote the list as `{...}`, which is the §4.2.13
// concatenation operator; annex G records the change ("Add apostrophe before
// opening { in list of values (to distinguish a list of values from the
// concatenation operator)"), and 4.2.13 itself warns that the concatenation
// "should not be confused with the assignment pattern '{ } which is used ...
// for ... coefficient arguments to the Laplace analog filters". This file is
// 153_laplace_nd_dc_gain.va, the legal neighbour, with every `'{` written `{`.
//
// VerA refuses each concatenation in a coefficient slot with E0572 ("filter
// coefficient argument is not an array"), once per call; the code is pinned.
// (4.5.1: "An array can either be passed as an array_identifier ... or an
// array assignment pattern".)
//
//! lrm 4.5.11
//! lrm 4.5.1
//! lrm A.8.2
//! reject-only E0572
//! reject-only is a concatenation
//! neighbour 153_laplace_nd_dc_gain.va
`include "check.vh"
module ch04_laplace_nd_dc_gain(in, n);
    inout in, n;
    electrical in, n;
    real y, y_second_order;

    analog begin
        y = laplace_nd(V(in, n), {6.0}, {3.0, 1n});      // illegal: a concatenation
        y_second_order = laplace_nd(V(in, n), {6.0, 2n, 1e-18}, {3.0, 1n, 1e-18});
        `CHECKX("H(0) = n0/d0, first order", y, 2.0);
        `CHECKX("H(0) = n0/d0, second order — the s^k>0 terms drop out", y_second_order, 2.0);
        I(in, n) <+ 0.0;
    end
endmodule
