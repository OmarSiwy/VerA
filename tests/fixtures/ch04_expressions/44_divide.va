// §4.2.4 Table 4-4: `a / b` is "a divide by b". The section's truncation rule —
// "Integer division truncates any fractional part toward zero" — is about
// INTEGER division; V(p,n) is real, so 3.0 / 2.0 is 1.5 and not the truncated
// 1.0. 1.5 is exact in IEEE 754 binary.
//
//! lrm 4.2.4
//! bias V(p) = 3.0
`include "check.vh"
module ch04_divide(p, n);
    inout p, n;
    electrical p, n;
    analog begin
        `CHECKX("3.0 / 2.0 keeps the fraction", V(p, n) / 2.0, 1.5);
        I(p, n) <+ V(p, n) / 2.0;
    end
endmodule
