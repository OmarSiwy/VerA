// AMS 4.2.3: unnecessary operands of &&, || and ?: are not evaluated when
// the expression contains no analog operators. An access function is not a
// stateful analog operator. Here the condition comes from the biased input:
// V(p,n)=0.75-0.25=0.5 > 0, so condition=1 and !condition=0.
// bump increments its separate inout counter and returns 7. Thus each
// selected call leaves its counter at 1; each unselected call leaves 0.
// Logical results are 0 or 1, while the selected conditional result is 7.
// All calls are bound before CHECK macros to avoid macro double evaluation.
// Four logical expressions give eight checks; two conditionals give six.
// This distinguishes eager evaluation and omission of required evaluation,
// with a runtime input instead of a literal condition. It does not cover
// analog-operator exceptions, x/z conditions, or runtime error suppression.
//! lrm 4.2.3
//! lrm 4.2.12
//! lrm 4.2.3:2
//! lrm 4.2.3:4
//! bias V(p) = 0.75, V(n) = 0.25
//! checks 14
`include "check.vh"
module audit_short_circuit_dynamic(p, n);
    inout p, n;
    electrical p, n;
    integer condition;
    integer and_skip, and_take, or_skip, or_take;
    integer true_take, true_skip, false_skip, false_take;
    integer a, b, c, d, e, f;
    analog function integer bump;
        inout count;
        integer count;
        begin
            count = count + 1;
            bump = 7;
        end
    endfunction
    analog begin
        condition = V(p,n) > 0;
        and_skip = 0; and_take = 0; or_skip = 0; or_take = 0;
        true_take = 0; true_skip = 0; false_skip = 0; false_take = 0;
        a = !condition && bump(and_skip);
        b = condition && bump(and_take);
        c = condition || bump(or_skip);
        d = !condition || bump(or_take);
        e = condition ? bump(true_take) : bump(true_skip);
        f = !condition ? bump(false_skip) : bump(false_take);
        `CHECKI("and skipped count", and_skip, 0);
        `CHECKI("and taken count", and_take, 1);
        `CHECKI("or skipped count", or_skip, 0);
        `CHECKI("or taken count", or_take, 1);
        `CHECKI("false and result", a, 0);
        `CHECKI("true and result", b, 1);
        `CHECKI("true or result", c, 1);
        `CHECKI("false or result", d, 1);
        `CHECKI("true conditional selected", true_take, 1);
        `CHECKI("true conditional skipped", true_skip, 0);
        `CHECKI("false conditional skipped", false_skip, 0);
        `CHECKI("false conditional selected", false_take, 1);
        `CHECKI("true conditional result", e, 7);
        `CHECKI("false conditional result", f, 7);
        I(p,n) <+ V(p,n);
    end
endmodule
