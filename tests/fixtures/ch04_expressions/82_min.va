// min() (LRM 4.3.1 Table 4-14): "min(x,y) is equivalent to (x < y) ? x : y",
// all x, all y. 4.3.1 also fixes the result type: both operands integer gives
// an integer, otherwise both are converted to real, as is the result.
`include "check.vh"
//! lrm 4.3.1
//! bias V(p) = 2.5
module ch04_min(p, n);
  inout p, n; electrical p, n;
  analog begin
    I(p, n) <+ min(V(p, n), 1.0);
    // 2.5 vs 1.0 — the second operand wins.
    `CHECKX("min picks the smaller (y)", min(V(p, n), 1.0), 1.0);
    // -2.5 vs 1.0 — the first operand wins, so both arms are exercised.
    `CHECKX("min picks the smaller (x)", min(-V(p, n), 1.0), -2.5);
    // Ties: (x < y) is false, so the tie yields y; same value either way.
    `CHECKX("min of equals", min(1.0, 1.0), 1.0);
    // Two integer operands keep an integer result.
    `CHECKI("min of two integers is integer", min(-7, 3), -7);
  end
endmodule
