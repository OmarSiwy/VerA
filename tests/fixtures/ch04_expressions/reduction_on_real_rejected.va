// Two sentences rule this out, and they agree.
//
// §4.2.1: "All other operators are considered illegal when used with real
// operands" — Table 4-2 has no reduction operator.
//
// §4.2.10: "The reduction operators can not be used inside the analog block and
// only have meaning when used in the digital context."
//
// `&x` below is a reduction of a REAL inside the analog block, so both apply.
// VerA reports the operand rule (E0319) first, because a real has no bits to
// fold whatever the context. The context rule alone, on an integer operand, is
// 06_reduction_rejected.va (E0348).
//
//! lrm 4.2.1
//! lrm 4.2.1:1
//! lrm 4.2.10
//! reject-only E0319
`include "disciplines.vams"
module ch04_reduction_on_real(p, n);
  inout p, n; electrical p, n;
  real x;
  analog begin
    x = 1.5;
    I(p, n) <+ (&x) * V(p, n);
  end
endmodule
