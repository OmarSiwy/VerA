// §4.5.11 "For arguments that require a vector, the vector may be represented
// as either a literal vector or a reference to a vector parameter." This is the
// parameter-reference half: the coefficient vectors are §3.4 array parameters,
// not '{...} literals at the call site.
//
//   H(s) = (n0 + n1*s) / (d0 + d1*s) = 1 / (2 + s)
//
// so H(0) = n0/d0 = 0.5, and with V(p,n) = 0.8 V the filter output is 0.4.
//
// d0 is 2 rather than 1 on purpose: a DC gain of 1 is also what a laplace_nd
// lowered as a pass-through returns, and what one that never read `numerator`
// or `denominator` at all would return. 0.4 separates them.
//
//! lrm 4.5.1
//! lrm 4.5.11
//! lrm 4.5.11:2
//! lrm 4.5.1:1000
//! bias V(p) = 0.8
//! bias V(n) = 0.0
`include "check.vh"
module ch04_filter_parameter_arrays(p, n);
    inout p, n;
    electrical p, n;
    parameter real numerator[0:1] = '{1.0, 0.0};
    parameter real denominator[0:1] = '{2.0, 1.0};
    real y;

    analog begin
        y = laplace_nd(V(p, n), numerator, denominator);
        `CHECK("DC gain of a filter whose coefficients are vector parameters", y, 0.4, 1e-12);
        I(p, n) <+ y;
    end
endmodule
