// §4.5.10: "The last_crossing() function returns a real value representing
// the simulation time when a signal expression last crossed zero (0)", and
// "it uses linear interpolation to estimate the time of the last crossing".
// §4.5: an analog operator's "output is a function of both the input and the
// internal state", so the crossing between the last accepted point and the
// point being evaluated is already the last one there (#54: VerA answered
// from the previous accepted step only, and reported it one point late).
//
// V(p) is forced to 0 at t = 0 and to 1 at t = 1n, so e = V(p) - 0.25 is
// -0.25 at t = 0 and +0.75 at t = 1n. The line through those two samples is
// zero at t = 0 + 0.25/(0.25 + 0.75) * 1n = 0.25n. At t = 0 it has not
// crossed yet: "Before the expression crosses zero (0) for the first time,
// the last_crossing() function returns a negative value." Direction 0 counts
// either edge; this one rises.
//
// Three verdicts: the negative check at both points (the $abstime operand
// makes it vacuous at 1n), the value at 1n only.
//
//! lrm 4.5.10
//! analysis tran
//! bias V(n) = 0
//! wave V(p) = 0, 1
//! time 0, 1n
//! print none
//! checks 3
`include "check.vh"
module last_crossing_in_creating_step(p, n);
    inout p, n;
    electrical p, n;
    real t;

    analog begin
        t = last_crossing(V(p) - 0.25, 0);
        `CHECKI("negative before the first crossing", (t < 0.0) || ($abstime > 0.0), 1);
        if ($abstime > 0.0)
            `CHECK("the crossing at 0.25n is the last one at 1n", t, 0.25e-9, 1e-18);
        I(p, n) <+ V(p, n);
    end
endmodule
