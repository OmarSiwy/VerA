// §4.5.7 absdelay in a small-signal analysis. The clause:
//
//   "In AC and other small-signal analyses, the absdelay() operator
//    phase-shifts the input expression to the output of the delay operator
//    based on the following formula.
//        Output(ω) = Input(ω) · e^(−jωtd)
//    td is evaluated as a constant at a particular time for any small signal
//    analysis."
//
// A host sees this through `acDyn` (`contract.acDynSlots`): the complex term
// of each Jacobian slot whose small-signal value depends on ω, the part `eval`
// leaves out under `analysis("ac")`. `//! acdyn (row,col) f= re= im=` reads it
// at ω = 2πf and the operating point V(in) = 0.75, every other node at 0.
//
// THE NUMBERS. td = 1 ns, so θ = ω·td = 2π·f·1e-9 is π/4, π/2 and 3π/4 at
// 125, 250 and 375 MHz, and e^(−jθ) = cos θ − j·sin θ. Each row is a KCL
// current into its node, so the slot (row, in) is ∂I/∂V(in):
//
//   a  2·V(in) + absdelay(V(in))    e^(−jθ). The 2 is flat in ω: it stays in
//                                   G, and `acDyn` carries only the delay.
//   b  absdelay(V(in))²             2·0.75·e^(−jθ) = 1.5·e^(−jθ): the outer
//                                   square is differentiated at the delayed
//                                   operating value, input(0) = 0.75.
//   c  absdelay(absdelay(V(in)))    e^(−j2θ): two delays in series.
//   d  ddt(1n · absdelay(V(in)))    jω·1n·e^(−jθ) = θ·(sin θ + j·cos θ), since
//                                   ω·1n = θ here; A = G + jωC takes the
//                                   charge's term rotated by jω.
//
//   f      a               b                       c        d
//   125M   (√2/2, −√2/2)   (1.5·√2/2, −1.5·√2/2)   (0, −1)  (π/4·√2/2, π/4·√2/2)
//   250M   (0, −1)         (0, −1.5)               (−1, 0)  (π/2, 0)
//   375M   (−√2/2, −√2/2)  (−1.5·√2/2, −1.5·√2/2)  (0, 1)   (3π/4·√2/2, −3π/4·√2/2)
//
// √2/2 = 0.7071067811865476, π/4·√2/2 = 0.5553603672697958,
// 3π/4·√2/2 = 1.6660811018093873. At f = 0 the delay is transparent,
// e^0 = 1, the DC gain §4.5.7 gives in operating point analyses, so each row
// reads its DC partial EXACTLY (tol=0): 1, 1.5 (= 2·0.75, dyadic), 1, and 0
// for the charge (jω·C at ω = 0). A transparent
// small-signal delay (the answer before this fixture) reads (1, 0) at every f
// and fails every non-zero row; a phase of +jωtd fails every imaginary part.
// The operating point itself is the clause's DC sentence, which the model can
// see: "In DC and operating point analyses, absdelay() returns the value of
// its input", 0.75.
//
//! lrm 4.5.7
//! lrm 4.5.7:1001
//! lrm 4.5.7:1003
//! bias V(in) = 0.75
//! print none
//! acdyn (a,in) f=0 re=1 im=0 tol=0
//! acdyn (b,in) f=0 re=1.5 im=0 tol=0
//! acdyn (c,in) f=0 re=1 im=0 tol=0
//! acdyn (d,in) f=0 re=0 im=0 tol=0
//! acdyn (a,in) f=125M re=0.7071067811865476 im=-0.7071067811865476
//! acdyn (a,in) f=250M re=0 im=-1
//! acdyn (a,in) f=375M re=-0.7071067811865476 im=-0.7071067811865476
//! acdyn (b,in) f=125M re=1.0606601717798214 im=-1.0606601717798214
//! acdyn (b,in) f=250M re=0 im=-1.5
//! acdyn (b,in) f=375M re=-1.0606601717798214 im=-1.0606601717798214
//! acdyn (c,in) f=125M re=0 im=-1
//! acdyn (c,in) f=250M re=-1 im=0
//! acdyn (c,in) f=375M re=0 im=1
//! acdyn (d,in) f=125M re=0.5553603672697958 im=0.5553603672697958
//! acdyn (d,in) f=250M re=1.5707963267948966 im=0
//! acdyn (d,in) f=375M re=1.6660811018093873 im=-1.6660811018093873
`include "check.vh"
module absdelay_ac_phase(in, a, b, c, d);
    inout in, a, b, c, d;
    electrical in, a, b, c, d;

    analog begin
        `CHECK("at the operating point absdelay returns its input", absdelay(V(in), 1n), 0.75, 1e-12);
        I(a) <+ 2.0 * V(in) + absdelay(V(in), 1n);
        I(b) <+ pow(absdelay(V(in), 1n), 2.0);
        I(c) <+ absdelay(absdelay(V(in), 1n), 1n);
        I(d) <+ ddt(1n * absdelay(V(in), 1n));
    end
endmodule
