// §4.2.9 decides a comparison's signedness from its OPERANDS:
//
//   "When one or both operands are unsigned, the expression shall be interpreted
//    as a comparison between unsigned values."
//
// An operand is often itself an expression, and ch4 gives no rule for the sign
// of one; the rule is IEEE 1364-2005 §5.5.1, "Rules for expression types":
//
//   "Comparison results (1, 0) are unsigned, regardless of the operands."
//   "For nonself-determined operands ... If any operand is unsigned, the result
//    is unsigned, regardless of the operator. If all operands are signed, the
//    result will be signed, regardless of operator"
//
// and §5.1.5: "the second operand of the power operator shall be treated as
// self-determined", so `**` takes its first operand's sign, as a shift does
// (VAMS §4.2.11: the right operand "has no effect on the signedness of the
// result").
//
// §3.2: an integer is 32 bits, signed. An unbased decimal literal is signed; a
// based literal without `s` (`32'd1`) is unsigned. a = -2 = 32'hFFFFFFFE.
//
//   r1 = ((a + 32'd1) < 0)   a + 32'd1 is UNSIGNED: 32'hFFFFFFFF = 4294967295,
//                            and 4294967295 < 0 is false                  -> 0
//   r2 = ((a < 0) < a)       (a < 0) is 1, UNSIGNED, so the outer comparison
//                            is unsigned: 1 < 4294967294 is true           -> 1
//   r3 = ((c ? a : 32'd0) < 0) with c = 1: the arms are nonself-determined, so
//                            the conditional is UNSIGNED; it selects a,
//                            4294967294 < 0 is false                      -> 0
//   r4 = ((a ** 32'd1) < 0)  CONTROL: `**` has a's sign whatever its exponent,
//                            so this is signed: -2 < 0                    -> 1
//   r5 = ((a + 1) < 0)       CONTROL: both operands signed: -1 < 0        -> 1
//
// r1-r3 used to come out 1, 0 and 1: VerA asked only a bare literal or name for
// its sign, answered "unknown" for every operator node, and an unknown beside a
// signed operand kept the signed compare.
//
//! lrm 4.2.9
//! lrm 4.2.12
//! bias V(p) = 0.5
`include "check.vh"
module unsigned_operand_expression(p);
  inout p; electrical p;
  integer a, c, r1, r2, r3, r4, r5;
  analog begin
    a = -2;
    c = 1;
    r1 = ((a + 32'd1) < 0);
    r2 = ((a < 0) < a);
    r3 = ((c ? a : 32'd0) < 0);
    r4 = ((a ** 32'd1) < 0);
    r5 = ((a + 1) < 0);
    `CHECKI("a sum with an unsigned operand is unsigned", r1, 0);
    `CHECKI("a comparison result is unsigned", r2, 1);
    `CHECKI("a conditional with an unsigned arm is unsigned", r3, 0);
    `CHECKI("** takes its first operand's sign", r4, 1);
    `CHECKI("a sum of signed operands is signed", r5, 1);
    I(p) <+ V(p);
  end
endmodule
