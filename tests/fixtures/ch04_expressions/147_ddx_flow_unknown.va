// LRM 4.5.6, verbatim: "The second argument shall be the potential of a scalar
// net or port or the flow through a branch, because these are the unknown
// variables in the system of equations for the analog solver."
//
// 18_ddx.va differentiates with respect to a POTENTIAL only, and so do the two
// rejects that guard the rule (131_ddx_two_node_probe_rejected.va,
// 132_ddx_nonprobe_argument_rejected.va). The flow half of that sentence — the
// "or certain branch currents" case 4.5.6 names as the second family of
// modified-nodal-analysis unknowns — is written nowhere in the chapter, so a
// compiler that accepted only V(...) as a ddx unknown passes every fixture.
//
// A flow is an unknown only where the branch is driven as a POTENTIAL source,
// which is why this is a separate module from 18: `V(p,n) <+ r*I(p,n)` is Ohm's
// law written the other way round, and it makes I(p,n) a solver unknown rather
// than an output. The derivative is then exact and needs no operating point at
// all:
//
//     d/dI(p,n) of ( r * I(p,n) )  =  r  =  100.0
//
// The second check is 4.5.6's closing sentence on the same unknown — "If the
// expression does not depend explicitly on the unknown, then ddx() returns zero
// (0)" — asked of a flow rather than a potential: V(p,n) is the branch
// potential, an unknown in its own right, and the constant 2.0 depends on
// neither.
//
// The bias makes the branch current 1.5/100 = 0.015 A, which is the only thing
// the operating point is for; both wants are independent of it.
//
//! lrm 4.5.6
//! lrm 4.5.6:1
//! bias V(p) = 1.5
//! bias V(n) = 0.0
//! print none
`include "check.vh"
module ch04_ddx_flow_unknown(p, n);
    inout p, n;
    electrical p, n;
    parameter real r = 100.0;
    real drop;

    analog begin
        drop = r * I(p, n);

        `CHECKX("d/dI of r*I is the resistance itself", ddx(drop, I(p, n)), 100.0);
        `CHECKX("a constant does not depend on the flow unknown",
                ddx(2.0, I(p, n)), 0.0);

        V(p, n) <+ drop;
    end
endmodule
