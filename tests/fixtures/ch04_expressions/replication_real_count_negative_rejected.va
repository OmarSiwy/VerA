// §4.2.1 converts a real replication factor to an integer by §4.2.1.1's rule
// before using it, and IEEE 1364-2005 §5.1.14 requires the count to be "a
// non-negative, non-x and non-z constant expression".
//
// -1.5 rounds away from zero to -2, which is negative, so the conversion does
// not rescue it. (-0.4 would round to 0, which is legal.)
//
// The legal neighbour is replication_real_count.va.
//
//! lrm 4.2.1
//! reject-only non-negative, got -2
//! neighbour replication_real_count.va
`include "disciplines.vams"
module ch04_replication_real_count_negative(p);
    inout p;
    electrical p;
    string a;
    analog begin
        a = {-1.5{"ab"}};
        I(p) <+ 0.0 * V(p);
    end
endmodule
