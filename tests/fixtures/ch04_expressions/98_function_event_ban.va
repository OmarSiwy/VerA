// LRM 5.2.1/4.7.2: event control statements are forbidden inside an analog
// function.
//! reject E0702
module ch4_fn_event(p); inout p; electrical p; analog function real sampled; input x; real x; begin @(cross(x,1)) sampled=x; end endfunction analog I(p)<+sampled(V(p)); endmodule
