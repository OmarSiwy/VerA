// §4.5.12.1-.4 — the four coefficient forms of the Z-transform filter, and the
// DC gain each one's transfer function fixes.
//
// A Z-filter's H is written in z^-1, so "DC" is z = 1, i.e. z^-1 = 1:
//
//   .1 zi_zp   H(z) = ∏(1 - z^-1·ζk) / ∏(1 - z^-1·ρk)   ->  ∏(1-ζk) / ∏(1-ρk)
//   .2 zi_zd   H(z) = ∏(1 - z^-1·ζk) / Σ dk·z^-k        ->  ∏(1-ζk) / Σ dk
//   .3 zi_np   H(z) = Σ nk·z^-k / ∏(1 - z^-1·ρk)        ->  Σ nk / ∏(1-ρk)
//   .4 zi_nd   H(z) = Σ nk·z^-k / Σ dk·z^-k             ->  Σ nk / Σ dk
//
// Every want below is that expression evaluated by hand on the arguments the
// call passes, and the four forms are given arguments that make them DIFFER —
// 2, 1/2, 8, 2 — so a lowering that dispatched one form to another's code is
// caught by the digit and not only by a crash. Note especially §4.5.12.3's 8:
// a numerator summed as coefficients (3 + 1 = 4) over a pole product (1 - 0.5 =
// 0.5), which no other form's arithmetic produces.
//
// WHY THIS IS A TRANSIENT AND WHY THE TOLERANCE IS 1e-4. Unlike §4.5.11, a
// Z-filter has no static short-circuit: its output is a recurrence, so the DC
// gain is the limit the recurrence approaches rather than a value it is handed.
// Every pole here has magnitude 1/2, so the error after k samples is of order
// 2^-k; at the 20 samples this runs it is below 1e-5 for all four, and the
// tolerance leaves a decade of margin. The check is written to fire only at the
// last point, and unconditionally — a comparison is an integer (§4.2.5), so it
// is an operand and never a branch.
//
// The timepoints are spaced at exactly the filter's own T, which keeps the
// arithmetic here easy to follow. It is not load-bearing:
// `156_zi_sampling_period.va` pins that the answer does not depend on the
// spacing at all.
//
// Corrected 2026-10-08 (construct only, the wants are unchanged): the
// coefficient vectors were VAMS 2.x concatenations, `{...}`. A.8.2's
// analog_filter_function_arg is a parameter, a part of one or a `'{...}`
// assignment pattern (annex G: "Add apostrophe before opening { in list of
// values"), and a concatenation there is E0572
// (reject_4_5_11_concatenation_coefficients.va), so each is now `'{...}`.
//
//! lrm 4.5.12.1
//! lrm 4.5.12.2
//! lrm 4.5.12.3
//! lrm 4.5.12.4
//! analysis tran
//! bias V(n) = 0
//! wave V(in) = 1, 1, 1, 1, 1, 1, 1, 1, 1, 1, 1, 1, 1, 1, 1, 1, 1, 1, 1, 1, 1
//! time 0, 1u, 2u, 3u, 4u, 5u, 6u, 7u, 8u, 9u, 10u, 11u, 12u, 13u, 14u, 15u, 16u, 17u, 18u, 19u, 20u
//! print none
`include "check.vh"
module ch04_zi_dc_gains(in, n);
    inout in, n;
    electrical in, n;
    real zp, zd, np, nd;

    analog begin
        // one zero at 0, one pole at 1/2  ->  1 / (1 - 1/2) = 2
        zp = zi_zp(V(in, n), '{0.0, 0.0}, '{0.5, 0.0}, 1u);
        // one zero at 0, denominator 4 - 2z^-1  ->  1 / (4 - 2) = 1/2
        zd = zi_zd(V(in, n), '{0.0, 0.0}, '{4.0, -2.0}, 1u);
        // numerator 3 + z^-1, one pole at 1/2  ->  (3 + 1) / (1 - 1/2) = 8
        np = zi_np(V(in, n), '{3.0, 1.0}, '{0.5, 0.0}, 1u);
        // numerator 1 + 2z^-1, denominator 1 + z^-1/2  ->  3 / (3/2) = 2
        nd = zi_nd(V(in, n), '{1.0, 2.0}, '{1.0, 0.5}, 1u);
        $strobe("t=%g zp=%g zd=%g np=%g nd=%g", $abstime / 1u, zp, zd, np, nd);
        `CHECKI("zi_zp settles to ∏(1-ζ)/∏(1-ρ) = 2", ($abstime < 20u) || (abs(zp - 2.0) < 1e-4), 1);
        `CHECKI("zi_zd settles to ∏(1-ζ)/Σd = 0.5", ($abstime < 20u) || (abs(zd - 0.5) < 1e-4), 1);
        `CHECKI("zi_np settles to Σn/∏(1-ρ) = 8", ($abstime < 20u) || (abs(np - 8.0) < 1e-4), 1);
        `CHECKI("zi_nd settles to Σn/Σd = 2", ($abstime < 20u) || (abs(nd - 2.0) < 1e-4), 1);
        I(in, n) <+ 0.0;
    end
endmodule
