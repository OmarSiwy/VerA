// §4.2.14 the assignment pattern '{...} fills a whole array in one statement, in
// declaration order — and unlike a §4.2.13 concatenation its elements keep
// their own identity and may be run-time expressions.
//
// `values[0:2]` is declared low-to-high, so element 0 takes the first entry
// (the signal), 1 takes 2.0 and 2 takes 3.0. A pattern applied in reverse — a
// real risk for a range written the other way — would put 3.0 in values[0].
//
// The bias is 0.75 rather than 0.7 so the signal element is exact in binary and
// the check can be an equality.
//
//! lrm 4.2.14
//! lrm 4.2.14:1000
//! bias V(p) = 0.75
//! bias V(n) = 0.0
`include "check.vh"
module ch04_array_assignment(p, n);
    inout p, n;
    electrical p, n;
    real values[0:2];

    analog begin
        values = '{V(p, n), 2.0, 3.0};
        `CHECKX("element 0 is the first entry, here a signal expression", values[0], 0.75);
        `CHECKX("element 1 is the second entry", values[1], 2.0);
        `CHECKX("element 2 is the third entry", values[2], 3.0);
        I(p, n) <+ values[0];
    end
endmodule
