// §4.2.13: "A concatenation is the result of the joining together of bits
// resulting from one or more expressions into a single value", and "the size
// of each operand in the concatenation is needed to calculate the complete size
// of the concatenation."
//
// §4.2.1 then excludes a real operand outright: "All other operators are
// considered illegal when used with real operands", and concatenation is not in
// Table 4-2. `{x}` below concatenates a real variable, which has no bits and no
// size. Sized-integer concatenation is 30_concatenation.va.
//
//! lrm 4.2.13
//! lrm 4.2.1
//! lrm 4.2.1:1
//! reject-only E0327
//! neighbour 30_concatenation.va
`include "disciplines.vams"
module ch04_concatenation_real_operand(p, n);
  inout p, n; electrical p, n;
  real x;
  integer k;
  analog begin
    x = 1.0;
    k = {x};
    I(p, n) <+ k * V(p, n);
  end
endmodule
