// AMS §4.2.4: "The result of a modulus operation takes the sign of the first
// operand." Table 4-6 includes 11 % -3 = 2. A divisor need not be constant;
// the invalid value is zero, isolated in modulo_integer_dynamic_zero.va and
// 111_modulus_by_zero_rejected.va.
//
// V(p)=3.75: §4.2.1.1 assigns +4/-4 to integers. V(p)-0.25=3.5 and its
// negative also become +4/-4, rounding ties away from zero;
// $rtoi truncates to 3 (§9.11). Thus 11 % (+/-4)=3 and -11 % (+/-4)=-3,
// while 11 % 3=2. 12 % 4=0. §4.2.1.3 evaluates the inner integer remainder
// before 8.0 is added: 8+3=11. With a real divisor, 10 % 3.75=10-2*3.75=2.5.
//
// §3.2's 32-bit two's-complement integer endpoints give -2^31 % -1=0 and
// (2^31-1) % 4=3. Away from the rounding boundaries, the integer remainder
// is locally constant. §4.5.6 ddx therefore gives 0 for it, 3 for its product
// with V(p), and -2 for the real remainder (10-2*V(p)). These are different
// derivative rules; the legal dynamic integer path must not acquire -2.
//! lrm 3.2
//! lrm 4.2.1.1
//! lrm 4.2.1.3
//! lrm 4.2.4
//! lrm 4.5.6
//! lrm 4.2.1.1:1
//! lrm 4.2.1.3:1000
//! bias V(p) = 3.75, V(n) = 0
//! checks 17
`include "check.vh"
module modulo_integer_dynamic(p, n);
  inout p, n; electrical p, n;
  integer divisor, negative, trunc_divisor, remainder, low, high, minus_one;
  integer positive_tie, negative_tie;
  real real_remainder;
  analog begin
    divisor = V(p,n);
    negative = -V(p,n);
    trunc_divisor = $rtoi(V(p,n));
    positive_tie = V(p,n) - 0.25;
    negative_tie = -V(p,n) + 0.25;
    remainder = 11 % divisor;
    low = -2147483647 - 1;
    high = 2147483647;
    minus_one = 3 - divisor;
    real_remainder = 10 % V(p,n);
    `CHECKI("implicit positive conversion rounds", divisor, 4);
    `CHECKI("implicit negative conversion rounds", negative, -4);
    `CHECKI("implicit positive tie rounds away", positive_tie, 4);
    `CHECKI("implicit negative tie rounds away", negative_tie, -4);
    `CHECKI("positive dividend positive divisor", remainder, 3);
    `CHECKI("positive dividend negative divisor", 11 % negative, 3);
    `CHECKI("negative dividend positive divisor", -11 % divisor, -3);
    `CHECKI("negative dividend negative divisor", -11 % negative, -3);
    `CHECKI("exact division", 12 % divisor, 0);
    `CHECKI("explicit truncation has a different divisor", 11 % trunc_divisor, 2);
    `CHECKX("integer inner operation survives real context", 8.0 + remainder, 11.0);
    `CHECKI("minimum integer modulo negative one", low % minus_one, 0);
    `CHECKI("maximum integer modulo four", high % divisor, 3);
    `CHECKX("real divisor uses the real remainder", real_remainder, 2.5);
    `CHECKX("integer remainder has no derivative", ddx(1.0 * remainder, V(p)), 0.0);
    `CHECKX("consumer retains its own derivative", ddx(remainder * V(p,n), V(p)), 3.0);
    `CHECKX("real remainder retains divisor derivative", ddx(real_remainder, V(p)), -2.0);
    I(p,n) <+ remainder * V(p,n);
  end
endmodule
