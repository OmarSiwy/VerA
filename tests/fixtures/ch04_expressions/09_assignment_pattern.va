// LRM 4.2.14 / A.8.1 constant_assignment_pattern: `'{...}` initialises a
// parameter array element-by-element, in declaration order, over the declared
// range [0:4]. So data[0] is the FIRST literal and data[4] the LAST.
//
// 3.4 makes each element a 64-bit IEEE 754 double, so `data[0]` must read back
// bit-identical to the literal 3.4 that initialised it. 3.4 + 7.1 is 10.5
// exactly: the two roundings cancel (3.4 rounds down by 8.88e-17 and 7.1 rounds
// down by 3.55e-16 relative to the decimals, and the sum re-rounds to 10.5).
//! lrm 4.2.14
//! lrm 4.2.14:1000
`include "check.vh"
module ch04_assignment_pattern(p, n);
    inout p, n;
    electrical p, n;
    parameter real data[0:4] = '{3.4, 5.6, 2.3, 4.5, 7.1};

    analog begin
        `CHECKX("first element of the pattern", data[0], 3.4);
        `CHECKX("last element of the pattern", data[4], 7.1);
        `CHECK("data[0] + data[4]", data[0] + data[4], 10.5, 1e-15);
        I(p, n) <+ data[0] + data[4];
    end
endmodule
