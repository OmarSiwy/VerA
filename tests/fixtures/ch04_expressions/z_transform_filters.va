// §4.5.12 the four Z-transform filter forms, and the one thing the clause
// actually fixes about them.
//
// WHAT 4.5.12 DOES NOT SAY. Read end to end, 4.5.12 specifies T ("is
// mandatory, and shall be positive"), tau, t0, the null argument, and the four
// transfer functions of 4.5.12.1-.4. It says NOTHING about DC or the operating
// point. Compare its neighbours, which each get an explicit sentence: ddt
// (4.5.3) "In DC analysis, ddt() returns zero (0)", absdelay (4.5.7) "In DC and
// operating point analyses, absdelay() returns the value of its input", slew
// (4.5.9) "In DC analysis, slew() simply passes the value of the destination to
// its output". The Z-filters have no such sentence.
//
// So a DC output of 2.0 for a one-pole accumulator — the H(z=1) steady-state
// reading, every sample equal so z = 1 — is a DEFENSIBLE implementation choice,
// not a normative value. 4.5.15's "All analog operators are considered to have
// no state history prior to time t == 0" supports 1.0 just as well: with x[-1]
// taken as zero, the first output of 1/(1 - 0.5 z^-1) is the input itself. This
// file used to assert 2.0 four times as if 4.5.12 had said so. It did not, and
// a conforming simulator that reads 4.5.15 the other way would have failed it.
//
// WHAT 4.5.12 DOES SAY, and what is asserted below.
//
// 1. A filter with no delay term is a pure gain, whatever the history
//    convention is, because there is no history in it:
//
//      zi_nd(x, '{2,0}, '{1,0}, 1u)          §4.5.12.4
//        H(z) = (2 + 0*z^-1) / (1 + 0*z^-1) = 2 for every z.
//
//    Both readings agree on 2.0 here, and it is exact in IEEE 754. That is the
//    one number in this file with digits, and it is earned. It also excludes
//    the two boring wrong lowerings — a pass-through and a dropped numerator.
//
// 2. The four forms of 4.5.12.1-.4 are four SPELLINGS of one transfer function,
//    so they shall produce the same output from the same input. The four
//    coefficient sets below are all
//
//      H(z) = (1 - 0.5 z^-1) / (1 - 0.25 z^-1)
//
//      zi_zp(x, '{0.5,0}, '{0.25,0}, 1u)     §4.5.12.1  root form both sides:
//        one real zero at 0.5 giving (1 - 0.5 z^-1), one real pole at 0.25
//      zi_zd(x, '{0.5,0}, '{1,-0.25}, 1u)    §4.5.12.2  same zero, denominator
//        written out as d0 + d1 z^-1 = 1 - 0.25 z^-1
//      zi_np(x, '{1,-0.5}, '{0.25,0}, 1u)    §4.5.12.3  numerator written out
//        as n0 + n1 z^-1 = 1 - 0.5 z^-1, same pole
//      zi_nd(x, '{1,-0.5}, '{1,-0.25}, 1u)   §4.5.12.4  both written out
//
//    NO ROOT IS ZERO, and that is deliberate. 4.5.12.1-.3 each close with "If a
//    root is zero (0), then the term associated with it is implemented as z,
//    rather than (1 - z/r)" — so a root at the origin contributes a factor of z
//    to the zero-pole spellings, while the coefficient spellings have no way to
//    express one: '{1,0} as a numerator vector IS 1, not z. The earlier version
//    of this file gave zi_zp and zi_zd a zero at the origin and asserted them
//    equal to a unit numerator, which is exactly the factor of z the clause
//    inserts. It went green only because `//! analysis dc` evaluates at z = 1,
//    where z and 1 coincide — a conforming implementation of the zero-root rule
//    fails it the moment it runs in transient. With every root away from the
//    origin the four spellings are the same H(z) under any reading of that
//    sentence, which is the identity being pinned.
//
//    Whatever value the implementation picks at the DC point, it shall pick the
//    SAME one for all four — that claim IS in 4.5.12 and there are no digits to
//    write for it, which is the case the README reserves `CHECKEQ for. It still
//    bites: it is exactly what a lowering that special-cases one of the four
//    forms, or that drops a feedback term in one of them, fails.
//
//! lrm 4.5.12
//! lrm 4.5.12:2
//! lrm 4.5.12.1
//! lrm 4.5.12.1:1
//! lrm 4.5.12.2
//! lrm 4.5.12.2:1
//! lrm 4.5.12.3
//! lrm 4.5.12.3:1
//! lrm 4.5.12.4
//! lrm 4.5.12.4:1000
//! analysis dc
//! bias V(p) = 1.0
//! bias V(n) = 0.0
`include "check.vh"
module ch04_z_transform_filters(p, n);
    inout p, n;
    electrical p, n;
    real gain, y_zp, y_zd, y_np, y_nd;

    analog begin
        gain = zi_nd(V(p, n), '{2.0, 0.0}, '{1.0, 0.0}, 1u);

        y_zp = zi_zp(V(p, n), '{0.5, 0.0}, '{0.25, 0.0}, 1u);
        y_zd = zi_zd(V(p, n), '{0.5, 0.0}, '{1.0, -0.25}, 1u);
        y_np = zi_np(V(p, n), '{1.0, -0.5}, '{0.25, 0.0}, 1u);
        y_nd = zi_nd(V(p, n), '{1.0, -0.5}, '{1.0, -0.25}, 1u);

        // The only digits 4.5.12 fixes here: a delay-free filter is its gain.
        `CHECKX("a Z-filter with no z^-1 term is the pure gain n0/d0", gain, 2.0);

        // One transfer function, four spellings, one output.
        `CHECKEQ("zi_zd spells the same H(z) as zi_zp", y_zd, y_zp, 1e-12);
        `CHECKEQ("zi_np spells the same H(z) as zi_zp", y_np, y_zp, 1e-12);
        `CHECKEQ("zi_nd spells the same H(z) as zi_zp", y_nd, y_zp, 1e-12);
        `CHECK("zi_zp independently has DC gain two-thirds", y_zp, 0.6666666666666666, 1e-12);
        `CHECK("zi_zd independently has DC gain two-thirds", y_zd, 0.6666666666666666, 1e-12);
        `CHECK("zi_np independently has DC gain two-thirds", y_np, 0.6666666666666666, 1e-12);
        `CHECK("zi_nd independently has DC gain two-thirds", y_nd, 0.6666666666666666, 1e-12);

        I(p, n) <+ gain;
        I(p, n) <+ y_zp;
        I(p, n) <+ y_zd;
        I(p, n) <+ y_np;
        I(p, n) <+ y_nd;
    end
endmodule
