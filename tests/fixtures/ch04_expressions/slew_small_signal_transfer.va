// Full operator behavior is observed by tests/host.py;
// these local value/Jacobian checks alone do not prove the live tolerance or AC rule.
// §4.5.9 the SMALL-SIGNAL half of slew(), which is a sentence with two
// numbers in it and no fixture anywhere:
//
//   "In DC analysis, slew() simply passes the value of the destination to its
//    output. In small-signal analyses, the slew() function has a TRANSFER
//    FUNCTION FROM THE FIRST ARGUMENT TO THE OUTPUT OF 1.0 WHEN NOT SLEWING
//    (e.g. for a small-signal analysis following a dc operating point) AND 0.0
//    WHEN SLEWING."
//
// The transfer function from the first argument to the output, linearised at
// the current operating point, is exactly what §4.5.6's ddx() returns:
//
//   "The operator returns the partial derivative of its first argument with
//    respect to the unknown indicated by the second argument, holding all other
//    unknowns fixed and evaluated at the current operating point."
//
// so `ddx(slew(V(in,n), ...), V(in))` is the number the quoted sentence names,
// and it is observable in a transient without needing an .ac run.
//
// THE HAND DERIVATION. max_pos_slew_rate = 3e8 V/s, max_neg_slew_rate = -3e8
// V/s (§4.5.9 fixes those signs), and a unit step at t = 1ns on a 1ns grid, so
// the limiter may move 0.3 V per accepted step:
//
//   t/ns          0     1     2     3     4     5
//   V(in)         0     1     1     1     1     1
//   slew out      0   0.3   0.6   0.9     1     1
//   slewing?     dc   yes   yes   yes    no    no
//   d out/d in    1     0     0     0     1     1
//
//   · t = 0 is the DC point, where the quoted sentence makes slew() the
//     identity ("passes the value of the destination to its output"), so the
//     derivative is 1.
//   · t = 1..3ns the output is on the rate limit — its value is set by the
//     PREVIOUS accepted output plus rate*dt and does not depend on the present
//     input at all — so the transfer is 0.
//   · at t = 4ns the previous output is 0.9 and the limit would allow 1.2, so
//     the output is the input itself and the transfer is back to 1. The step
//     from 0.9 (not from 1.0) is deliberate: it keeps the last slewing point
//     strictly inside the limit rather than exactly on it, so the boundary
//     case where "reached the destination" and "still rate-limited" coincide
//     is not what decides the fixture.
//
// The ramp itself is asserted alongside so the derivative claim is anchored to
// a known operating point: min(1, 0.3*t/1ns) is §4.5.9's rate limit with the
// numbers above substituted by hand.
//
// STATUS AND WHAT THIS FILE IS FOR. Both checks PASS at all six points
// (re-run 2026-10-04 at ae9633f1 with `vera --emit-exe`). That is deliberate and disclosed: §4.5.9's small-signal sentence has
// no fixture anywhere under tests/fixtures/ — slew.va and
// slew_rate_sign_rejected.va cover the rate limit, the two default-rate
// spellings and the rate-sign refusal, and none of them touches the transfer
// function — so this file is a REGRESSION FLOOR for a number that is currently
// right and currently unpinned, not a claim that HEAD is broken. It is not
// vacuous: a kernel that lowered slew() as a first-order lag, or one whose
// ddx() did not see through the limiter, reads an intermediate slope here and
// fails the second check at 1e-15. A ddx() that treats slew() as the
// identity reads 1 where the table wants 0, at t = 1, 2 and 3 ns, and
// prints ok=0 there.
//
// WHAT WAS REMOVED, AND WHERE IT WENT. An earlier third check asserted
//
//     ddx(slew(...), V(in)) == 0.0 || ddx(slew(...), V(in)) == 1.0
//
// with the operator spelled twice, once in each operand of a `||`. Each side
// alone already reads exactly 0.0 or exactly 1.0 at every point; what failed
// was the disjunction, because the right-hand site is lowered into the `else`
// arm of a short-circuit branch and is fed a branch-local input. That is a
// §4.5.15 defect about where an analog operator may be evaluated, not a §4.5.9
// defect about slew()'s transfer function, and leaving it here invited
// "fixing" slew() to satisfy a check §4.5.9 does not license. The claim is not
// withdrawn: it now lives, still in this row, as
// analog_operator_in_short_circuit_operand.va, cited to §4.5.15.
//
//! lrm 4.5.9
//! lrm 4.5.9:1002
//! lrm 4.5.6
//! bias V(n) = 0
//! wave V(in) = 0, 1
//! time 0, 1n, 2n, 3n, 4n, 5n
//! analysis tran
//! print none
`include "check.vh"
module a04_slew_small_signal(in, n);
    inout in, n;
    electrical in, n;

    analog begin
        `CHECKEQ("the rate limit itself, 0.3 V per accepted step",
                 slew(V(in, n), 3e8, -3e8), min(1.0, 0.3 * ($abstime * 1e9)), 1e-12);
        // The clause's two numbers. The want is 0 exactly while the limiter is
        // active and 1 exactly when it is not; nothing between them is legal.
        `CHECKEQ("transfer is 0 while slewing and 1 when not",
                 ddx(slew(V(in, n), 3e8, -3e8), V(in)),
                 ($abstime <= 0.0 || $abstime >= 4n) ? 1.0 : 0.0, 1e-15);

        I(in, n) <+ 0.0;
    end
endmodule
