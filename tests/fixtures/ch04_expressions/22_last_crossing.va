// §4.5.10 last_crossing. Two statements from the LRM, and nothing more, because
// the LRM deliberately leaves the accuracy loose ("does not control the timestep
// ... it uses linear interpolation to estimate the time of the last crossing"):
//
//   "Before the expression crosses zero (0) for the first time, the
//    last_crossing() function returns a negative value."
//
//   direction +1 means the last time the input had a RISING edge.
//
// V(p,n) is held at -1 V through t = 1ns and steps to +1 V at t = 2ns, so the
// one rising crossing lies strictly inside (1ns, 2ns) — linear interpolation
// between the two samples puts it at 1.5ns, and any interpolation at all puts
// it in that open interval.
//
// Every check is gated by $abstime as an OPERAND rather than a branch, so each
// is a real restriction on the points it covers and vacuously true elsewhere:
// the first bites at t = 0 and 1ns, the second at t = 2ns, 3ns and 4ns.
// Corrected 2026-10-18 (#54): t = 2ns used to be skipped, citing "§4.5.2 lets
// the history advance on the accepted step". §4.5.2 is about tolerances and
// says nothing about history; §4.5 says an operator's "output is a function of
// both the input and the internal state", and at t = 2ns the input HAS crossed
// ("when a signal expression last crossed zero"), so the crossing is reported
// at the point that creates it (last_crossing_in_creating_step.va).
//
// 4.5.10 admits three direction indicators, +1, -1 and 0. This file queries
// +1 only; the other two are 146_last_crossing_directions.va, split off because
// VerA does not implement them and one file cannot be both green and xfail.
//
//! lrm 4.5.10
//! lrm 4.5.10:1001
//! bias V(n) = 0
//! wave V(p) = -1, -1, 1, 1, 1
//! time 0, 1n, 2n, 3n, 4n
//! analysis tran
//! print none
`include "check.vh"
module ch04_last_crossing(p, n);
    inout p, n;
    electrical p, n;
    real crossing_time;

    analog begin
        crossing_time = last_crossing(V(p, n), 1);

        `CHECKI("negative until the input has actually crossed",
                (crossing_time < 0.0) || ($abstime > 1.5e-9), 1);
        `CHECKI("the reported rising crossing lies inside (1ns, 2ns)",
                ($abstime < 1.5e-9) ||
                ((crossing_time > 1e-9) && (crossing_time < 2e-9)), 1);

        I(p, n) <+ crossing_time;
    end
endmodule
