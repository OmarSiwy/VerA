// LRM 4.7.1: an analog function body may reference only its own arguments,
// its locals and module-level parameters -- never a module-level variable.
//! reject E0314
//! reject outer
module ch4_fn_nonlocal(p); inout p; electrical p; real outer; analog function real nonlocal; input x; real x; nonlocal=x+outer; endfunction analog I(p)<+nonlocal(V(p)); endmodule
