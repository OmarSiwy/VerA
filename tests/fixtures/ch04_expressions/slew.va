// §4.5.9 slew — "slew() forces all transitions of expr faster than
// max_pos_slew_rate to change at max_pos_slew_rate rate". Unlike the transition
// filter, this one the LRM pins numerically: the output moves at exactly the
// limit while limiting, and stops at the input.
//
// The rates here are 1e6 V/s up and -2e6 V/s down, so the time base is
// microseconds: 1e6 * 1e-6 = 1.0 exactly in binary, one volt per step. A 5 V
// step applied at t = 1us therefore takes five steps to arrive, and the output
// at t is min(5, t/1us):
//
//   t/us    0    1    2    3    4    5    6
//   in      0    5    5    5    5    5    5
//   out     0    1    2    3    4    5    5
//
// which is written below as output minus that closed form, so the want is one
// literal at every time point. The closed form is spelled in $abstime and not
// in V(p,n), so it is an independent oracle and not an identity between two
// VerA expressions. The t = 0 point is the DC point and covers §4.5.9's "In DC
// analysis, slew() simply passes the value ... to its output".
//
// 4.5.9's general form is `slew(expr [, max_pos_slew_rate [,
// max_neg_slew_rate ]])` — three shapes, and the clause fixes what each of the
// two shorter ones means:
//
//   "If the max_neg_slew_rate is not specified, it defaults to the opposite of
//    the max_pos_slew_rate."
//     -> slew(x, 1e6) limits rising at 1e6 and falling at -1e6. The waveform
//        here only ever rises, so it must track the SAME min(5, t/1us) ramp.
//   "If no rates are specified, slew() passes the signal through unchanged."
//     -> slew(x) is x, which on this waveform is 0 before the step and 5 after.
//        `5.0 * ($abstime > 0.5u)` is that step written from the clock: §4.2.5
//        makes the comparison an integer 1 or 0, so it is an operand and the
//        assertion stays unconditional.
//
// Both are literal wants. Before this the two-rate form was the only shape
// written anywhere in the chapter.
//
//! lrm 4.5.9
//! lrm 4.5.9:1001
//! lrm 4.5.9:1
//! bias V(n) = 0
//! wave V(p) = 0, 5
//! time 0, 1u, 2u, 3u, 4u, 5u, 6u
//! analysis tran
//! print none
`include "check.vh"
module ch04_slew(p, n);
    inout p, n;
    electrical p, n;

    analog begin
        `CHECK("rises at exactly 1e6 V/s, then stops at the input",
               slew(V(p, n), 1e6, -2e6) - min(5.0, $abstime * 1e6), 0.0, 1e-12);
        `CHECK("a missing max_neg_slew_rate defaults to -max_pos_slew_rate",
               slew(V(p, n), 1e6) - min(5.0, $abstime * 1e6), 0.0, 1e-12);
        `CHECK("the omitted negative rate limits an actual falling signal to minus one million",
               slew(-V(p, n), 1e6) + min(5.0, $abstime * 1e6), 0.0, 1e-12);
        `CHECK("an explicit different negative rate gives a faster fall",
               slew(-V(p, n), 1e6, -2e6) + min(5.0, $abstime * 2e6), 0.0, 1e-12);
        `CHECK("with no rates at all slew passes the signal through unchanged",
               slew(V(p, n)) - 5.0 * ($abstime > 0.5e-6), 0.0, 1e-12);
        // "If the rate of change of expr is less than the specified maximum
        // slew rates, slew() returns the value of expr" — so it approaches the
        // input from below and never overshoots it.
        `CHECKI("never overshoots its input", slew(V(p, n), 1e6, -2e6) <= V(p, n), 1);

        I(p, n) <+ slew(V(p, n), 1e6, -2e6);
    end
endmodule
