// §4.5.13: limexp "internally limits the change of its output from iteration
// to iteration ... Thus, the simulator can only converge when the output of
// limexp() equals the exponential of the input", and "The apparent behavior
// of limexp() is not distinguishable from exp()".
//
// The bias is forced, so this evaluation is a point the solver accepts as it
// stands: whatever limexp limits between iterations, its output here is the
// exponential of its input. The argument is V(p, n) = 100, past the knee at
// 80 where VerA's limexp used to leave exp for the tangent e^80 * (1 + x - 80)
// (= 1.163530700722637e36 at 100, #52), so a junction biased past 80 Vt
// (about 2.07 V) converged to a current 2.3e7 times too small.
//
// The want, from mpmath at 40 digits: e^100 = 2.688117141816135448e43, whose
// nearest double 2.6881171418161356e43 is 0.33 ulp away; one ulp is 1.84e-16
// relative, so RTOL 1e-15 admits a faithful exp and excludes the tangent by
// seven orders of magnitude. The derivative is §4.5.13's too: d/dV of
// limexp(V) is exp(V), the same number, so the conductance is checked at the
// same RTOL. `exp` beside it is the identity the clause states, compared bit
// for bit (CHECKEQ, tolerance 0: no digits of its own).
//
//! lrm 4.5.13
//! lrm 4.5.13:1001
//! bias V(p) = 100, V(n) = 0
//! checks 3
`include "check.vh"
module ch04_limexp_converged(p, n);
    inout p, n;
    electrical p, n;
    analog begin
        `CHECKR("limexp(100) is e^100 at a converged point", limexp(V(p, n)), 2.6881171418161356e43, 1e-15);
        `CHECKR("d limexp(V)/dV is e^100 there", ddx(limexp(V(p, n)), V(p)), 2.6881171418161356e43, 1e-15);
        `CHECKEQ("limexp(V) is exp(V)", limexp(V(p, n)), exp(V(p, n)), 0.0);
        I(p, n) <+ V(p, n);
    end
endmodule
