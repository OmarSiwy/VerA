// §4.1 "Any legal operand, such as an integer or an indexed element from an
// array of reals, without a operator is also considered an expression.
// Wherever a value is needed in a Verilog-AMS HDL statement, an expression can
// be used. Some statement constructs require an expression to be a constant
// expression. The operands of a constant expression consists of constant
// numbers and parameter names, but they can use any of the operators defined in
// Table 4-1, Table 4-14, and Table 4-15."
//
// Two claims, each pinned where the rule bites:
//
// 1. A parameter declaration is a statement construct that REQUIRES a constant
//    expression (§3.4). Its initializer below mixes constant numbers, another
//    parameter's name, and Table 4-1 operators (shift, subtraction, division,
//    the conditional operator), plus a Table 4-14 function (`abs`):
//
//      w     = 3
//      mask  = (1 << w) - 1                 = 8 - 1           = 7
//      half  = w / 2.0                      = 1.5
//      pick  = (mask > 6) ? abs(-half) : 0  = 1.5
//
//    A second constant-expression site, a generate-if scheme, selects the arm
//    whose `level` is 0.25 because mask == 7. (§6.2: multiple analog blocks
//    combine in the order they appear, after generate selection, so the arm's
//    assignment runs before the main block's checks.)
//
// 2. "an indexed element from an array of reals, without a operator" is an
//    expression: `arr[1]` alone on the right of an assignment. arr[1] = 0.625.
//
// Every value is an integer or dyadic, so every check is exact.
//
//! lrm 4.1
//! lrm 4.1:1000
//! bias V(p) = 0.5
`include "check.vh"
module ch04_constant_expression_of_parameters_and_operators(p);
  inout p;
  electrical p;
  parameter integer w = 3;
  parameter integer mask = (1 << w) - 1;
  parameter real half = w / 2.0;
  parameter real pick = (mask > 6) ? abs(-half) : 0.0;

  real arr[0:1];
  real x, level;

  generate
    if (mask == 7) begin : seven
      analog level = 0.25;
    end else begin : other
      analog level = 0.0;
    end
  endgenerate

  analog begin
    `CHECKI("§4.1 a parameter from numbers, another parameter and <<, -", mask, 7);
    `CHECKX("§4.1 a parameter from a parameter name and /", half, 1.5);
    `CHECKX("§4.1 a parameter from ?: and a Table 4-14 function", pick, 1.5);
    `CHECKX("§4.1 a constant expression chose the generate arm", level, 0.25);
    arr[0] = 0.125;
    arr[1] = 0.625;
    x = arr[1];
    `CHECKX("§4.1 an indexed array element alone is an expression", x, 0.625);
    I(p) <+ V(p) * half;
  end
endmodule
