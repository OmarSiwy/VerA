// §4.5.8, the third of the four interrupted-transition cases (Figures 4-10
// and 4-11):
//
//   "If the original transition was falling and the new destination value is
//    below the value at the interruption, then the original transition's
//    origin shall be used to compute the new origin. ... Then the original
//    transition's origin (v1) shall be used along with the new fall time
//    (tf3), to calculate the slope: (v3-v1)/tf3. This slope will be applied
//    from the point of interruption (ti,vi), and the readjusted transition's
//    expected end time (t3) is then calculated using this slope, along with
//    the time and value level at the point of the interruption:
//    t3 = ti + (v3-vi)/slope."
//
// HAND DERIVATION. transition(V(p, n), 0, 2n, 4n): td = 0, rise 2ns, fall 4ns.
// The input is 4 at the DC point (passed straight through, §4.5.8), 0 from
// t = 1ns, then -4 from 3ns.
//
//   Original fall: (t1,v1) = (1ns, 4) to (t2,v2) = (5ns, 0), slope -1 V/ns.
//   At ti = 3ns the output is vi = 2 and the input becomes v3 = -4 < vi.
//   tf3 = 4ns (the fall time). slope = (v3 - v1)/tf3 = (-4 - 4)/4ns = -2 V/ns,
//   from (3ns, 2); t3 = ti + (v3 - vi)/slope = 3 + (-6)/(-2) = 6ns.
//
//   t/ns   0   1   2   3   4   5    5.5   6    7
//   out    4   4   3   2   0   -2   -3    -4   -4
//
// The wrong readings differ at 4, 5, 5.5 and 6ns: a fresh fall from (ti,vi)
// over tf3, slope (v3-vi)/tf3 = -1.5 V/ns, reads 0.5, -1, -1.75, -2.5;
// using the destination v2 as origin, (v3-v2)/tf3 = -1 V/ns, reads 1, 0,
// -0.5, -1. (python3 check: piecewise-linear through (1,4), (3,2), (6,-4).)
//
//! lrm 4.5.8
//! lrm 4.5.8:8
//! lrm 4.5.8:9
//! lrm 4.5.8:7
//! lrm 4.5.8:10
//! analysis tran
//! bias V(n) = 0
//! wave V(p) = 4, 0, 0, -4
//! time 0, 1n, 2n, 3n, 4n, 5n, 5.5n, 6n, 7n
//! print none
//! checks 9
`include "check.vh"
module b2_transition_interrupted_falling_lower(p, n);
    inout p, n;
    electrical p, n;
    real tns, y;

    analog begin
        tns = $abstime * 1e9;
        y = transition(V(p, n), 0, 2n, 4n);
        if (tns < 0.5)
            `CHECK("falling, interrupted downward: at t = 0", y, 4.0, 1e-9);
        else if (tns < 1.5)
            `CHECK("falling, interrupted downward: at t = 1ns", y, 4.0, 1e-9);
        else if (tns < 2.5)
            `CHECK("falling, interrupted downward: at t = 2ns", y, 3.0, 1e-9);
        else if (tns < 3.5)
            `CHECK("falling, interrupted downward: at t = 3ns (ti, vi)", y, 2.0, 1e-9);
        else if (tns < 4.5)
            `CHECK("falling, interrupted downward: at t = 4ns", y, 0.0, 1e-9);
        else if (tns < 5.25)
            `CHECK("falling, interrupted downward: at t = 5ns", y, -2.0, 1e-9);
        else if (tns < 5.75)
            `CHECK("falling, interrupted downward: at t = 5.5ns", y, -3.0, 1e-9);
        else if (tns < 6.5)
            `CHECK("falling, interrupted downward: at t = 6ns = t3", y, -4.0, 1e-9);
        else
            `CHECK("falling, interrupted downward: at t = 7ns", y, -4.0, 1e-9);
        I(p, n) <+ 1e-3 * y;
    end
endmodule
