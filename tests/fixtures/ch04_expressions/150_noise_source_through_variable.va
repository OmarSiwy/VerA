// §4.6.4.6's own shape: a noise function's output held in a variable and then
// contributed. The clause prints it as the way correlated noise is written —
//
//     n = white_noise(pwr);
//     V(a,b) <+ c1*n;
//     V(c,d) <+ c2*n;
//
// — so it is not an exotic spelling, it is THE spelling for the one thing §4.6.4
// says you cannot get any other way: "Perfectly correlated noise is generated by
// using the output of one noise function for more than one noise source."
//
// This fixture takes the simplest case of it — one source, one use — because
// that isolates what breaks. A generator was declared and it belongs to branch
// (a,b); §4.6.4.1's inline form
// (`ch04_expressions/148_white_noise_topology.va`) exports exactly that, and
// putting the same source through a variable first must not change which
// generator the device tells its host about. The value half is unchanged either
// way and is asserted below; the topology half is what `//! noise` reads.
//
// Its sibling `38_correlated_noise.va` pins the value rule for the two-branch
// form.
//
// What this cost to close: `Lower.var_noise` records the sources a variable
// name carries, and `noiseSrcsOf` consults it when the walk reaches an
// identifier. It is reaching and not dataflow — a name is never cleared — so a
// variable reassigned away from a source still counts as holding one. That
// over-reports a row in a topology table; what it replaces under-reported a
// GENERATOR, which is a PSD a host had no way to know it should ask for.
//
// The other half of §4.6.4.6 is the `#0` below: `contract.NoiseGen.source`
// names the generator identity, so a host can tell one source reached through
// a variable from two independent ones. `38_correlated_noise.va` pins the
// two-branch sharing; `161_partially_correlated_noise.va` pins Example 2.
//
//! lrm 4.6.4.6
//! lrm 4.6.4.1
//! noise thermal(a,b)#0
//! analysis dc
//! bias V(a) = 1.0
//! bias V(b) = 0.0
`include "check.vh"
module ch04_noise_source_through_variable(a, b);
    inout a, b;
    electrical a, b;
    parameter real R = 1000.0 from (0:inf);
    real n;

    analog begin
        n = white_noise(4.0 * `P_K * $temperature / R, "thermal");
        I(a, b) <+ V(a, b)/R + n;
        `CHECKX("a variable-held white_noise source is inactive in a dc analysis", n, 0.0);
        `CHECKX("so the dc current is the resistive term alone", V(a,b)/R, 1e-3);
    end
endmodule
