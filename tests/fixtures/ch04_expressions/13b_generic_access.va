// LRM 4.4, verbatim: "As an alternative to using the access attribute specified
// in the discipline, the generic potential and flow access functions are also
// supported (see 5.5.1)." Table 4-16 lists them as rows of their own —
// `potential(b1)` "Alternative access of the voltage across the branch b1" and
// `flow(n1)` "Alternative access of the current flowing in the unnamed branch
// from n1 to ground" — and the general rule takes "a branch identifier, or a
// list of one or two nets or port expressions", so the two-net form
// `potential(p, n)` is equally in.
//
// "Alternative" is the whole claim: the generic name reaches the SAME signal as
// the discipline's own access function, so the identities below hold at every
// operating point and are what CHECKEQ exists for. The potential side also has
// digits, and they are written down: the bias puts p at 1.5 V and n at 0.5 V,
// both exact in IEEE 754, so potential(p, n) is exactly 1.0 and a compiler that
// resolved the generic name to a fresh zero unknown fails that check rather
// than agreeing with itself.
//
// This file used to be `//! reject expression` — a diagnostic substring so
// generic that almost anything satisfies it — on source 4.4 declares supported.
//
//! lrm 4.4
//! xfail VerA's parser does not know the generic access functions: `potential` and `flow` are not spellings it accepts as an operand, so both die at E0209
//! bias V(p) = 1.5
//! bias V(n) = 0.5
`include "check.vh"
module ch04_generic_access(p, n);
    inout p, n;
    electrical p, n;

    analog begin
        `CHECKX("potential(p,n) at the declared bias", potential(p, n), 1.0);
        `CHECKEQ("potential(p,n) and V(p,n) are one signal", potential(p, n), V(p, n), 0.0);
        `CHECKEQ("flow(p) and I(p) are one signal", flow(p), I(p), 0.0);
        I(p, n) <+ V(p, n) / 1.0k;
    end
endmodule
