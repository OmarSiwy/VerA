// LRM 4.6.1 Table 4-22, the TRAN column — the mirror image of 26_analysis.va,
// which only ever queries the DC Sweep column. Between them the two fixtures
// pin two columns of the table, and neither alone can: a compiler that
// hardwired analysis() to 1 for "dc"/"static" and 0 for everything else passes
// 26 clean.
//
// Table 4-22 splits TRAN into two sub-columns, OP and Tran, and the rows
// disagree between them: "nodeset", "static" and "ic" are 1 during the initial
// operating point and 0 during the transient steps. Which of the two a given
// evaluation lands in is the simulator's business, so those three rows are NOT
// asserted here — that would over-specify the table. The four rows that read
// the same in both sub-columns are:
//
//     "tran"    1  1
//     "dc"      0  0
//     "ac"      0  0
//     "noise"   0  0
//
// and 4.6.1 fixes the multi-argument form independently: analysis() "returns
// one (1) if ANY argument matches the current analysis type", so
// analysis("ac", "tran") is 1 here on the strength of its second argument
// alone, which is what catches a lowering that only inspects the first.
//
// "Any unsupported type names are assumed to not be a match", so a name no
// simulator defines reads 0 rather than raising anything.
//
//! lrm 4.6.1
//! lrm 4.6.1:1002
//! lrm 4.6.1:1
//! analysis tran
//! bias V(p) = 0.5
`include "check.vh"
module ch04_analysis_transient(p, n);
    inout p, n;
    electrical p, n;

    analog begin
        `CHECKI("analysis(\"tran\") in a transient analysis", analysis("tran"), 1);
        `CHECKI("analysis(\"dc\") is false in a transient analysis", analysis("dc"), 0);
        `CHECKI("analysis(\"ac\") is false in a transient analysis", analysis("ac"), 0);
        `CHECKI("analysis(\"noise\") is false in a transient analysis", analysis("noise"), 0);
        `CHECKI("a multi-argument analysis() is the OR of its arguments", analysis("ac", "tran"), 1);
        `CHECKI("an unsupported type name is not a match", analysis("montecarlo"), 0);
        I(p, n) <+ V(p, n);
    end
endmodule
