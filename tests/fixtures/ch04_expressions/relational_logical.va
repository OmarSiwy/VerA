// LRM 4.2.5 relational, 4.2.7 logical equality, 4.2.8 logical: each yields the
// INTEGER 1 when the relation holds and 0 when it does not -- never -1 and never
// a distinct boolean type, which is what lets the nine results be summed.
//
// The bias fixes a = V(p,n) = 0.5 against b = 1.0, so with 0 < a < b:
//   (a<b)=1  (a<=b)=1  (a>b)=0  (a>=b)=0  (a==b)=0  (a!=b)=1
//   !(a==0.0) = !0 = 1
//   ((a>0)&&(b>0)) = 1      ((a<0)||(b>0)) = 1
// value = 1+1+0+0+0+1+1+1+1 = 6.
// Check the individual operators too: swapping two opposite results can
// preserve that sum. Fractional and negative real operands are nonzero for
// logical operations; converting them to integers first would be incorrect.
//
// 4.2.8's precedence: && binds tighter than ||, and both bind less tightly
// than the equality operators. Each literal below is chosen so the wrong
// grouping gives the other value:
//   1 || 0 && 0   = 1 || (0 && 0) = 1   (left grouping would be (1 || 0) && 0 = 0)
//   2 == 2 && 3   = (2 == 2) && 3 = 1   (&& tighter would be 2 == (2 && 3) = 0)
//   2 == 2 || 0   = (2 == 2) || 0 = 1   (|| tighter would be 2 == (2 || 0) = 0)
//
//! lrm 4.2.5
//! lrm 4.2.7
//! lrm 4.2.8
//! lrm 4.2.1:1001
//! lrm 4.2.5:1000
//! lrm 4.2.7:1
//! lrm 4.2.8:1000
//! bias V(p) = 0.5
//! checks 17
`include "check.vh"
module ch04_relational_logical(p, n);
    inout p, n;
    electrical p, n;
    real a, b;
    integer value;

    analog begin
        a = V(p, n);
        b = 1.0;
        value = (a < b) + (a <= b) + (a > b) + (a >= b) +
                (a == b) + (a != b) + !(a == 0.0) +
                ((a > 0.0) && (b > 0.0)) + ((a < 0.0) || (b > 0.0));
        `CHECKI("a true relation is exactly 1", (a != b), 1);
        `CHECKI("a false relation is exactly 0", (a >= b), 0);
        `CHECKI("sum of the nine results at a=0.5, b=1.0", value, 6);
        `CHECKI("less-than is independently true", a < b, 1);
        `CHECKI("less-or-equal is independently true", a <= b, 1);
        `CHECKI("greater-than is independently false", a > b, 0);
        `CHECKI("equality is independently false", a == b, 0);
        `CHECKI("logical not of a fractional real is false", !a, 0);
        `CHECKI("logical not of zero is true", !(a - 0.5), 1);
        `CHECKI("two fractional reals are both logically true", a && -a, 1);
        `CHECKI("logical and with zero is false", a && (a - 0.5), 0);
        `CHECKI("logical or accepts a negative nonzero real", (a - 0.5) || -a, 1);
        `CHECKI("logical or of two zeros is false", (a - 0.5) || (a - 0.5), 0);
        `CHECKI("a comparison may be used as an integer operand", (a < b) + 2, 3);
        `CHECKI("&& binds tighter than ||", 1 || 0 && 0, 1);
        `CHECKI("== binds tighter than &&", 2 == 2 && 3, 1);
        `CHECKI("== binds tighter than ||", 2 == 2 || 0, 1);
        I(p, n) <+ value;
    end
endmodule
