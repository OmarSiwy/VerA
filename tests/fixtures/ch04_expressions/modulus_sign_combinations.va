// AMS 4.2.4: real modulus subtracts trunc(a/b)*b from a, expressed in
// the LRM using ceil for negative quotients and floor otherwise.
// Input a=V(p,n)=5.5; b is +/-2.0. Quotients are +/-2.75, truncated to
// +/-2, so the four remainders follow a's sign: +1.5,+1.5,-1.5,-1.5.
// All values are exact in binary. Integer 11%2 is 11-5*2=1.
// The positive-divisor cases are legal neighbors of the isolated zero tests.
// This covers input-derived dividends with constant divisors, not dynamic
// divisor-zero handling, exceptional magnitudes, or signed-zero bit patterns.
//! lrm 4.2.4
//! bias V(p) = 5.5, V(n) = 0
//! checks 5
`include "check.vh"
module audit_modulus_sign_combinations(p, n);
    inout p, n;
    electrical p, n;
    analog begin
        `CHECKX("positive positive", V(p,n) % 2.0, 1.5);
        `CHECKX("positive negative", V(p,n) % (-2.0), 1.5);
        `CHECKX("negative positive", (-V(p,n)) % 2.0, -1.5);
        `CHECKX("negative negative", (-V(p,n)) % (-2.0), -1.5);
        `CHECKI("integer legal neighbor", 11 % 2, 1);
        I(p,n) <+ V(p,n);
    end
endmodule
