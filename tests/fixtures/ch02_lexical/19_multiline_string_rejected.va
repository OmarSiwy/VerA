// LRM 2.7: "A string literal is a sequence of characters enclosed by double
// quotes and contained on a single line."
//! reject ParseError
//! reject E0138
//! reject a string literal may not span lines
//! lrm 2.7
module ch02_multiline_string_rejected;
    string value = "first
second";
endmodule
