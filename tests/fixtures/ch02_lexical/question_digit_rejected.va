// Annex C.3 is the authority here, not §2.6.1. §2.6.1 makes `?` "a Verilog-AMS
// HDL alternative for the z character", and Annex C.3 withdraws it from
// Verilog-A in the same sentence that withdraws x and z: "In the same
// paragraph, the use of the question mark character as an alternative for z is
// also limited to the mixed signal context."
//
// `4'b?` is in an analog block with no mixed-signal context, so refusing it is
// conformance, not debt — the alias is exactly as unavailable as the `z` it
// stands for.
//! lrm C.3
//! lrm 2.6.1
//! reject-only E0130
module ch02_question_digit_rejected;
    integer value;
    analog value = 4'b?;
endmodule
