// Annex C.3 is the authority here, not §2.6.1. §2.6.1 gives x and z their bit
// semantics for Verilog-AMS, and Annex C.3 then withdraws them from Verilog-A:
// "From 2.6, Numbers: support for x and z values is limited in the analog block
// to the mixed signal context, as defined in 7.3.2."
//
// `4'b01xz` is in an analog block with no mixed-signal context, so refusing it
// is conformance, not debt. A Verilog-AMS compiler with the mixed-signal
// context available is outside what this fixture claims.
//! lrm C.3
//! lrm 2.6.1
//! reject-only E0130
module ch02_xz_integer_rejected;
    integer value;
    analog value = 4'b01xz;
endmodule
