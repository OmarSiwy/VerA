// DEBT — this rejection is NOT conformance.
// The LRM permits what VerA refuses here. The substrings below record
// CURRENT behavior so the suite stays green on it; they do not claim it
// is right. `zig build ledger` counts this rule against VerA.
//
// VAMS-2.6.1-14  (ch2-lexical.html)
// An x shall set 4 bits to unknown in the hexadecimal base, 3 bits in the octal base, and 1 bit in the binary base.
// VAMS-2.6.1-15  (ch2-lexical.html)
// Similarly, a z shall set 4 bits, 3 bits, and 1 bit, respectively, to the high-impedance value.
// VAMS-2.6.1-17  (ch2-lexical.html)
// If the left-most bit in the unsigned number is an x or a z , then an x or a z shall be used to pad to the left respectively.
// VAMS-2.6.1-20  (ch2-lexical.html)
// Unsized unsigned constants where the high order bit is unknown ( X or x ) or three-state ( Z or z ) shall be extended to the size of the expression co
// … and 1 more rule(s); see tests/lrm-rules/
//
//! reject E0130
// EXPECT: error
module ch02_xz_integer_rejected;
    integer value;
    analog value = 4'b01xz;
endmodule
