// §2.6 Numbers, verbatim:
//
//   "Constant numbers can be specified as integer constants (defined in 2.6.1)
//    or real constants."
//
// followed by Syntax 2-2, whose first production is the whole clause's
// grammar — `number ::= decimal_number | octal_number | binary_number |
// hex_number | real_number` — and which DEFINES `real_number`, `exp` and
// `scale_factor` at 2.6 rather than at 2.6.2.
//
// WHAT THIS FILE PINS, and why it is not a repeat of 04/06/07. The arms are
// the children's and are pinned by them (04_integer_bases for the four integer
// forms, 06_real_notation for real_number's first two alternatives,
// 07_si_scale_factors for the third and for the scale-factor alphabet) — each
// of those files puts its literals in an ANALOG EXPRESSION. This file puts one
// arm of the production in `constant_primary`, the position `number` is
// reached from through A.8.4's `constant_primary ::= number` and A.8.7:
//
//     parameter_declaration ... = constant_mintypmax_expression
//       -> ... -> constant_primary -> number
//
// The six defaults below are therefore the union claim of 2.6 stated where it
// can be observed: the ONE production serves the constant-expression grammar
// as well as the analog one, so a real constant is as much a constant_primary
// as an integer constant is, and a based integer as much as a simple decimal.
// A compiler can implement every child rule and still fail here — that is the
// point of the file. The three ways it happens:
//
//   * CONSTANT FOLDING THAT IS INTEGER-ONLY. `parameter real sc = 24.7K;`
//     compiles only if the scale factor is folded into a real. A folder that
//     keeps the mantissa and drops the suffix prints 24.7 where 24700 was
//     written; one that never visits the real arm rejects the line.
//   * A LEXER THAT ENDS A NUMBER AT A LETTER. `24.7K` would lex as the real
//     24.7 followed by the identifier K — a syntax error at best, 24.7 at
//     worst. The same lexer reads `1.30e-2` as 1.30, then `e`, then `-2`.
//   * A SIZE THAT IS READ AS DIGITS. `4'b1001` is nine, not one thousand and
//     one. Dropping the `4'b` and reading the value in decimal prints 1001.
//
// Every want is hand-derived:
//
//   659        a simple decimal number, literally the value              659
//   'o7460     7*512 + 4*64 + 6*8 + 0                               =  3888
//   4'b1001    1*8 + 0*4 + 0*2 + 1                                  =     9
//   8'hA5      10*16 + 5                                            =   165
//   24.7K      24.7 x 10^3, the LRM's own scaled example            = 24700
//   1.30e-2    1.30 x 10^-2, the LRM's own scientific example       = 0.013
//
// The last two are CHECKX rather than a relative tolerance because they were
// measured exact in this suite's own terms: 24.7 and 1.3 are the correctly
// rounded doubles nearest those decimals and scaling by a power of ten
// reproduces the double the want spells (07_si_scale_factors.va says the same
// of the first), and §2.6.2 puts real constants under IEEE Std 754, whose
// decimal conversion is correctly rounded (06_real_notation.va's argument).
//
// A real constant in a real expression, and a based literal in an analog
// primary, are the children's half of the union and are not re-pinned; the
// contribution at the end uses them because a module with no contribution
// solves nothing.
//! lrm 2.6
//! lrm 2.6:1
//! lrm 2.6.1
//! lrm 2.6.1:1
`include "check.vh"
module ch02_number_positions(p, n);
    inout p, n;
    electrical p, n;
    parameter integer decimal_arm = 659;
    parameter integer octal_arm = 'o7460;
    parameter integer binary_arm = 4'b1001;
    parameter integer hex_arm = 8'hA5;
    parameter real scaled_arm = 24.7K;
    parameter real exponent_arm = 1.30e-2;

    analog begin
        `CHECKI("decimal_number in a constant_primary", decimal_arm, 659);
        `CHECKI("octal_number in a constant_primary", octal_arm, 3888);
        `CHECKI("binary_number in a constant_primary", binary_arm, 9);
        `CHECKI("hex_number in a constant_primary", hex_arm, 165);
        `CHECKX("real_number, scale_factor arm, in a constant_primary", scaled_arm, 24700.0);
        `CHECKX("real_number, exp arm, in a constant_primary", exponent_arm, 0.013);
        I(p, n) <+ scaled_arm + exponent_arm;
    end
endmodule
