// AMS2.2/2.4, printed11/PDF24: comments are lexical tokens; neighboring
// tokens must not be welded after removing a comment. The declaration below
// is real then value, not identifier realvalue. The later assignment/readback
// yields7 and establishes a legal neighbor to39_block_comment_separates_tokens.
//! lrm 2.2
//! lrm 2.4
//! lrm 2.2:1
//! lrm 2.4:2
//! checks 1
`include "check.vh"
module audit_comment_separator_legal_neighbor(p);
    inout p;
    electrical p;
    real/* token separator */value;
    analog begin
        value = 7.0;
        `CHECKX("comment separates keyword and identifier", value, 7.0);
        I(p) <+ 0.0;
    end
endmodule
