// §2.5: "A conditional operator shall have two operator characters which
// separate three operands."
//
// `c ? a;` has one operator character and two operands: the `:` and the third
// operand are missing, so it is not a conditional expression and the statement
// does not parse. b1_2_5_conditional_three_operands.va is this file with the
// `: b` present; that is the only difference.
//
// VerA reads `c ? a` and then wants the second operator character: E0207
// "unexpected token", found `;`, expected `:`.
//
//! lrm 2.5
//! lrm 2.5:3
//! reject-only E0207
//! reject expected `:`
//! neighbour b1_2_5_conditional_three_operands.va
`include "check.vh"
module b1_conditional_three_operands(p, n);
    inout p, n;
    electrical p, n;
    real a, b, x;
    integer c;

    analog begin
        a = 10.0;
        b = 20.0;
        c = 0;
        x = c ? a;
        `CHECKX("c ? a : b with c = 0 selects the third operand", x, 20.0);
        I(p, n) <+ x * V(p, n);
    end
endmodule
