// LRM 2.7, Table 2-2: "A character specified in 1–3 octal digits".
// For fewer than three digits the next character must not be octal. Exercise
// all three lengths and the stopping rule: A ends the short forms, while the
// fourth digit in \1012 is a separate ASCII '2', not part of the escape.
// String literals in integer expressions pack one unsigned ASCII byte per
// character. Derived wants: 7*256+65=1857; 63*256+65=16193;
// 65*256+50=16690; 255 is the largest mandatory octal byte; 0*256+65=65.
// No claim is made about \400: Table 2-2 permits an implementation to reject
// an escape above \377. These checks do not depend on that optional choice.
//! lrm 2.7
//! lrm 2.7:2
`include "check.vh"
module ch02_octal_escape_boundaries(p, n);
    inout p, n;
    electrical p, n;
    analog begin
        `CHECKI("one octal digit then non-octal", "\7A", 1857);
        `CHECKI("two octal digits then non-octal", "\77A", 16193);
        `CHECKI("three octal digits then an ordinary digit", "\1012", 16690);
        `CHECKI("maximum mandatory octal byte is unsigned", "\377", 255);
        `CHECKI("zero octal byte before A", "\000A", 65);
        I(p, n) <+ 0.0;
    end
endmodule
