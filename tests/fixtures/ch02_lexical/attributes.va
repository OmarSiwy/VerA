// §2.9: an attribute_instance is a prefix on a declaration or module item and
// carries tool properties, including properties used by simulators. This is
// a decorated-declaration computation regression, not proof that attributes
// are universally inert or that metadata reporting works. Here
// `conductance` still holds the §2.6.2 scaled literal `1m` = 1e-3 after four
// attributes were attached to it, and the module still conducts. The
// metadata/report observations (AMS-ATTR-DESC-HELP, AMS-ATTR-OP-YES,
// AMS-ATTR-MULT-NONE) are not claimed here.
//! lrm 2.9
//! lrm 3.4.3
//! lrm 2.9:2
//! lrm 2.9.1
//! lrm 2.9.1:1000
`include "check.vh"
(* optimize_power = 1 *)
module ch02_attributes(p, n);
    (* desc = "positive terminal" *) inout p, n;
    (* desc = "disciplined terminals" *) electrical p, n;
    (* desc = "conductance", units = "S", op = "yes", multiplicity = "none" *)
    parameter real conductance = 1m;

    analog begin
        `CHECKX("an attributed parameter keeps its default", conductance, 0.001);
        I(p, n) <+ conductance * V(p, n);
    end
endmodule
