// §2.4: block comments do not nest and `//` has no special meaning inside one,
// so `2.0 /* // */ + 3.0` is one addition of two operands, not a truncated line.
// §2.6.2: an underscore anywhere in a number after the first character is
// IGNORED, so `1_000.0` is the same double as `1000.0` — not 1.0, and not an
// identifier `_000` glued to a 1.
// §2.4 again, the rule the whole `//!` mechanism rests on: a one-line
// comment "ends with a newline" and a block comment "ends with */", with no
// exception carved out for the grave accent. So a compiler directive written
// inside a comment is comment text and nothing else. CH02_SCALE is defined
// once, for real, then "redefined" twice inside comments; if either of those
// reached the preprocessor the macro would read 9.0 or 16.0 instead of 4.0.
// This is what lets a `//! bias` line be an expectation to the harness and a
// plain comment to every other tool.
//! lrm 2.4
//! lrm 2.6.2
//! lrm 2.4:1
//! lrm 2.4:2
//! lrm 2.4:4
//! lrm A.9.2
//! lrm A.9.2:1000
`include "check.vh"
`define CH02_SCALE 4.0
// `define CH02_SCALE 9.0
/* `define CH02_SCALE 16.0 */
module ch02_whitespace_comments(p, n); // a one-line comment
	/* The // token is ordinary text inside a block comment. */
	inout p, n;
	electrical p, n;
	analog begin
		`CHECKX("underscore in a real literal is ignored", 1_000.0, 1000.0);
		`CHECKX("// inside a block comment does not start a comment", 2.0 /* // */ + 3.0, 5.0);
		`CHECKX("a define inside a one-line or block comment is not a directive", `CH02_SCALE, 4.0);
		I(p, n) <+ V(p, n) / 1_000.0;
	end
endmodule
`undef CH02_SCALE
