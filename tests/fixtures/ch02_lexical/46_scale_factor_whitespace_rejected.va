// LRM 2.6.2, immediately under Table 2-1: "No space is permitted between the
// number and the symbol." So `1.3 u` is not 1.3e-6; the `u` is not part of the
// literal and is left dangling after a complete expression.
//
// The positive half of the rule -- `1u` == 1e-6, and the rest of Table 2-1 --
// is 07_si_scale_factors.va. This file is the negative that closes it, and
// it matters: silently reading `1.3 u` as 1.3e-6 would be a six-decade error
// that no value assertion elsewhere could catch.
//! lrm 2.6.2
//! lrm 2.6.2:1001
//! lrm A.10
//! lrm A.10:1
//! reject-only E0207
//! neighbour 07_si_scale_factors.va
module ch02_scale_factor_whitespace_rejected;
    real value;
    analog value = 1.3 u;
endmodule
