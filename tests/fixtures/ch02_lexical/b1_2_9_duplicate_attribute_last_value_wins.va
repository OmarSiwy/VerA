// §2.9: "If the same attribute name is defined more than once for the same
// language element, the last attribute value shall be used and a tool can give
// a warning that a duplicate attribute specification has occurred."
//
// 20_duplicate_attributes.va repeats `desc` and `units`, whose values no
// arithmetic can see, so it cannot tell first from last. This file repeats an
// attribute whose value changes what the device computes: VerA's `vera_nodiff`
// (AGENTS.md §6, ch04_expressions/ddx_vera_nodiff_assignment.va). On (1), the
// assignment stores its value with no derivative; off (0), the derivative is
// kept. §4.5.6 `ddx` reads which one happened.
//
// Both spellings of "more than once for the same language element" are here:
// two specs in one attribute_instance, and two attribute_instances in front of
// one statement (A.6.4's `{ attribute_instance }` prefix).
//
// DERIVATION. V(a) = 0.5, V(b) = 0, c = V(a)^2 = 0.25, ddx(c, V(a)) = 2 V(a) = 1.0.
//   (* vera_nodiff = 1, vera_nodiff = 0 *)    last is 0: kept      ddx = 1.0
//   (* vera_nodiff = 0, vera_nodiff = 1 *)    last is 1: stopped   ddx = 0.0
//   (* vera_nodiff = 1 *) (* vera_nodiff = 0 *)  last is 0         ddx = 1.0
//   (* vera_nodiff = 0 *) (* vera_nodiff = 1 *)  last is 1         ddx = 0.0
// A tool that used the FIRST value gives the other number on every line. The
// stop changes lanes, never a value, so every k is 0.25.
//
//! lrm 2.9
//! lrm 2.9:4
//! lrm 4.5.6
//! fd-exempt `(* vera_nodiff *)` stores its assignments with no derivative by design (AGENTS.md §6), so the Jacobian omits what a difference sees
//! bias V(a) = 0.5, V(b) = 0.0
//! checks 5
`include "check.vh"
module b1_duplicate_attribute_last_value_wins(a, b);
    inout a, b;
    electrical a, b;
    real c, k1, k2, k3, k4;

    analog begin
        c = V(a) * V(a);
        (* vera_nodiff = 1, vera_nodiff = 0 *) k1 = c;
        (* vera_nodiff = 0, vera_nodiff = 1 *) k2 = c;
        (* vera_nodiff = 1 *) (* vera_nodiff = 0 *) k3 = c;
        (* vera_nodiff = 0 *) (* vera_nodiff = 1 *) k4 = c;
        I(a, b) <+ (k1 + k2 + k3 + k4) * V(a, b);
        `CHECKX("one instance, last value 0: the derivative is kept", ddx(k1, V(a)), 1.0);
        `CHECKX("one instance, last value 1: the derivative is stopped", ddx(k2, V(a)), 0.0);
        `CHECKX("two instances, last value 0: the derivative is kept", ddx(k3, V(a)), 1.0);
        `CHECKX("two instances, last value 1: the derivative is stopped", ddx(k4, V(a)), 0.0);
        `CHECKX("the stop changes no value", k2, 0.25);
    end
endmodule
