// §2.6.2 Table 2-1, one row per check. The wants are the table, not a
// derivation: T=1e12, G=1e9, M=1e6, K and k both 1e3, m=1e-3, u=1e-6, n=1e-9,
// p=1e-12, f=1e-15, a=1e-18.
//
// The row that actually catches something is `M`: it is MEGA in Verilog-AMS,
// not milli, and it is the one scale factor whose case matters in the opposite
// direction from `K`/`k` (both of which are 1e3). Checking the sum alone would
// hide a swapped M/m under the 1e12 term.
//
// Exact equality is legitimate here: scaling by a power of ten is one
// multiplication of an exact small integer by the same double the want spells,
// so a correct lexer reproduces the want bit for bit.
`include "check.vh"
module ch02_si_scale_factors(p, n);
    inout p, n;
    electrical p, n;
    real scaled;

    analog begin
        `CHECKX("T is 1e12", 1T, 1000000000000.0);
        `CHECKX("G is 1e9", 1G, 1000000000.0);
        `CHECKX("M is mega, not milli", 1M, 1000000.0);
        `CHECKX("K is 1e3", 1K, 1000.0);
        `CHECKX("k is 1e3 as well", 1k, 1000.0);
        `CHECKX("m is milli", 1m, 0.001);
        `CHECKX("u is micro", 1u, 1e-6);
        `CHECKX("n is nano", 1n, 1e-9);
        `CHECKX("p is pico", 1p, 1e-12);
        `CHECKX("f is femto", 1f, 1e-15);
        `CHECKX("a is atto", 1a, 1e-18);
        // Left as it was: the sum is what the module contributes, but its
        // rounding is a §4 arithmetic property, so the rows above carry the
        // lexical claim on their own.
        scaled = 1T + 1G + 1M + 1K + 1k + 1m + 1u + 1n + 1p + 1f + 1a;
        I(p, n) <+ scaled;
    end
endmodule
