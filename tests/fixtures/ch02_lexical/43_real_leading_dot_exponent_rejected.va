// LRM 2.6.2 lists `.2e-7` verbatim, fourth of six, among "invalid forms of
// real numbers because they do not have at least one digit on each side of the
// decimal point". A leading point is illegal even when an exponent follows, so
// the point cannot start a real and is left where an expression was expected.
//
// The other five forms are pinned one file each -- a reject fixture stops at
// its first diagnostic, so they cannot share one module. `.12` is 14, `9.` is
// 15, `4.E3` is 16, `.1p` is 44, `34.M` is 45.
//! lrm 2.6.2
//! lrm 2.6.2:2
//! reject-only E0209
module ch02_real_leading_dot_exponent_rejected;
    real value;
    analog value = .2e-7;
endmodule
