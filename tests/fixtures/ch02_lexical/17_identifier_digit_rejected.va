// LRM 2.8: "The first character of an identifier shall not be a digit or $; it
// can be a letter or an underscore." `2gain` opens with a digit, so it is not
// an identifier and cannot name the real declared here.
//
// The complementary half of the same sentence -- a leading $ -- is pinned by
// 47_identifier_dollar_first_rejected.va, and the fact that $ is legal AFTER
// the first character (`n$657`) is exercised in 02_simple_identifiers.va.
//! lrm 2.8
//! lrm 2.8:4
//! lrm A.10
//! lrm A.10:2
//! reject-only E0208
//! neighbour 02_simple_identifiers.va
module ch02_identifier_digit_rejected;
    real 2gain;
endmodule
