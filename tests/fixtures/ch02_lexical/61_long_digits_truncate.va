// §2.6.1 truncates the digit string to the declared width before signed
// interpretation. More than 64 source bits must not cause decoder overflow.
//! lrm 2.6.1
//! lrm 2.6.1:18
`include "check.vh"
module ch02_long_digits_truncate(p,n);
    inout p,n;
    electrical p,n;
    analog begin
        `CHECKI("long hex truncation", 8'h123456789abcdef0123456789abcdef, 239);
        `CHECKI("long decimal truncation", 8'd18446744073709551617, 1);
        `CHECKI("long signed truncation", 8'shffffffffffffffffffffffffffff, -1);
        I(p,n) <+ 0;
    end
endmodule
