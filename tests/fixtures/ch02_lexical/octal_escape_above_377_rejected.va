// LRM 2.7, Table 2-2, the row for \ddd: "A character specified in 1-3 octal
// digits ... Implementations may issue an error if the character represented
// is greater than \377." IEEE 1364-2005 3.6.3 has the same row.
//
// VerA issues it (specification/Vague_Decisions.md VD-053): a string holds 8-bit
// bytes and \477 = 4*64 + 7*8 + 7 = 319 names none, so keeping some byte of
// it would be a value VerA invented. The escape is isolated: the module is
// otherwise octal_escape_377_largest_byte.va, its legal neighbour, with
// "\377" (255) spelled "\477". A tool that accepts the escape conforms too,
// so this fixture tests VerA's choice.
//! lrm 2.7
//! reject-only E0148
//! reject octal escape is above \377
//! neighbour octal_escape_377_largest_byte.va
`include "check.vh"
module octal_escape_above_377_rejected(p, n);
    inout p, n;
    electrical p, n;
    analog begin
        `CHECKI("an escape above \\377 has no byte", "\477", 63);
        I(p, n) <+ V(p, n);
    end
endmodule
