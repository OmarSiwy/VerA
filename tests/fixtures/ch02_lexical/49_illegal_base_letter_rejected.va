// LRM 2.6.1 names the legal base letters exhaustively: "Legal base
// specifications are d, D, h, H, o, O, b, or B, for the bases decimal,
// hexadecimal, octal, and binary respectively." `y` is not among the eight.
//
// 35_uppercase_bases_hex.va proves all eight spellings are accepted; this is
// the negative that closes it. Without it, a lexer that treated the base
// letter as "any letter, defaulting to decimal" would pass the whole chapter.
//! lrm 2.6.1
//! lrm 2.6.1:6
//! reject-only E0131
//! neighbour 35_uppercase_bases_hex.va
module ch02_illegal_base_letter_rejected;
    integer value;
    analog value = 8'y11;
endmodule
