// AMS2.4, printed11/PDF24: block comments do not nest; the first closer
// ends the comment. A second opener within it is comment text, not a reason
// to refuse otherwise legal source. The assignment after that first closer
// therefore executes and supplies5. Unlike13_nested_comment_rejected.va,
// there is no later stray closer or malformed trailing source here.
//! lrm 2.4
//! lrm 2.4:3
//! lrm A.9.2
//! lrm A.9.2:1000
//! checks 1
`include "check.vh"
module audit_comment_nonnest_legal_neighbor(p);
    inout p;
    electrical p;
    integer value;
    analog begin
        /* outer comment /* ordinary inner opener */ value = 5;
        `CHECKI("first closer ends nonnested comment", value, 5);
        I(p) <+ 0.0;
    end
endmodule
