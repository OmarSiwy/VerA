// §2.6.1: "the numbers specified with the base format shall be treated as
// signed integers if the s designator is included or as unsigned integers if
// the base format only is used. The s designator does not affect the bit
// pattern specified, only its interpretation. A plus or minus operator
// preceding the size constant is a unary plus or minus operator. ... Negative
// numbers shall be represented in 2's complement form."
//
// Example 3 states three of these four answers outright:
//   4'shf   "the 4-bit number '1111', to be interpreted as a 2's complement
//            number, or '-1'"                                       -> -1
//   4'hf    the same bits with no s designator, so plain unsigned   -> 15
//   -4'sd15 "this is equivalent to -(-4'd 1), or '0001'"            ->  1
//            (15 truncated to 4 bits is 1111; read signed that is -1; the
//             leading minus is a unary operator applied to it, giving +1)
//   -8'd6   "the two's complement of 6, held in 8 bits — equivalent to
//            -(8'd 6)"                                              -> -6
//
// Without these wants a compiler that ignores `s` and answers 15 everywhere
// passes, which is exactly what this file used to allow.
//! lrm 2.6.1
//! lrm 2.6.1:13
//! lrm 2.6.1:6
//! lrm 2.6.1:11
`include "check.vh"
module ch02_signed_based_number(p, n);
    inout p, n;
    electrical p, n;
    integer value;
    analog begin
        value = 4'shf;
        `CHECKI("4'shf is 1111 read as 2's complement", value, -1);
        `CHECKI("4'hf without the s designator is unsigned", 4'hf, 15);
        `CHECKI("-4'sd15 is -(-4'd1)", -4'sd15, 1);
        `CHECKI("-8'd6 is a unary minus on the sized constant", -8'd6, -6);
        I(p, n) <+ value + 0.0 * V(p, n);
    end
endmodule
