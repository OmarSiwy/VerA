// §2.8.4 / §10.3 `define with arguments: the macro is TEXT substituted, so the
// parentheses written around `value` in the body are what make the argument
// bind first. With `1.0 + 2.0` as the argument the body reads
// `((1.0 + 2.0) * 2.0)` = 6.0; a preprocessor that dropped the parameter's
// parentheses would produce `1.0 + 2.0 * 2.0` = 5.0, which is why the argument
// here is a sum and not a single number.
//! lrm 2.8.4
//! lrm 10.3
//! lrm 2.8.4:1
`include "check.vh"
`define CH02_GAIN(value) ((value) * 2.0)
module ch02_compiler_directive_macro(p, n);
    inout p, n;
    electrical p, n;

    analog begin
        `CHECKX("macro argument keeps its own precedence", `CH02_GAIN(1.0 + 2.0), 6.0);
        I(p, n) <+ `CH02_GAIN(V(p, n));
    end
endmodule
`undef CH02_GAIN
