// §2.6.1 based integer constants, with §2.6.1's underscore rule ("legal
// anywhere in a number except as the first character... ignored"). The four
// wants are hand-converted, base by base:
//
//   27_195                     -> 27195 decimal, underscores dropped
//   16'b0011_0101_0001_1111    -> 0x351F = 3*4096 + 5*256 + 1*16 + 15 = 13599
//   12'o7460                   -> 7*512 + 4*64 + 6*8 + 0             = 3888
//   32'h12ab_f001              -> 0x12ABF001                     = 313257985
//
// Every one fits its declared size (12'o7460 needs 12 bits exactly, and
// 0x12ABF001 has a clear MSB so it is positive in a 32-bit signed integer),
// so none of them exercises the left-truncation rule.
//! lrm 2.6.1
//! lrm 2.6.1:2
//! lrm 2.6.1:8
//! lrm 2.6.1:22
`include "check.vh"
module ch02_integer_bases(p, n);
    inout p, n;
    electrical p, n;
    integer decimal_value, binary_value, octal_value, hexadecimal_value;

    analog begin
        decimal_value = 27_195;
        binary_value = 16'b0011_0101_0001_1111;
        octal_value = 12'o7460;
        hexadecimal_value = 32'h12ab_f001;
        `CHECKI("decimal with underscores", decimal_value, 27195);
        `CHECKI("16'b0011_0101_0001_1111", binary_value, 13599);
        `CHECKI("12'o7460", octal_value, 3888);
        `CHECKI("32'h12ab_f001", hexadecimal_value, 313257985);
        I(p, n) <+ decimal_value + binary_value + octal_value + hexadecimal_value;
    end
endmodule
