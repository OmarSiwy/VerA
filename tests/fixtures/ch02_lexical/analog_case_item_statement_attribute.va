// §2.9: an attribute_instance is "a prefix attached to a declaration, a
// module item, a statement, or a port connection". A.6.7 `analog_case_item
// ::= analog_expression { , analog_expression } : analog_statement_or_null
// | default [ : ] analog_statement_or_null`, and A.6.4 puts
// `{ attribute_instance }` before each analog_statement: an instance may
// prefix every item's statement.
//
// Legal neighbour of analog_case_attribute_before_endcase_rejected.va: the
// same (* a *) prefixes each item's statement instead of `endcase`. §2.9.1
// standardizes no `a`, so each statement runs as if it were absent. k = 2
// selects the `2:` item (§5.8.3: the item whose expression equals the case
// expression), so x = V(p) = 0.625, exact in binary.
//
//! lrm 2.9
`include "check.vh"
//! bias V(p) = 0.625
module ch2_case_arm_attr(p);
  inout p; electrical p;
  integer k;
  real x;
  analog begin
    k = 2;
    case (k)
      1: (* a *) x = 1.0;
      2: (* a *) x = V(p);
      default: (* a *) x = 0.0;
    endcase
    I(p) <+ x;
    `CHECKX("attributed_case_item_runs", x, 0.625);
  end
endmodule
