// LRM 2.6.2 lists `34.M` verbatim, sixth and last, among "invalid forms of
// real numbers because they do not have at least one digit on each side of the
// decimal point". Here the missing digit is on the right of the point, with a
// Table 2-1 scale factor (M = 1e6) behind it.
//
// The diagnostic differs from its two leading-point siblings 43 and 44: there
// the point arrives where an expression was expected (E0209), here `34` is
// already a complete expression and the point is a stray token after it
// (E0207). Both codes are pinned so a change to either path is visible.
//! lrm 2.6.2
//! lrm 2.6.2:2
//! reject-only E0207
module ch02_real_trailing_dot_scale_rejected;
    real value;
    analog value = 34.M;
endmodule
