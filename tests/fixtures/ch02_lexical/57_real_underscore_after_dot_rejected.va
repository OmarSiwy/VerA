// LRM 2.6.2 states two exceptions to the underscore rule, not one: "The
// underscore character is legal anywhere in a real constant except as the first
// character of the constant or the first character after the decimal point. The
// underscore character is ignored."
//
// 34_real_underscores.va covers the positive side with the LRM's own example
// `236.123_763_e-12`, and the first exception — a leading underscore — is the
// 2.6.1 sentence "legal anywhere in a number except as the first character".
// The second exception has never been written down. It is the one that needs a
// separate rule at all: underscores ARE ignored, so a lexer that simply strips
// them before parsing turns `1._5` into `1.5` and accepts it silently, which is
// precisely why 2.6.2 has to name the position after the point.
//
// The rule it protects is the neighbouring sentence, "Real numbers expressed
// with a decimal point shall have at least one digit on each side of the
// decimal point": an underscore is not a digit, so the fraction of `1._5`
// begins with a non-digit and the requirement is unmet.
//! lrm 2.6.2
//! lrm 2.6.2:2
//! lrm 2.6.2:1002
//! reject-only E0207
//! neighbour 34_real_underscores.va
module ch02_real_underscore_after_dot_rejected;
    real value;
    analog value = 1._5;
endmodule
