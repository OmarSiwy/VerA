// LRM 2.8.3, Syntax 2-3: the character class after the `$` is mandatory, not
// optional —
//
//     system_function_identifier ::= $ [ a-zA-Z0-9_$ ] { [ a-zA-Z0-9_$ ] }
//     system_task_identifier     ::= $ [ a-zA-Z0-9_$ ] { [ a-zA-Z0-9_$ ] }
//
// The first `[ ... ]` is a character class, the following `{ ... }` is the
// repetition — so exactly one character is required and the rest are optional.
// The prose says the same: "A name following the $ is interpreted as a system
// task or a system function." A lone `$` names nothing, so it does not form a
// token and there is no primary for the expression to take.
//
// 18_system_whitespace_rejected.va is the neighbouring rule — the `$` may not
// be SEPARATED from its name. This one is that the name may not be absent.
//! lrm 2.8.3
//! lrm 2.8.3:1
//! reject-only E0209
//! neighbour 09_system_identifiers.va
module ch02_bare_dollar_rejected;
    real value;
    analog value = $ ;
endmodule
