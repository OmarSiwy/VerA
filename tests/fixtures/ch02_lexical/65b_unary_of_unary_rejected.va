// Annex A.8.3: `analog_expression ::= ... | unary_operator { attribute_instance }
// analog_primary | ...` (IEEE 1364-2005 A.8.3: `unary_operator
// { attribute_instance } primary`). A unary operator's operand is a primary,
// and `-x` is not one, so `- -x` and `!!k` do not derive. VerA refuses each at
// its second operator: E0209 "expected an expression".
//
// Legal neighbour: 65_operator_arity.va writes the same values as -(-2.0) and
// !(!1), and keeps `3.0 - -2.0` (binary, then unary on a primary).
//
//! lrm 2.5
//! reject-only E0209
//! neighbour 65_operator_arity.va
`include "disciplines.vams"
module ch02_unary_of_unary_rejected(p, n);
  inout p, n;
  electrical p, n;
  real x;
  integer k;

  analog begin
    k = 1;
    x = - -2.0;     // illegal: unary minus applied to a unary expression
    k = !!k;        // illegal: the same with logical not
    I(p, n) <+ x + k;
  end
endmodule
