// LRM 2.9: an attribute_instance may prefix a module declaration, an attr_spec
// may omit its `= constant_expression` (value then defaults to 1), and several
// attr_specs may be comma-separated in one instance. The default-1 rule lives
// in the tool's attribute database and is not visible to HDL, so what is
// observed here is only computation with decorated syntax, not metadata or
// universal attribute inertness. Default-value evidence remains AMS-ATTR-DEFAULT
// in docs/rules/ams-attributes.json. There is one instance containing three
// specs, not multiple adjacent attribute instances.
// V(p) is held at 0.375 (exact in binary), so V(p)*8 is exactly 3.
//! lrm 2.9
`include "check.vh"
//! bias V(p) = 0.375
(* optimize_power, full_case=1, parallel_case=0 *) module ch2_attr_defaults(p); inout p; electrical p; analog begin I(p)<+V(p);
  `CHECKX("module_prefix_attrs_are_inert", V(p)*8.0, 3.0);
end endmodule
