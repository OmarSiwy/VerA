// LRM 2.6.1 Example 1 is four lines, and the fourth is labelled illegal by the
// standard itself:
//
//     659       // is a decimal number
//     'h 837FF  // is a hexadecimal number
//     'o7460    // is an octal number
//     4af       // is illegal (hexadecimal format requires 'h)
//
// The rule behind the label is the definition of the second form of an integer
// constant: it "shall be composed of up to three tokens — an optional size
// constant, an apostrophe character (', ASCII 0x27) followed by a base format
// character, and the digits". With no apostrophe there is no base format, so
// `4af` is an unsigned_number `4` with the letters `af` glued to it, and hex
// digits are unreachable.
//
// Distinct from 49_illegal_base_letter_rejected.va, which has the apostrophe
// and a base letter outside the legal eight. That one tests the alphabet; this
// one tests that the apostrophe is required at all. A lexer that scanned a
// number as "digits then any trailing alphanumerics" would pass 49 and fail
// here, so neither file subsumes the other.
//! lrm 2.6.1
//! lrm 2.6.1:2
//! reject-only E0133
//! neighbour 04_integer_bases.va
module ch02_hex_without_base_rejected;
    integer value;
    analog value = 4af;
endmodule
