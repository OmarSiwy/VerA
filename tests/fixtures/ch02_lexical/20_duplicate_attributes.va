// §2.9: "If the same attribute name is defined more than once for the same
// language element, the last attribute value shall be used and a tool can give
// a warning that a duplicate attribute specification has occurred." So a
// repeated name is legal, not an error. This fixture does not observe which
// metadata value wins: unchanged arithmetic cannot distinguish first/last.
// That obligation (AMS-ATTR-LAST) is open in docs/ROADMAP.md.
// The repeated attribute is put on a parameter as well as on the
// module, so there is a value to read back: `scale` still holds its §3.4
// default of 2.5, and the module still conducts through it.
//! lrm 2.9
//! lrm 2.9:4
`include "check.vh"
(* desc = "first", desc = "last" *)
module ch02_duplicate_attributes(p, n);
    inout p, n;
    electrical p, n;
    (* units = "V/V", units = "none" *)
    parameter real scale = 2.5;
    analog begin
        `CHECKX("a repeated attribute name leaves the declaration alone", scale, 2.5);
        I(p, n) <+ scale * V(p, n);
    end
endmodule
