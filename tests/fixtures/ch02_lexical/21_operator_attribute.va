// §2.9: an attribute_instance "can appear as a suffix to an operator ... in an
// expression", and A.8.3 admits `{ attribute_instance }` after a binary
// operator. Example 6 is `a = b + (* mode = "cla" *) c;`.
//
// §2.9 calls an attribute a property "used by various tools", so the observable
// claim is that it changes NOTHING about the arithmetic: the sum is still the
// sum. 1.0 + 2.0 = 3.0 and 4.0 * 8.0 = 32.0 are both exact in binary, so CHECKX
// is the right strength, and both results differ from either operand, so an
// operand swallowed along with the attribute shows up as a wrong number instead
// of a pass. Example 8's attribute on `?:` is asserted in
// 33_conditional_attribute.va.
//! lrm 2.9
//! lrm A.8.3
//! lrm 2.9:2
//! lrm A.8.3:1000
//! lrm A.9.1
//! lrm A.9.1:1000
`include "check.vh"
module ch02_operator_attribute(p, n);
    inout p, n;
    electrical p, n;
    real value;
    analog begin
        value = 1.0 + (* mode = "cla" *) 2.0;
        `CHECKX("an attribute on a binary operator does not change the sum", value, 3.0);
        `CHECKX("an attribute on a binary operator does not change the product", 4.0 * (* mode = "wallace" *) 8.0, 32.0);
        I(p, n) <+ value + 0.0 * V(p, n);
    end
endmodule
