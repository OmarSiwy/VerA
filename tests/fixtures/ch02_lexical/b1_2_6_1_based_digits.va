// §2.6.1, two sentences about the digits of a based number:
//
//   "The third token, an unsigned number, shall consist of digits that are
//    legal for the specified base format."
//   "The underscore character ( _ ) shall be legal anywhere in a number except
//    as the first character."
//
// Syntax 2-2 says the same per base: binary_value ::= binary_digit { _ |
// binary_digit }, and likewise octal_value, hex_value and unsigned_number, so
// the first character of the value is a digit and an underscore may follow.
//
// The legal half of three pairs. Each refusal below is this file with ONE
// literal changed:
//   b1_2_6_1_binary_digit_f_rejected.va          4'b1011  -> 4'b101f
//   b1_2_6_1_underscore_first_sized_rejected.va  8'hf_f   -> 8'h_ff
//   b1_2_6_1_underscore_first_unsized_rejected.va 'b1_0   -> 'b_10
//
// DERIVATION, by hand (python3 int(s, base) agrees):
//   4'b1011  = 8 + 2 + 1      = 11
//   8'o17    = 1*8 + 7        = 15
//   8'd19                     = 19
//   8'h1f    = 1*16 + 15      = 31
//   8'hf_f   -> 8'hff = 15*16 + 15 = 255   (underscore ignored)
//   'b1_0    -> 'b10  = 2                   (underscore ignored)
//   1_000    -> 1000                        (simple decimal, underscore ignored)
// Each value fits its size, so no truncation rule is involved; none has an `s`,
// and all are below 2^31, so signedness is moot.
//
//! lrm 2.6.1
//! lrm 2.6.1:8
//! lrm 2.6.1:22
//! bias V(p) = 0.75, V(n) = 0.25
//! checks 7
`include "check.vh"
module b1_based_digits(p, n);
    inout p, n;
    electrical p, n;
    integer bin, oct, dec, hex, hex_us, bin_us, dec_us;

    analog begin
        bin = 4'b1011;
        oct = 8'o17;
        dec = 8'd19;
        hex = 8'h1f;
        hex_us = 8'hf_f;
        bin_us = 'b1_0;
        dec_us = 1_000;
        `CHECKI("4'b1011, binary digits", bin, 11);
        `CHECKI("8'o17, octal digits", oct, 15);
        `CHECKI("8'd19, decimal digits", dec, 19);
        `CHECKI("8'h1f, hex digits", hex, 31);
        `CHECKI("8'hf_f, underscore after the first digit", hex_us, 255);
        `CHECKI("'b1_0, underscore after the first digit", bin_us, 2);
        `CHECKI("1_000, underscore in a simple decimal", dec_us, 1000);
        I(p, n) <+ (bin + oct + dec + hex + hex_us + bin_us + dec_us) * V(p, n);
    end
endmodule
