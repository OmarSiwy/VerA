// AMS §2.6.2 permits decimal/scientific real constants but forbids scale
// factors in digital delays. §7.3.6.5 makes a digital value visible to the
// analog block at its delivery tick. In 1ns units, #2.5 delivers code=1 at
// 2.5ns and the following #5e3 delivers code=2 at 5002.5ns. All delays are
// exact integer multiples of the 1ps precision. Samples 0.1ns before, at,
// and 0.1ns after each delivery must read 0,1,1 and 1,2,2 respectively.
// Scaled literals remain legal in analog expressions and fixture times.
// No computed oracle is needed: the ordered declared points derive the six
// comparisons below. Invalid neighbour: digital_scaled_delay_rejected.va.
//! lrm 2.6.2
//! lrm 7.3.6.5
//! analysis tran
//! time 2.4n, 2.5n, 2.6n, 5002.4n, 5002.5n, 5002.6n
//! checks 6
`timescale 1ns/1ps
`include "check.vh"
module digital_delay_notation(p);
  inout p;
  electrical p;
  integer code;
  initial begin
    code = 0;
    #2.5 code = 1;
    #5e3 code = 2;
  end
  analog begin
    if ($abstime < 2.5n) `CHECKI("before decimal delay", code, 0);
    else if ($abstime < 5002.5n) `CHECKI("after decimal before scientific delay", code, 1);
    else `CHECKI("after scientific delay", code, 2);
    I(p) <+ code * 1m;
  end
endmodule
