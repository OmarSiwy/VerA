// §2.6, Syntax 2-2, marks the base productions with footnote 1:
//
//     hex_base1 ::= '[s|S]h | '[s|S]H
//     1)  Embedded spaces are illegal
//
// so `8' hff`, with a space between the apostrophe and the base letter, is
// not a hex_number. The space that IS legal is the one between the base and
// the value (`8'h ff`, which is a separate token boundary, not a space inside
// the base production): VerA accepts that form in the same position (probed),
// so this file isolates the one illegal space.
//
// VerA refuses it as E0131 "expected a numeric base after the apostrophe".
//
//! lrm 2.6
//! lrm 2.6:1
//! lrm 2.6.1
//! lrm 2.6.1:7
//! reject-only E0131
//! neighbour 66_number_positions.va
`include "disciplines.vams"
module ch2_space_in_base(p, n);
  inout p, n;
  electrical p, n;
  real x;

  analog begin
    x = 8' hff;     // illegal: embedded space inside the base specifier
    I(p, n) <+ x;
  end
endmodule
