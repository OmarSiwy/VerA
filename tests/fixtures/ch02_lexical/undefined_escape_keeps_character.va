// LRM 2.7 Table 2-2 (IEEE 1364-2005 3.6.3, Table 3-1) lists five escapes:
// \n, \t, \\, \" and \ddd. Neither standard says what a backslash before any
// other character means, or whether it is an error.
//
// VerA's choice (specification/Vague_Decisions.md VD-036, specification/Vague_Decisions.md):
// keep the character, drop the backslash, and warn W0149 so the portability
// hazard is never silent. A tool that keeps both bytes or refuses also
// conforms, so this fixture tests VerA's choice, not the clause.
//
// HAND DERIVATION. A one-character string in an integer expression is its
// byte's unsigned value (§2.7, 08_string_escapes.va), so "\q" is 'q' = 113
// and "\%" is '%' = 37. "a\qb" is "aqb" = 97*65536 + 113*256 + 98 = 6356992 + 28928 + 98 = 6386018.
// Legal neighbour: 08_string_escapes.va uses only Table 2-2 escapes and
// warns nothing.
//! lrm 2.7
//! warn W0149
//! checks 3
`include "check.vh"
module undefined_escape_keeps_character(p, n);
    inout p, n;
    electrical p, n;
    analog begin
        `CHECKI("backslash q is q", "\q", 113);
        `CHECKI("backslash percent is percent", "\%", 37);
        `CHECKI("an undefined escape mid-string", "a\qb", 6386018);
        I(p, n) <+ V(p, n);
    end
endmodule
