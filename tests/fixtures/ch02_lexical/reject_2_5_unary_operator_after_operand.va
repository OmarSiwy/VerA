// §2.5: "Unary operators shall appear to the left of their operand."
//
// `y -` puts the unary minus to the RIGHT of its operand. It cannot be read
// as a binary minus either, because §2.5 also says "Binary operators shall
// appear between their operands" and there is no right-hand operand before
// the `;`. So the expression is not derivable and the statement is an error.
// Moving the operator to the left (`x = -y;`) is the legal spelling.
//
// VerA refuses at the `;` where the missing operand should be: E0209
// "expected an expression: found `;`".
//
//! lrm 2.5
//! lrm 2.5:1
//! lrm 2.5:2
//! reject-only E0209
//! neighbour 65_operator_arity.va
`include "disciplines.vams"
module ch2_unary_after_operand(p, n);
  inout p, n;
  electrical p, n;
  real x, y;

  analog begin
    y = 1.0;
    x = y -;        // illegal: unary operator to the right of its operand
    I(p, n) <+ x;
  end
endmodule
