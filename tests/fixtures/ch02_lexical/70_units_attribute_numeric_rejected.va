// LRM 2.9.2, units: "The attribute must be assigned a string."
// 1.0 is a real constant, not a string. No other attribute is present.
//! lrm 2.9.2
//! reject E0358
module ch02_units_attribute_numeric_rejected(p, n);
    inout p, n;
    electrical p, n;
    (* units = 1.0 *) parameter real gain = 1.0;
    analog I(p, n) <+ gain * V(p, n);
endmodule
