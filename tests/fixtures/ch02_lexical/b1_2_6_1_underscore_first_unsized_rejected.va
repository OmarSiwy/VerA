// §2.6.1: "The underscore character ( _ ) shall be legal anywhere in a number
// except as the first character." Syntax 2-2: binary_value ::= binary_digit
// { _ | binary_digit }, and the size is optional, so an unsized based number
// is held to the same rule.
//
// `'b_10` starts its value with `_`. This file is b1_2_6_1_based_digits.va with
// that one literal changed from `'b1_0`, which is legal and reads 2.
//
// VerA refuses the literal with E0133 "invalid number literal".
//
//! lrm 2.6.1
//! lrm 2.6.1:22
//! reject-only E0133
//! neighbour b1_2_6_1_based_digits.va
`include "check.vh"
module b1_based_digits(p, n);
    inout p, n;
    electrical p, n;
    integer bin, oct, dec, hex, hex_us, bin_us, dec_us;

    analog begin
        bin = 4'b1011;
        oct = 8'o17;
        dec = 8'd19;
        hex = 8'h1f;
        hex_us = 8'hf_f;
        bin_us = 'b_10;
        dec_us = 1_000;
        `CHECKI("4'b1011, binary digits", bin, 11);
        `CHECKI("8'o17, octal digits", oct, 15);
        `CHECKI("8'd19, decimal digits", dec, 19);
        `CHECKI("8'h1f, hex digits", hex, 31);
        `CHECKI("8'hf_f, underscore after the first digit", hex_us, 255);
        `CHECKI("'b1_0, underscore after the first digit", bin_us, 2);
        `CHECKI("1_000, underscore in a simple decimal", dec_us, 1000);
        I(p, n) <+ (bin + oct + dec + hex + hex_us + bin_us + dec_us) * V(p, n);
    end
endmodule
