// DEBT — this rejection is NOT conformance.
// The LRM permits what VerA refuses here. The substrings below record
// CURRENT behavior so the suite stays green on it; they do not claim it
// is right. `zig build ledger` counts this rule against VerA.
//
// VAMS-2.6.1-03  (ch2-lexical.html)
// It shall be legal to macro substitute these three tokens.
//
//! reject DiagnosticsReported
`define BASE 'h
`define DIGITS A5
module ch2_macro_based(p); inout p; electrical p; integer x; analog begin x=8 `BASE `DIGITS; I(p)<+x+0.0*V(p); end endmodule
// EXPECT: error -- normative syntax/restriction snapshot for this rule family.
