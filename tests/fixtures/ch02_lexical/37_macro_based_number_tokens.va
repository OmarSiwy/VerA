// §2.6.1: a based constant "shall be composed of up to three tokens—an optional
// size constant, an apostrophe character (') followed by a base format
// character, and the digits representing the value of the number. It shall be
// legal to macro substitute these three tokens."
//
// So the size is written literally, the base arrives from `BASE and the digits
// from `DIGITS; after §10.3 text substitution the three tokens are 8, 'h, A5.
// 0xA5 = 10*16 + 5 = 165.
//! lrm 2.6.1
//! lrm 10.3
//! xfail VerA lexes a based number before macro expansion can rejoin the three tokens, so `8 `BASE `DIGITS` stops at E0207 "expected `;`" on the expanded `'h` (src/frontend/lexer.zig)
`include "check.vh"
`define BASE 'h
`define DIGITS A5
module ch2_macro_based(p); inout p; electrical p; integer x; analog begin x=8 `BASE `DIGITS;
  `CHECKI("macro-substituted base and digit tokens", x, 165);
  I(p)<+x+0.0*V(p);
end endmodule
