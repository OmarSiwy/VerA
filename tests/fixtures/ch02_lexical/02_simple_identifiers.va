// §2.8: "Identifiers shall be case sensitive", and a simple identifier may
// contain `$` and `_` after the first character (`n$657` is the LRM's own
// example). `gain_factor` and `Gain_Factor` are therefore two distinct
// variables: a compiler that folded case would leave one variable holding 3.0,
// making the difference below 0.0 instead of 1.0.
//! lrm 2.8
//! lrm 2.8:5
//! lrm 2.8:2
//! lrm 2.8:3
`include "check.vh"
module Ch02_CaseSensitive(_port0, n$657);
    inout _port0, n$657;
    electrical _port0, n$657;
    real gain_factor, Gain_Factor;

    analog begin
        gain_factor = 2.0;
        Gain_Factor = 3.0;
        `CHECKX("case-distinct identifiers are separate storage", Gain_Factor - gain_factor, 1.0);
        `CHECKX("the lowercase one keeps its own value", gain_factor, 2.0);
        I(_port0, n$657) <+ (gain_factor + Gain_Factor) * V(_port0, n$657);
    end
endmodule
