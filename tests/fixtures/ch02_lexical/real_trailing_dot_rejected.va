// LRM 2.6.2 lists `9.` verbatim among "invalid forms of real numbers because
// they do not have at least one digit on each side of the decimal point".
// The `.` therefore cannot join the 9, and is left as a stray token.
//! lrm 2.6.2
//! lrm 2.6.2:2
//! reject-only E0207
module ch02_real_trailing_dot_rejected;
    real value;
    analog value = 9.;
endmodule
