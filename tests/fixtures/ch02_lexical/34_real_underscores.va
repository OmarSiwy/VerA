// LRM 2.6.2: "The underscore character is legal anywhere in a real constant
// except as the first character of the constant or the first character after
// the decimal point. The underscore character is ignored." `236.123_763_e-12`
// is verbatim the LRM's own example, so both wants below are the same literal
// with the underscores deleted.
//! lrm 2.6.2
//! lrm 2.6.2:1002
`include "check.vh"
module ch2_real_underscores(p); inout p; electrical p; parameter real a=1_234.5_67; parameter real b=236.123_763_e-12;
analog begin
  I(p)<+(a+b)*V(p);
  // Exact: underscores are *ignored*, so these must be bit-identical doubles.
  `CHECKX("underscores_in_mantissa", a, 1234.567);
  `CHECKX("underscores_before_exponent", b, 236.123763e-12);
end
endmodule
