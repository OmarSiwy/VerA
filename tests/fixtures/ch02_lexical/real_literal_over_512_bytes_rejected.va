// AN ENGINE CEILING, PINNED FROM THE ENFORCING SIDE. §2.6.2 writes a real
// number as digits with no length bound. VerA decodes a literal through a
// 512-byte buffer (specification/Vague_Decisions.md) and refuses a longer one with
// E0134 rather than read it wrong. The literal below is "1." and 600 zeros,
// 602 bytes.
//
// Legal neighbour: every fixture that writes a real literal.
//
//! reject-only E0134
module real_literal_over_512_bytes_rejected(p);
  inout p; electrical p;
  analog I(p) <+ 1.000000000000000000000000000000000000000000000000000000000000000000000000000000000000000000000000000000000000000000000000000000000000000000000000000000000000000000000000000000000000000000000000000000000000000000000000000000000000000000000000000000000000000000000000000000000000000000000000000000000000000000000000000000000000000000000000000000000000000000000000000000000000000000000000000000000000000000000000000000000000000000000000000000000000000000000000000000000000000000000000000000000000000000000000000000000000000000000000000000000000000000000000000000000000000000000000000000000000000000000000 * V(p);
endmodule
