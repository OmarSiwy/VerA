// LRM 2.6.2, Syntax 2-2: the three alternatives of real_number1 are a CHOICE,
// and the exponent and the scale factor live in different arms of it:
//
//     real_number1 ::=
//             unsigned_number . unsigned_number
//           | unsigned_number [ . unsigned_number ] exp [ sign ] unsigned_number
//           | unsigned_number [ . unsigned_number ] scale_factor
//
// So a literal carries an exponent or a scale factor, never both. 2.6.2's prose
// says the same by listing them as three separate notations — "in decimal
// notation (e.g., 14.72), in scientific notation (e.g., 39e8 ...) or in scaled
// notation (e.g., 24.7K ...)" — and none of its examples combines two.
//
// `1.0e3K` reads plausibly as 1e3 x 1e3, which is why the rule needs a fixture:
// a lexer that loops over trailing modifiers instead of taking one arm accepts
// it and silently produces 1e6.
//
// 56_scale_factor_alphabet_rejected.va is the other negative on this
// production; 07_si_scale_factors.va and 06_real_notation.va are the positives
// for the scaled and scientific arms respectively.
//! lrm 2.6.2
//! reject-only E0207
//! neighbour 06_real_notation.va
//! neighbour 07_si_scale_factors.va
module ch02_exponent_and_scale_factor_rejected;
    real value;
    analog value = 1.0e3K;
endmodule
