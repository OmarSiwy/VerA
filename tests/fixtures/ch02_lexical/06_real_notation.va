// §2.6.2 real constants, "represented as described by IEEE Std 754". Each want
// is written in a DIFFERENT notation from the literal under test, so the check
// is a conversion claim and not the same text on both sides:
//
//   2394.26331 (decimal)   == 2.39426331e3 (scientific), bit for bit
//   1.2E12                 == 1200000000000, exactly — an integer below 2^53
//   1.30e-2                == 0.013, the same correctly rounded double
//
// Every row is CHECKX. 754 requires decimal-to-binary conversion to be
// correctly rounded, so two spellings of one real value land on the same
// double; a relative tolerance here would pass a converter that is merely
// close, which is exactly what "represented as described by IEEE Std 754"
// forbids.
//
// The last two rows take the other half of real_number1's second alternative,
// `unsigned_number [ . unsigned_number ] exp [ sign ] unsigned_number` — the
// fraction is bracketed, so the dot is OPTIONAL and the mantissa may be a bare
// integer. Both literals are the LRM's own 2.6.2 examples, and both wants are
// the same value respelled in decimal notation, so the check is still a
// conversion claim: 23E10 = 23 x 1e10 = 230000000000, 29E-2 = 29 / 100 = 0.29.
//! lrm 2.6.2
//! lrm 2.6.2:1
//! lrm 2.6.2:2
`include "check.vh"
module ch02_real_notation(p, n);
    inout p, n;
    electrical p, n;
    real decimal_value, scientific_value, signed_exponent;

    analog begin
        decimal_value = 2394.26331;
        scientific_value = 1.2E12;
        signed_exponent = 1.30e-2;
        `CHECKX("decimal notation", decimal_value, 2.39426331e3);
        `CHECKX("uppercase E exponent", scientific_value, 1200000000000.0);
        `CHECKX("negative exponent", signed_exponent, 0.013);
        `CHECKX("dot-less exponent", 23E10, 230000000000.0);
        `CHECKX("dot-less negative exponent", 29E-2, 0.29);
        I(p, n) <+ decimal_value + scientific_value + signed_exponent;
    end
endmodule
