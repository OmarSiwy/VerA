// §2.6.2 real constants, "represented as described by IEEE Std 754". Each want
// is written in a DIFFERENT notation from the literal under test, so the check
// is a conversion claim and not the same text on both sides:
//
//   2394.26331 (decimal)   == 2.39426331e3 (scientific), to the last few ulps
//   1.2E12                 == 1200000000000, exactly — an integer below 2^53
//   1.30e-2                == 0.013, the same correctly rounded double
`include "check.vh"
module ch02_real_notation(p, n);
    inout p, n;
    electrical p, n;
    real decimal_value, scientific_value, signed_exponent;

    analog begin
        decimal_value = 2394.26331;
        scientific_value = 1.2E12;
        signed_exponent = 1.30e-2;
        `CHECKR("decimal notation", decimal_value, 2.39426331e3, 1e-15);
        `CHECKX("uppercase E exponent", scientific_value, 1200000000000.0);
        `CHECKX("negative exponent", signed_exponent, 0.013);
        I(p, n) <+ decimal_value + scientific_value + signed_exponent;
    end
endmodule
