// §2.6.1: a based constant "shall be composed of up to three tokens—an optional
// size constant, an apostrophe character (') followed by a base format
// character, and the digits representing the value of the number. It shall be
// legal to macro substitute these three tokens."
//
// So the size is written literally, the base arrives from `BASE and the digits
// from `DIGITS; after §10.3 text substitution the three tokens are 8, 'h, A5.
// 0xA5 = 10*16 + 5 = 165.
//! lrm 2.6.1
//! lrm 2.6.1:3
//! lrm 10.3
`include "check.vh"
`define SIZE 8
`define BASE 'h
`define DIGITS A5
module ch2_macro_based(p); inout p; electrical p; integer x; analog begin x=`SIZE `BASE `DIGITS;
  `CHECKI("macro-substituted size, base and digit tokens", x, 165);
  I(p)<+x+0.0*V(p);
end endmodule
