// §2.8.3: a `$` introduces a system function, and §9.15 (Syntax 9-10,
// environment_parameter_functions) gives these two their values —
// `$temperature` "returns the circuit's ambient temperature in Kelvin units",
// and `$vt` without the optional argument "returns the thermal voltage (kT/q)"
// using `$temperature`.
//
// The testbench pins the ambient at 300 K exactly, so kT/q is a number a human
// can write down. Annex D's constants.vams carries several `ifdef'd constant
// sets that disagree in the fifth significant digit, so the want is the
// un-ifdef'd DEFAULT one, NIST1998: the arm a source defining no
// PHYSICAL_CONSTANTS_* macro gets, and the only set every edition of Annex D
// has spelled the same way.
//
//   P_K_NIST1998 = 1.3806503e-23, P_Q_NIST1998 = 1.602176462e-19
//   300 K * P_K / P_Q = 0.025852026903638286 V
//
// The 1e-4 relative band admits every other set Annex D lists (the widest miss
// is the SPICE pair, 0.025851241113725592, 3.0e-5 relative) while still
// rejecting a $vt computed at the wrong temperature: at 300.15 K every set
// gives ~0.0258649, at least 4.7e-4 relative away and out of band.
//
//! temp 300
//! lrm 2.8.3
//! lrm 9.15
//! lrm D.2
//! lrm 2.8.3:1
`include "check.vh"
module ch02_system_identifiers(p, n);
    inout p, n;
    electrical p, n;

    analog begin
        `CHECKX("$temperature is the ambient in kelvin", $temperature, 300.0);
        `CHECKR("$vt is kT/q at $temperature", $vt, 0.025852026903638286, 1e-4);
        I(p, n) <+ $vt + 1u * $temperature;
    end
endmodule
