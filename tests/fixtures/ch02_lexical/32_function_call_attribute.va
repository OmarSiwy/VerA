// §2.9: an attribute_instance "can appear as a suffix to an operator or a
// Verilog-AMS function name in an expression", and Example 7 prints the form
// verbatim — `a = add (* mode = "cla" *) (b, c);`. A.8.2 puts the same rule in
// the grammar: `analog_function_call ::= analog_function_identifier
// { attribute_instance } ( analog_expression { , analog_expression } )`.
//
// So the attribute is a SUFFIX on the NAME, not a call of its own: `twice`
// still receives V(p) as its single argument. With V(p) biased at 0.7,
// twice(x) = 2.0*x is 1.4. 0.7 is not exact in binary, but doubling a double is
// exact (it only bumps the exponent), so 2.0*fl(0.7) == fl(1.4) to the bit and
// CHECKX is the right strength.
//! lrm 2.9
//! lrm A.8.2
//! xfail VerA's parser has no `{ attribute_instance }` slot between a function name and its argument list, so Example 7's form dies at E0207 "unexpected token: found `(*`, expected `)`" (src/frontend/parser.zig)
//! bias V(p) = 0.7
`include "check.vh"
module ch2_call_attr(p);
  inout p;
  electrical p;
  analog function real twice;
    input x;
    real x;
    twice = 2.0 * x;
  endfunction
  analog begin
    `CHECKX("attribute after a function name is a suffix, not a call", twice (* mode="fast" *) (V(p)), 1.4);
    I(p) <+ 0.0;
  end
endmodule
