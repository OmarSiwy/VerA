// LRM 2.6.2, Syntax 2-2, gives the scale-factor alphabet as a closed list of
// eleven symbols:
//
//     scale_factor ::= T | G | M | K | k | m | u | n | p | f | a
//
// K and k are the only pair, so every other letter's case is load-bearing: `M`
// is mega and `m` is milli (Table 2-1), and there is no `g`, no `t`, no `P`,
// no `F`, no `A`, no `N` and no `U`. `1g` therefore is not "1 giga" spelled
// carelessly — it is the integer 1 followed by an identifier.
//
// 07_si_scale_factors.va proves all eleven are accepted with the Table 2-1
// values; this is the negative that closes it. Without it, a lexer that
// case-folded the alphabet would pass the whole chapter while reading `1M` and
// `1m` as the same nine-decade-apart number.
//
// The mutual-exclusion half of the production — a literal takes `exp` or
// `scale_factor`, never both — is 58_exponent_and_scale_factor_rejected.va.
//! lrm 2.6.2
//! reject-only E0207
//! neighbour 07_si_scale_factors.va
module ch02_scale_factor_alphabet_rejected;
    real value;
    analog value = 1g;
endmodule
