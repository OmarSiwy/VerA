// LRM 2.9.2 standardizes four attribute names and states a value domain for
// each, with "must" every time:
//
//   desc          "The attribute must be assigned a string."
//   units         "The attribute must be assigned a string."
//   op            "must be assigned a value, which must be either
//                  \"yes\" or \"no\""
//   multiplicity  "must be assigned one of the following string values:
//                  \"multiply\", \"divide\", or \"none\""
//
// These are not free-form tool hints like the ones in 11_attributes.va. The
// standard fixes their meaning — multiplicity picks the $mfactor scaling of an
// operating-point report — so an out-of-domain value has no reading at all.
// `op = "maybe"` below is neither "yes" nor "no", so nothing says whether the
// parameter appears in the short report.
//
// SIBLING VIOLATIONS, so whoever implements this covers all four in one pass
// rather than fixing the one line this fixture happens to name:
//
//   (* multiplicity = "sideways" *)   not one of the three listed strings
//   (* desc  = 7 *)                   not a string
//   (* units = 1.0 *)                 not a string
//   (* op    = 1 *)                   not a string, and not yes/no either
//
// All four compile clean under VerA today. A reject fixture stops at its first
// diagnostic, so they cannot be checked from one module; when the check lands,
// split the other three into files of their own and cross-reference them here.
//
// 11_attributes.va is the positive half: it supplies all four names with
// in-domain values and proves the decorated parameter is untouched.
//
// The pin was the PHASE label for as long as no code existed for this rule, on
// the reasoning that pinning a code the construct cannot produce would freeze the
// file at XFAIL forever. E0358 is that code and the pin is now it.
//! lrm 2.9.2
//! reject E0358
module ch02_standard_attribute_domain_rejected(p, n);
    inout p, n;
    electrical p, n;
    (* op = "maybe" *) parameter real gain = 1.0;
    analog I(p, n) <+ gain * V(p, n);
endmodule
