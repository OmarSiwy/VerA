// §2.6.1: "If the size of the unsigned number is smaller than the size
// specified for the constant, the unsigned number shall be padded to the left
// with zeros. ... If the size of the unsigned number is larger than the size
// specified for the constant, the unsigned number shall be truncated from the
// left."
//
// integer_bases.va says in its own header that every literal in it fits its
// declared size, "so none of them exercises the left-truncation rule". This is
// that file. The x/z half of the same paragraph is out of the Verilog-A subset
// (Annex C.3), but the two-state half is not, and it is plain arithmetic:
//
//   2'd7    111       -> keep the low 2 bits    11 =   3
//   3'b1101 1101      -> keep the low 3 bits   101 =   5
//   8'h1ff  1_1111_1111 -> keep the low 8 bits  ff = 255
//   4'b1    1         -> pad left with zeros  0001 =   1
//   16'h5   101       -> pad left with zeros        =   5
//
// Three of the five have their top bit SET after truncation (2'd7 -> 11,
// 3'b1101 -> 101, 8'h1ff -> ff), so signedness is not moot here — read as two's
// complement those would be -1, -3 and -1, not 3, 5 and 255. What makes the
// unsigned reading the only one is the other sentence of §2.6.1: "the numbers
// specified with the base format shall be treated as signed integers if the s
// designator is included or as unsigned integers if the base format only is
// used". No literal below carries the `s` designator, so all five are unsigned.
// signed_based_number.va is the positive for the `s` arm of that sentence.
//! lrm 2.6.1
//! lrm 2.6.1:16
//! lrm 2.6.1:18
//! lrm 2.6.1:4
`include "check.vh"
module ch02_size_truncation_and_padding(p, n);
    inout p, n;
    electrical p, n;
    integer value;
    analog begin
        value = 8'h1ff;
        `CHECKI("2'd7 truncates from the left to 11", 2'd7, 3);
        `CHECKI("3'b1101 truncates from the left to 101", 3'b1101, 5);
        `CHECKI("8'h1ff truncates from the left to ff", value, 255);
        `CHECKI("4'b1 pads to the left with zeros", 4'b1, 1);
        `CHECKI("16'h5 pads to the left with zeros", 16'h5, 5);
        `CHECKI("zero padding preserves all sixteen bits in a concatenation", {4'h1, 16'h5}, 65541);
        `CHECKI("zero padding preserves all four bits in a concatenation", {4'h1, 4'b1}, 17);
        I(p, n) <+ value + 0.0 * V(p, n);
    end
endmodule
