// §2.6.1's four-state digit-width rules, and the decimal exception:
//
//   "An x shall set 4 bits to unknown in the hexadecimal base, 3 bits in the
//    octal base, and 1 bit in the binary base. Similarly, a z shall set 4
//    bits, 3 bits, and 1 bit, respectively, to the high-impedance value."
//
//   "If the left-most bit in the unsigned number is an x or a z, then an x or
//    a z shall be used to pad to the left respectively."
//
//   "In a decimal constant, the unsigned number token shall not contain any x,
//    z, or ? digits, unless there is exactly one digit in the token, indicating
//    that every bit in the decimal constant is x or z."
//
// The observed value is the four-state comparison itself, §7.3.2's permitted
// analog use of `===`; a four-state literal in any other analog position is
// E0130. Every comparison is against a two-state-value spelling of the pattern
// the rule demands, so a digit of the wrong width changes the answer:
//
//   4'hx           the one hex digit is FOUR x bits            -> xxxx
//   4'hz           likewise for z                              -> zzzz
//   3'ox, 3'oz     one octal digit is THREE bits                -> xxx, zzz
//   12'hx0         leftmost bit is x, so the pad is x: xxxx_xxxx_0000
//   12'hz0         likewise z:                         zzzz_zzzz_0000
//   12'h0x         leftmost bit is 0, so the pad is 0: 0000_0000_xxxx
//   4'dx, 4'dz     exactly one decimal digit: all bits x or z   -> xxxx, zzzz
//
// The negative rows are the same rule seen from the other side: `4'hx` is not
// `4'bxxx0`, and `12'h0x` is not `12'bxxxx_xxxx_0000`, because the left pad
// follows the left-most DIGIT and not the value of the whole literal.
//
//! lrm 2.6.1
//! lrm 7.3.2
//! lrm 2.6.1:14
//! lrm 2.6.1:15
//! lrm 2.6.1:17
//! lrm 2.6.1:21
`include "check.vh"
module ch02_xz_digit_width_and_padding(p, n);
    inout p, n;
    electrical p, n;

    analog begin
        `CHECKI("a hex x digit is four unknown bits", 4'hx === 4'bxxxx, 1);
        `CHECKI("a hex z digit is four high-impedance bits", 4'hz === 4'bzzzz, 1);
        `CHECKI("an octal x digit is three unknown bits", 3'ox === 3'bxxx, 1);
        `CHECKI("an octal z digit is three high-impedance bits", 3'oz === 3'bzzz, 1);

        `CHECKI("left-most x pads with x", 12'hx0 === 12'bxxxx_xxxx_0000, 1);
        `CHECKI("left-most z pads with z", 12'hz0 === 12'bzzzz_zzzz_0000, 1);
        `CHECKI("left-most zero pads with zero", 12'h0x === 12'b0000_0000_xxxx, 1);

        `CHECKI("a single decimal x digit means every bit is x", 4'dx === 4'bxxxx, 1);
        `CHECKI("a single decimal z digit means every bit is z", 4'dz === 4'bzzzz, 1);

        `CHECKI("hex x is not x in the low bit only", 4'hx === 4'bxxx0, 0);
        `CHECKI("the zero-padded form is not the x-padded form", 12'h0x === 12'bxxxx_xxxx_0000, 0);
        I(p, n) <+ V(p, n);
    end
endmodule
