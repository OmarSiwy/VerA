// §2.5: "A conditional operator shall have two operator characters which
// separate three operands."
//
// The legal half of a pair: b1_2_5_conditional_missing_third_operand_rejected.va
// is this file with the `: b` deleted, and nothing else changed.
//
// DERIVATION. a = 10.0, b = 20.0, c = 0. `c ? a : b` has the two operator
// characters `?` and `:` separating the three operands c, a and b. §4.2.12:
// with the test false the third operand is the result, so x = 20.0, exact in
// binary. A parser that took `:` as anything but the second operator character
// would have no third operand to select.
//
//! lrm 2.5
//! lrm 2.5:3
//! bias V(p) = 0.75, V(n) = 0.25
//! checks 1
`include "check.vh"
module b1_conditional_three_operands(p, n);
    inout p, n;
    electrical p, n;
    real a, b, x;
    integer c;

    analog begin
        a = 10.0;
        b = 20.0;
        c = 0;
        x = c ? a : b;
        `CHECKX("c ? a : b with c = 0 selects the third operand", x, 20.0);
        I(p, n) <+ x * V(p, n);
    end
endmodule
