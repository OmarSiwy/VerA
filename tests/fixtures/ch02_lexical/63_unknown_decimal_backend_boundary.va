// §2.6.1 makes `80'sd?` legal SYNTAX: a decimal constant may be a single x or z
// digit (`?` is z), which pads to the declared 80 bits. What is illegal is where
// this file puts it. §7.3.2: "Accessing digital net and digital binary constant
// operands are supported within analog context expressions. It is an error if
// these operands return x or z bit values when solved." An all-z constant
// assigned in an analog block returns z bits by construction, and §7.3.2's list
// of features that carry x and z into the analog context names only "binary,
// octal and hexadecimal numeric constants", not decimal ones.
//
// So the refusal is conformance, under §7.3.2 rather than §2.6.1. VerA reaches
// it through E0130, whose own text calls it a backend boundary rather than the
// rule; the code is pinned because it is the one VerA emits.
//
//! lrm 7.3.2
//! lrm 7.3.2:2
//! reject-only E0130
module ch02_unknown_decimal_backend_boundary;
    integer value;
    analog value = 80'sd?__;
endmodule
