// LRM 2.4: "Block comments shall not be nested." So the comment below ends at
// the FIRST */, and `still_outer */` is left behind as source text where a
// module item is expected. That leftover is the observable consequence of the
// no-nesting rule, and it is what must be diagnosed: a compiler that nested
// comments would swallow the whole line and accept the module.
//
// E0240 (`not a module item`) is the syntax code for text no A.1.4
// module_item derives -- VerA has no nested-comment-specific diagnostic,
// because per 2.4 there is no such construct to name. It fires exactly where
// the non-nesting rule leaves the trailing tokens. (It was E0205 "unsupported
// module item" until that code was kept for derivable items VerA lacks.)
//! lrm 2.4
//! lrm 2.4:3
//! reject-only E0240
//! neighbour audit_comment_nonnest_legal_neighbor.va
module ch02_nested_comment_rejected;
    /* outer /* nested */ still_outer */
endmodule
