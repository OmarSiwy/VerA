//! reject module item
// EXPECT: error
module ch02_nested_comment_rejected;
    /* outer /* nested */ still_outer */
endmodule
