// §2.5 Operators, all three of its sentences:
//
//   "Operators are single, double, or triple character sequences and are used
//    in expressions."
//
//   "Unary operators shall appear to the left of their operand. Binary
//    operators shall appear between their operands."
//
//   "A conditional operator shall have two operator characters which separate
//    three operands."
//
// The file is one module of arithmetic written so that every value below is
// forced by the ARITY of an operator and not by its meaning. Each want is
// derived by hand, and the derivation is also the counterfactual — a compiler
// that had the arity wrong prints the number in the "instead" column:
//
//   -(-2.0)       unary minus twice. The outer operator is to the LEFT of its
//                 operand, the parenthesized `-2.0`; so the value is
//                 -(-2.0) = 2.0. An operator that applied to its RIGHT
//                 neighbour would read 2.0 as the operand of the second minus
//                 and this as -2.0. The parentheses are required: annex A.8.3
//                 is `unary_operator { attribute_instance } analog_primary`
//                 (IEEE 1364-2005 A.8.3: `primary`), so `- -2.0` does not
//                 derive (65b_unary_of_unary_rejected.va).
//   3.0 - -2.0    one binary minus between two operands, then a unary minus on
//                 the right operand: 3.0 - (-2.0) = 5.0. Read with the second
//                 minus applied to the left (or dropped) it is 1.0. Legal:
//                 the unary minus applies to the primary 2.0 (A.8.3).
//   3.0 + +2.0    the same shape with unary plus (§4.2.4): 3.0 + (+2.0) = 5.0.
//                 `++` is not an operator either, so the pair must not fuse.
//   !0            logical not, unary, to the left of the integer 0. §4.2.8:
//                 "the operator ... yields the value 1 if the operand is
//                 logical 1, and 0 if the operand is logical 0", so 1.
//   !(!1)         the same operator twice, left of the same operand, which is
//                 the parenthesized `!1`: !(!1) = !0 = 1. `!!1` does not
//                 derive, for A.8.3's reason above.
//   2.0 ** 3.0    a DOUBLE-character operator, single token: 2^3 = 8.0. It is
//                 the arity that is load-bearing here and not the power — a
//                 lexer that stopped at the first `*` has `2.0 * * 3.0`, and
//                 `*` is not a unary operator, so the line does not parse.
//   1 ? 10.0 : 20.0
//                 the conditional operator: two operator characters (`?` and
//                 `:`) which separate three operands (1, 10.0, 20.0). The test
//                 operand is true, so §4.2.12's "expression3 is evaluated and
//                 used as the result" names the SECOND, and the answer is 10.0.
//   0 ? 10.0 : 20.0
//                 the same three operands with the test false: 20.0. The pair
//                 is what makes the colon an OPERATOR CHARACTER and not
//                 punctuation: one character cannot both select an arm and
//                 label it, and a parser that took only `?` would need a
//                 fourth operand to put after the `:`.
//
// NOT PINNED HERE, deliberately: the third arm of the first sentence's
// "single, double, or triple". The language's only three-character operators
// are `===` and `!==` (§4.2.6). annex_a_syntax/66_case_equality_in_analog.va
// runs both in the analog block, and ch04_expressions/29_case_equality.va
// refuses them on real operands (E0369, §4.2.1). Adding them to this file
// would make a §2.5 fixture depend on §4.2.6's four-state support.
//
// §2.5 says what an operator IS; §4.2 says what each one does, and the atomics
// (41_add.va … 64_unary_minus.va) pin the meanings. Nothing here restates one:
// every line is an arity claim that would still hold if the operator were
// redefined.
//
//! lrm 2.5
//! lrm 2.5:1
//! lrm 2.5:2
//! lrm 2.5:3
`include "check.vh"
module ch02_operator_arity(p, n);
    inout p, n;
    electrical p, n;
    real r;
    integer i;

    analog begin
        `CHECKX("unary minus twice, left of its operand", -(-2.0), 2.0);
        `CHECKX("binary between two operands, then unary on the right", 3.0 - -2.0, 5.0);
        `CHECKX("3.0 + +2.0 is 3.0 plus unary plus 2.0", 3.0 + +2.0, 5.0);
        `CHECKI("logical not is unary and left of the integer 0", !0, 1);
        `CHECKI("!(!1), two single-character operators", !(!1), 1);
        `CHECKX("a double-character operator is one token", 2.0 ** 3.0, 8.0);
        `CHECKX("two operator characters, three operands, test true", 1 ? 10.0 : 20.0, 10.0);
        `CHECKX("two operator characters, three operands, test false", 0 ? 10.0 : 20.0, 20.0);

        r = (-(-2.0)) + (3.0 - -2.0) + (3.0 + +2.0) + (2.0 ** 3.0);
        i = !0 + !(!1);
        I(p, n) <+ r + i + (1 ? 1.5 : 2.5);
    end
endmodule
