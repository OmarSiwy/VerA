// §2.6.1: "The third token, an unsigned number, shall consist of digits that
// are legal for the specified base format." Syntax 2-2: binary_digit ::= x_digit
// | z_digit | 0 | 1.
//
// `4'b101f` puts the hexadecimal digit `f` in a binary value. This file is
// b1_2_6_1_based_digits.va with that one literal changed from `4'b1011`; the
// other six literals are the legal ones it asserts.
//
// VerA rejoins the `f` the lexer stops at to the number it follows (it is a
// hexadecimal digit written against the number) and refuses the whole literal
// with E0133 "invalid number literal".
//
//! lrm 2.6.1
//! lrm 2.6.1:8
//! reject-only E0133
//! neighbour b1_2_6_1_based_digits.va
`include "check.vh"
module b1_based_digits(p, n);
    inout p, n;
    electrical p, n;
    integer bin, oct, dec, hex, hex_us, bin_us, dec_us;

    analog begin
        bin = 4'b101f;
        oct = 8'o17;
        dec = 8'd19;
        hex = 8'h1f;
        hex_us = 8'hf_f;
        bin_us = 'b1_0;
        dec_us = 1_000;
        `CHECKI("4'b1011, binary digits", bin, 11);
        `CHECKI("8'o17, octal digits", oct, 15);
        `CHECKI("8'd19, decimal digits", dec, 19);
        `CHECKI("8'h1f, hex digits", hex, 31);
        `CHECKI("8'hf_f, underscore after the first digit", hex_us, 255);
        `CHECKI("'b1_0, underscore after the first digit", bin_us, 2);
        `CHECKI("1_000, underscore in a simple decimal", dec_us, 1000);
        I(p, n) <+ (bin + oct + dec + hex + hex_us + bin_us + dec_us) * V(p, n);
    end
endmodule
