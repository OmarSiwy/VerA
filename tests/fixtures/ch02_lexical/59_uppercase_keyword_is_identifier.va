// LRM 2.8.2: "Keywords are predefined simple identifiers which are used to
// define the language constructs. ... All keywords are defined in lowercase
// only. Annex B lists all defined Verilog-AMS HDL keywords."
//
// Annex B is an inventory of the lowercase spellings; it is a list, so it
// cannot state the case rule — that sentence in 2.8.2 does, and with 2.8's
// "Identifiers shall be case sensitive" it settles what `REAL`, `MODULE` and
// `BEGIN` are: three ordinary simple identifiers, not keywords, not each
// other, and not the lowercase words they resemble.
//
// 26_escaped_keyword.va covers the OTHER half of 2.8.2, the escape ("A
// Verilog-AMS HDL keyword preceded by an escape character is not interpreted
// as a keyword"). The case half needs its own fixture because the failure mode
// is the opposite one: a lexer that folds case before matching its keyword
// table does not mis-name these three, it refuses the declaration outright.
//
// The three wants are distinct powers of two and the last check sums them, so
// two of them aliasing to one storage cell cannot cancel out: 1 + 2 + 4 = 7,
// and any collision lands on 2, 3, 5, 6, 8 or 12 instead. Every value is exact
// in binary, hence CHECKX.
//! lrm 2.8.2
//! lrm 2.8
//! lrm 2.8:5
//! lrm 2.8.2:1000
`include "check.vh"
module ch02_uppercase_keyword_is_identifier(p, n);
    inout p, n;
    electrical p, n;
    real REAL, MODULE, BEGIN;

    analog begin
        REAL = 1.0;
        MODULE = 2.0;
        BEGIN = 4.0;
        `CHECKX("REAL is an ordinary identifier, not the keyword", REAL, 1.0);
        `CHECKX("MODULE is an ordinary identifier, not the keyword", MODULE, 2.0);
        `CHECKX("BEGIN is an ordinary identifier, not the keyword", BEGIN, 4.0);
        `CHECKX("the three are separate storage", REAL + MODULE + BEGIN, 7.0);
        I(p, n) <+ (REAL + MODULE + BEGIN) * V(p, n);
    end
endmodule
