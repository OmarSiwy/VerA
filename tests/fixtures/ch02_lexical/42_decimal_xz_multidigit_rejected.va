// LRM 2.6.1: "In a decimal constant, the unsigned number token shall not
// contain any x, z, or ? digits, unless there is exactly one digit in the
// token, indicating that every bit in the decimal constant is x or z."
// `8'd1x` has two digits, one of them x, so it is grammatically illegal.
//
// Not a duplicate of 05_xz_integer_rejected.va or 24_question_digit_rejected.va.
// Those two reject forms that 2.6.1 PERMITS in Verilog-AMS and that only Annex
// C.3 withdraws from the analog subset. This one is an outright prohibition in
// 2.6.1 itself: it holds in full Verilog-AMS, mixed-signal context or not, so
// no C.3 cite belongs here.
//
// KNOWN, so the next reader does not mistake this for proof: VerA's E0130 is
// "x/z digit in a number literal" — the Annex C.3 subset rejection — so against
// VerA today this file fires on the `x`, not on the two-digit arity, and it
// proves nothing 05 does not already. The claim it states is still the 2.6.1
// one, and a full Verilog-AMS compiler with mixed-signal context available must
// reject it while accepting 05's `4'b01xz`; that is what the `//! lrm` cite
// carries. Retarget this line the day VerA grows an arity-specific code.
//! lrm 2.6.1
//! reject E0130
module ch02_decimal_xz_multidigit_rejected;
    integer value;
    analog value = 8'd1x;
endmodule
