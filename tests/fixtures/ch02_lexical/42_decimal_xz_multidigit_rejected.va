// LRM 2.6.1: "In a decimal constant, the unsigned number token shall not
// contain any x, z, or ? digits, unless there is exactly one digit in the
// token, indicating that every bit in the decimal constant is x or z."
// `8'd1x` has two digits, one of them x, so it is grammatically illegal.
//
// Not a duplicate of 05_xz_integer_rejected.va or 24_question_digit_rejected.va.
// Those two reject forms that 2.6.1 PERMITS in Verilog-AMS and that only Annex
// C.3 withdraws from the analog subset. This one is an outright prohibition in
// 2.6.1 itself: it holds in full Verilog-AMS, mixed-signal context or not, so
// no C.3 cite belongs here.
//
// E0133 now diagnoses the malformed decimal syntax before the analog
// execution boundary. Legal single X/Z decimal digits parse successfully.
//! lrm 2.6.1
//! lrm 2.6.1:21
//! reject-only E0133
//! neighbour 77_xz_digit_width_and_padding.va
module ch02_decimal_xz_multidigit_rejected;
    integer value;
    analog value = 8'd1x;
endmodule
