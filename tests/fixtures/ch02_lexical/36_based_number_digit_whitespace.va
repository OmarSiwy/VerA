// DEBT — this rejection is NOT conformance.
// The LRM permits what VerA refuses here. The substrings below record
// CURRENT behavior so the suite stays green on it; they do not claim it
// is right. `zig build ledger` counts this rule against VerA.
//
// VAMS-2.6.1-09  (ch2-lexical.html)
// The unsigned number token shall immediately follow the base format, optionally preceded by white space.
//
//! reject DiagnosticsReported
module ch2_based_ws(p); inout p; electrical p; integer x; analog begin x=8'h Af + 8'b 1010 + 8'o 17 + 8'd 12; I(p)<+x+0.0*V(p); end endmodule
// EXPECT: error -- normative syntax/restriction snapshot for this rule family.
