// LRM 2.9.1, Syntax 2-8, puts a `{ attribute_instance }` slot on every arm of
// the block item declaration, and A.2.8 spells the analog form of it:
//
//     analog_block_item_declaration ::=                          // from A.2.8
//             { attribute_instance } parameter_declaration ;
//           | { attribute_instance } integer_declaration
//           | { attribute_instance } real_declaration
//           | { attribute_instance } string_declaration
//
// A.2.6 then routes an analog FUNCTION body through the same production:
//
//     analog_function_item_declaration ::=                       // from A.2.6
//             analog_block_item_declaration
//           | input_declaration ; | output_declaration ; | inout_declaration ;
//
// So the slot reaches two places nothing else in this chapter does — inside a
// named analog block, and inside an analog function body. Every other 2.9
// fixture here attaches an attribute at module, port, module-item or expression
// level.
//
// NOT the ANSI function port list. Syntax 2-8's other production,
// `function_port_list ::= { attribute_instance } tf_input_declaration ...`,
// belongs to a digital `function_declaration`, which an analog function never
// uses; `analog_function_item_declaration` above carries no attribute slot on
// its `input_declaration` arm at all. Nor is `input real x;` derivable —
// A.2.1.2 reads `input [ discipline_identifier ] [ net_type | wreal ] [ signed ]
// [ range ] list_of_port_identifiers` and A.2.2.1's net_type is supply0 |
// supply1 | tri | triand | trior | tri0 | tri1 | uwire | wire | wand | wor, with
// no `real` in it. The argument is declared the way §4.7.1's own analog-function
// examples declare one, and the way 32_function_call_attribute.va does: `input
// x;` then `real x;`.
//
// What is proved, per 2.9: an attribute "specif[ies] properties about objects,
// statements and groups of statements ... that can be used by various tools",
// so it must leave the thing it decorates alone. The wants are all exact
// binary, so a decorated declaration losing its value shows up as a bit-level
// miss rather than a rounding one:
//
//   the bias holds V(p,n) at 0.5, so the attributed block real `v` is 0.5
//   the attributed block parameter `g` keeps its 3.0 default
//   the attributed real inside the function holds 2.0 * 0.5 = 1.0
//   and the two together: g * v = 3.0 * 0.5 = 1.5
//
//! bias V(p) = 0.5
//! lrm 2.9.1
//! lrm A.2.6
//! lrm A.2.8
//! lrm 2.9.1:1000
//! lrm A.2.6:1000
//! lrm A.2.8:1000
//! lrm A.9.1
//! lrm A.9.1:1000
`include "check.vh"
module ch02_attribute_block_item_and_function_port(p, n);
    inout p, n;
    electrical p, n;

    analog function real scale_by_two;
        input x;
        real x;
        (* desc = "doubled argument", units = "V" *) real doubled;
        begin
            doubled = 2.0 * x;
            scale_by_two = doubled;
        end
    endfunction

    analog begin : main
        (* desc = "scratch" *) real v;
        (* desc = "local gain", units = "S" *) parameter real g = 3.0;

        v = V(p, n);
        `CHECKX("an attributed block real holds the solved value", v, 0.5);
        `CHECKX("an attributed block parameter keeps its default", g, 3.0);
        `CHECKX("an attributed real inside an analog function still computes",
                scale_by_two(v), 1.0);
        `CHECKX("both attributed declarations still compose", g * v, 1.5);
        I(p, n) <+ g * v;
    end
endmodule
