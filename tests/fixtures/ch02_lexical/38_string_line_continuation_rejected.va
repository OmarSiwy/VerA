// LRM 2.7: "A string literal is a sequence of characters enclosed by double
// quotes and contained on a single line", and Table 2-2 lists no \<newline>
// escape. The continuation is an IEEE 1800 SystemVerilog addition (5.9);
// Verilog-AMS derives from IEEE 1364-2005 (1.1), whose 3.6 has the same
// single-line rule. Verbatim from bsim4va.va:3658 -- a vendor extension, not
// a lexer gap, so the rejection is the correct answer and is pinned here.
//! reject-only E0138
//! reject a string literal may not span lines
//! lrm 2.7
//! lrm 2.7:1001
//! neighbour 08_string_escapes.va
module ch02_string_line_continuation_rejected;
    analog begin
        $strobe("Temperature effect has caused pbs to be less than 0.01. \
                 Pbs is clamped to 0.01.\n");
    end
endmodule
