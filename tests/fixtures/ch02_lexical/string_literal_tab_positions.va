// AMS2.3 preserves literal tabs in strings. AMS2.7 maps each character to
// its8-bit ASCII value in integer expressions: TAB=9,A=65,B=66.
// The quoted inputs below contain actual byte09, not backslash-t escapes.
// Leading:9*65536+65*256+66=606530.
// Interior:65*65536+9*256+66=4262210.
// Trailing:65*65536+66*256+9=4276745.
// These distinct values expose stripping, whitespace collapsing or reversal.
//! lrm 2.3
//! lrm 2.7
//! lrm 2.3:3
//! lrm 2.7:1
//! checks 3
`include "check.vh"
module audit_string_literal_tab_positions(p);
    inout p;
    electrical p;
    analog begin
        `CHECKI("literal leading tab", "	AB", 606530);
        `CHECKI("literal interior tab", "A	B", 4262210);
        `CHECKI("literal trailing tab", "AB	", 4276745);
        I(p) <+ 0.0;
    end
endmodule
