// §2.8.4: "The compiler behavior dictated by a compiler directive shall take
// effect as soon as the compiler reads the directive. The directive shall
// remain in effect for the rest of the compilation unless a different
// compiler directive specifies otherwise."
//
// The consequence this file pins is the other direction of "as soon as": a
// `define has NO effect on text the compiler read before it. `GAIN is used in
// the analog block and defined only after `endmodule`, so at the point of use
// no macro GAIN exists and the reference is an error. Moving the `define above
// the module makes the same file legal.
//
// VerA reports E0115 "undefined macro: `GAIN".
//
//! lrm 2.8.4
//! lrm 2.8.4:1
//! lrm 2.8.4:2
//! reject-only E0115
//! neighbour 10_compiler_directive_macro.va
`include "disciplines.vams"
module ch2_macro_before_define(p, n);
  inout p, n;
  electrical p, n;
  real x;

  analog begin
    x = `GAIN;      // illegal: GAIN is not defined until after this line is read
    I(p, n) <+ x * V(p, n);
  end
endmodule
`define GAIN 2.0
