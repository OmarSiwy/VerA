// LRM 2.6.2 lists `.1p` verbatim, fifth of six, among "invalid forms of real
// numbers because they do not have at least one digit on each side of the
// decimal point".
//
// It is the only one of the six on the scale-factor branch of the real number
// grammar (`unsigned_number [ . unsigned_number ] scale_factor`) rather than
// the exponent branch, so it is the form that would survive a lexer that
// special-cased `e`/`E` only. `p` is a legal scale factor per Table 2-1
// (1e-12) -- 07_si_scale_factors.va shows it accepted after a digit -- which
// is precisely why the leading point has to be what is refused.
//! lrm 2.6.2
//! lrm 2.6.2:2
//! reject-only E0209
//! neighbour 07_si_scale_factors.va
module ch02_real_leading_dot_scale_rejected;
    real value;
    analog value = .1p;
endmodule
