// §2.6.1: the size constant is OPTIONAL, an unadorned base format is unsigned,
// and "the number of bits that make up an unsized number ... shall be at least
// 32". Example 1's second and third lines are exactly these two literals,
// `'h 837FF` and `'o7460`.
//
// The wants are hand-converted:
//   'h837ff = 8*65536 + 3*4096 + 7*256 + 15*16 + 15
//           = 524288 + 12288 + 1792 + 240 + 15         = 538623
//   'o7460  = 7*512 + 4*64 + 6*8 + 0 = 3584 + 256 + 48 = 3888
// 0x000837FF has a clear bit 31, so a signed and an unsigned reading agree and
// the value does not depend on which width above the 32-bit floor the
// implementation picked — §2.6.1 leaves that open, so the fixture must not pin
// it.
//! lrm 2.6.1
//! lrm 2.6.1:2
`include "check.vh"
module ch02_unsized_based_number(p, n);
    inout p, n;
    electrical p, n;
    integer value;
    analog begin
        value = 'h837ff;
        `CHECKI("unsized 'h837ff is at least 32 bits and unsigned", value, 538623);
        `CHECKI("unsized 'o7460", 'o7460, 3888);
        I(p, n) <+ value + 0.0 * V(p, n);
    end
endmodule
