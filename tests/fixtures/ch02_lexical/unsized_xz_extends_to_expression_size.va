// §2.6.1: "Unsized unsigned constants where the high order bit is unknown
// (X or x) or three-state (Z or z) shall be extended to the size of the
// expression containing the constant."
//
// An unsized based constant occupies the integer width (§2.6.1:19's "at least
// 32"); the clause above decides what fills the bits ABOVE its digits when the
// expression is wider. For a constant whose leftmost digit is x or z the fill
// is that same x or z, not zero; for one whose leftmost digit is known the
// ordinary zero extension applies. The expressions compared below are 40 bits,
// eight more than the unsized operand's own 32, so the fill is observable:
//
//   'hx0   the digits are x,0 -> the leftmost digit is x
//          in 40 bits: 40'hxxxxxxxxx0   (36 x bits, then the 0 digit)
//   'hz0   likewise with z:        40'hzzzzzzzzz0
//   'h0x   the leftmost digit is 0, so the fill is zero:
//                                  40'h000000000x
//
// The first two comparisons are true only under the x/z fill; the third is the
// zero-fill shape and must be false. `'h0x` against the same zero-filled
// pattern is the other side of the rule: a known high digit does not get the
// x fill. The 32-bit comparisons pin the same constants at the operand width,
// where the fill reaches the whole expression.
//
// The comparisons run in a discrete initial block: §7.3.2 keeps an x or z bit
// out of the analog context except as a direct `===`/`!==` operand, and the
// unsized four-state literal is wider than the analog comparison path carries,
// so the four-state comparison belongs to the digital half. The analog CHECKs
// read the stored one-bit results, gated to the t = 1 point because §8.4.1
// leaves the DC solve and the first digital statements unordered.
//
//! lrm 2.6.1
//! lrm 2.6.1:20
//! analysis tran
//! time 0, 1
//! bias V(p) = 0.0
`include "check.vh"
module ch02_unsized_xz_extends_to_expression_size(p);
  inout p;
  electrical p;
  reg x32, z32, x40, z40, x40_zero, known40;

  initial begin
    x32 = ('hx === 32'hxxxxxxxx);
    z32 = ('hz === 32'hzzzzzzzz);
    x40 = ('hx0 === 40'hxxxxxxxxx0);
    z40 = ('hz0 === 40'hzzzzzzzzz0);
    x40_zero = ('hx0 === 40'h00000000x0);
    known40 = ('h0x === 40'h000000000x);
  end

  analog begin
    `CHECKI("unsized x fills the 32-bit expression", ($abstime > 0.5) ? x32 : 1, 1);
    `CHECKI("unsized z fills the 32-bit expression", ($abstime > 0.5) ? z32 : 1, 1);
    `CHECKI("unsized x0 extends to the 40-bit expression", ($abstime > 0.5) ? x40 : 1, 1);
    `CHECKI("unsized z0 extends to the 40-bit expression", ($abstime > 0.5) ? z40 : 1, 1);
    `CHECKI("the extension is x, not zero", ($abstime > 0.5) ? x40_zero : 0, 0);
    `CHECKI("a known high digit uses zero extension", ($abstime > 0.5) ? known40 : 1, 1);
    I(p) <+ V(p);
  end
endmodule
