// LRM 2.6: the value token of a based number is an UNSIGNED number, so the
// sign in `8'd -6` is not part of the literal.
//! reject ParseError
//! reject E0209
module ch02_base_sign_current_behavior(p, n);
    inout p, n;
    electrical p, n;
    integer value;
    analog begin
        value = 8'd -6;
        I(p, n) <+ value;
    end
endmodule
