// LRM 2.8: "The first character of an identifier shall not be a digit or $; it
// can be a letter or an underscore." 17_identifier_digit_rejected.va pins the
// digit half; this is the $ half.
//
// The two interlock with a third rule in the same paragraph: a simple
// identifier "shall be any sequence of letters, digits, dollar signs ($), and
// the underscore characters (_)", so $ is perfectly legal from the second
// character on -- the LRM's own example list includes `n$657`, exercised in
// 02_simple_identifiers.va. Only the leading position is barred.
//! lrm 2.8
//! lrm 2.8:4
//! lrm A.10
//! lrm A.10:2
//! reject-only E0208
//! neighbour 02_simple_identifiers.va
module ch02_identifier_dollar_first_rejected;
    real $gain;
endmodule
