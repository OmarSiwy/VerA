//! lrm 2.9
//! lrm A.8.3
//! lrm A.8.3:1000
`include "check.vh"
//! bias V(p) = 0.5
module ch2_cond_attr(p); inout p; electrical p; analog begin I(p)<+(V(p)>0.0 ? (* no_glitch *) 1.0 : 0.0);
  // A.8.3: `conditional_expression ::= expr ? { attribute_instance } expr : expr`.
  // The attribute sits in the TRUE arm's slot and carries no value, so it must
  // not be mistaken for that arm. With V(p) held at 0.5 the true arm selects
  // 7.25 and the mirrored test selects the false arm, -3.5 — distinct literals,
  // so an arm swap or a swallowed arm shows up as a wrong number, not a pass.
  `CHECKX("attr_after_question_true_arm", (V(p)>0.0 ? (* no_glitch *) 7.25 : -3.5), 7.25);
  `CHECKX("attr_after_question_false_arm", (V(p)<0.0 ? (* no_glitch *) 7.25 : -3.5), -3.5);
end endmodule
// Annex A.8.3 allows `{ attribute_instance }` after the `?` of a conditional
// expression, and §2.9 Example 8 prints exactly this form — `a = b ? (*
// no_glitch *) c : d;` — so this must COMPILE. Not 2.9.1: Syntax 2-5 through
// 2-10 there cover module, port, module-item, function-port/task/block, port
// connection and UDP, and none of them reaches a conditional expression.
