// LRM 2.7, Table 2-2: \ddd is "A character specified in 1-3 octal digits",
// and an implementation "may issue an error if the character represented is
// greater than \377". \377 itself is not greater, so it is legal everywhere.
//
// Legal neighbour of octal_escape_above_377_rejected.va (same module, \377
// where that one has \477). HAND DERIVATION: \377 = 3*64 + 7*8 + 7 = 255. A
// one-character string in an integer expression is that byte's unsigned value
// (67_octal_escape_boundaries.va), so "\377" is 255.
//! lrm 2.7
//! lrm 2.7:3
//! nowarn
//! checks 1
`include "check.vh"
module octal_escape_377_largest_byte(p, n);
    inout p, n;
    electrical p, n;
    analog begin
        `CHECKI("\\377 is the largest byte", "\377", 255);
        I(p, n) <+ V(p, n);
    end
endmodule
