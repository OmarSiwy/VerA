// §2.9.2 "The Verilog-AMS HDL standardizes the following attributes: The desc
// attribute ... The units attribute ... The op attribute ... must be either
// "yes" or "no" ... The multiplicity attribute ... must be assigned one of the
// following string values: "multiply", "divide", or "none". ... Note that this
// scaling only applies to operating-point value reports; it does not affect the
// automatic scaling detailed in 6.3.6."
//
// The positive half. 52/69/70/71/72_*_rejected.va pin the refusal of a badly
// typed standard attribute; this file attaches every standard attribute, each
// with a LEGAL value, including the clause's own example verbatim, and shows
// the declarations still behave as the declarations they decorate.
//
// WHAT IS ASSERTED. An attribute is a report annotation, so the one value-level
// claim the clause makes is the last sentence: `multiplicity` scales REPORTS
// only. A variable carrying multiplicity="divide" and a parameter carrying
// multiplicity="multiply" must read exactly what was assigned / declared:
//
//   reff  = 2.0 * V(p, n) = 2.0 * 0.5 = 1.0         (V(p)=0.75, V(n)=0.25)
//   rsh   = 3.0                                      (declared default)
//   gdiv  = 0.25                                     (multiplicity "none")
//
// all exact in binary64. A compiler that applied the report scaling to the
// value itself (divide by $mfactor, or multiply) would only pass at $mfactor = 1,
// so this pins the other half too: the attribute is not an operator.
//
//! lrm 2.9.2
//! bias V(p) = 0.75, V(n) = 0.25
`include "check.vh"
module ch02_standard_attributes_on_declarations(p, n);
  inout p, n;
  electrical p, n;

  (* desc="sheet resistance", units="Ohms", op="yes", multiplicity="multiply" *)
  parameter real rsh = 3.0;
  (* desc="a divider", units="", op="no", multiplicity="none" *)
  parameter real gdiv = 0.25;

  (* desc="effective resistance", units="Ohms", op="yes",
     multiplicity="divide" *)
  real reff;

  analog begin
    reff = 2.0 * V(p, n);
    `CHECKX("§2.9.2 a variable with standard attributes holds its assigned value", reff, 1.0);
    `CHECKX("§2.9.2 a parameter with standard attributes keeps its declared value", rsh, 3.0);
    `CHECKX("§2.9.2 multiplicity=\"none\" leaves the parameter unscaled", gdiv, 0.25);
    I(p, n) <+ V(p, n) * reff * gdiv;
  end
endmodule
