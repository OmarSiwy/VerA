// §2.8.1 escaped identifiers. Two separate claims:
//
//   1. An escaped identifier may contain any printable ASCII, so `\gain+trim`
//      is ONE name and not `gain` `+` `trim` — reading it back has to find the
//      4.0 that was written to it.
//   2. "Neither the leading backslash character nor the terminating white space
//      is considered to be part of the identifier. Therefore, an escaped
//      identifier \cpu3 is treated the same as a non-escaped identifier cpu3."
//      So `\trim ` declares `trim`, and the plain spelling reaches the same
//      storage. A lexer that kept the backslash in the name would not resolve
//      the reference at all.
//   3. The terminator is "white space (space, tab, newline, or formfeed)", not
//      a space, so `\***error-condition***` closed by a TAB is the same kind of
//      name — declared with a tab terminator and read back with one.
//   4. The charset is "any of the printable ASCII characters ... (the decimal
//      values 33 through 126)", well past the `+` above: `\{a,b}` is one of the
//      LRM's own six examples and its braces and comma are all inside the name.
//
// The first check reads `\gain+trim ` through a plain variable rather than
// naming it inside the CHECK macro: VerA's preprocessor drops the identifier's
// terminating white space when it substitutes a macro argument, so the lexer
// then swallows the `)` that follows into the name and the expansion does not
// parse (E0207). That is a §10.3 substitution bug, not a §2.8.1 one, so this
// fixture states the §2.8.1 claim in a form the bug does not block.
//! lrm 2.8.1
//! lrm 2.8
//! lrm 2.8:2
//! lrm 2.8.1:1
//! lrm 2.8.1:1001
`include "check.vh"
module ch02_escaped_identifiers(p, n);
    inout p, n;
    electrical p, n;
    real \gain+trim ;
    real \trim ;
    real \***error-condition***	;
    real \{a,b} ;
    real read_back, tab_read_back, wide_read_back;

    analog begin
        \gain+trim  = 4.0;
        \trim  = 2.5;
        \***error-condition***	= 1.25;
        \{a,b} = -0.75;
        read_back = \gain+trim ;
        tab_read_back = \***error-condition***	;
        wide_read_back = \{a,b} ;
        `CHECKX("escaped identifier containing + is one name", read_back, 4.0);
        `CHECKX("escaped \\trim is the same object as plain trim", trim, 2.5);
        `CHECKX("a tab terminates an escaped identifier", tab_read_back, 1.25);
        `CHECKX("braces and a comma are ordinary characters inside one", wide_read_back, -0.75);
        I(p, n) <+ \gain+trim  * V(p, n);
    end
endmodule
