// LRM 2.6.2 lists `4.E3` verbatim among "invalid forms of real numbers because
// they do not have at least one digit on each side of the decimal point".
// A digit is required after the point even when an exponent follows.
//! lrm 2.6.2
//! lrm 2.6.2:2
//! reject-only E0207
module ch02_real_dot_exponent_rejected;
    real value;
    analog value = 4.E3;
endmodule
