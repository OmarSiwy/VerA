// LRM 2.3: "spaces and tabs shall be considered significant characters in
// strings". LRM 2.7 gives one 8-bit ASCII value per character in integer
// expressions. The first operand below contains a literal tab, not \t.
// ASCII tab=9, space=32, A=65. Thus tab-space=9*256+32=2336,
// space-tab=32*256+9=8201, and space-A-space=32*65536+65*256+32=2113824.
// Distinct orders catch stripping, collapsing, and byte-order reversal.
//! lrm 2.3
//! lrm 2.7
//! lrm 2.3:3
//! lrm 2.7:1
`include "check.vh"
module ch02_string_whitespace_significant(p, n);
    inout p, n;
    electrical p, n;
    analog begin
        `CHECKI("literal tab followed by space", "	 ", 2336);
        `CHECKI("space followed by escaped tab", " \t", 8201);
        `CHECKI("leading and trailing spaces", " A ", 2113824);
        I(p, n) <+ 0.0;
    end
endmodule
