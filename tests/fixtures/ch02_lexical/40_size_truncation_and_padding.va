// §2.6.1: "If the size of the unsigned number is smaller than the size
// specified for the constant, the unsigned number shall be padded to the left
// with zeros. ... If the size of the unsigned number is larger than the size
// specified for the constant, the unsigned number shall be truncated from the
// left."
//
// 04_integer_bases.va says in its own header that every literal in it fits its
// declared size, "so none of them exercises the left-truncation rule". This is
// that file. The x/z half of the same paragraph is out of the Verilog-A subset
// (Annex C.3), but the two-state half is not, and it is plain arithmetic:
//
//   2'd7    111       -> keep the low 2 bits    11 =   3
//   3'b1101 1101      -> keep the low 3 bits   101 =   5
//   8'h1ff  1_1111_1111 -> keep the low 8 bits  ff = 255
//   4'b1    1         -> pad left with zeros  0001 =   1
//   16'h5   101       -> pad left with zeros        =   5
// Every size here has a clear top bit after truncation, so the values are the
// same whether the constant is read signed or unsigned.
//! lrm 2.6.1
`include "check.vh"
module ch02_size_truncation_and_padding(p, n);
    inout p, n;
    electrical p, n;
    integer value;
    analog begin
        value = 8'h1ff;
        `CHECKI("2'd7 truncates from the left to 11", 2'd7, 3);
        `CHECKI("3'b1101 truncates from the left to 101", 3'b1101, 5);
        `CHECKI("8'h1ff truncates from the left to ff", value, 255);
        `CHECKI("4'b1 pads to the left with zeros", 4'b1, 1);
        `CHECKI("16'h5 pads to the left with zeros", 16'h5, 5);
        I(p, n) <+ value + 0.0 * V(p, n);
    end
endmodule
