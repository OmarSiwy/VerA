// LRM 2.6.1 (A.8.7): the base is '[s|S]d|'[s|S]D, 'b|'B, 'o|'O, 'h|'H — the
// base letter is case-insensitive — and hex_digit admits both a..f and A..F.
// So 8'HAf = 0xAF = 175, 8'B1010 = 10, 8'O17 = 8+7 = 15, 8'D12 = 12, summing
// to 212. Every digit below is one a reader can redo on paper.
//! lrm 2.6.1
//! lrm A.8.7
//! lrm 2.6.1:6
//! lrm 2.6.1:10
//! lrm A.8.7:1000
`include "check.vh"
module ch2_upper_bases(p); inout p; electrical p; integer x; analog begin x=8'HAf+8'B1010+8'O17+8'D12; I(p)<+x+0.0*V(p);
  `CHECKI("hex_upper_base_mixed_case_digits", 8'HAf, 175);
  `CHECKI("octal_upper_base", 8'O17, 15);
  `CHECKI("binary_upper_base", 8'B1010, 10);
  `CHECKI("decimal_upper_base", 8'D12, 12);
  `CHECKI("uppercase_signed_designator", 8'SHff, -1);
  `CHECKI("upper_base_sum", x, 212);
end endmodule
