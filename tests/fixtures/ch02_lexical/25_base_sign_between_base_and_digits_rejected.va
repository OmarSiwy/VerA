// LRM 2.6.1: "A plus or minus operator preceding the size constant is a unary
// plus or minus operator. A plus or minus operator between the base format and
// the number is an illegal syntax."
//
// This is the first line of the chapter's Example 3, `8 'd -6`, which the LRM
// itself annotates `// this is illegal syntax`. The third token of a based
// constant is an UNSIGNED number, so the sign has no slot to occupy: the
// rejection is normative, which is why this file is named `_rejected` and not
// filed as a behaviour snapshot. The legal spelling is Example 3's second line,
// `-8 'd 6`, where the sign is a unary operator on the size constant.
//
// The size and the apostrophe are written closed up as `8'd -6`. The white
// space Example 3 puts there is optional per 2.6.1 and is a separate rule
// (36_based_number_digit_whitespace.va owns it, and VerA does not meet it yet),
// so leaving it out keeps this fixture failing for the sign and nothing else.
//! lrm 2.6.1
//! reject ParseError
//! reject E0209
module ch02_base_sign_between_base_and_digits_rejected(p, n);
    inout p, n;
    electrical p, n;
    integer value;
    analog begin
        value = 8'd -6;
        I(p, n) <+ value;
    end
endmodule
