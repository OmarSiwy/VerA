// LRM 2.8.2: "A Verilog-AMS HDL keyword preceded by an escape character is not
// interpreted as a keyword" — so `\analog ` is an ordinary variable name.
// LRM 2.8.1: "Neither the leading backslash character nor the terminating white
// space is considered to be part of the identifier. Therefore, an escaped
// identifier \cpu3 is treated the same as a non-escaped identifier cpu3."
// That second sentence is an equality between two spellings of ONE object, so
// `cpu3` is declared plainly, written through `\cpu3 `, and read back plainly.
//! lrm 2.8.2
//! lrm 2.8.1
//! lrm 2.8.1:1
//! lrm 2.8.2:1000
`include "check.vh"
//! bias V(p) = 1.5
module ch02_escaped_keyword(p, n);
    inout p, n;
    electrical p, n;
    real \analog ;
    real cpu3;

    analog begin
        \analog  = 1.0;
        I(p, n) <+ \analog ;
        // n sits at 0 and the bias holds p at 1.5, so V(p,n) is exactly 1.5
        // and 4*1.0 + 1.5 = 5.5 — exact in binary, hence CHECKX.
        \cpu3  = 4.0 * \analog  + V(p, n);
        `CHECKX("escaped_keyword_names_storage", \analog  * 6.0, 6.0);
        `CHECKX("escaped_ident_is_the_unescaped_one", cpu3, 5.5);
    end
endmodule
