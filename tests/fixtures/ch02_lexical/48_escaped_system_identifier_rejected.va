// LRM 2.8.3, Syntax 2-3 footnote 1, second sentence: "A system_function_
// identifier or system_task_identifier shall not be escaped."
// 18_system_whitespace_rejected.va pins the first sentence; this is the second.
//
// Why E0314 (`unknown identifier`) is the CONFORMING answer, and not a weaker
// one to be "fixed" later: per 2.8.1 an escaped identifier is an ordinary
// identifier whose name is the escaped text, so `\$vt ` names a plain user
// object called `$vt`. It does NOT reach the system parameter $vt -- that is
// the whole content of the rule. Nothing in this module declares such an
// object, so the only thing left to say is that the name does not exist. A
// compiler that resolved `\$vt ` to $vt = kT/q and compiled this file would be
// violating 2.8.3, and would fail here.
//! lrm 2.8.3
//! lrm 2.8.1
//! lrm 2.8.3:2
//! lrm A.10
//! lrm A.10:4
//! reject-only E0314
//! neighbour 09_system_identifiers.va
module ch02_escaped_system_identifier_rejected;
    real value;
    analog value = \$vt ;
endmodule
