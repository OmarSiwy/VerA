// LRM 2.6: a real number must have at least one digit on each side of the
// decimal point, so `.12` is not a legal real number.
//! reject E0209
module ch02_real_leading_dot_current_behavior(p, n);
    inout p, n;
    electrical p, n;
    analog I(p, n) <+ .12;
endmodule
