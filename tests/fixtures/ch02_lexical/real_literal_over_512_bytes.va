// LRM 2.6.2 writes a real number as digits with no length bound. VerA once
// decoded a literal through a 512-byte buffer and refused a longer one with
// E0134; the literal below is 609 bytes and decodes in full.
//
// HAND DERIVATION. The literal is "0." then 600 zeros then "125e603":
// 0.(600 zeros)125 = 125 * 10^-603, and e603 scales it to exactly 125.0,
// which a double holds exactly. A decoder that dropped any digit past byte
// 512 would read 0.0 (the 125 sits at bytes 603-605).
//
//! lrm 2.6.2
//! checks 1
`include "check.vh"
module real_literal_over_512_bytes(p);
  inout p; electrical p;
  real r;
  analog begin
    r = 0.000000000000000000000000000000000000000000000000000000000000000000000000000000000000000000000000000000000000000000000000000000000000000000000000000000000000000000000000000000000000000000000000000000000000000000000000000000000000000000000000000000000000000000000000000000000000000000000000000000000000000000000000000000000000000000000000000000000000000000000000000000000000000000000000000000000000000000000000000000000000000000000000000000000000000000000000000000000000000000000000000000000000000000000000000000000000000000000000000000000000000000000000000000000000000000000000000000000000000000000000125e603;
    `CHECKX("a 610-byte literal reads every digit", r, 125.0);
    I(p) <+ r * V(p);
  end
endmodule
