// LRM 2.8.3, Syntax 2-3 footnote 1: "The $ character in a
// system_function_identifier, system_task_identifier, or
// system_parameter_identifier shall not be followed by white_space."
// So `$ vt` is not the system parameter $vt; the lone $ is not a token at all.
//
// The second sentence of the same footnote -- a system identifier shall not be
// escaped -- is pinned by 48_escaped_system_identifier_rejected.va.
//! lrm 2.8.3
//! lrm 2.8.3:1
//! lrm A.10
//! lrm A.10:3
//! reject-only E0209
//! neighbour 09_system_identifiers.va
module ch02_system_whitespace_rejected;
    real value;
    analog value = $ vt;
endmodule
