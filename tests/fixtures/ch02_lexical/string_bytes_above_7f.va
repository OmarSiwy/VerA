// LRM A.8.8: string_literal ::= " { Any_ASCII_Characters } ". IEEE 1364-2005
// 3.6 (inherited through §2.7): a string is "a sequence of 8-bit ASCII
// values, with one 8-bit ASCII value representing one character", and §2.7
// treats one used as an operand as an unsigned integer of those values.
//
// ASCII is 7-bit, so the production and the storage model disagree about a
// byte above 0x7F. VerA's choice (specification/Vague_Decisions.md VD-014,
// specification/Vague_Decisions.md): each such byte is one opaque 8-bit character. No
// refusal is pinned because VerA refuses nothing here; a tool that refuses
// these bytes or decodes UTF-8 also conforms, so this tests VerA's choice.
//
// HAND DERIVATION. This file is UTF-8, so the degree sign U+00B0 is the two
// bytes C2 B0. "°C" is then three characters, C2 B0 43, and as an integer
// 0xC2B043 = 194*65536 + 176*256 + 67 = 12713984 + 45056 + 67 = 12759107.
// Decoding UTF-8 instead would give 0xB043 = 45123 (two characters).
// "°" alone is 0xC2B0 = 194*256 + 176 = 49840.
//! lrm 2.7
//! lrm A.8.8
//! nowarn
//! checks 2
`include "check.vh"
module string_bytes_above_7f(p, n);
    inout p, n;
    electrical p, n;
    analog begin
        `CHECKI("degree C is three bytes C2 B0 43", "°C", 12759107);
        `CHECKI("the degree sign alone is two bytes C2 B0", "°", 49840);
        I(p, n) <+ V(p, n);
    end
endmodule
