//! lrm 2.9
//! lrm 2.9:2
`include "check.vh"
//! bias V(p) = 0.625
module ch2_stmt_attr(p); inout p; electrical p; real x; analog begin (* assign_attr *) x=V(p); (* contribution_attr=1 *) I(p)<+x;
  // LRM 2.9: an attribute_instance is a PREFIX to the statement; it neither
  // suppresses it nor contributes a value to it. The bias holds V(p) at 0.625
  // (exact in binary), so an attributed `x = V(p)` must leave x at 0.625 —
  // not at 0 (statement dropped) and not at 1 (the attr_spec's value leaking).
  `CHECKX("attributed_assign_still_runs", x, 0.625);
end endmodule
// An attribute_instance "can appear in the Verilog-AMS description as a prefix
// attached to a declaration, a module item, a STATEMENT, or a port connection"
// — LRM 2.9 prose, not 2.9.1: Syntax 2-5 through 2-10 there carry no statement
// production. They are parsed and skipped, so this must COMPILE.
