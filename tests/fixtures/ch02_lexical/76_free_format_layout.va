// §2.2: "The layout of tokens in a source file is free format — that is,
// spaces and newlines shall not be syntactically significant other than being
// token separators, except escaped identifiers (see 2.8.1)."
//
// The exception is 03_escaped_identifiers.va's business (its terminating white
// space IS the terminator and is never a token separator). This file pins the
// rule for ordinary tokens by splitting one expression at every operator and
// operand boundary and writing another with tabs: if a newline or a tab meant
// anything more than "tokens are separate", the arithmetic would not be the
// arithmetic those tokens spell.
//
// WANTS. `a` is 2.0 * 3.0 + 1.0 = 7.0 and `b` is 10.0 - 4.0 = 6.0, both exact
// in binary64. The two spellings are also checked against each other through
// their values, not their text: the clause is about syntax, so the claim is
// that the layouts are the same program.
//
//! lrm 2.2
//! lrm 2.2:1
//! lrm 2.2:3
`include "check.vh"
module ch02_free_format_layout(p, n);
    inout p, n;
    electrical p, n;
    real
        a,
        b;

    analog begin
        a = 2.0
            *
            3.0
            +
            1.0;
        b =
            10.0	-	4.0
            ;
        `CHECKX("operators and operands may sit on different lines", a, 7.0);
        `CHECKX("tabs between tokens are separators like any white space", b, 6.0);
        I(p, n) <+ (a - b) * V(p, n);
    end
endmodule
