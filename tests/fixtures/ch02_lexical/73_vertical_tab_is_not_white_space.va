// §2.3: "White space shall contain the characters for spaces, tabs, newlines,
// and formfeeds." Four characters, and vertical tab (ASCII 0x0B) is not one
// of them. It is not in the alphabet of any other token either (§2.5-§2.8),
// so a vertical tab between two tokens is not a separator: it is a character
// no lexical rule accepts, and the file is illegal.
//
// The line below reads `real x;` with a raw 0x0B byte in place of the usual
// space. (`std.ascii.isWhitespace`, which the lexer used, admits VT; the
// preprocessor's own white-space set never did.) Carriage return stays
// white space as a deliberate CRLF extension.
//
// No class-1 code names this: the lexer turns the byte into one `.invalid`
// token and whichever parse position meets it reports "found invalid token"
// (here E0208, expecting the variable name), so the phrase is what is pinned.
//
//! lrm 2.3
//! lrm 2.3:1
//! reject-only invalid token
`include "disciplines.vams"
module ch02_vertical_tab_is_not_white_space(p, n);
  inout p, n; electrical p, n;
  realx;
  analog I(p, n) <+ V(p, n);
endmodule
