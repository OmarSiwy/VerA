// §2.6.1: "The number of bits that make up an unsized number (which is a simple
// decimal number or a number without the size specification) shall be at least
// 32."
//
// The clause fixes a FLOOR and leaves the width above it to the implementation,
// so every check below holds for any width of 32 bits or more and fails for a
// narrower one. (VerA's choice, `integer.parse`: max(64, digits * bits per
// digit). It is deliberately not asserted.)
//
// §2.6.1 also makes a based number without `s` unsigned: "treated ... as
// unsigned integers if the base format only is used". So 'hffff_ffff is the
// non-negative value 0xFFFFFFFF in every width >= 32.
//
// DERIVATION (python3 agrees: 0xffffffff = 4294967295, 0x80000000 >> 31 = 1):
//   'hffff_ffff == 32'hffff_ffff   both are 0xFFFFFFFF, unsigned; equal -> 1.
//                                  At 16 bits the unsized one is 0xFFFF -> 0.
//   'd4294967295 == 32'hffff_ffff  an unsized BASED decimal: 2^32 - 1 needs all
//                                  32 bits; equal -> 1.
//   'h8000_0000 >> 31              bit 31 survives only with >= 32 bits; a
//                                  logical shift (§4.2.11) brings it to bit 0 -> 1.
//   2147483647 == 32'h7fff_ffff    a SIMPLE decimal: 2^31 - 1 needs 31 value bits
//                                  plus the sign of a signed integer -> 1.
//   real r = 'hffff_ffff           §4.2.1.1 integer to real of the unsigned value
//                                  -> 4294967295.0, exact in binary64. A 32-bit
//                                  SIGNED reading would give -1.0.
//
//! lrm 2.6.1
//! lrm 2.6.1:19
//! bias V(p) = 0.75, V(n) = 0.25
//! checks 5
`include "check.vh"
module b1_unsized_at_least_32_bits(p, n);
    inout p, n;
    electrical p, n;
    integer eq_hex, eq_dec, top_bit, eq_simple;
    real r;

    analog begin
        eq_hex = ('hffff_ffff == 32'hffff_ffff);
        eq_dec = ('d4294967295 == 32'hffff_ffff);
        top_bit = 'h8000_0000 >> 31;
        eq_simple = (2147483647 == 32'h7fff_ffff);
        r = 'hffff_ffff;
        `CHECKI("'hffff_ffff keeps all 32 bits", eq_hex, 1);
        `CHECKI("'d4294967295 keeps all 32 bits", eq_dec, 1);
        `CHECKI("bit 31 of 'h8000_0000 is there to shift", top_bit, 1);
        `CHECKI("the simple decimal 2147483647 is not truncated", eq_simple, 1);
        `CHECKX("'hffff_ffff converts to real as 2^32 - 1", r, 4294967295.0);
        I(p, n) <+ (eq_hex + eq_dec + top_bit + eq_simple) * V(p, n);
    end
endmodule
