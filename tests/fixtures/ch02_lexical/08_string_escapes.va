// §2.7: "A string literal used as an operand in expressions and assignments
// shall be treated as unsigned integer constants represented by a sequence of
// 8-bit ASCII values, with one 8-bit ASCII value representing one character."
// That makes every row of Table 2-2 a number a reader can look up, and makes a
// multi-character literal a base-256 numeral, most significant character first.
//
// The wants, one per escape, are the ASCII code points:
//   \n  new line              10
//   \t  tab                    9
//   \\  backslash             92   (0x5C)
//   \"  double quote          34   (0x22)
//   " " a plain space         32   — §2.7 makes it a character like any other
//   "AB"  'A'*256 + 'B'    = 65*256 + 66 = 16706
//   "A\101"  \101 is octal 65 = 'A', so the literal is "AA" = 65*256 + 65 = 16705
// \ddd is Table 2-2's last row, "a character specified in 1-3 octal digits".
// Every escape here is in Table 2-2, so none warns W0149: this is the legal
// neighbour of undefined_escape_keeps_character.va.
//! lrm 2.7
//! lrm 2.7:1001
//! lrm 2.7:1
//! lrm 2.3
//! nowarn
//! lrm 2.3:3
//! lrm 2.7:2
`include "check.vh"
module ch02_string_escapes(p, n);
    inout p, n;
    electrical p, n;
    analog begin
        `CHECKI("\\n is 10", "\n", 10);
        `CHECKI("\\t is 9", "\t", 9);
        `CHECKI("\\\\ is 92", "\\", 92);
        `CHECKI("\\\" is 34", "\"", 34);
        `CHECKI("a space is significant in a string", " ", 32);
        `CHECKI("AB is a base-256 numeral", "AB", 16706);
        `CHECKI("A\\101 is AA", "A\101", 16705);
        I(p, n) <+ 0.0;
    end
endmodule
