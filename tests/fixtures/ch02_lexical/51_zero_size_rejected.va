// LRM 2.6.1 states the size constraint twice, once in the grammar and once in
// prose, and both times it excludes zero. Syntax 2-2:
//
//     size ::= non_zero_unsigned_number
//     non_zero_unsigned_number ::= non_zero_decimal_digit { _ | decimal_digit }
//     non_zero_decimal_digit   ::= 1 | 2 | 3 | 4 | 5 | 6 | 7 | 8 | 9
//
// and 2.6.1: the size constant "shall specify the size of the constant in terms
// of its exact number of bits. It shall be specified as a non-zero unsigned
// decimal number." A zero-bit constant has no bits to hold a value, so `0'b1`
// is not a narrow number — it is not a number.
//
// This is not the same claim as the absence of a size. 22_unsized_based_number.va
// pins the legal `'h...` form, where the size is OMITTED and 2.6.1 gives it a
// floor of 32 bits. Written out as `0`, the size is present and out of range.
// A compiler that stores "unsized" as width 0 will conflate the two and accept
// this file, which is exactly what VerA does today.
//
// The pinned code is the general E0133 "invalid number literal" (LRM 2.6), not
// E0131, which is specifically "expected a numeric base after the apostrophe" —
// the base here is fine, the size is not. There is no zero-size diagnostic yet;
// if the fix adds one, retarget this line at it.
//! lrm 2.6.1
//! reject E0133
//! xfail VerA accepts a zero size constant: width 0 is the lexer's unsized sentinel, so `0'b1` is read as an unsized `'b1` (src/frontend/lexer.zig)
module ch02_zero_size_rejected;
    integer value;
    analog value = 0'b1;
endmodule
