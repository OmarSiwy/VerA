// LRM 2.4: "Block comments shall start with /* and end with */." The comment
// below never gets its */, so the file ends inside a comment. The lexer, not
// the parser, is the layer that must notice, so the stable pin is E0102
// (`unterminated block comment`) and not the generic phase label ParseError,
// which every malformed file in this directory would also satisfy.
//! lrm 2.4
//! lrm 2.4:2
//! reject-only E0102
//! neighbour 01_whitespace_comments.va
module ch02_unclosed_comment;
/* this block comment never terminates
endmodule
