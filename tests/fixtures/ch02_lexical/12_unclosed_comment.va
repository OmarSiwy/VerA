//! reject ParseError
// EXPECT: error
module ch02_unclosed_comment;
/* this block comment never terminates
endmodule
