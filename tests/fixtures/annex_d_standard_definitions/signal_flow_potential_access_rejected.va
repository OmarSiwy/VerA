// The mirror of signal_flow_flow_access_rejected.va. Annex D.1 declares
// `current` as a signal-flow discipline with `flow Current` and no potential
// nature, so `V` — the access of the Voltage nature — names nothing on a
// `current` net.
//
// §4.4 requires the access function to match the net's discipline. Both halves
// of the signal-flow pair have to be checked, because a compiler that looks up
// the access name in a table of "all natures the discipline mentions" passes one
// and fails the other.
//
//! lrm D.1
//! lrm 4.4
//! lrm 4.4:5
//! reject E0501
`include "disciplines.vams"
module annex_d_signal_flow_potential_access(p);
  inout p;
  current p;
  analog V(p) <+ 1.0;
endmodule
