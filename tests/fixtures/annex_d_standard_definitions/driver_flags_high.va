// Annex D.3 driver_access.vams, the high six flags. D.3 assigns each mask one
// specific bit with a 32'b literal (annex-d-stddefs.html:456-461): SDF 32,
// NODELETE 64, NOPREEMPT 128, KERNEL 256, WOR 512, WAND 1024. Each is pinned on
// its own, because an OR alone is permutation-invariant — swap SDF and NODELETE
// and it is still 2016 — and the bit positions are the entire content of D.3.
// The OR stays as the disjointness claim: it equals the sum
// 32+64+128+256+512+1024 = 2016 = 2^11 - 2^5 only if no two masks share a bit.
//
// WHAT THIS FILE DOES NOT TEST. As in driver_flags_low.va, the masks are
// `defined here rather than read from the annex file, so got and want are both
// the fixture's own text and the lexer's 32'b conversion is what is under test.
// D.3's real requirement — that the implementation SUPPLY driver_access.vams —
// is stated in driver_access_include.va, which `includes it.
// No `ifdef DRIVER_ACCESS_VAMS guard, deliberately — see driver_flags_low.va.
//
//! lrm D.3
`include "check.vh"
`include "disciplines.vams"
`define DRIVER_SDF 32'b00000100000
`define DRIVER_NODELETE 32'b00001000000
`define DRIVER_NOPREEMPT 32'b00010000000
`define DRIVER_KERNEL 32'b00100000000
`define DRIVER_WOR 32'b01000000000
`define DRIVER_WAND 32'b10000000000
module annex_d_driver_high(p);
  inout p; electrical p; integer flags;
  analog begin
    flags = `DRIVER_SDF | `DRIVER_NODELETE | `DRIVER_NOPREEMPT | `DRIVER_KERNEL | `DRIVER_WOR | `DRIVER_WAND;
    `CHECKI("DRIVER_SDF is bit 5", `DRIVER_SDF, 32);
    `CHECKI("DRIVER_NODELETE is bit 6", `DRIVER_NODELETE, 64);
    `CHECKI("DRIVER_NOPREEMPT is bit 7", `DRIVER_NOPREEMPT, 128);
    `CHECKI("DRIVER_KERNEL is bit 8", `DRIVER_KERNEL, 256);
    `CHECKI("DRIVER_WOR is bit 9", `DRIVER_WOR, 512);
    `CHECKI("DRIVER_WAND is bit 10", `DRIVER_WAND, 1024);
    `CHECKI("the high six flags are disjoint, so they OR to 2016", flags, 2016);
    I(p) <+ flags + 0.0*V(p);
  end
endmodule
