// The literal standard electrical disciplines, taken from the implementation's
// disciplines.vams and not re-declared here — an earlier revision declared
// `electrical`, `voltage` and `current` itself, so the assertion read back the
// fixture's own text and a compiler shipping no annex D file passed.
//
// Annex D.1 makes `electrical` conservative, potential Voltage / flow Current,
// so `V(p)` is the potential and `I(p) <+ V(p)` is a 1 S element; and it makes
// `voltage` a SIGNAL-FLOW discipline with a potential nature only, whose access
// is the same `V`. Both wants are the bias the testbench stores into the
// unknown vector, loaded straight back, so the difference is exactly 0.0 and
// CHECKX is the honest macro.
//
// `vn` is an `input` and not an `inout`, and that is Annex D's own doing rather
// than a harness convenience: D.1's `voltage` binds a potential nature only, and
// §1.3.4.1 says "nets of potential signal flow disciplines in modules may only
// be bound to `input` or `output` ports of the module, not to `inout` ports"
// (E0360). `p` keeps `inout` because `electrical` is conservative. So one module
// header carries both rules, which is the point of pinning them on the standard
// names.
//
//! lrm D.1
//! lrm 1.3.4.1
//! lrm 1.3.4.1:2
//! bias V(p) = 0.9
//! bias V(vn) = 0.4
`include "check.vh"
`include "disciplines.vams"
module annex_d_literal_electrical(p, vn);
  inout p;
  input vn;
  electrical p;
  voltage vn;
  analog begin
    `CHECKX("V is the potential access of the standard-named `electrical`", V(p), 0.9);
    `CHECKX("V is the potential access of the signal-flow `voltage`", V(vn), 0.4);
    I(p) <+ V(p);
  end
endmodule
