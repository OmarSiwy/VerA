// Annex D.2: PHYSICAL_CONSTANTS_SPICE is tested before OLD and NIST2010, so with
// all three defined the SPICE arm wins. These are the constants SPICE2/SPICE3
// shipped, deliberately short: q = 1.60219e-19, k = 1.38062e-23,
// h = 6.62620e-34, eps0 = 8.854214871e-12. Every one differs from its CODATA
// counterpart in the 6th significant digit or earlier, so the selection is
// visible in the value and not just in the preprocessor. `P_U0 is still the
// pre-2019 4e-7*pi -- the chain assigns it before the SPICE test.
//
// The chain under test is the IMPLEMENTATION's constants.vams. The engine
// prepends it with no selector defined, so it has already taken the NIST1998
// arm; `undef CONSTANTS_VAMS reopens its own include guard and the re-include
// re-runs the chain with the selectors set.
//
//! lrm D.2
`include "check.vh"
`include "disciplines.vams"
`undef CONSTANTS_VAMS
`define PHYSICAL_CONSTANTS_SPICE 1
// Both lower-priority selectors are set: SPICE must still win.
`define PHYSICAL_CONSTANTS_OLD 1
`define PHYSICAL_CONSTANTS_NIST2010 1
`include "constants.vams"
module annex_d_spice_constants(p);
  inout p; electrical p;
  analog begin
    `CHECKX("P_Q is the SPICE elementary charge", `P_Q, 1.60219e-19);
    `CHECKX("P_K is the SPICE Boltzmann constant", `P_K, 1.38062e-23);
    `CHECKX("P_H is the SPICE Planck constant", `P_H, 6.62620e-34);
    `CHECKX("P_EPS0 is the SPICE permittivity", `P_EPS0, 8.854214871e-12);
    `CHECKX("P_U0 is 4e-7*pi", `P_U0, 1.2566370614359173e-6);
    I(p) <+ `P_Q + `P_K + `P_H + `P_EPS0 + `P_U0 + 0.0*V(p);
  end
endmodule
