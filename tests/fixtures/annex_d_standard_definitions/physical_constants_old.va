// Annex D.2: PHYSICAL_CONSTANTS_OLD sits above NIST2010 in the nested chain, so
// with both defined the OLD arm must win. These are the legacy pre-CODATA values
// carried by constants.vams for backward compatibility -- q = 1.6021918e-19,
// k = 1.3806226e-23, h = 6.6260755e-34 -- with the old permittivity written to
// 21 digits, 8.85418792394420013968e-12, which differs from the CODATA-1998
// 8.854187817e-12 in the 8th digit and so cannot be confused with it.
`include "check.vh"
`define PHYSICAL_CONSTANTS_OLD 1
// NIST2010 is also set: OLD has higher priority in the normative chain.
`define PHYSICAL_CONSTANTS_NIST2010 1
`include "physical_constants_select.vh"
module annex_d_old(p);
  inout p; electrical p;
  analog begin
    `CHECKX("P_Q is the legacy elementary charge", `P_Q, 1.6021918e-19);
    `CHECKX("P_K is the legacy Boltzmann constant", `P_K, 1.3806226e-23);
    `CHECKX("P_H is the legacy Planck constant", `P_H, 6.6260755e-34);
    `CHECKX("P_EPS0 is the legacy permittivity", `P_EPS0, 8.85418792394420013968e-12);
    `CHECKR("P_U0 is 4e-7*pi", `P_U0, 1.2566370614359173e-6, 1e-15);
    I(p) <+ `P_Q + `P_K + `P_H + `P_EPS0 + `P_U0 + 0.0*V(p);
  end
endmodule
