// Annex D.1 publishes every standard nature with its `units` and its default
// `abstol` (the `else arm of each `ifdef X_ABSTOL; no X_ABSTOL is defined
// here, and VerA prepends the annex files, so the defaults are what the
// prelude declared). §5.5.3 makes both readable through a net:
// `net.potential.abstol`, `net.flow.units`. Each want below is copied from
// annex-d-stddefs.html, nature by nature:
//
//   Voltage 1e-6 "V"        Current 1e-12 "A"        Charge 1e-14 "coul"
//   Flux 1e-9 "Wb"          Magneto_Motive_Force 1e-12 "A*turn"
//   Temperature 1e-4 "K"    Power 1e-9 "W"
//   Position 1e-6 "m"       Velocity 1e-6 "m/s"      Acceleration 1e-6 "m/s^2"
//   Impulse 1e-6 "m/s^3"    Force 1e-6 "N"
//   Angle 1e-6 "rads"       Angular_Velocity 1e-6 "rads/s"
//   Angular_Acceleration 1e-6 "rads/s^2"            Angular_Force 1e-6 "N*m"
//
// Twelve natures sit in D.1's own disciplines (electrical, magnetic, thermal,
// kinematic, kinematic_v, rotational, rotational_omega). Charge, Acceleration,
// Impulse and Angular_Acceleration are in none, so a user discipline binds
// each as its potential; that also exercises D.1's access names `Q`, `Acc`,
// `Imp` and `Alpha`, which no other fixture probes: each reads its stored
// bias back (exact in binary64, so CHECKX).
//
// The idt_nature/ddt_nature links are transcribed but not asserted: §3.6.1.2
// says only that they "can be used to reduce the need to specify tolerances"
// and the tolerance "can be taken from the node", a permission with no value
// an implementation must produce. The refusals that neighbour this file
// (an access function a discipline does not bind) are
// signal_flow_flow_access_rejected.va, signal_flow_potential_access_rejected.va
// and unbound_nature_access_rejected.va.
//
//! lrm D.1
//! lrm D.1:1001
//! lrm 5.5.3
//! lrm 3.6.1.2
//! checks 36
//! bias q = 0.5, a = 0.25, i = 0.125, al = 0.0625
`include "disciplines.vams"
`include "check.vh"
discipline annex_d_charge_d; potential Charge; flow Current; enddiscipline
discipline annex_d_acc_d; potential Acceleration; flow Force; enddiscipline
discipline annex_d_imp_d; potential Impulse; flow Force; enddiscipline
discipline annex_d_alpha_d; potential Angular_Acceleration; flow Angular_Force; enddiscipline
module annex_d_nature_attribute_defaults(e, m, t, k, kv, r, ro, q, a, i, al);
  inout e, m, t, k, kv, r, ro, q, a, i, al;
  electrical e; magnetic m; thermal t; kinematic k; kinematic_v kv;
  rotational r; rotational_omega ro;
  annex_d_charge_d q; annex_d_acc_d a; annex_d_imp_d i; annex_d_alpha_d al;
  analog begin
    `CHECKX("Voltage abstol", e.potential.abstol, 1e-6);
    `CHECKI("Voltage units", e.potential.units == "V", 1);
    `CHECKX("Current abstol", e.flow.abstol, 1e-12);
    `CHECKI("Current units", e.flow.units == "A", 1);
    `CHECKX("Charge abstol", q.potential.abstol, 1e-14);
    `CHECKI("Charge units", q.potential.units == "coul", 1);
    `CHECKX("Flux abstol", m.flow.abstol, 1e-9);
    `CHECKI("Flux units", m.flow.units == "Wb", 1);
    `CHECKX("Magneto_Motive_Force abstol", m.potential.abstol, 1e-12);
    `CHECKI("Magneto_Motive_Force units", m.potential.units == "A*turn", 1);
    `CHECKX("Temperature abstol", t.potential.abstol, 1e-4);
    `CHECKI("Temperature units", t.potential.units == "K", 1);
    `CHECKX("Power abstol", t.flow.abstol, 1e-9);
    `CHECKI("Power units", t.flow.units == "W", 1);
    `CHECKX("Position abstol", k.potential.abstol, 1e-6);
    `CHECKI("Position units", k.potential.units == "m", 1);
    `CHECKX("Velocity abstol", kv.potential.abstol, 1e-6);
    `CHECKI("Velocity units", kv.potential.units == "m/s", 1);
    `CHECKX("Acceleration abstol", a.potential.abstol, 1e-6);
    `CHECKI("Acceleration units", a.potential.units == "m/s^2", 1);
    `CHECKX("Impulse abstol", i.potential.abstol, 1e-6);
    `CHECKI("Impulse units", i.potential.units == "m/s^3", 1);
    `CHECKX("Force abstol", k.flow.abstol, 1e-6);
    `CHECKI("Force units", k.flow.units == "N", 1);
    `CHECKX("Angle abstol", r.potential.abstol, 1e-6);
    `CHECKI("Angle units", r.potential.units == "rads", 1);
    `CHECKX("Angular_Velocity abstol", ro.potential.abstol, 1e-6);
    `CHECKI("Angular_Velocity units", ro.potential.units == "rads/s", 1);
    `CHECKX("Angular_Acceleration abstol", al.potential.abstol, 1e-6);
    `CHECKI("Angular_Acceleration units", al.potential.units == "rads/s^2", 1);
    `CHECKX("Angular_Force abstol", r.flow.abstol, 1e-6);
    `CHECKI("Angular_Force units", r.flow.units == "N*m", 1);
    `CHECKX("Q reads the Charge potential", Q(q), 0.5);
    `CHECKX("Acc reads the Acceleration potential", Acc(a), 0.25);
    `CHECKX("Imp reads the Impulse potential", Imp(i), 0.125);
    `CHECKX("Alpha reads the Angular_Acceleration potential", Alpha(al), 0.0625);
    I(e) <+ V(e);
  end
endmodule
