// Annex D.2 constants.vams, the vacuum constants. `P_C is 299792458 m/s EXACTLY
// -- it is the SI definition of the metre, not a measurement, so exact equality
// is the right claim. `P_U0_OLD is the pre-2019 definition mu0 = 4e-7*pi H/m,
// and the two together fix the permittivity through eps0 = 1/(mu0*c^2), which
// reproduces Annex D's own `P_EPS0_NIST1998 (8.854187817e-12) to nine digits.
//
// All three macros come from the implementation's constants.vams, `included
// above the way the LRM's own examples include it; nothing here `defines them.
// `P_U0_OLD is the only annex D constant whose body
// is an EXPRESSION, `(4.0e-7 * `M_PI)`, and §10.4 expansion is textual, so its
// parentheses are load-bearing. The bare `1.0/`P_U0_OLD` check is what sees
// them: with the parentheses that is 795774.7154594767, without them the same
// text reads (1.0/4.0e-7)*pi = 7853981.633974483, a factor of 9.87 out. Every
// use of the macro inside an already-parenthesised product hides that.
//
// The wants are exact doubles, not rounded decimals: 4.0e-7 * M_PI and
// 1.0/(u0*c*c) are pure multiplies and divides on binary64, evaluated here in
// the same order as the source, and the README documents strict IEEE in every
// optimize mode.
//
//! lrm D.2
`include "check.vh"
`include "constants.vams"
`include "disciplines.vams"
module annex_d_vacuum(p);
  inout p; electrical p;
  analog begin
    `CHECKX("P_C is exactly 299792458 m/s", `P_C, 299792458.0);
    `CHECKX("P_U0_OLD = 4e-7*pi H/m", `P_U0_OLD, 1.2566370614359173e-6);
    `CHECKX("P_U0_OLD keeps its parentheses under expansion",
            1.0 / `P_U0_OLD, 795774.7154594767);
    `CHECKX("1/(mu0*c^2) is the vacuum permittivity",
            1.0 / (`P_U0_OLD * `P_C * `P_C), 8.854187817620389e-12);
    I(p) <+ `P_C + `P_U0_OLD + 0.0*V(p);
  end
endmodule
