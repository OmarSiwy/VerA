// Annex D: the standard natures and disciplines are a FILE, disciplines.vams,
// that a description brings in with `include. A description that does not
// include it has no `electrical` at all, and §3.6.2 lets it declare one: a
// discipline name is an ordinary identifier with source-text scope (§3.13.1).
// This file does exactly that, without the include, so by the LRM the
// declaration below IS `electrical`, and its access functions are the ones its
// natures name (§3.6.1.4): `Vx` for the potential and `Ix` for the flow.
//
// VerA prepends its own copy of disciplines.vams to every compilation, so it
// sees two declarations of the name, the prelude's first. The prelude is not
// part of this description, which is why §3.13.1's duplicate rule (E0342) is
// applied per file, and why the answer must be this file's declaration. Every
// stage has to agree on that: lowering already took the user's declaration,
// while elaboration took the prelude's.
//
// WHAT MAKES IT OBSERVABLE. Annex E's `resistor` is written with the
// nature-neutral `V`/`I`, and E.3.2 says they are the potential and flow of the
// discipline the port resolved to. With both ports on this file's electrical,
// the resistor's branch is read as `Vx`/`Ix`. An elaborator that looked up the
// prelude's electrical rewrites nothing (its accesses ARE `V`/`I`), and the
// file is then refused for probing an electrical net with `V`.
//
// The digits are Table E.1's resistor row, V = I*r, with 2.0 imposed across the
// branch and r = 1k: Ix = 2.0/1000.
//
//! lrm D
//! lrm 3.6.2
//! lrm 3.13.1
//! lrm E.3.2
//! lrm 3.13.1:1000
//! bias p = 2.0, n = 0.0
`include "check.vh"
nature annex_d_user_potential;
    units = "V";
    access = Vx;
    abstol = 1u;
endnature
nature annex_d_user_flow;
    units = "A";
    access = Ix;
    abstol = 1p;
endnature
discipline electrical;
    potential annex_d_user_potential;
    flow annex_d_user_flow;
enddiscipline

module annex_d_user_declared_electrical(p, n);
    inout p, n;
    electrical p, n;
    resistor #(.r(1k)) r1(p, n);
    analog begin
        `CHECKX("this file's electrical probes the potential with Vx", Vx(r1.p, r1.n), 2.0);
        `CHECKR("Table E.1 V = I*r, read through this file's Ix", Ix(r1.p, r1.n), 2.0e-3, 1e-15);
    end
endmodule
