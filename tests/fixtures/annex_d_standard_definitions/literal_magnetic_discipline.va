// Annex D.1: `discipline magnetic` binds `potential Magneto_Motive_Force`
// (access MMF, units "A*turn") and `flow Flux` — and Flux is the SAME nature
// D.1 gives as Voltage's `idt_nature` in the electrical block. There is no
// separate Magnetic_Flux, so the magnetic flow access is the electrical `Phi`.
//
// The discipline comes from the implementation's disciplines.vams; an earlier
// revision declared a verbatim copy here and then bound it to nothing, so the
// file read back its own text and asserted nothing at all.
//
// The observable claim is the BINDING: on a magnetic node `MMF` is the
// POTENTIAL, so a node held at 3 A*turn probes as exactly 3 — were MMF the
// flow of the flow-source branch below, the probe would not read the bias
// back. The want is the bias the testbench stores into the unknown vector,
// loaded straight back, so the difference is exactly 0.0 and CHECKX is honest.
//
// The flow half deliberately gets no number: what a flow probe of a flow
// source reads back is not fixed by Annex D or §5.4.2. What D.1 does fix is
// that `Phi` is the access of magnetic's flow nature, which is why the
// contribution below names it and is accepted.
//
//! lrm D.1
//! bias p = 3.0
`include "check.vh"
`include "disciplines.vams"
module annex_d_literal_magnetic(p);
  inout p;
  magnetic p;
  analog begin
    `CHECKX("MMF is the magnetic potential access", MMF(p), 3.0);
    Phi(p) <+ MMF(p);
  end
endmodule
