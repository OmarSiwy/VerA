// Annex D.1 declares `voltage` as a SIGNAL-FLOW discipline: `potential Voltage`
// and nothing else. It binds no flow nature, so on a `voltage` net the name `I`
// — the access of the Current nature — is bound to nothing at all.
//
// §4.4: "The access function name shall match the discipline declaration for the
// nets, ports, or branch given in the argument expression list." `I(p)` does not
// match, so this is an error, not a 0 A contribution.
//
// The positive half (V(p) on a `voltage` net, which IS the potential access) is
// pinned by literal_electrical_disciplines.va; this file pins only the reject.
//
//! lrm D.1
//! lrm 4.4
//! reject E0501
//! xfail VerA accepts flow access on a potential-only signal-flow net: checkAccessMatch (src/ir/lower.zig) returns early when the discipline binds no nature for that half, so `I` on a `voltage` net resolves silently
module annex_d_signal_flow_flow_access(p);
  inout p;
  voltage p;
  analog I(p) <+ 1.0;
endmodule
