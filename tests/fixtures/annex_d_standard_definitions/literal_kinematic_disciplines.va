// Annex D.1's kinematic pair, taken from the implementation's
// disciplines.vams and not re-declared here — an earlier revision declared both
// and then bound neither to a net, so nothing was asserted.
//
//   discipline kinematic    potential Position (Pos) / flow Force (F)
//   discipline kinematic_v  potential Velocity (Vel) / flow Force (F)
//
// The pair is the interesting shape in D.1: two DIFFERENT potential natures
// sharing ONE flow nature. A compiler that keys a discipline's flow access off
// its potential nature passes `kinematic` and fails `kinematic_v`, so both are
// probed here and both contribute through the same `F`.
//
// Each want is the bias the testbench stores into the unknown vector, loaded
// straight back, so the difference is exactly 0.0 and CHECKX is the honest
// macro. If `Pos`/`Vel` were bound as the flow instead, each probe would read
// the flow of a flow source and not the bias.
//
//! lrm D.1
//! bias p = 2.5
//! bias q = 4.0
`include "check.vh"
`include "disciplines.vams"
module annex_d_literal_kinematic(p, q);
  inout p, q;
  kinematic p;
  kinematic_v q;
  analog begin
    `CHECKX("Pos is the kinematic potential access", Pos(p), 2.5);
    `CHECKX("Vel is the kinematic_v potential access", Vel(q), 4.0);
    F(p) <+ Pos(p);
    F(q) <+ Vel(q);
  end
endmodule
