// The engine prepends annex D (constants.vams / disciplines.vams), which already
// defines CONSTANTS_VAMS and DISCIPLINES_VAMS, so this fixture carries its own
// include guard instead of the standard one -- otherwise its body is skipped.
//
// Annex D.2 constants.vams, mathematical constants. Every want below is the
// double nearest to the MATHEMATICAL value (e, log2(e), ln 10, pi/4, 2/sqrt(pi),
// ...), computed independently; the got is the macro the annex defines. So the
// check pins two things at once: that the preprocessor hands the full literal to
// the expression, and that the annex's 20-digit decimal really is that constant.
// `M_LOG10E's published decimal is one ulp off 1/ln(10), which is why these are
// relative-tolerance checks and not exact ones.
`ifdef ANNEX_D_MATHEMATICAL_CONSTANTS
`else
`define ANNEX_D_MATHEMATICAL_CONSTANTS 1
`include "check.vh"
`define M_E 2.7182818284590452354
`define M_LOG2E 1.4426950408889634074
`define M_LOG10E 0.43429448190325182765
`define M_LN2 0.69314718055994530942
`define M_LN10 2.30258509299404568402
`define M_PI 3.14159265358979323846
`define M_TWO_PI 6.28318530717958647693
`define M_PI_2 1.57079632679489661923
`define M_PI_4 0.78539816339744830962
`define M_1_PI 0.31830988618379067154
`define M_2_PI 0.63661977236758134308
`define M_2_SQRTPI 1.12837916709551257390
`define M_SQRT2 1.41421356237309504880
`define M_SQRT1_2 0.70710678118654752440
module annex_d_math(p);
  inout p; electrical p;
  analog begin
    `CHECKR("M_E = e", `M_E, 2.718281828459045, 1e-15);
    `CHECKR("M_LOG2E = 1/ln(2)", `M_LOG2E, 1.4426950408889634, 1e-15);
    `CHECKR("M_LOG10E = 1/ln(10)", `M_LOG10E, 0.43429448190325176, 1e-15);
    `CHECKR("M_LN2 = ln(2)", `M_LN2, 0.6931471805599453, 1e-15);
    `CHECKR("M_LN10 = ln(10)", `M_LN10, 2.302585092994046, 1e-15);
    `CHECKR("M_PI = pi", `M_PI, 3.141592653589793, 1e-15);
    `CHECKR("M_TWO_PI = 2*pi", `M_TWO_PI, 6.283185307179586, 1e-15);
    `CHECKR("M_PI_2 = pi/2", `M_PI_2, 1.5707963267948966, 1e-15);
    `CHECKR("M_PI_4 = pi/4", `M_PI_4, 0.7853981633974483, 1e-15);
    `CHECKR("M_1_PI = 1/pi", `M_1_PI, 0.3183098861837907, 1e-15);
    `CHECKR("M_2_PI = 2/pi", `M_2_PI, 0.6366197723675814, 1e-15);
    `CHECKR("M_2_SQRTPI = 2/sqrt(pi)", `M_2_SQRTPI, 1.1283791670955126, 1e-15);
    `CHECKR("M_SQRT2 = sqrt(2)", `M_SQRT2, 1.4142135623730951, 1e-15);
    `CHECKR("M_SQRT1_2 = 1/sqrt(2)", `M_SQRT1_2, 0.7071067811865476, 1e-15);
    I(p) <+ `M_E + `M_LOG2E + `M_LOG10E + `M_LN2 + `M_LN10
        + `M_PI + `M_TWO_PI + `M_PI_2 + `M_PI_4 + `M_1_PI + `M_2_PI
        + `M_2_SQRTPI + `M_SQRT2 + `M_SQRT1_2 + 0.0*V(p);
  end
endmodule
`endif
