// Annex D.2 constants.vams, the fourteen mathematical constants. Nothing here
// `defines them: constants.vams is `included the way the LRM's own examples
// include it, and the implementation's copy of that file must supply every one,
// so the check reads the annex file rather than a copy the fixture handed it.
// (Under VerA the include is a no-op — the engine prepends both annex files and
// the CONSTANTS_VAMS guard swallows the second pass, which
// disciplines_vams_guard_idempotent.va pins — so the line costs nothing here
// and is what makes the fixture run on a compiler that does not prepend.)
//
// Each want is the binary64 nearest to the true mathematical value, derived to
// 40 decimal digits (decimal.Decimal: exp/ln/sqrt) and rounded once. All
// fourteen decimals published at annex-d-stddefs.html:340-353 round to exactly
// those same doubles — ulp difference 0 for every one, re-checked here. An
// earlier revision of this fixture claimed `M_LOG10E's published decimal was
// one ulp off 1/ln(10) and used that to justify 1e-15 slack on all fourteen;
// the LRM is right and it was the fixture's want that was one ulp low
// (0.43429448190325176 for the correct 0.4342944819032518).
//
// So the checks are exact. §3.3 pins `real` to IEEE-754 binary64 and D.2 pins
// the decimal, which leaves exactly one conforming double per constant; a
// tolerance here could only hide a preprocessor that truncates the literal on
// its way into the expression.
//
//! lrm D.2
//! lrm D.2:1001
`include "check.vh"
`include "constants.vams"
`include "disciplines.vams"
module annex_d_math(p);
  inout p; electrical p;
  analog begin
    `CHECKX("M_E = e", `M_E, 2.718281828459045);
    `CHECKX("M_LOG2E = 1/ln(2)", `M_LOG2E, 1.4426950408889634);
    `CHECKX("M_LOG10E = 1/ln(10)", `M_LOG10E, 0.4342944819032518);
    `CHECKX("M_LN2 = ln(2)", `M_LN2, 0.6931471805599453);
    `CHECKX("M_LN10 = ln(10)", `M_LN10, 2.302585092994046);
    `CHECKX("M_PI = pi", `M_PI, 3.141592653589793);
    `CHECKX("M_TWO_PI = 2*pi", `M_TWO_PI, 6.283185307179586);
    `CHECKX("M_PI_2 = pi/2", `M_PI_2, 1.5707963267948966);
    `CHECKX("M_PI_4 = pi/4", `M_PI_4, 0.7853981633974483);
    `CHECKX("M_1_PI = 1/pi", `M_1_PI, 0.3183098861837907);
    `CHECKX("M_2_PI = 2/pi", `M_2_PI, 0.6366197723675814);
    `CHECKX("M_2_SQRTPI = 2/sqrt(pi)", `M_2_SQRTPI, 1.1283791670955126);
    `CHECKX("M_SQRT2 = sqrt(2)", `M_SQRT2, 1.4142135623730951);
    `CHECKX("M_SQRT1_2 = 1/sqrt(2)", `M_SQRT1_2, 0.7071067811865476);
    I(p) <+ `M_E + `M_LOG2E + `M_LOG10E + `M_LN2 + `M_LN10
        + `M_PI + `M_TWO_PI + `M_PI_2 + `M_PI_4 + `M_1_PI + `M_2_PI
        + `M_2_SQRTPI + `M_SQRT2 + `M_SQRT1_2 + 0.0*V(p);
  end
endmodule
