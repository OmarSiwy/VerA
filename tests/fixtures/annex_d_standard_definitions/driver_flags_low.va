// Annex D.3 driver_access.vams, the low six flags. D.3 assigns each mask one
// specific bit with a 32'b literal (annex-d-stddefs.html:450-455): UNKNOWN 0,
// DELAYED 1, GATE 2, UDP 4, ASSIGN 8, BEHAVIORAL 16. Each is pinned on its own,
// because an OR alone is permutation-invariant — swap GATE and UDP and it is
// still 31 — and the bit positions are the entire content of D.3. The OR stays
// as the disjointness claim: it equals the sum 0+1+2+4+8+16 = 31 only if no two
// masks share a bit.
//
// WHAT THIS FILE DOES NOT TEST. The masks are `defined here rather than read
// from the annex file, so both the got and the want are the fixture's own text:
// what is actually under test is the lexer's 32'b -> integer conversion, and a
// compiler that ships no driver_access.vams — or a wrong one, which this file
// would shadow — passes anyway. D.3's real requirement, that the implementation
// SUPPLY the file, is stated in driver_access_include.va, which `includes it.
// Read the two together; this one is only the bit-position transcription.
//
// The module is deliberately NOT wrapped in the `ifdef DRIVER_ACCESS_VAMS
// guard the annex file carries — with it, an implementation that does ship D.3
// erases the whole module, the file still compiles, and the fixture asserts
// nothing.
//
//! lrm D.3
`include "check.vh"
`include "disciplines.vams"
`define DRIVER_UNKNOWN 32'b00000000000
`define DRIVER_DELAYED 32'b00000000001
`define DRIVER_GATE 32'b00000000010
`define DRIVER_UDP 32'b00000000100
`define DRIVER_ASSIGN 32'b00000001000
`define DRIVER_BEHAVIORAL 32'b00000010000
module annex_d_driver_low(p);
  inout p; electrical p; integer flags;
  analog begin
    flags = `DRIVER_UNKNOWN | `DRIVER_DELAYED | `DRIVER_GATE | `DRIVER_UDP | `DRIVER_ASSIGN | `DRIVER_BEHAVIORAL;
    `CHECKI("DRIVER_UNKNOWN carries no bit", `DRIVER_UNKNOWN, 0);
    `CHECKI("DRIVER_DELAYED is bit 0", `DRIVER_DELAYED, 1);
    `CHECKI("DRIVER_GATE is bit 1", `DRIVER_GATE, 2);
    `CHECKI("DRIVER_UDP is bit 2", `DRIVER_UDP, 4);
    `CHECKI("DRIVER_ASSIGN is bit 3", `DRIVER_ASSIGN, 8);
    `CHECKI("DRIVER_BEHAVIORAL is bit 4", `DRIVER_BEHAVIORAL, 16);
    `CHECKI("the low six flags are disjoint, so they OR to 31", flags, 31);
    I(p) <+ flags + 0.0*V(p);
  end
endmodule
