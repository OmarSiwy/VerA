// D.2, physical PDF page 411: the published constants file defines each
// vintage-specific name independently of which selector is active. Reading
// only P_Q/P_K/P_H/P_EPS0 permits an implementation to inline selected values
// and omit the public base names. This fixture names every such base macro.
// Expected decimal literals are transcribed from the PDF, not the compiler.
// P_U0_OLD is the source identity (4.0e-7 * M_PI), so CHECKEQ asserts that
// identity without inventing extra digits. No claim about real-number accuracy
// beyond the implementation's common conversion of the published literals.
// Twenty charge/Boltzmann/Planck/permittivity names plus two permeability
// names give twenty-two observations at the default single evaluation point.
//! lrm D.2
//! checks 22
`include "check.vh"
`include "disciplines.vams"
`include "constants.vams"
module audit_physical_base_names(p);
  inout p; electrical p;
  analog begin
    `CHECKX("P_Q_SPICE", `P_Q_SPICE, 1.60219e-19);
    `CHECKX("P_Q_OLD", `P_Q_OLD, 1.6021918e-19);
    `CHECKX("P_Q_NIST1998", `P_Q_NIST1998, 1.602176462e-19);
    `CHECKX("P_Q_NIST2010", `P_Q_NIST2010, 1.602176565e-19);
    `CHECKX("P_Q_NIST2018", `P_Q_NIST2018, 1.602176634e-19);
    `CHECKX("P_K_SPICE", `P_K_SPICE, 1.38062e-23);
    `CHECKX("P_K_OLD", `P_K_OLD, 1.3806226e-23);
    `CHECKX("P_K_NIST1998", `P_K_NIST1998, 1.3806503e-23);
    `CHECKX("P_K_NIST2010", `P_K_NIST2010, 1.3806488e-23);
    `CHECKX("P_K_NIST2018", `P_K_NIST2018, 1.380649e-23);
    `CHECKX("P_H_SPICE", `P_H_SPICE, 6.62620e-34);
    `CHECKX("P_H_OLD", `P_H_OLD, 6.6260755e-34);
    `CHECKX("P_H_NIST1998", `P_H_NIST1998, 6.62606876e-34);
    `CHECKX("P_H_NIST2010", `P_H_NIST2010, 6.62606957e-34);
    `CHECKX("P_H_NIST2018", `P_H_NIST2018, 6.62607015e-34);
    `CHECKX("P_EPS0_SPICE", `P_EPS0_SPICE, 8.854214871e-12);
    `CHECKX("P_EPS0_OLD", `P_EPS0_OLD, 8.85418792394420013968e-12);
    `CHECKX("P_EPS0_NIST1998", `P_EPS0_NIST1998, 8.854187817e-12);
    `CHECKX("P_EPS0_NIST2010", `P_EPS0_NIST2010, 8.854187817e-12);
    `CHECKX("P_EPS0_NIST2018", `P_EPS0_NIST2018, 8.8541878128e-12);
    `CHECKEQ("P_U0_OLD identity", `P_U0_OLD, (4.0e-7 * `M_PI), 0.0);
    `CHECKX("P_U0_NIST2018", `P_U0_NIST2018, 1.25663706212e-6);
    I(p) <+ V(p);
  end
endmodule
