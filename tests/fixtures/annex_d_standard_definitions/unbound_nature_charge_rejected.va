// Annex D.1 declares sixteen natures but binds only twelve into disciplines.
// Charge (units "coul", access Q, ddt_nature Current) is one of the leftovers:
// it exists so that Current has an `idt_nature`, and no standard discipline
// names it. So `Q` is a declared access function that is an access function of
// NO net.
//
// §4.4 requires the access name to match the net's discipline; `electrical`
// binds Voltage and Current, so `Q(p)` matches nothing. This is the strictly
// weaker half of unbound_nature_access_rejected.va — there the nature belonged
// to another discipline, here it belongs to none — and the two are pinned
// apart because a compiler can plausibly resolve one and not the other.
//
//! lrm D.1
//! lrm 4.4
//! lrm 4.4:5
//! reject-only E0501
`include "disciplines.vams"
module annex_d_unbound_nature_charge(p);
  inout p;
  electrical p;
  analog I(p) <+ Q(p);
endmodule
