// Annex D.1's thermal block is written in the §3.6.1/§3.6.2 declaration syntax
// (annex-d-stddefs.html:158-184): Temperature (units "K", access Temp, abstol
// 1e-4) and Power (units "W", access Pwr, abstol 1e-9), joined by a
// conservative discipline. literal_thermal_discipline.va pins the
// IMPLEMENTATION's copy of that block; this file pins the other half — that a
// USER writing the annex's own declaration syntax gets a working discipline.
//
// The nature names are prefixed, deliberately. An earlier revision declared
// `Temperature` and `Power` verbatim — the names the prepended disciplines.vams
// already declares — and then wrote `thermal p;` on the port, so `thermal_d`
// was bound to nothing, both assertions ran against the PRELUDE's discipline,
// and the file proved nothing its sibling did not.
//
// The observable claim is the BINDING: on a `thermal_d` node `AnnexDTemp` is
// the POTENTIAL, so a node held at 400 K probes as exactly 400 — were it the
// flow of the flow-source branch below, the probe would not read the bias back.
// The Celsius line then crosses into D.2 through the annex's own `P_CELSIUS0
// (273.15) rather than a local literal: 400.0 - 273.15 is 126.85000000000002 in
// binary64, 2.8e-14 off the decimal, so CHECK with 1e-12 and not CHECKX.
//
// The flow half gets no number. `AnnexDPwr(p) <+ ...` makes (p, gnd) a flow
// source (§5.4.2.2) and what a flow PROBE of one reads back is not a value
// Annex D or §5.4.2 fixes. What D.1 does fix is that the flow nature's access
// is the name a flow contribution has to use, which is why it is named here and
// accepted. `units` and `abstol` are transcribed as the annex writes them but
// cannot be asserted: §5.5.3's `p.potential.abstol` is not parsed by VerA
// (E0207) and no other language construct reads either attribute back.
//
//! lrm D.1
//! lrm D.2
//! lrm 3.6.1
//! lrm 3.6.2
//! bias p = 400
`include "check.vh"
`include "constants.vams"

nature annex_d_temperature;
  units = "K";
  access = AnnexDTemp;
  abstol = 1e-4;
endnature

nature annex_d_power;
  units = "W";
  access = AnnexDPwr;
  abstol = 1e-9;
endnature

discipline thermal_d;
  potential annex_d_temperature;
  flow annex_d_power;
enddiscipline

module annex_d_thermal(p);
  inout p; thermal_d p;
  analog begin
    `CHECKX("AnnexDTemp is the potential access of the user-declared thermal_d", AnnexDTemp(p), 400.0);
    `CHECK("400 K is 126.85 degC through P_CELSIUS0", AnnexDTemp(p) - `P_CELSIUS0, 126.85, 1e-12);
    AnnexDPwr(p) <+ AnnexDTemp(p);
  end
endmodule
