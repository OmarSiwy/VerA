// The standard discrete discipline whose name is an ESCAPED identifier:
// Annex D.1 writes `discipline \logic ;`, because `logic` would otherwise be a
// reserved word. The declaration is the implementation's, from
// disciplines.vams — an earlier revision of this file declared a verbatim copy
// itself, so the fixture passed with no standard `\logic` in existence.
//
// Naming the prelude's escaped identifier puts §2.7.1 termination under test
// too: the trailing space in `\logic n ;` ends the token and is not part of the
// name, so a lexer that keeps or drops it inconsistently will not resolve the
// declared discipline.
//
// `\logic` is natureless (`domain discrete` only), so §3.6.3 forbids using the
// net in an analog behavioral description: no natures, therefore no access
// functions, therefore `V(n)` names nothing.
//
//! lrm D.1
//! lrm 3.6.3
//! reject-only E0501
`include "disciplines.vams"
module annex_d_literal_logic(n);
  inout n;
  \logic n ;
  analog V(n) <+ 0.0;
endmodule
