// Annex D.1: "Default absolute tolerances may be overridden by setting the
// appropriate _ABSTOL prior to including this file" (annex-d-stddefs.html:68-69).
// Every published nature carries the shape
//   `ifdef X_ABSTOL / abstol = `X_ABSTOL; / `else / abstol = <default>; / `endif
// and there are sixteen of them (CURRENT, CHARGE, VOLTAGE, FLUX,
// MAGNETO_MOTIVE_FORCE, TEMPERATURE, POWER, POSITION, VELOCITY, ACCELERATION,
// IMPULSE, FORCE, ANGLE, ANGULAR_VELOCITY, ANGULAR_ACCELERATION, ANGULAR_FORCE
// — annex-d-stddefs.html:79, :91, :103, :115, :143, :162, :173, :193, :206,
// :219, :231, :242, :267, :280, :292, :303).
//
// All sixteen are `defined below, BEFORE `include "disciplines.vams", which is
// the exact usage the sentence prescribes. On a compiler that does not prepend
// the annex files, that include is the first pass over disciplines.vams and
// every one of the sixteen `ifdef arms is the arm taken — and the natures so
// produced are the ones `electrical q` below is elaborated from, so a compiler
// that mis-parses `abstol = `VOLTAGE_ABSTOL;` fails here. Nothing in the arms
// is supplied by this fixture except the sixteen values; the structure under
// test is the annex file's.
//
// §5.5.3 makes potential.abstol readable. The local nature below checks
// the selected value 2e-6 directly, as well as access-function binding.
// Its other branch would select 1e-6, so this detects an ignored override.
// The built-in natures have already been prepended under VerA; their later
// macro definitions cannot retroactively alter the earlier declarations.
//
// UNDER VERA specifically, the include is a no-op — the engine prepends both
// annex files before any user text, so DISCIPLINES_VAMS is already set and the
// prelude's natures took their `else arms. So the sixteen arms are exercised
// only on a non-prepending compiler; the local nature below is the half that is
// observable everywhere, because it is declared here and its `ifdef arm is
// taken here. (`undef DISCIPLINES_VAMS + re-include would force the arms under
// VerA too, but that re-declares all sixteen natures, which a conforming
// compiler is entitled to reject as a duplicate declaration — the guard exists
// precisely to stop it. Not portable, so not done.)
//
// The two potential wants are the stated biases, exact in binary64. The
// attribute want is the local macro's 2e-6 literal read through the nature.
//
//! lrm D.1
//! lrm 3.6.1.2
//! lrm 5.5.3
//! bias p = 1.25
//! bias V(q) = 3.0
`include "check.vh"

// D.1's sixteen published override macros, set before the include as the annex
// requires. Each differs from the default the `else arm would have supplied.
`define CURRENT_ABSTOL              2e-12
`define CHARGE_ABSTOL               2e-14
`define VOLTAGE_ABSTOL              2e-6
`define FLUX_ABSTOL                 2e-9
`define MAGNETO_MOTIVE_FORCE_ABSTOL 2e-12
`define TEMPERATURE_ABSTOL          2e-4
`define POWER_ABSTOL                2e-9
`define POSITION_ABSTOL             2e-6
`define VELOCITY_ABSTOL             2e-6
`define ACCELERATION_ABSTOL         2e-6
`define IMPULSE_ABSTOL              2e-6
`define FORCE_ABSTOL                2e-6
`define ANGLE_ABSTOL                2e-6
`define ANGULAR_VELOCITY_ABSTOL     2e-6
`define ANGULAR_ACCELERATION_ABSTOL 2e-6
`define ANGULAR_FORCE_ABSTOL        2e-6
`include "disciplines.vams"

// The same shape, declared here, so that the `ifdef arm is provably the taken
// one on every compiler including the ones that prepend the annex files.
`define ANNEX_D_OVR_ABSTOL 2e-6

nature annex_d_override_voltage;
  units = "V";
  access = AnnexDOvr;
`ifdef ANNEX_D_OVR_ABSTOL
  abstol = `ANNEX_D_OVR_ABSTOL;
`else
  abstol = 1e-6;
`endif
endnature

nature annex_d_override_current;
  units = "A";
  access = AnnexDOvrFlow;
  abstol = 1e-12;
endnature

discipline annex_d_override_disc;
  potential annex_d_override_voltage;
  flow annex_d_override_current;
enddiscipline

module annex_d_abstol_overrides(p, q);
  inout p, q;
  annex_d_override_disc p;
  electrical q;
  analog begin
    `CHECKX("a nature whose abstol came from the `ifdef arm still binds its access function", AnnexDOvr(p), 1.25);
    `CHECKX("the local override reaches the declared nature attribute", p.potential.abstol, 2e-6);
    `CHECKX("D.1's Voltage access function remains bound", V(q), 3.0);
    AnnexDOvrFlow(p) <+ AnnexDOvr(p);
    I(q) <+ V(q);
  end
endmodule
