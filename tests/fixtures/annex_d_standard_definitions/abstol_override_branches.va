// Annex D.1: "Default absolute tolerances may be overridden by setting the
// appropriate _ABSTOL prior to including this file" (annex-d-stddefs.html:68).
// Every published nature carries the shape
//   `ifdef X_ABSTOL / abstol = `X_ABSTOL; / `else / abstol = <default>; / `endif
// and this fixture pins that shape end to end: the override is `defined first,
// the `ifdef arm is the one taken, and the nature it produces is bound into a
// discipline, put on a port, and read through its access function — so the arm
// is actually elaborated into a device rather than merely preprocessed.
//
// WHAT IS NOT ASSERTED, AND WHY. `abstol` is not readable from the language, so
// no fixture can compare the selected tolerance against 2e-6. The previous
// revision worked around that by summing the sixteen override macros it had
// itself `defined and checking the total against 69.0 — arithmetic over the
// fixture's own literals, which cannot fail for any Annex D reason. That check
// and its `current_abstol` twin are gone. Nor can the override reach the
// PRELUDE's natures: constants.vams and disciplines.vams are processed before
// the user source, so every standard nature has already taken its `else arm by
// the time a `define here is seen. Hence one local, non-shadowing nature.
//
// The want is the bias stored into the unknown vector and loaded straight back,
// exact in binary64.
//
//! lrm D.1
//! lrm 3.6.1.2
//! bias p = 1.25
`include "check.vh"
`define ANNEX_D_OVR_ABSTOL 2e-6

nature annex_d_override_voltage;
  units = "V";
  access = AnnexDOvr;
`ifdef ANNEX_D_OVR_ABSTOL
  abstol = `ANNEX_D_OVR_ABSTOL;
`else
  abstol = 1e-6;
`endif
endnature

nature annex_d_override_current;
  units = "A";
  access = AnnexDOvrFlow;
  abstol = 1e-12;
endnature

discipline annex_d_override_disc;
  potential annex_d_override_voltage;
  flow annex_d_override_current;
enddiscipline

module annex_d_abstol_overrides(p);
  inout p; annex_d_override_disc p;
  analog begin
    `CHECKX("AnnexDOvr is the potential access of the overridden nature", AnnexDOvr(p), 1.25);
    AnnexDOvrFlow(p) <+ AnnexDOvr(p);
  end
endmodule
