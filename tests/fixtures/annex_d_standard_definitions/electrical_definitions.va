// Annex D.1's electrical block (annex-d-stddefs.html:72-135) is four natures
// with their units/abstol attributes and their idt_nature/ddt_nature
// cross-links, one conservative discipline, and the two SIGNAL-FLOW disciplines
// the annex derives from the same natures. literal_electrical_disciplines.va
// pins the implementation's copy under the standard names; this file pins that
// the §3.6.1/§3.6.2 declaration syntax the annex is written in works when a
// USER writes it.
//
// Hence the prefixed names. An earlier revision declared `Voltage`, `Current`,
// `Charge` and `Flux` verbatim — the names the prepended disciplines.vams
// already declares — so a compiler that dropped the re-declaration and resolved
// `electrical_d`'s potential to the PRELUDE's Voltage passed anyway. It also
// wrapped everything in a private `ifdef ANNEX_D_ELECTRICAL_DEFINITIONS guard
// that nothing else defines: an `else arm that is always taken, and a comment
// claiming a skipped body that could not happen. Both are gone.
//
// voltage_d and current_d were dead: declared, then bound to nothing. Each now
// carries a port. What D.1 fixes about them is the BINDING — voltage_d has a
// potential and no flow, current_d a flow and no potential — so the
// potential-only net is probed against its bias, and the flow-only net is
// driven through the flow access, which is the only thing nameable on it. The
// rejects for the missing halves (`I` on a potential-only net, `V` on a
// flow-only one) are pinned on the standard-named disciplines in
// signal_flow_flow_access_rejected.va and its mirror.
//
// The BINDING fixes the port direction too, so the header is not free to write
// `inout` on all three: §1.3.4.1/§1.3.4.2 restrict a single-nature net to an
// `input` or an `output` port (E0360), the direction being the direction of the
// one quantity. `vn` is read and so is an `input`; `cn` is driven and so is an
// `output` — driving an `input` is E0425, the sibling rule. Only `p`, whose
// electrical_d is conservative, keeps `inout`.
//
// No flow PROBE is asserted: `AnnexDI(p) <+ ...` makes (p, gnd) a flow source
// (§5.4.2.2) and what a flow probe of one reads back is not a value Annex D
// fixes. Nor are `units`, `abstol` or the idt_nature/ddt_nature links — they are
// transcribed as the annex writes them, but §5.5.3's `p.potential.abstol` is not
// parsed by VerA (E0207) and no other construct reads an attribute back.
//
// Both wants are the bias the testbench stores into the unknown vector, loaded
// straight back, so the difference is exactly 0.0 and CHECKX is honest.
//
//! lrm D.1
//! lrm 3.6.1
//! lrm 3.6.2
//! lrm 1.3.4.1
//! lrm 1.3.4.2
//! bias p = 0.7
//! bias vn = 0.4
`include "check.vh"

nature annex_d_current;
  units = "A";
  access = AnnexDI;
  idt_nature = annex_d_charge;
  abstol = 1e-12;
endnature

nature annex_d_charge;
  units = "coul";
  access = AnnexDQ;
  ddt_nature = annex_d_current;
  abstol = 1e-14;
endnature

nature annex_d_voltage;
  units = "V";
  access = AnnexDV;
  idt_nature = annex_d_flux;
  abstol = 1e-6;
endnature

nature annex_d_flux;
  units = "Wb";
  access = AnnexDPhi;
  ddt_nature = annex_d_voltage;
  abstol = 1e-9;
endnature

discipline electrical_d;
  potential annex_d_voltage;
  flow annex_d_current;
enddiscipline

discipline voltage_d;
  potential annex_d_voltage;
enddiscipline

discipline current_d;
  flow annex_d_current;
enddiscipline

module annex_d_electrical(p, vn, cn);
  inout p;
  input vn;
  output cn;
  electrical_d p;
  voltage_d vn;
  current_d cn;
  analog begin
    `CHECKX("AnnexDV is the potential access of the user-declared electrical_d", AnnexDV(p), 0.7);
    `CHECKX("voltage_d binds the same nature as a potential-only discipline", AnnexDV(vn), 0.4);
    AnnexDI(p) <+ AnnexDV(p);
    AnnexDI(cn) <+ 1.0;
  end
endmodule
