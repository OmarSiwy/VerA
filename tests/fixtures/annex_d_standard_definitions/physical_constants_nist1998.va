// Annex D.2 constants.vams: the physical-constant selector chain. No selector is
// defined here, so the innermost `else` of the nested chain must win and every
// constant is the CODATA-1998 value. The wants are the 1998 adjustment as
// published (e = 1.602176462e-19 C, k = 1.3806503e-23 J/K, h = 6.62606876e-34
// J*s, eps0 = 8.854187817e-12 F/m); `P_U0 comes from the `else` arm that assigns
// it before the SPICE/OLD/NIST2010 tests, so it is the pre-2019 4e-7*pi.
`include "check.vh"
`include "physical_constants_select.vh"
module annex_d_nist1998(p);
  inout p; electrical p;
  analog begin
    `CHECKX("P_Q is the CODATA-1998 elementary charge", `P_Q, 1.602176462e-19);
    `CHECKX("P_K is the CODATA-1998 Boltzmann constant", `P_K, 1.3806503e-23);
    `CHECKX("P_H is the CODATA-1998 Planck constant", `P_H, 6.62606876e-34);
    `CHECKX("P_EPS0 is the CODATA-1998 permittivity", `P_EPS0, 8.854187817e-12);
    `CHECKR("P_U0 falls back to 4e-7*pi", `P_U0, 1.2566370614359173e-6, 1e-15);
    I(p) <+ `P_Q + `P_K + `P_H + `P_EPS0 + `P_U0 + 0.0*V(p);
  end
endmodule
