// Both annex D source files open with a multiple-inclusion guard —
// `ifdef DISCIPLINES_VAMS / `else / `define DISCIPLINES_VAMS 1, closed by an
// `endif at the end of the file (annex-d-stddefs.html:51-53), and the same shape
// around CONSTANTS_VAMS at :336-338. The rule the guard states is idempotence:
// including the file a second time contributes nothing, so a design where two
// modules each `include "disciplines.vams" must not fail with a duplicate
// nature or duplicate discipline.
//
// Nothing else in the suite includes either file twice. Every other fixture in
// this chapter includes each file ONCE, the way the LRM's own examples do, and
// relies on this file to show that costs nothing on an implementation that also
// prepends them: under VerA the prepended copy has already set both guards, so
// the two includes below are the SECOND and THIRD pass over the same text.
//
// Only this direction is testable. Suppression — `define DISCIPLINES_VAMS 1
// ahead of the include so that `electrical` is never declared — cannot be
// expressed, because the prelude runs before any user text and has set the
// guard already, so the `define is a no-op and no diagnostic can be provoked.
//
// The wants are the biases the testbench stores into the unknown vector, loaded
// straight back (exactly, hence CHECKX), and 273.15. 273.15 is NOT exact in
// binary64 — it is 273.1499999999999772626324556767940521240234375 — but both
// sides here parse the same decimal string to the same double, so the equality
// is exact and CHECKX is right for the structural reason, not an arithmetic one.
// They are here so the file is not merely a compile test: after the re-includes
// the standard `electrical` must still be a usable discipline and `P_CELSIUS0
// must still hold its one value, not a redefinition warning's leftovers.
//
//! lrm D.1
//! lrm D.1:1002
//! lrm D.2
//! lrm 10.1
//! lrm 10.4
//! bias V(p) = 0.5
`include "check.vh"
`include "disciplines.vams"
`include "disciplines.vams"
`include "constants.vams"
`include "constants.vams"
module annex_d_guard_idempotent(p);
  inout p; electrical p;
  analog begin
    `CHECKX("electrical survives a double include of disciplines.vams", V(p), 0.5);
    `CHECKX("P_CELSIUS0 survives a double include of constants.vams", `P_CELSIUS0, 273.15);
    I(p) <+ V(p);
  end
endmodule
