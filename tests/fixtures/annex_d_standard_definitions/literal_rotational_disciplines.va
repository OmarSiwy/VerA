// Annex D.1's rotational pair, from the implementation's disciplines.vams and
// not re-declared here — an earlier revision declared both and bound neither.
//
//   discipline rotational        potential Angle (Theta) / flow Angular_Force (Tau)
//   discipline rotational_omega  potential Angular_Velocity (Omega) / same Tau
//
// It repeats the kinematic structure: two different potential natures over one
// shared flow nature, so a compiler that derives the flow access from the
// potential nature passes the first and fails the second. Both are probed, and
// both contribute through the same `Tau`.
//
// Each want is the bias the testbench stores into the unknown vector, loaded
// straight back — exactly, so CHECKX. Were Theta/Omega bound as the flow, each
// probe would read the flow of a flow source rather than the bias.
//
//! lrm D.1
//! bias p = 1.5
//! bias q = 6.25
`include "check.vh"
`include "disciplines.vams"
module annex_d_literal_rotational(p, q);
  inout p, q;
  rotational p;
  rotational_omega q;
  analog begin
    `CHECKX("Theta is the rotational potential access", Theta(p), 1.5);
    `CHECKX("Omega is the rotational_omega potential access", Omega(q), 6.25);
    Tau(p) <+ Theta(p);
    Tau(q) <+ Omega(q);
  end
endmodule
