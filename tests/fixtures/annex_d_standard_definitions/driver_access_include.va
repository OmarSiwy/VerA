// Annex D.3 is a FILE, driver_access.vams, that an implementation supplies and
// a design `includes (annex-d-stddefs.html:447-462). driver_flags_low.va and
// driver_flags_high.va pin the twelve bit values, but they `define the masks
// themselves, so what they actually exercise is the lexer's 32'b conversion:
// they pass on a compiler that ships no D.3 file at all, and on one that ships
// a wrong one they shadow it. This file is the other half — the one that reads
// the annex file — and it is the only place in the suite where D.3's actual
// requirement is stated.
//
// The twelve wants are D.3's own literals converted to decimal: UNKNOWN 0,
// DELAYED 1, GATE 2, UDP 4, ASSIGN 8, BEHAVIORAL 16, SDF 32, NODELETE 64,
// NOPREEMPT 128, KERNEL 256, WOR 512, WAND 1024. Each is pinned on its own,
// because an OR alone is permutation-invariant; the two ORs are the
// disjointness claims, 0+1+2+4+8+16 = 31 and 32+...+1024 = 2016 = 2^11 - 2^5,
// which hold only if no two masks share a bit.
//
// Nothing here `defines a DRIVER_* macro. Every one must come out of the
// implementation's driver_access.vams, so a compiler that does not ship it
// cannot pass.
//
//! lrm D.3
//! lrm D.3:1001
`include "check.vh"
`include "disciplines.vams"
`include "driver_access.vams"
module annex_d_driver_access_include(p);
  inout p; electrical p; integer low, high;
  analog begin
    low = `DRIVER_UNKNOWN | `DRIVER_DELAYED | `DRIVER_GATE | `DRIVER_UDP | `DRIVER_ASSIGN | `DRIVER_BEHAVIORAL;
    high = `DRIVER_SDF | `DRIVER_NODELETE | `DRIVER_NOPREEMPT | `DRIVER_KERNEL | `DRIVER_WOR | `DRIVER_WAND;
    `CHECKI("driver_access.vams DRIVER_UNKNOWN carries no bit", `DRIVER_UNKNOWN, 0);
    `CHECKI("driver_access.vams DRIVER_DELAYED is bit 0", `DRIVER_DELAYED, 1);
    `CHECKI("driver_access.vams DRIVER_GATE is bit 1", `DRIVER_GATE, 2);
    `CHECKI("driver_access.vams DRIVER_UDP is bit 2", `DRIVER_UDP, 4);
    `CHECKI("driver_access.vams DRIVER_ASSIGN is bit 3", `DRIVER_ASSIGN, 8);
    `CHECKI("driver_access.vams DRIVER_BEHAVIORAL is bit 4", `DRIVER_BEHAVIORAL, 16);
    `CHECKI("driver_access.vams DRIVER_SDF is bit 5", `DRIVER_SDF, 32);
    `CHECKI("driver_access.vams DRIVER_NODELETE is bit 6", `DRIVER_NODELETE, 64);
    `CHECKI("driver_access.vams DRIVER_NOPREEMPT is bit 7", `DRIVER_NOPREEMPT, 128);
    `CHECKI("driver_access.vams DRIVER_KERNEL is bit 8", `DRIVER_KERNEL, 256);
    `CHECKI("driver_access.vams DRIVER_WOR is bit 9", `DRIVER_WOR, 512);
    `CHECKI("driver_access.vams DRIVER_WAND is bit 10", `DRIVER_WAND, 1024);
    `CHECKI("the low six flags are disjoint, so they OR to 31", low, 31);
    `CHECKI("the high six flags are disjoint, so they OR to 2016", high, 2016);
    I(p) <+ low + high + 0.0*V(p);
  end
endmodule
