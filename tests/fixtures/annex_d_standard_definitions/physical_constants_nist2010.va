// Annex D.2: PHYSICAL_CONSTANTS_NIST2010 selects the CODATA-2010 adjustment --
// e = 1.602176565e-19 C, k = 1.3806488e-23 J/K, h = 6.62606957e-34 J*s. 2010 did
// not change the permittivity, so `P_EPS0 is still 8.854187817e-12 F/m and only
// the other three separate this fixture from the NIST1998 fallback. `P_U0 is the
// pre-2019 4e-7*pi, assigned by the chain's outer `else`.
`include "check.vh"
`define PHYSICAL_CONSTANTS_NIST2010 1
`include "physical_constants_select.vh"
module annex_d_nist2010(p);
  inout p; electrical p;
  analog begin
    `CHECKX("P_Q is the CODATA-2010 elementary charge", `P_Q, 1.602176565e-19);
    `CHECKX("P_K is the CODATA-2010 Boltzmann constant", `P_K, 1.3806488e-23);
    `CHECKX("P_H is the CODATA-2010 Planck constant", `P_H, 6.62606957e-34);
    `CHECKX("P_EPS0 is unchanged from 1998", `P_EPS0, 8.854187817e-12);
    `CHECKR("P_U0 is 4e-7*pi", `P_U0, 1.2566370614359173e-6, 1e-15);
    I(p) <+ `P_Q + `P_K + `P_H + `P_EPS0 + `P_U0 + 0.0*V(p);
  end
endmodule
