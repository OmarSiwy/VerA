// Annex D.1 opens disciplines.vams with two natureless disciplines,
// `\logic` and `ddiscrete`, each carrying only `domain discrete`. This file
// pins `ddiscrete`; literal_logic_discipline.va pins the escaped-name half.
//
// Both come from the implementation's disciplines.vams and are NOT re-declared
// here — an earlier revision declared `ddiscrete` (plus an invented
// `logic_disc` that appears nowhere in Annex D) and then bound neither to a
// net, so the file asserted nothing about either.
//
// §3.6.3: "Nets declared with a natureless discipline or declared without a
// discipline do not have declared natures, so such nets can not be used in
// analog behavioral descriptions (because the access functions are not
// known)." `ddiscrete` binds no nature, so `V(n)` names nothing and this must
// not compile.
//
//! lrm D.1
//! lrm 3.6.3
//! reject E0501
//! xfail VerA accepts an analog access function on a natureless `ddiscrete` net: the discipline binds no natures, so nothing constrains which access name resolves on it
module annex_d_discrete(n);
  inout n;
  ddiscrete n;
  analog V(n) <+ 0.0;
endmodule
