// `Temp` is a perfectly well-declared standard access function — Annex D.1
// gives it to the Temperature nature and binds that nature into `thermal`. It
// is simply not an access of `electrical`.
//
// §4.4: "The access function name shall match the discipline declaration for
// the nets, ports, or branch given in the argument expression list." A compiler
// that keeps one flat table of every access name in disciplines.vams accepts
// this; the name must be looked up in the NET's discipline.
//
// The sibling unbound_nature_charge_rejected.va pins the other failure mode: an
// access name whose nature is declared but bound into no discipline at all. The
// two are separate fixtures because a compiler can plausibly resolve one and not
// the other — the resolution paths differ even in VerA, where `Temp` reaches the
// discipline-mismatch check and `Q` never enters the access table at all. Both
// pin the CODE and not the wording: the LRM fixes that this is an error, not how
// an implementation phrases it, and only the code is portable across compilers.
//
//! lrm D.1
//! lrm 4.4
//! lrm 4.4:5
//! reject-only E0501
`include "disciplines.vams"
module annex_d_unbound_nature_access(p);
  inout p;
  electrical p;
  analog I(p) <+ Temp(p);
endmodule
