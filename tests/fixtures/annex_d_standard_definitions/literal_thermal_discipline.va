// Annex D.1: `discipline thermal` binds `potential Temperature` / `flow Power`,
// whose natures give the access functions `Temp` and `Pwr`. The discipline
// comes from the implementation's disciplines.vams — an earlier revision
// declared it here, so the check read back the fixture's own declaration.
//
// The observable claim is the BINDING: on a thermal node `Temp` is the
// POTENTIAL, so a node held at 350 K probes as exactly 350 — if `Temp` were the
// flow of a flow-source branch instead, this would not read the bias back.
//
// The flow half is deliberately NOT given a number. `Pwr(p) <+ ...` makes
// (p, gnd) a flow source (§5.4.2.2), and what a flow PROBE of a flow source
// reads back is not a value Annex D or §5.4.2 fixes; asserting one would pin an
// implementation choice rather than the standard. What D.1 fixes is that `Pwr`
// is the access of the flow nature, which is why the contribution below names
// it and is accepted.
//
//! lrm D.1
//! bias p = 350
`include "check.vh"
`include "disciplines.vams"
module annex_d_literal_thermal(p);
  inout p; thermal p;
  analog begin
    `CHECKX("Temp is the thermal potential access", Temp(p), 350.0);
    Pwr(p) <+ Temp(p);
  end
endmodule
