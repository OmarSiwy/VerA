// Annex D.3's file opens "`ifdef DRIVER_ACCESS_VAMS `else `define
// DRIVER_ACCESS_VAMS 1" and closes with "`endif" (annex-d-stddefs.html), the
// same guard D.1 and D.2 carry. disciplines_vams_guard_idempotent.va pins the
// guard of those two; this pins D.3's: three includes of driver_access.vams
// (the second and third are no-ops under the guard) must not redefine a
// DRIVER_* macro into a different value or fail. Without the guard a
// conforming preprocessor would still accept a redefinition of an identical
// macro, so the value checks are the observable half: DRIVER_WAND keeps
// D.3's 32'b10000000000 = 1024 and DRIVER_UNKNOWN its 0. There is no invalid
// form to neighbour: an include of a guarded file is always legal.
//
//! lrm D.3
//! lrm 10.4
//! checks 2
`include "check.vh"
`include "disciplines.vams"
`include "driver_access.vams"
`include "driver_access.vams"
`include "driver_access.vams"
module annex_d_driver_access_guard_idempotent(p);
  inout p; electrical p;
  analog begin
    `CHECKI("DRIVER_WAND survives a triple include", `DRIVER_WAND, 1024);
    `CHECKI("DRIVER_UNKNOWN survives a triple include", `DRIVER_UNKNOWN, 0);
    I(p) <+ V(p);
  end
endmodule
