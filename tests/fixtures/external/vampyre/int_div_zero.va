// VAMPyRE self-test: an integer division whose divisor, the parameter `k`,
// may be 0 by its declared range. VAMPyRE: "Integer divide" and "Possible
// division by zero for parameter k" on line 13. VerA: W0653 on line 13.
// vampyre-agree: intdiv0/int_div_zero.va:13
`include "disciplines.vams"
module int_div_zero(p, n);
  inout p, n; electrical p, n;
  (* units = "" *) parameter integer k = 2 from [0:10];
  integer j;
  analog begin
    // integer division, divisor in [0:10]
    // (line 13 is the next one)
    j = 10 / k;
    I(p, n) <+ j * V(p, n);
  end
endmodule
