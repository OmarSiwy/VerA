// VAMPyRE self-test: `last` is read before it is set in the evaluation, so
// its value comes from the previous one. VAMPyRE: "Variable cur depends on
// last, which has not been set". VerA: §3.2 retention, `last` held across
// evaluations as `retained`.
// vampyre-agree: hidden/last
`include "disciplines.vams"
module hidden_state(p, n);
  inout p, n; electrical p, n;
  real last, cur;
  analog begin
    cur = V(p, n) + last;
    last = V(p, n);
    I(p, n) <+ cur;
  end
endmodule
