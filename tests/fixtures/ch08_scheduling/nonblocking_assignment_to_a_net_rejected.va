// §8.5.3.4: "A nonblocking assignment statement (see 9.2.2 of IEEE Std 1364
// Verilog) always computes the updated value and schedules the update as a
// nonblocking assign update event, either in this time step if the delay is zero
// or as a future event if the delay is nonzero. The values in effect when the
// update is placed on the event queue are used to compute both the right-hand
// value and the left-hand target."
//
// The "nonblocking assign update event" is region 3 of §8.5.1's queue — "Events
// that have been evaluated during some previous simulation time, but that shall
// be ASSIGNED at this simulation time" — and what it assigns is a variable.
// A.6.2:
//
//   nonblocking_assignment ::= variable_lvalue <= [ delay_or_event_control ] expression
//
// `w` is a `wire`, so `w <= 1'b1` names no variable_lvalue. A net's value is not
// updated by an event; it is re-resolved from its drivers (§7.2.3), and a
// nonblocking assignment is not one of the three ways §7.2.3 lists to create a
// driver ("declaring a reg, instantiating a digital primitive or using a
// continuous assign statement").
//
// The positive half is `ch07_mixed_signal/m02_07_glitch_absorbed_at_one_tick.va`
// and `m02_10_macro_process_runs_after_nba.va`, whose nonblocking assignments to
// `reg`s run and are asserted.
//
// WHAT THIS PINS THAT NOTHING ELSE DID. Before 2026-09-24 VerA accepted this
// module (E0482 is new).
//
// §8.5.3, the parent, is cited too: "Assignments are translated into processes
// and events as follows" — a statement outside A.6.2's assignment forms is not
// translated into any of them.
//
//! lrm 8.5.3.4
//! lrm 8.5.3
//! lrm A.6.2
//! lrm A.6.2:1000
//! reject-only E0482
//! neighbour ../ch07_mixed_signal/m02_07_glitch_absorbed_at_one_tick.va
`timescale 1ns/1ns
`include "disciplines.vams"
module ch8534_nba_wire(p);
  inout p;
  electrical p;
  wire w;

  initial w <= #5 1'b1;

  analog I(p) <+ V(p) / 1k;
endmodule
