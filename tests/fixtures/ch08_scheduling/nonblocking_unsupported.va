// §8.5.3.4: a nonblocking update lands in region 3 of the stratified queue.
// The `<=` inside an `always` body is A.6.2's `nonblocking_assignment`, grammar
// in every module's discrete context, so this parses now; it used to be E0205
// on the `always` under annex C.7, a rule of the Verilog-A subset.
//
// VerA's CEILING, named by E0437: the `always` process needs §8.5.1's event
// queue, which VerA does not yet run beside a device. The `<=` in an ANALOG
// block is still refused, by the grammar (annex_c_analog_subset/22).
//
//! lrm 8.5.3.4
//! reject E0437
//! reject always
module ch8_nonblocking;
  integer source, target;
  always @(source) target <= source;
endmodule
