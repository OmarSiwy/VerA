// Annex C.7: "No digital behavior or events are supported in Verilog-A." The
// nonblocking update needs the digital event queue's nonblocking region, and the
// `always` process that would drive it is not a Verilog-A module item at all.
//! lrm C.7
//! lrm 8.5.3.4
//! reject E0205
//! reject always
module ch8_nonblocking;
  integer source, target;
  always @(source) target <= source;
endmodule
