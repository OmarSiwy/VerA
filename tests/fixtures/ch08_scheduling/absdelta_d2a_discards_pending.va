// Host-only input for 8.4.6:1000/1001. The observer pauses after the
// analog solver has looked ahead to 12 ns and queued interpolated events.
// The first event at 2.5 ns is consumed. At 4 ns the digital clamp changes,
// forcing a D2A solution and invalidating the still-pending 5/7.5/10 ns
// events derived from the earlier 12 ns ramp solution. The replacement
// waveform is constant 0.4 V and generates no further delta crossing.
`timescale 1ns/1fs
`include "disciplines.vams"
module absdelta_d2a_discards_pending(p);
  inout p;
  electrical p;
  integer clamp, events;
  initial begin
    clamp = 0;
    events = 0;
    #4 clamp = 1;
  end
  always @(absdelta(V(p), 0.25, 1p, 1u)) begin
    events = events + 1;
    $display("absdelta-d2a count=%0d time_ns=%g voltage=%g",
             events, $realtime, V(p));
  end
  analog V(p) <+ clamp ? 0.4 : $abstime * 1.0e8;
endmodule
