// LRM 8.3.1 nodal analysis: the simulator forms f(v, t) = dq(v, t)/dt + i(v, t)
// = 0, where f is "a vector containing the total flow out of each node". This
// module contributes only the STATIC half i(v, t) -- there is no ddt, so q is
// identically zero and the whole equation is the constitutive relation
// evaluated at v.
//
// The constitutive relation is a 2 mS conductance (2m = 2e-3 by the LRM 2.6.2
// Table 2-1 scale factor). At V(p) = 1.5 and V(n) = 0.25 the branch potential is 1.25 V,
// so i = 2e-3 * 1.25 = 2.5e-3 A. KFL makes that same flow leave p and enter n,
// so the relation read across the reversed branch is its negation.
//
//! lrm 8.3.1
//! lrm 2.6.2
//! bias V(p) = 1.5, V(n) = 0.25
`include "check.vh"
module ch8_static(p, n);
  inout p, n; electrical p, n;
  analog begin
    `CHECK("static flow out of p", 2m * V(p, n), 2.5e-3, 1e-15);
    `CHECK("KFL: the same flow enters n", 2m * V(n, p), -2.5e-3, 1e-15);
    I(p, n) <+ 2m * V(p, n);
  end
endmodule
