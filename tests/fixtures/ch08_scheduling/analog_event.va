// LRM 5.10.3.1 cross(): "The cross() function will not generate events for
// non-transient analyses, such as ac, dc, or noise analyses"; it "can only
// generate an event after the simulation time has advanced from zero".
//
// This is a dc operating point, so the +1 crossing is NOT detected even though
// V(c) sits above zero. The guarded assignment never runs and `sample` keeps the
// value LRM 3.5 gives a real variable at the start of a simulation: 0.0.
//
// V(p) = 0.75 is the discriminator — an implementation that fires cross() during
// dc prints 0.75 for sample. The first check pins that the probe really is
// nonzero, so the second one cannot pass by accident.
//
//! lrm 5.10.3.1
//! bias V(p) = 0.75, V(c) = 0.9
`include "check.vh"
module ch8_event(p, c);
  inout p, c; electrical p, c; real sample;
  analog begin
    @(cross(V(c), +1)) sample = V(p);
    `CHECKX("the probe the guard would have sampled", V(p), 0.75);
    `CHECKX("cross() is silent in dc, so sample is still its 0.0 init", sample, 0.0);
    I(p) <+ sample;
  end
endmodule
