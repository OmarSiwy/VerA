// LRM 8.4.3.2: "The process may also wake itself up early for reevaluation by
// use of a timer". LRM 5.10.3.3 fixes exactly WHEN: "The timer() function
// schedules an event which occurs at an absolute time (start_time) ... At that
// time point, the event evaluates to True. ... If the period is specified as
// greater than zero (0), the timer function schedules subsequent events at
// multiples of period."
//
// So `timer(1n, 2n, 1p)` fires at 1 ns, 3 ns, 5 ns, ... and NOWHERE ELSE. In
// particular it does not fire at the origin: start_time is 1 ns, not a period
// offset from it.
//
// `//! analysis tran` is not decoration. 5.10.3.3 is a transient service, and a
// tool is entitled to gate it on the analysis kind exactly as 5.10.3.1 gates
// cross(). Under the dc default this file used to carry, such a tool passes
// vacuously -- nothing fires, and the only want was "nothing fired". The
// declared points now straddle start_time, so both directions carry a literal:
//
//   t = 0, 0.25n, 0.5n, 0.75n   no event yet   -> state = 0.0
//   t = 1n                      start_time     -> state = 1.0 - 0.0 = 1.0
//
// The first check is the row-INVARIANT "nothing fired early": multiplying by
// the sub-0.9n indicator zeroes the firing row, so the whole walk must answer
// 0.0. It catches the classic off-by-one that treats start_time as an offset
// from the origin. The second is two-sided -- state must agree with the
// indicator at EVERY row -- and it is the one a lowering that silently drops
// `@(...) stmt;` fails, because such a lowering leaves state at 0.0 on the 1 ns
// row where the indicator is 1. 0.9n sits strictly between the last quiet point
// (0.75n) and start_time, so a fire one row either side fails as well.
//
// The walk stops AT start_time on purpose: with a period of 2 ns the next event
// is at 3 ns, and the value in between depends on whether module variables
// persist across time points, which is not what this file is pinning.
//
//! lrm 8.4.3.2
//! lrm 8.4.3.2:2
//! lrm 5.10.3.3
//! analysis tran
//! time 0, 0.25n, 0.5n, 0.75n, 1n
`include "check.vh"
module ch8_timer_wakeup(p);
  inout p; electrical p; real state;
  analog begin
    @(timer(1n, 2n, 1p)) state = 1.0 - state;
    `CHECKX("no timer event before start_time = 1 ns", state * ($abstime < 0.9n), 0.0);
    `CHECKI("the timer wakes the process at start_time = 1 ns, and only there",
            state == ($abstime > 0.9n), 1);
    V(p) <+ transition(state, 0.0, 1p);
  end
endmodule
