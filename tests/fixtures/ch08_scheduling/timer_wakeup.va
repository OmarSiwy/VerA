// LRM 8.4.3.2: "The process may also wake itself up early for reevaluation by
// use of a timer". LRM 5.10.3.3 fixes exactly WHEN: "The timer() function
// schedules an event which occurs at an absolute time (start_time) ... If the
// period is specified as greater than zero (0), the timer function schedules
// subsequent events at multiples of period."
//
// So `timer(1n, 2n, 1p)` fires at 1 ns, 3 ns, 5 ns, ... and NOWHERE ELSE. In
// particular it does not fire at the origin: start_time is 1 ns, not 0. Every
// declared time point below is strictly inside [0, 1 ns), so no event has
// occurred yet and the guarded statement has never run -- `state` still holds
// the zero a real variable is initialized to, and the toggle to 1.0 is still in
// the future. A timer that fired at t=0 (the classic off-by-one, treating
// start_time as a period offset from the origin) turns this ok=1 into ok=0.
//
//! time 0, 0.25n, 0.5n, 0.75n
`include "check.vh"
module ch8_timer_wakeup(p);
  inout p; electrical p; real state;
  analog begin
    @(timer(1n, 2n, 1p)) state = 1.0 - state;
    `CHECKX("no timer event before start_time = 1 ns", state, 0.0);
    V(p) <+ transition(state, 0.0, 1p);
  end
endmodule
