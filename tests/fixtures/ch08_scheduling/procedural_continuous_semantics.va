// §8.5.3.2, verbatim: "A procedural continuous assignment (which is the assign
// or force statement; see 9.3 of IEEE Std 1364 Verilog) corresponds to a
// process that is sensitive to the source elements in the expression. When the
// value of the expression changes, it causes an active update event to be added
// to the event queue, using current values to determine the target."
// And: "A deassign or a release statement deactivates any corresponding assign
// or force statement(s)."
//
// TWO SENTENCES, TWO THINGS A COMPILER CAN GET WRONG, AND ONE NUMBER AT THE END.
// The `initial` block below changes `target` exactly once, explicitly; every
// other change of `target` has to come from the process the clause describes.
//
//     t = 0    source = 1'b1;         target is forced; §9.3 of 1364 assigns on
//                                     the spot, so target = 1
//     t = 0    force target = source;  the process is installed
//     t = 0    source = 1'b0;          NO statement mentions target again. If
//                                      the force is a process sensitive to its
//                                      source elements, this update event sets
//                                      target = 0 on its own.
//     t = 10   #10 release target;     the force is deactivated
//     t = 20   #10 source = 1'b1;      the force is GONE, so target must not
//                                      follow source back to 1.
//
// The second sentence is the reason the last step is the assertion: without a
// `release`, a conforming simulator leaves target at 1 here, so the one literal
// below separates a compiler whose release works from one whose release does
// nothing. A compiler that installed no process at all leaves target at its
// forced value (1) and fails the same check; a compiler that installed the
// process but dropped it when releasing gives 1 too.
//
// WHY THE GUARD. At t = 0 the analog engine's DC analysis and the digital
// engine's first statements share a time, and §8.4.1 does not order them
// against each other, so which of them a t = 0 row sees is not fixed. The row
// that carries the claim is the LAST one, after the schedule has nothing left
// to run; `($abstime > 15.0)` selects it and makes the earlier row assert the
// one value that is true whatever the interleaving was — this is not slack for
// the rule, it is the statement that the rule is about t = 20 and later.
//
// WHY THIS IS `//! xfail` AND NOT `//! reject`. The sentences above are the
// LRM's, not VerA's ceiling, and a conforming compiler runs this block and
// prints 0. VerA refuses the block instead, so the file has to carry the rule
// it cannot reach, exactly as procedural_release_unsupported.va carries the
// refusal of the same keyword. The two are not duplicates: that file pins the
// diagnostic, this one pins the behaviour, and this one XPASSes the day the
// diagnostic stops being the answer.
//
//! lrm 8.5.3.2
//! xfail VerA has no statement production for `force` or for a `#` delay in an initial block (E0209, lib/frontend/parser.zig), so the block is refused and no transcript exists to read `target` from
//! analysis tran
//! time 0, 25
`include "check.vh"
module ch8_procedural_continuous(p);
  inout p;
  electrical p;

  reg source, target;

  initial begin
    source = 1'b1;
    force target = source;
    source = 1'b0;
    #10 release target;
    #10 source = 1'b1;
  end

  analog begin
    `CHECKI("the force followed its source, and the release stopped it",
            ($abstime > 15.0) ? target : 1'b0, 0);
    I(p) <+ V(p);
  end
endmodule
