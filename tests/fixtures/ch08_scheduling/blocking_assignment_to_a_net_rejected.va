// §8.5.3.3: "A blocking assignment statement (see 9.2.1 of IEEE Std 1364
// Verilog) with a delay computes the right-hand side value using the current
// values, then causes the executing process to be suspended and scheduled as a
// future event. ... When the process is returned (or if it returns immediately
// if no delay is specified), the process performs the assignment to the
// left-hand side and enables any events based upon the update of the left-hand
// side."
//
// "Performs the assignment to the left-hand side" is a store, and A.6.2 fixes
// what can be stored into:
//
//   blocking_assignment ::= variable_lvalue = [ delay_or_event_control ] expression
//
// `w` is a `wire`. A net is not a variable_lvalue: it has no storage for a
// blocking assignment to update, only drivers whose resolution IS its value
// (§7.2.3). So `#5 w = 1'b1;` is outside the grammar.
//
// The module is a mixed one on purpose — the `#5` makes the `initial` block a
// process the kernel runs (§8.5), which is the case §8.5.3.3 is about and the
// one VerA used to accept. (A constant-shape `initial` writing a net is refused
// by the same rule.)
//
// The positive half is `blocking_assignment_delay.va` in this directory, which
// runs a delayed blocking assignment to an `integer` and asserts the sampled
// right-hand side.
//
//! lrm 8.5.3.3
//! lrm A.6.2
//! lrm A.6.2:1000
//! reject-only E0482
//! neighbour blocking_assignment_delay.va
`timescale 1ns/1ns
`include "disciplines.vams"
module ch8533_blocking_wire(p);
  inout p;
  electrical p;
  wire w;

  initial #5 w = 1'b1;

  analog I(p) <+ V(p) / 1k;
endmodule
