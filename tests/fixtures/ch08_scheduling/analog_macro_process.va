// LRM 8.1, verbatim: an analog macro-process is "a set of continuous nodes
// that must be solved together because they are joined by analog blocks or
// analog primitives". This module joins p and n with one contribution, so both
// nodes belong to one macro-process and the branch quantity the block reads is
// the DIFFERENCE of the two node potentials (LRM 4.4, Table 4-16: V(n1,n2)
// accesses the voltage difference), not either node against ground.
//
// At V(p) = 1.0 and V(n) = 0.25 that difference is 0.75 V, so the contributed
// flow is 0.75 A — a model that read V(p) alone would say 1.0.
//
//! lrm 8.1
//! lrm 4.4
//! bias V(p) = 1.0, V(n) = 0.25
`include "check.vh"
module ch8_macro(p, n);
  inout p, n; electrical p, n;
  analog begin
    `CHECKX("the joined nodes are read as one branch potential", V(p, n), 0.75);
    `CHECKX("and the reverse branch is its negation", V(n, p), -0.75);
    I(p, n) <+ V(p, n);
  end
endmodule
