// §8.5.1's stratified event queue, rows 3b and 4:
//
//   "3b. Analog macro-process events shall be processed after all active,
//    explicit D2A events, inactive events and non blocking assign update
//    events are processed."
//   "4. Events that shall be processed after all the active, explicit D2A,
//    inactive, non blocking assign update events and analog macro-process
//    events are processed. These are the monitor events."
//
// and "The $monitor, $strobe and $debug system tasks ... create monitor events
// for their arguments." So a $strobe executed at a tick reports the values as
// they stand AFTER that tick's analog macro-process solve.
//
// THE CONSTRUCTION. At tick 4 the digital initial block sets q = 1 (region 1).
// The analog block reads q unguarded, so by §8.5 the change is an implicit D2A
// event and causes a region-3b macro-process event: the analog solve at 4.0 ns
// sees q = 1 and drives V(vo) to 7.0 (vo is free, `//! solve`, so 7.0 is the
// solver's answer). The same process then executes a $strobe of V(vo), a
// probe in the discrete context (§7.3.3). Its argument is evaluated in region
// 4, after 3b, so it reads the 4.0 ns solution:
//
//     V(vo) = 7.0      (q = 1)
//
// A tool that evaluated monitor events before the macro-process solve would
// read the solution from before tick 4, where q = 0: 0.0. §7.3.6.3 has the
// digital read use "the analog value calculated for the time corresponding to
// a real promotion of the digital time", 4.0 ns, and the post-3b solution is
// that value; no interpolation is involved. 7.0 is exact in binary.
//
// The verdict is printed by the DIGITAL $strobe, once, at tick 4: `//! checks
// 1`. (A continuous VARIABLE would show the same thing, but a discrete read of
// one is §7.3.3's other half, which b3_analog_initial_before_digital_initial.va
// carries; the probe keeps this file about the region order alone.)
//
//! lrm 8.5.1
//! lrm 8.5.1:5
//! lrm 8.5.1:4
//! lrm 7.3.6.3
//! analysis tran
//! time 0, 2n, 4n, 6n
//! solve
//! checks 1
`timescale 1ns/1ns
`include "check.vh"
module b3_strobe_after_macro_process(vo);
  inout vo; electrical vo;
  reg q;
  initial begin
    q = 1'b0;
    #4 q = 1'b1;           // tick 4, region 1: an implicit D2A, so a 3b solve
    `CHECKX("$strobe (region 4) reads the node potential of this tick's 3b solve", V(vo), 7.0);
  end
  analog V(vo) <+ (q ? 7.0 : 0.0);
endmodule
