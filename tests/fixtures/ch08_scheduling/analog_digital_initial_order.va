// §8.4.1 circuit initialization, with BOTH initial constructs in one module: the
// §5.2.1 `analog initial` block, which is a statement inside the analog block and
// runs once per analysis, and A.6.2's digital `initial` construct, which is a
// module item and runs once before the simulation proper. They are two different
// things that share a keyword, and this is the only file in the suite where both
// appear at once.
//
// THIS FILE USED TO DEMAND E0205, on "annex C: the digital `initial` block is
// outside Verilog-A, so there is no analog/digital initial ordering to schedule."
// C.7 and C.10 are the two subset clauses that argument rests on, and both are
// rules of the Verilog-A SUBSET. VerA targets Verilog-AMS, so the file was
// demanding a diagnostic a conforming AMS compiler must not emit. The cites are
// kept because the clauses are still the ones this file is about — re-scoped to
// a `--std=verilog-a` gate this compiler does not have, exactly as
// annex_c_analog_subset/09_default_discipline_accepted.va keeps its `//! lrm C.4`.
//
// WHAT IS ASSERTED, and what is deliberately NOT. Both initializations have
// happened by the time the ordinary analog block runs, so it reads 1.0 + 1: a
// tool that dropped either one reads 1.0 or 1.0 + 0, and both come out ≠ 2.0.
// What this does NOT claim is a relative ORDER between the two blocks — that
// would need an observation that can only be made by reading one from the other,
// and §5.2.1 forbids the only direction in which the question is decidable
// ("digital values cannot be accessed from the analog initial block as they have
// not yet been assigned when the analog initial block is executed", which
// ch05_analog_behavior/analog_initial_digital_access_rejected.va pins as E0431).
// So the honest claim here is coexistence and completeness, not sequence, and the
// two are not the same fixture.
//
// 2.0 is exact in binary and both operands are, so the tolerance is CHECKX's.
//
// §8.4, the parent, is cited too: it opens the mixed-signal cycle with "the
// semantics of the initialization", and what this fixture asserts — both
// initial blocks complete before the solve reads them — is that initialization.
//
//! lrm 8.4
//! lrm 8.4.1
//! lrm 5.2.1
//! lrm C.7
//! lrm C.10
//! bias V(p) = 0.5
`include "check.vh"
module ch8_analog_digital_initial_order(p);
  inout p; electrical p; real analog_value; integer digital_value;
  analog initial analog_value = 1.0;
  initial digital_value = 1;
  analog begin
    `CHECKX("both initial constructs have run before the analog block", analog_value + digital_value, 2.0);
    I(p) <+ analog_value + digital_value;
  end
endmodule
