//! reject unsupported module item
// EXPECT: error -- force/assign processes need the digital scheduler.
module ch8_proc_continuous;
  integer source, target;
  always begin force target = source; end
endmodule
