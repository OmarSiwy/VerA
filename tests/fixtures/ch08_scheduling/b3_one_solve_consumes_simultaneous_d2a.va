// §8.5.3.7 Processing analog macro-process events (region 3b): "Note that if
// multiple events for a particular analog macro-process are active, then a
// single evaluation of the analog macro-process shall consume all of these
// events from the queue."
//
// THE CONSTRUCTION. Two digital processes each wake at tick 4 and set one reg
// (a and b, both 0 -> 1). The analog block reads both unguarded, so each
// change is an implicit D2A event and each causes an analog macro-process
// event for the same macro-process (§8.5). Both are active at tick 4, so ONE
// evaluation consumes both, and it runs after regions 1-3 (§8.5.1 row 3b), when
// both regs already hold 1:
//
//     t = 0, 2n   a + b = 0
//     t = 4n      a + b = 2        (one solution, seeing both changes)
//     t = 6n      a + b = 2
//
// The block asserts a + b once per reported solution, so the transcript has
// one verdict per analog solution: four, `//! checks 4`. A tool that evaluated
// the macro-process once per event would report a second solution at 4 ns
// (five verdicts), and one that evaluated it as each change arrived would
// report a + b = 1 there. The tick-4 D2A lands on the declared 4n point, so no
// extra point is due. Small integers converted to real are exact, so CHECKX.
//
//! lrm 8.5.3.7
//! lrm 8.5.3.7:1
//! lrm 8.5.1:4
//! analysis tran
//! time 0, 2n, 4n, 6n
//! checks 4
`timescale 1ns/1ns
`include "check.vh"
module b3_one_solve_consumes_simultaneous_d2a(vo);
  inout vo; electrical vo;
  reg a, b;
  initial begin a = 1'b0; #4 a = 1'b1; end
  initial begin b = 1'b0; #4 b = 1'b1; end
  analog begin
    `CHECKX("one solution per tick, and it sees both changes",
            (a ? 1.0 : 0.0) + (b ? 1.0 : 0.0), ($abstime < 4n) ? 0.0 : 2.0);
    V(vo) <+ (a ? 1.0 : 0.0) + (b ? 1.0 : 0.0);
  end
endmodule
