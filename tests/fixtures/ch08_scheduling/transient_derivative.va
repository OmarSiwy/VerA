// LRM 8.3.2 transient analysis, verbatim: "The simulator replaces the time
// derivative operator (dq/dt) with a discrete-time finite difference
// approximation. The simulation time interval is discretized and solved at
// individual time points along the interval."
//
// Its sibling dynamic_nodal.va pins the DC special case, where 4.5.3 makes
// ddt() identically zero by fiat. That says nothing about the substitution:
// a lowering that computed v/dt instead of a difference of successive values
// passes it, because in dc there is no time step to divide by. This file is the
// transient half -- the same module, walked over four time points.
//
// WHY THE BIAS IS HELD CONSTANT. The finite difference RULE is not fixed by the
// LRM: 8.3.2 requires only "a discrete-time finite difference approximation",
// and backward Euler, trapezoidal and gear all qualify, so the first-step value
// of ddt() on a RAMP legitimately differs between conformant tools and there is
// no literal to write. On a CONSTANT history every consistent rule agrees, and
// agrees on zero:
//
//   backward Euler   (x[k] - x[k-1]) / h = (0.75 - 0.75) / h = 0
//   trapezoidal      2*(x[k] - x[k-1])/h - dx[k-1] = 0 - 0   = 0   (dx[0] = 0)
//
// So 0.0 is implementation-independent here, and the wrong answer is neither
// small nor subtle: a naive v/dt at t = 1 ns gives 0.75 / 1e-9 = 7.5e8, and a
// stale-history bug that treated x[k-1] as the 3.2 default gives the same.
//
// The bias check is what keeps the zero from being a dead branch -- the branch
// really is at 0.75 V on every row -- and the 1p scaling is the contribution as
// the nodal equation of 8.3.1 sees it, dq/dt with q = C*v.
//
// §8.3, the parent, is cited too: "Through transient analysis, the value and
// flow equations are solved incrementally with respect to time" — the four
// time points here are that increment, and each is asserted.
//
// 8.3.2:1000's step-control clause has no source-level observer: the solver's
// transient accuracy-control unit test is registered as the specialized
// evidence for it. The declared time points are the "solved at individual time
// points" half — every row evaluates and asserts the substituted ddt.
//
//! lrm 8.3
//! lrm 8.3.2
//! lrm 8.3.2:1000
//! lrm 4.5.3
//! analysis tran
//! time 0, 1n, 2n, 3n
//! bias V(p) = 1.0, V(n) = 0.25
`include "check.vh"
module ch8_transient_derivative(p, n);
  inout p, n; electrical p, n;
  analog begin
    `CHECKX("the branch really is biased, on every row", V(p, n), 0.75);
    `CHECKX("a constant history differences to zero under any finite-difference rule",
            ddt(V(p, n)), 0.0);
    `CHECKX("so the dynamic contribution is zero too", 1p * ddt(V(p, n)), 0.0);
    I(p, n) <+ 1p * ddt(V(p, n));
  end
endmodule
