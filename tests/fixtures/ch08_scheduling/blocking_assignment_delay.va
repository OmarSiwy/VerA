// §8.5.3.3, verbatim: "A blocking assignment statement (see 9.2.1 of IEEE Std
// 1364 Verilog) with a delay computes the right-hand side value using the
// current values, then causes the executing process to be suspended and
// scheduled as a future event. If the delay is 0, the process is scheduled as
// an inactive event for the current time."
//
// "COMPUTES THE RIGHT-HAND SIDE VALUE USING THE CURRENT VALUES" is the sentence
// with a number in it, and the statement below is the smallest one that can
// catch it being deferred:
//
//     t = 0    x = 1;
//     t = 0    y = #5 x;    the RHS is sampled NOW, against x = 1
//     t = 0    x = 2;       this runs while the assignment is pending
//     t = 5    the process resumes and performs the assignment, so y = 1
//
// A compiler that evaluated the right-hand side when the process RESUMED —
// the natural way to write it if the delay is lowered as "suspend first, then
// evaluate" — reads x = 2 and leaves y = 2. That is not a rounding difference;
// it is the whole rule, and the clause's second sentence is what makes the
// distinction explicit rather than accidental: "the values at the time the
// process resumes are used to determine the TARGET(s)", not the value. The
// target is `y`; the value being assigned was fixed at t = 0.
//
// WHY THE GUARD. The assignment has not resumed at t = 0, so the t = 0 row
// asserts the constant that is true whatever the scheduler did with the
// pending process — this is not slack for the rule, it is the statement that
// the rule is about t = 5 and later. `($abstime > 5.0)` selects those rows, and
// the one literal below is what they must read: 1, the value x held when the
// right-hand side was sampled, not 2.
//
// WHY `y = 0` FIRST. A digital-context `integer` starts at x (§3.2), and §7.3.2
// says "It will be an error if the value of the digital variable being accessed
// in the analog context goes either to x or z". `y` IS accessed in the analog
// block, so an earlier revision, which left `y` at x until t = 5 and relied on
// the unselected `?:` arm not counting as an access, could be refused by a
// conforming tool at t = 0. §8.4.1 runs the digital initial block for time zero
// before the DC analysis, so `y = 0` is what the analog block reads until the
// delayed assignment lands. It does not touch the rule: `y` is still written
// at t = 5, from the x sampled at t = 0.
//
// The xfail this row used to carry (E1100, no default time unit for `#5`) went
// stale when the delay started compiling; what then stopped it was the x above.
//
// THE ZERO-DELAY SENTENCE has its own observation. At t = 10 the second initial
// block writes d = 2 in the active region, then `d = #0 3;` suspends and its
// resume is an inactive event for the same tick. The analog block reads d, so
// each write is an implicit D2A event and the analog macro-process event is
// processed after the active and inactive regions (§8.5.1), so the 10 s
// solution reads 3. A tool that treats #0 as an immediate active write and
// solves the macro-process on the intermediate change reads d = 2 there. The
// intermediate 2 must never be a solved value — that is what scheduling the
// process as an inactive event buys.
//
// §8.5.3, the parent, is cited too: "Assignments are translated into processes
// and events as follows" — this is its blocking-assignment row, run.
//
//! lrm 8.5.3
//! lrm 8.5.3.3
//! lrm 8.5.3.3:1001
//! analysis tran
//! time 0, 10, 25
`include "check.vh"
module ch8_blocking_delay(p);
  inout p;
  electrical p;

  integer x, y, d;

  initial begin
    y = 0;
    x = 1;
    y = #5 x;
    x = 2;
  end

  initial begin
    d = 1;
    #10 d = 2;
    d = #0 3;
  end

  analog begin
    `CHECKI("a delayed blocking assignment samples its right-hand side first",
            ($abstime > 5.0) ? y : 1, 1);
    `CHECKI("the #0 resume is an inactive event, so the solve sees only d = 3",
            ($abstime >= 10.0) ? d : 3, 3);
    I(p) <+ V(p);
  end
endmodule
