// LRM 5.10.3.1: cross(expr, dir, time_tol, expr_tol) asks the solver to place a
// wake-up at the threshold crossing — "cross() controls the timestep to
// accurately resolve the crossing", with 1p and 1u here as the time and
// expression tolerances. That timestep control is a TRANSIENT service: the same
// clause says cross() "will not generate events for non-transient analyses, such
// as ac, dc, or noise" and "can only generate an event after the simulation time
// has advanced from zero".
//
// This operating point is dc, and V(p) - 0.5 = +0.5 is already on the far side
// of the threshold, so there is nothing to cross even in principle. `state`
// therefore keeps the 0.0 LRM 3.2 gives a real variable, and the contributed
// flow is 0 A rather than the 1 A the guarded body would assign.
//
//! lrm 5.10.3.1
//! bias V(p) = 1.0
`include "check.vh"
module ch8_cross_wakeup(p);
  inout p; electrical p; real state;
  analog begin
    @(cross(V(p) - 0.5, 0, 1p, 1u)) state = 1.0;
    `CHECKX("the threshold expression is above zero", V(p) - 0.5, 0.5);
    `CHECKX("yet no dc wake-up fires, so state is untouched", state, 0.0);
    I(p) <+ state;
  end
endmodule
