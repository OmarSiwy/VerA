// §8.5.1's stratified event queue: "3b. Analog macro-process events shall be
// processed after all active, explicit D2A events, inactive events and non
// blocking assign update events are processed." "4. Events that shall be
// processed after all the active, explicit D2A, inactive, non blocking assign
// update events and analog macro-process events are processed. These are the
// monitor events." And: "The $monitor, $strobe and $debug system tasks ...
// create monitor events for their arguments. These events are continuously
// re-enabled in every successive time step."
//
// IEEE 1364-2005 §17.1.3: $monitor displays its arguments "whenever the value
// of any one of the variables or expressions in the argument list changes",
// except $time, $stime and $realtime.
//
// b3_strobe_after_macro_process.va pins $strobe (one call, once). This is the
// $monitor half: a monitor armed at time 0 on a node potential, V(vo) (a
// probe in the discrete context, §7.3.3), which an analog solve sets.
//
// THE CONSTRUCTION. The analog block drives V(vo) = 7 when q is 1, else 0, and
// reads q unguarded, so q's change at tick 4 is an implicit D2A event and the
// 3b solve at 4 ns makes V(vo) = 7 (`//! solve`). The monitor's region 4
// comes after that solve, so:
//
//     t = 0 ns   first report:                       V(vo) = 0
//     t = 2 ns   analog solution, V(vo) still 0:     no report
//     t = 4 ns   V(vo) changed to 7 in this tick's 3b solve:  report, V = 7
//     t = 6 ns   unchanged:                          no report
//
// Two reports. Each prints ok = whether its (time, value) pair is one of the
// two above. A tool that ran region 4 before 3b would see V(vo) = 0 at 4 ns
// and report the 7 only at 6 ns, printing ok=0; one that never re-evaluated
// the monitor after an analog solve would print one report. The solutions at
// 2 ns and 6 ns, which no digital event shares, are checked too
// (monitor_at_analog_only_solutions.va), and V(vo) has not moved at either;
// the third argument does fall to 0 at 2 ns, but only through $realtime,
// which is no change (VD-111). 0.0, 4.0 and 7.0 are exact in binary.
//
// The analog CHECK pins the solve the monitor reads, once per accepted
// solution (0, 2, 4, 6 ns; the D2A time is the declared 4 ns): V(vo) is 0
// before 4 ns and 7 from it. Four analog checks and two reports: six.
//
//! lrm 8.5.1
//! lrm 8.5.1:5
//! lrm 8.5.1:4
//! lrm 8.4
//! lrm 7.3.3
//! inherited IEEE 1364-2005 17.1.3
//! analysis tran
//! time 0, 2n, 4n, 6n
//! solve
//! checks 6
`timescale 1ns/1ns
`include "check.vh"
module monitor_after_macro_process(vo);
  inout vo; electrical vo;
  reg q;
  initial begin
    q = 1'b0;
    $monitor("monitor t=%0t v=%g ok=%0d", $realtime, V(vo),
             ($realtime == 0.0 && V(vo) == `VERA_PW(0.0)) || ($realtime == 4.0 && V(vo) == `VERA_PW(7.0)));
    #4 q = 1'b1;
  end
  analog begin
    V(vo) <+ (q ? 7.0 : 0.0);
    `CHECKX("the solve the monitor reads", V(vo), ($abstime < 4n) ? 0.0 : 7.0);
  end
endmodule
