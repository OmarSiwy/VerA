// LRM 8.3.1 nodal analysis: the equations "are a restatement of Kirchhoff's Flow
// Law", f being "a vector containing the total flow out of each node". Three
// resistive branches share the three nodes, so each node's row is the SUM of the
// branch flows leaving it, with sign taken from the branch orientation.
//
// At V(p) = 1.0, V(n) = 0.2, V(c) = 0.5, and with LRM 2.6.2 Table 2-1 making 1k = 1000:
//   I(p,n) = (1.0 - 0.2)/1000 =  800 uA
//   I(p,c) = (1.0 - 0.5)/2000 =  250 uA
//   I(n,c) = (0.2 - 0.5)/3000 = -100 uA   (flow runs c -> n)
// Total out of p = 800u + 250u = 1.05 mA; out of n = -800u + -100u = -900 uA,
// out of c = -250u + 100u = -150 uA. The three sum to zero, as KFL demands of a
// network with no external source.
//
//! lrm 8.3.1
//! lrm 2.6.2
//! bias V(p) = 1.0, V(n) = 0.2, V(c) = 0.5
`include "check.vh"
module ch8_kfl(p, n, c);
  inout p, n, c; electrical p, n, c;
  analog begin
    `CHECKR("the 1k scale factor makes this branch 800 uA", V(p, n) / 1k, 8.0e-4, 1e-12);
    `CHECKR("the c-n branch flows backwards", V(n, c) / 3k, -1.0e-4, 1e-12);
    `CHECKR("total flow out of p is the sum of its two branches",
            V(p, n) / 1k + V(p, c) / 2k, 1.05e-3, 1e-12);
    `CHECK("and out of n, counting the branch that enters it",
           -V(p, n) / 1k + V(n, c) / 3k, -9.0e-4, 1e-15);
    I(p, n) <+ V(p, n) / 1k;
    I(p, c) <+ V(p, c) / 2k;
    I(n, c) <+ V(n, c) / 3k;
  end
endmodule
