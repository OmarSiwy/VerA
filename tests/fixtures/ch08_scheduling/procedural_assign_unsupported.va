//! reject unsupported module item
// EXPECT: error -- procedural assign updates require the digital scheduler.
module ch8_procedural_assign;
  reg source, target;
  initial begin
    assign target = source;
  end
endmodule
