// §8.5.1, the last paragraph of the stratified-queue clause: "Note that A2D
// events must be analog event controlled statements ( e.g., @cross, @timer).
// These are scheduled just like other event controlled statements in
// Verilog-HDL (e.g., @posedge)."
//
// An A2D event is the analog domain waking a digital process. §7.3.5 names the
// only way the discrete context detects one: "monitored continuous events can
// be detected in a discrete context", by Syntax 7-3's `analog_event_functions`
// (cross, above, timer, absdelta) — functions the analog solver MONITORS, so it
// can place the event in time (§8.4.3.2: "If the analog process identifies
// future analog events such as 'crossings' or timer events ... then it will
// schedule its wake-up event for the time of the first such event").
//
// `always @(posedge (V(in) > 2.5))` asks for the same threshold as the
// clause's own `@(cross(V(in) - 2.5, 1))`, but as a digital edge of a probe
// read: an A2D event that is not an analog event controlled statement, with no
// monitored function for the solver to locate. That is what the note rules out.
//
// The positive half is `ch07_mixed_signal/m01_09_cross_event_in_a_digital_always.va`,
// which writes the threshold as `cross()` in an `always` block and asserts it
// fires once on the rising crossing. The probe itself is legal in a digital
// EXPRESSION (§7.3.3, `ch07_mixed_signal/m01_08`); what is refused is waiting
// on it.
//
//! lrm 8.5.1
//! lrm 8.5.1:7
//! lrm 7.3.5
//! reject-only E0484
//! neighbour ../ch07_mixed_signal/m01_09_cross_event_in_a_digital_always.va
`timescale 1ns/1ns
`include "disciplines.vams"
module ch851_a2d_probe(in, out);
  input in;
  output out;
  electrical in;
  reg out;

  initial out = 1'b0;

  always @(posedge (V(in) > 2.5))
    out = 1'b1;
endmodule
