// Host-only input for AMS 8.4.7:1004; the exact observer is
// tests/host.py.
//
// Accept initialization at 0, consume its one absdelta event, then pause the
// digital kernel. A tentative analog solution at 12 ns is 1.2 V and creates
// four unconsumed interpolated events near 2.5, 5, 7.5 and 10 ns. The host
// must observe these real pending events before rejecting that solution.
// Their provenance must disappear on rejection. Retry at 2 ns (0.2 V,
// below delta), then accept 4 ns (0.4 V): only one newly generated delta
// event, near 2.5 ns, may run. The accepted control consumes all four.
//
// No standalone assertion or synthetic rejection: the host must exercise
// and observe the simulator's actual trial/queue/rejection interface.
`timescale 1ns/1fs
`include "disciplines.vams"
module absdelta_unconsumed_events_rejected(p);
  inout p;
  electrical p;
  parameter real delta = 0.25, time_tol = 1p, expr_tol = 1u;
  parameter integer monitor_enabled = 1;
  integer events;
  initial events = 0;
  generate if (monitor_enabled) begin
    always @(absdelta(V(p), delta, time_tol, expr_tol)) begin
      events = events + 1;
      $display("absdelta-observed count=%0d time_ns=%g voltage=%g",
               events, $realtime, V(p));
    end
  end endgenerate
  analog V(p) <+ $abstime * 1.0e8;
endmodule
