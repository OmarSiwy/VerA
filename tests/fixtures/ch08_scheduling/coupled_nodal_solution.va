// VAMS 8.3.1, physical PDF page 215: static nodal equations enforce zero
// total flow at each free node. Unlike checks of voltage arithmetic at pinned
// nodes, this fixture asks the host to solve TWO coupled free unknowns.
// All four conductances are 1 S. With p=5 and n=0, KFL gives
//   at a: (a-5) + (a-b) + a = 0, hence 3a-b=5;
//   at b: (b-a) + b = 0, hence 2b-a=0.
// Therefore a=2 and b=1. The n-to-a contribution is deliberately reversed;
// its negative flow still adds +a to the a-node row. Dropping that branch
// gives a=10/3,b=5/3; dropping coupling gives a=2.5,b=0. Either fails.
// Tolerance allows floating-point elimination error, not a different circuit.
// This observes static equation assembly/solution in the fixture host, not
// adaptive transient accuracy or every convergence/rollback requirement.
//! lrm 8.3.1
//! solve
//! bias V(p) = 5.0, V(n) = 0.0
//! checks 2
`include "check.vh"
`include "disciplines.vams"
module audit_coupled_nodal_solution(p, n);
  inout p, n; electrical p, n, a, b;
  analog begin
    I(p,a) <+ V(p,a);
    I(a,b) <+ V(a,b);
    I(b,n) <+ V(b,n);
    I(n,a) <+ V(n,a);
    `CHECK("first coupled free node", V(a,n), 2.0, 1e-12);
    `CHECK("second coupled free node", V(b,n), 1.0, 1e-12);
  end
endmodule
