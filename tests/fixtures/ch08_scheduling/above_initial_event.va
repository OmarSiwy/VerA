// LRM 5.10.3.2 above() has exactly two "shall"s, and this fixture is placed on
// the first of them:
//
//   "The above() function can generate an event during initialization. If the
//    expression is positive at the conclusion of the initial condition analysis
//    THAT PRECEDES A TRANSIENT ANALYSIS, the above() function SHALL generate an
//    event."
//
// (The second is "During a dc sweep, the above() function shall also generate
// an event when the expression crosses zero from below" -- a sweep with a
// crossing, which this is not.)
//
// Hence `//! analysis tran` and a two-point walk starting at the origin: the
// initial condition analysis that precedes it is the normative trigger. A
// standalone single-point dc operating point, which this file used to declare,
// matches NEITHER "shall" -- it lands on the permissive "can generate an event
// during initialization", and a tool that fires above() only where the clause
// says "shall" is conformant and would fail it. No digit changes.
//
// At the initial condition V(c) - 0.5 = 0.9 - 0.5 = +0.4 is positive, so the
// event fires and the guarded assignment runs: sample takes the V(p) of that
// row, 0.75.
//
// AND THEN IT MUST NOT FIRE AGAIN. The same clause says above() "generates a
// monitored analog event to detect threshold crossings in analog signals when
// the expression crosses zero (0) from below" and "maintains its internal
// state". V(c) is held at 0.9, so the threshold expression stays at +0.4 for
// the whole walk and never crosses zero from below after the initial
// condition. The sampled probe is therefore stepped instead: V(p) moves to 0.25
// at t = 1 ns, and a conforming tool still reports sample = 0.75 there, because
// the latch closed at the initial condition and nothing re-armed it.
//
// That step is what makes the row at 1 ns a test. With a HELD V(p), which this
// file used to declare, "fires once at the IC and holds" and "fires at every
// solution" print the identical 0.75 / 0.75 transcript, so the assertion could
// not see the over-firing direction at all -- and over-firing is the direction a
// level-test lowering of above() is wrong in. Under-firing is still covered:
// a tool that treats above() like cross() and skips the IC leaves sample at the
// 0.0 LRM 3.2 gives an unassigned real, on both rows.
//
//! lrm 5.10.3.2
//! analysis tran
//! time 0, 1n
//! bias V(c) = 0.9
//! wave V(p) = 0.75, 0.25
//! xfail VerA lowers above() as a stateless level test (`if (expr.val() > 0.0)`, src/backend/codegen.zig), so it re-fires at every solution instead of only on an upward zero crossing, and sample follows V(p) down to 0.25
`include "check.vh"
module ch8_above(p, c);
  inout p, c; electrical p, c; real sample;
  analog begin
    @(above(V(c) - 0.5)) sample = V(p);
    `CHECKX("above(+0.4) fires at the initial condition and the latch holds it", sample, 0.75);
    I(p) <+ sample;
  end
endmodule
