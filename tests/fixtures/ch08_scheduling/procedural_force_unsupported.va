// A.6.2 `procedural_continuous_assignment ::= force variable_lvalue = expression`
// inside an `initial` block. §8.5's simulation cycle is what gives a force its
// meaning: it overrides every driver of its target until a `release` drops it,
// which is a statement about the digital event queue and about nothing else.
//
// THE VERDICT IS VerA'S CEILING, NAMED. `reg` and the digital `initial` block are
// legal Verilog-AMS (A.2.1.3, A.6.2) and VerA now accepts both — the annex C
// argument this file used to make ("no digital behavior or events are supported
// in Verilog-A") is a rule of the SUBSET, and VerA targets Verilog-AMS. What
// remains true is narrower and belongs to this compiler: there is no statement
// production for `force`, so the keyword arrives where an expression was
// expected and the file is refused at E0209.
//
// The pin is that CODE and not the word `reg` or the word `initial`. Those two
// substrings are how this file used to pass, and they came only from the prose of
// E0205's "found `reg`" message — so its verdict rode on a diagnostic's wording
// and would have flipped on a rewording as readily as on a rule change. E0209
// says WHICH refusal happened, and the day a discrete kernel lands this file is
// one line away from being a positive fixture instead of silently green.
//
//! lrm 8.5
//! reject E0209
//! reject force
module ch8_procedural_force;
  reg source, target;
  initial force target = source;
endmodule
