// LRM 8.2 simulation initialization: "module-level variable declaration
// assignments are evaluated followed by the execution of analog initial
// blocks", and only then does the simulation cycle of 8.3 begin. So by the time
// the ordinary analog block is evaluated, `initialized` already holds 3.0 —
// not the 0.0 LRM 3.2 gives an unassigned real.
//
// The ordering is what is under test, so the operating point is chosen to make
// the two readings differ: at V(p) = 0.4 the contribution is 3.0 * 0.4 = 1.2 A,
// while a block that ran before `analog initial` would contribute 0.
//
//! lrm 8.2
//! lrm 8.2:1
//! bias V(p) = 0.4
`include "check.vh"
module ch8_initial(p);
  inout p; electrical p; real initialized;
  analog initial initialized = 3.0;
  analog begin
    `CHECKX("analog initial ran before the analog block", initialized, 3.0);
    `CHECK("so the contribution is 3.0 * 0.4", initialized * V(p), 1.2, 1e-15);
    I(p) <+ initialized * V(p);
  end
endmodule
