// §5.2.1 `analog initial` versus §5.10.2 `initial_step`, on a PARAMETRIC SWEEP.
// They coincide everywhere else, which is why VerA models the first as a guard
// on the second and why nothing in the suite caught it until now.
//
// §5.2.1, the sentence that separates them:
//
//   "The analog initial block is executed once for each analysis, and can be
//    executed for each sub-task of parameter sweep analysis (such as dc sweep).
//    ... If a parameter or variable that is referenced from an analog initial
//    block is changed during a sub-task of a parameter sweep analysis, then the
//    analog initial block SHALL BE RE-EXECUTED so that the new value is taken
//    into account."
//
// §8.2 puts it in the initialization flow: "module-level variable declaration
// assignments are evaluated followed by the execution of analog initial blocks",
// and that flow is entered per sub-task.
//
// `initial_step` does NOT re-execute. Table 5-1 makes it the FIRST POINT of an
// analysis, and a dc sweep is one analysis whose sweep points are its sub-tasks
// — so a body guarded on `initial_step` runs once, at the first point, and
// never again.
//
// THE GAP THIS FIXTURE OPENED. `lib/ir/lower.zig` used to lower an `analog
// initial` block as its body guarded on a synthetic `initial_step`, so `seeded`
// was computed from `gain` as it stood at the first sweep point and then frozen.
// `//! psweep` below changes `gain` at every sub-task, and `gain` IS referenced
// from the analog initial block, which is exactly the condition §5.2.1 attaches
// its "shall" to. The guard is now its own predicate (`analog_initial`, answered
// from `Instance.is_analog_initial`), set by the harness on the first evaluation
// of every sub-task rather than of the whole analysis.
//
// WHY THE SWEEP IS OVER A PARAMETER AND NOT A NODE. §5.2.1 forbids access
// functions inside an analog initial block ("shall not contain ... statements
// with access functions or analog operators"), so a node voltage can never be
// what the block reads. A parameter is the only thing whose change can be
// observed here, which is why `//! psweep` had to exist before this fixture
// could be written at all.
//
// The wants are `10.0 * gain` at each sub-task, written out:
//   gain = 1.0  ->  10.0
//   gain = 2.0  ->  20.0
//   gain = 4.0  ->  40.0
// All three are exact in binary.
//
// WHAT VerA USED TO ANSWER, which is worse than a stale value: 10 at the first
// sub-task, then 0 at both of the others. Not the seed frozen at its
// first-sub-task value — the DECLARATION default of `seeded`. Two things
// compounded. The block was guarded on `initial_step`, so it did not re-run; and
// a module variable is re-initialised from its declaration at the top of every
// evaluation, so with nothing to re-seed it the value collapsed to 0 rather than
// persisting. A reader who assumed "stale but plausible" would have been wrong in
// a way that matters: a model doing `analog initial` setup on a sweep got zero,
// not a slightly outdated number, and zero is much likelier to divide. The second
// half of that is still true and is what makes the re-execution load-bearing
// rather than an optimization.
//
//! lrm 5.2.1
//! lrm 5.2.1:2
//! lrm 8.2
//! lrm 8.2:2
//! psweep gain = 1.0, 2.0, 4.0
// Two assertions at each of the three sweep points; omitting a point must fail.
//! checks 6
//! analysis dc
//! print none
`include "check.vh"
module ch8_analog_initial_psweep(p);
  inout p;
  electrical p;
  parameter real gain = 1.0 from (0:inf);
  real seeded;
  analog initial begin
    seeded = 10.0 * gain;
  end
  analog begin
    // PRIMARY, and a LITERAL, because a row-invariant one exists: the three
    // swept gains are powers of two, so `10.0 * gain` is exact in binary and
    // `seeded / gain` is exactly 10.0 at every sub-task. No need for the
    // weaker relational form to carry the claim — and under the defect
    // documented above this line answers 0, not 10.0.
    `CHECKX("analog initial re-runs for each sub-task, so the seed tracks the swept parameter",
            seeded / gain, 10.0);
    // (The relational `CHECKEQ(seeded, 10.0 * gain)` this file used to lead
    // with is exactly equivalent to the line above and strictly weaker, so it
    // is gone: seeded/gain == 10.0 iff seeded == 10.0*gain, and only one of
    // the two lets VerA supply its own expectation.)
    // Row-INVARIANT: whatever else is true, the seed can never still be the
    // first sub-task's value once `gain` has moved past 1.0.
    `CHECKI("the seed is not frozen at the first sub-task", (gain > 1.5) ? (seeded > 15.0) : 1, 1);
    I(p) <+ 0.0;
  end
endmodule
