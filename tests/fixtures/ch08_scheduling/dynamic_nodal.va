// LRM 8.3.1 splits the nodal equation into a dynamic and a static part,
// f(v,t) = dq(v,t)/dt + i(v,t) = 0. This module contributes only the dynamic
// part, 1p * ddt(V(p,n)).
//
// At a dc operating point there is no dq/dt: LRM 4.5.3 states it outright —
// "In DC analysis, ddt() returns zero (0)." So the whole contribution is 0 A
// however hard the branch is biased. The first check pins the bias at 0.75 V so
// the zero below is a statement about ddt and not about a dead branch.
//
//! lrm 8.3.1
//! lrm 4.5.3
//! bias V(p) = 1.0, V(n) = 0.25
`include "check.vh"
module ch8_dynamic(p, n);
  inout p, n; electrical p, n;
  analog begin
    `CHECKX("the branch really is biased", V(p, n), 0.75);
    `CHECKX("but the dynamic term is zero in dc", ddt(V(p, n)), 0.0);
    I(p, n) <+ 1p * ddt(V(p, n));
  end
endmodule
