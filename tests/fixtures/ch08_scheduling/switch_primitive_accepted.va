// A switch primitive between two electrical nets is legal Verilog-AMS once
// §3.9's precondition holds, so this file is a run fixture and not a
// `//! reject`.
//
// Annex A.4.1: `gate_instantiation ::= ... | pass_switchtype pass_switch_instance ;`
// with `pass_switchtype ::= tran | rtran`, and A.1.4 makes gate_instantiation a
// `module_or_generate_item`. That is the clause that admits the construct.
//
// §3.9 IS WHAT THE FILE USED TO BREAK. "For digital primitives the domain is
// discrete and thus the discipline is set via the default_discipline directive
// as it is for digital modules. If the discipline of digital connections
// (vpiLoConn) to a mixed net are unknown then the default_discipline must be
// specified ... If not specified, an error will result during discipline
// resolution." A `tran` is a digital primitive (§8.5.3.5 processes it in the
// discrete cycle), and `a`/`b` are electrical, so both are mixed nets. The
// earlier version of this file wrote no `default_discipline and argued from
// Annex C that Verilog-A admits the switch — but C.4 withdraws
// `default_discipline from Verilog-A, so under Verilog-A the connection's
// discipline could never be known and the file was an error there too. A
// conforming compiler refused it; VerA passed it only because it did not check
// §3.9. That refusal is now pinned by
// ch03_data_types/digital_primitive_on_mixed_net_rejected.va (E0960), and the
// C.8 claim this file carried went with the Verilog-A argument.
//
// So the file supplies both halves the LRM asks for: `default_discipline logic
// names the switch's discrete side (§3.8 "a default discrete discipline"), and
// since `a` and `b` then join two domains, §3.11's Signal Domain Rule wants a
// connect statement between logic and electrical, which `ch8_sw_rules` gives
// (an inout/inout bridge, Table 7-2's third row). The bare `default_discipline
// after the module withdraws the default again (§10.2).
//
// ACCEPTANCE IS NOT MODELLING, AND VerA SAYS SO. The instance is parsed and
// contributes nothing to the device, with a W0250 at the keyword saying that
// out loud (`--deny=W0250` refuses the module instead): §8.5.3.5 gives a pass
// switch its meaning in the DISCRETE cycle and no continuous behavior, and
// VerA inserts no connect module (§7.8's insertion does not run — see
// ch07_mixed_signal/connect_mode_accepted.va), so the analog device has
// nothing to stamp for it.
//
// WHAT IS ASSERTED. The harness imposes node values rather than solving a
// network, so the electrical effect of the switch is not observable from inside
// the module. What the fixture pins is the part that is: the source is
// accepted, and the analog block of a module that also carries a switch
// primitive is still elaborated and evaluated at its operating point, reading
// 0.75 - 0.25 = 0.5 V across the pair.
//
//! lrm A.4.1
//! lrm 3.8
//! lrm 3.8:1000
//! bias V(a) = 0.75, V(b) = 0.25
`include "check.vh"
connectmodule ch8_sw_bridge(d, e);
  inout d, e; logic d; electrical e;
endmodule
`default_discipline logic
module ch8_switch(a, b);
  inout a, b; electrical a, b;
  tran (a, b);
  analog begin
    `CHECKX("the analog block of a module carrying a switch primitive still runs", V(a, b), 0.5);
    I(a, b) <+ 0.0;
  end
endmodule
`default_discipline
connectrules ch8_sw_rules;
  connect ch8_sw_bridge;
endconnectrules
