// A switch primitive is INSIDE the Verilog-A subset, so this file is a run
// fixture and not a `//! reject`.
//
// Annex A.4.1: `gate_instantiation ::= ... | pass_switchtype pass_switch_instance ;`
// with `pass_switchtype ::= tran | rtran`, and A.1.4 makes gate_instantiation a
// `module_or_generate_item`. Annex C.8 keeps the Clause 6 hierarchical
// structure applicable to Verilog-A with one stated exception (real value
// ports), and that exception is not this. C.16's list of keywords Verilog-A
// does not use -- connect, connectmodule, connectrules, driver_update,
// endconnectrules, merged, net_resolution, resolvedto, split, wreal -- does not
// contain `tran` either, though absence from a negative list is only
// corroboration; A.4.1 is the clause that admits the construct.
//
// So a conforming Verilog-A compiler accepts this source, and VerA now does.
// An earlier version of this file wrote the gap as `//! reject E0205`, which
// inverted it: a conforming compiler would have failed the fixture and only
// VerA would have passed. A later one carried `//! xfail` while `tran` was
// E0205 "unsupported module item".
//
// ACCEPTANCE IS NOT MODELLING, AND VerA SAYS SO. The instance is parsed and
// contributes nothing to the device, with a W0250 at the keyword saying that
// out loud (`--deny=W0250` refuses the module instead). That is not a shortcut
// this fixture is papering over: 8.5.3.5 gives a pass switch its meaning in the
// DISCRETE cycle -- logic values and strengths across two terminals -- and no
// continuous behavior anywhere, so a compiled analog device has nothing to
// stamp for it and any equation VerA invented would be VerA's convention rather
// than the standard's.
//
// It is NOT a gap in 8.5.3.5. Switch processing is part of the digital
// simulation cycle, which Annex C.10 puts outside Verilog-A ("The mixed-signal
// simulation cycle from 8.2 is only applicable to Verilog-AMS HDL"), so no
// amount of instantiation support would make this file cover that clause.
//
// WHAT IS ASSERTED. The harness imposes node values rather than solving a
// network, so the electrical effect of an ideal bidirectional switch -- a and b
// driven to one potential -- is not observable from inside the module. What the
// fixture pins is the part that is: the source is accepted, and the analog block
// of a module that also carries a switch primitive is still elaborated and
// evaluated at its operating point, reading 0.75 - 0.25 = 0.5 V across the pair.
// That is the whole of what A.4.1 plus C.8 require of this file, and it is why
// the fixture can be green while the switch stamps nothing: nothing here claims
// the switch conducts, because nothing in the LRM says what it would conduct in
// a continuous domain.
//
//! lrm A.4.1
//! lrm C.8
//! bias V(a) = 0.75, V(b) = 0.25
`include "check.vh"
module ch8_switch(a, b);
  inout a, b; electrical a, b;
  tran (a, b);
  analog begin
    `CHECKX("the analog block of a module carrying a switch primitive still runs", V(a, b), 0.5);
    I(a, b) <+ 0.0;
  end
endmodule
