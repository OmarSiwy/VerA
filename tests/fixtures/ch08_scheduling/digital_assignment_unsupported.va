// A.6.1 `continuous_assign ::= assign list_of_net_assignments ;` is a module
// item of every module (A.1.4), so `assign` parses in a `.va` now; it used to be
// E0205 under an annex C.7 argument that is a rule of the Verilog-A SUBSET, not
// of the Verilog-AMS VerA compiles.
//
// What refuses it is E0437: a continuous assignment is a §8.5.3.1 process on the
// digital event queue, and VerA does not yet run that queue beside a device.
//
// NOTE the target is an `integer`, a VARIABLE. IEEE 1364-2005 §6.1 gives a
// continuous assignment a `net_lvalue` only, so this source stays illegal once
// the queue runs; the fixture then needs that rule's own code, not E0437.
//
//! lrm 8.5
//! lrm A.6.1
//! reject E0437
//! reject assign
module ch8_continuous_assignment;
  integer source, target;
  assign target = source;
endmodule
