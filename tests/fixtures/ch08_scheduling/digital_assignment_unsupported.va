// annex C: the digital continuous `assign` is outside Verilog-A.
//! lrm C.7
//! reject E0205
//! reject assign
module ch8_continuous_assignment;
  integer source, target;
  assign target = source;
endmodule
