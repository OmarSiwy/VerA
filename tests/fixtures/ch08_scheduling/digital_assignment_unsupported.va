// A.6.1 `continuous_assign ::= assign list_of_net_assignments ;` is a module
// item of every module (A.1.4), so `assign` parses in a `.va` now; it used to be
// E0205 under an annex C.7 argument that is a rule of the Verilog-A SUBSET, not
// of the Verilog-AMS VerA compiles.
//
// The target is an `integer`, a VARIABLE. A.6.1's `net_assignment` drives a
// `net_lvalue` only (IEEE 1364-2005 §6.1, part of the language by VAMS §1.1): a
// continuous assignment is a DRIVER and only a net has drivers. That rule's own
// code is E0438. (It was E0437 while VerA could not run the event queue at all;
// the queue runs now, and the source is still illegal.)
//
//! lrm 8.5
//! lrm A.6.1
//! lrm A.6.1:1000
//! reject-only E0438
//! reject assign
module ch8_continuous_assignment;
  integer source, target;
  assign target = source;
endmodule
