// LRM 6.2: "A module definition may have multiple analog blocks. The behavior of
// multiple analog blocks shall be defined by assuming they internally combine
// into a single analog block in the order that the analog blocks appear in the
// module description (i.e., they are concatenated in order)." LRM 8.4.3.1 adds
// that the apparent concurrency is not permission to reorder shared memory.
//
// So `first`, written by the earlier block, is already 0.9 when the later block
// reads it — the check that would fail if the blocks were run independently, or
// back to front, or only one of them at all.
//
// Both blocks contribute to the same branch, and LRM 8.3.1 sums them into one
// nodal row: 0.9 + ddt(...) = 0.9 A here, since LRM 4.5.3 makes ddt zero in dc.
//
//! lrm 6.2
//! lrm 6.2:7
//! lrm 6.2:8
//! lrm 8.4.3.1
//! lrm 8.3.1
//! lrm 6.9.1
//! lrm 6.9.1:1
//! lrm 6.9.1:2
//! lrm 6.9.1:3
//! bias V(p) = 0.9
`include "check.vh"
module ch8_concurrent(p);
  inout p; electrical p; real first;
  analog begin
    first = V(p);
    I(p) <+ V(p);
  end
  analog begin
    `CHECKX("the earlier block's write is visible to the later one", first, 0.9);
    `CHECKX("this block's dynamic term is zero in dc", ddt(V(p)), 0.0);
    `CHECKX("so the concatenated pair contributes the static term", V(p) + ddt(V(p)), 0.9);
    I(p) <+ ddt(V(p));
  end
endmodule
