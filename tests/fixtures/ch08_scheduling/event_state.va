// LRM 5.10.2, Table 5-1: initial_step returns 1 at the operating point of a DCOP
// analysis, so an or-list containing it fires at this single dc point. Its
// partner timer(1n, 1n) (LRM 5.10.3.3) is a transient service and its start time
// is 1 ns anyway, so the or-list is carried entirely by initial_step here — LRM
// 5.10.1: any one of the OR-ed events triggers the statement.
//
// The guarded assignment therefore runs and `last` holds V(p) = 0.625, which is
// then the whole contributed flow. A tool that never raises initial_step in dc
// leaves `last` at the 0.0 of LRM 3.2 and contributes nothing.
//
//! lrm 5.10.2
//! lrm 5.10.1
//! lrm 5.10.1:1
//! bias V(p) = 0.625
`include "check.vh"
module ch8_event_state(p);
  inout p; electrical p; real last;
  analog begin
    @(initial_step or timer(1n, 1n)) last = V(p);
    `CHECKX("initial_step fires at the dc operating point", last, 0.625);
    I(p) <+ last;
  end
endmodule
