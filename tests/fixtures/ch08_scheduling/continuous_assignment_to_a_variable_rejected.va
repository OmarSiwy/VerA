// §8.5.3.1: "A continuous assignment statement (6.1 of IEEE Std 1364 Verilog)
// corresponds to a process, sensitive to the source elements in the expression.
// When the value of the expression changes, it causes an active update event to
// be added to the event queue, using current values to determine the target."
//
// The target of that update is a NET. A.6.1, the grammar this LRM prints for
// the statement:
//
//   continuous_assign ::= assign [ drive_strength ] [ delay3 ]
//                         list_of_net_assignments ;
//   net_assignment    ::= net_lvalue = expression
//
// A continuous assignment is a DRIVER, one of the drivers the net's value is
// resolved from (§7.2.3: "Drivers are created by declaring a reg, instantiating
// a digital primitive or using a continuous assign statement"); a variable has
// no drivers to resolve — it holds what the last procedural write stored. `r`
// is a `reg`, so `assign r = ...` has no net_lvalue and no target for §8.5.3.1's
// update event.
//
// The positive half is `ch07_mixed_signal/ddiscrete_net_continuously_assigned.va`
// and `ch07_mixed_signal/m02_01_dc_time_zero_settle.va`, which drive NETS by
// continuous assignment and assert the value the analog block reads.
//
//! lrm 8.5.3.1
//! lrm A.6.1
//! lrm A.6.1:1000
//! reject-only E0438
//! neighbour ../ch07_mixed_signal/ddiscrete_net_continuously_assigned.va
//! neighbour ../ch07_mixed_signal/m02_01_dc_time_zero_settle.va
`timescale 1ns/1ns
`include "disciplines.vams"
module ch8531_assign_reg(p);
  inout p;
  electrical p;
  reg r;
  reg d;

  initial begin
    d = 1'b0;
    #5 d = 1'b1;
  end

  assign r = d;

  analog I(p) <+ V(p) / 1k;
endmodule
