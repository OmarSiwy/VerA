// Host-only input. The host observes the actual crossing event's solution
// identity and pending digital queue before acceptance, rejection or delivery.
// See tests/host.py for the required live observations.
`timescale 1ns/1ns
`include "disciplines.vams"
module cross_pending_host_observations(p);
  inout p; electrical p;
  integer events;
  real sampled;
  initial begin events = 0; sampled = -1.0; end
  always @(cross(V(p)-0.52, 1, 1p, 1u)) begin
    events = events + 1;
    sampled = V(p);
    $display("cross-pending count=%0d tick=%g voltage=%g", events, $realtime, sampled);
  end
  analog V(p) <+ $abstime * 1.0e8;
endmodule
