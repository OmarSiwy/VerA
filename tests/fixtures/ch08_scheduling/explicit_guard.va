// LRM 8.4.3.2: "Analog processes are sensitive to changes in all variables and
// digital signals read by the process unless that access is only in statements
// 'guarded' by event expressions" — the clocked D2A example, where latching the
// data behind @(posedge clk) is what stops the block from tracking it.
//
// Here V(p) is read ONLY inside the @(cross(...)) guard, so it reaches `latched`
// only when the clock crossing fires. LRM 5.10.3.1: cross() generates no events
// for non-transient analyses, and this is a dc operating point — even though
// V(clock) - 0.5 = +0.5 already sits above the threshold, no crossing happened.
// So `latched` keeps its 0.0 (LRM 3.2) while V(p) sits at 1.25: the guard is
// doing exactly the job the clause describes, and an implementation that leaks
// the unguarded probe through prints 1.25.
//
//! lrm 8.4.3.2
//! lrm 5.10.3.1
//! bias V(p) = 1.25, V(clock) = 1.0
`include "check.vh"
module ch8_guard(p, clock);
  inout p, clock; electrical p, clock; real latched;
  analog begin
    @(cross(V(clock) - 0.5, +1)) latched = V(p);
    `CHECKX("the guarded data probe is live and nonzero", V(p), 1.25);
    `CHECKX("but nothing crossed, so the latch never took it", latched, 0.0);
    I(p) <+ latched;
  end
endmodule
