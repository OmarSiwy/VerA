// §8.5.3.5 "Switches provide bi-directional signal flow and require coordinated
// processing of nodes connected by switches. The IEEE Std 1364 Verilog source
// elements that model switches are various forms of transistors, called tran,
// tranif0, tranif1, rtran, rtranif0, and rtranif1. Switch processing shall
// consider all the devices in a bidirectional switch-connected net before it
// can determine the appropriate value for any node on the net, because the
// inputs and outputs interact."
//
// The positive rule: a value driven onto ONE node of a switch-connected net
// reaches every node of it, in either direction through the switches.
//
// DERIVATION. One driver and two bidirectional switches:
//
//   a  <- assign 1'b1
//   tran t1(a, b);        b follows a: 1
//   tran t2(c, b);        c is on the far side of b, listed FIRST so the value
//                         must flow right-to-left through t2: 1
//
// A simulator that treated each tran as a one-way gate from its first terminal
// would leave c undriven (z), since t2's first terminal is c itself; one that
// processed t2 before t1 without considering the whole net would do the same.
// Only whole-net processing, as the clause requires, makes c read 1.
//
// The analog block reads both discrete wires through §7.3.1 Table 7-1, where a
// 1-bit 1 is the integer 1. Checked at t = 10n, well after time zero settles;
// the t = 0 read is a scheduling question this fixture does not ask.
//
//! lrm 8.5.3.5
//! analysis tran
//! time 0, 10n
//! print none
//! xfail VerA accepts `tran` but stamps nothing (W0250), and resolves the switch-connected wires b and c as continuous nets, refusing their digital read with E0315 "net must be read through an access function"; §8.5.3.5 requires the switch network to carry a's value to every node
`timescale 1ns/1ns
`include "check.vh"
module ch8_switch_network_resolved_as_a_whole(out);
  inout out;
  electrical out;
  wire a, b, c;
  assign a = 1'b1;
  tran t1(a, b);
  tran t2(c, b);

  analog begin
    if ($abstime > 5n) begin
      `CHECKI("§8.5.3.5 the value crosses the first switch", b, 1);
      `CHECKI("§8.5.3.5 and the second, against its terminal order", c, 1);
    end
    V(out) <+ c;
  end
endmodule
