// A digital process — an `always` block driven by a signal-valued event control
// (A.6.2, §8.5). It used to be refused as annex C.7 ("no digital behavior or
// events are supported in Verilog-A"); that is a rule of the Verilog-A SUBSET,
// and `always` is a module item of every Verilog-AMS module (A.1.4), so it
// parses now.
//
// VerA's CEILING, named by E0437: the process re-runs on §8.5.1's event queue,
// which VerA does not yet run beside a device. The sibling
// annex_c_analog_subset/14_digital_always_rejected.va records the bare
// `always`; this one records the event-controlled form.
//
//! lrm 8.5
//! reject E0437
//! reject always
module ch8_digital_process;
  integer state;
  always @(state) state = !state;
endmodule
