// DEBT — this rejection is NOT conformance.
// The LRM permits what VerA refuses here. The substrings below record
// CURRENT behavior so the suite stays green on it; they do not claim it
// is right. `zig build ledger` counts this rule against VerA.
//
// VAMS-8.4.3.3-03  (ch8-scheduling.html)
// If connector A detects a positive threshold crossing, the resulting falling edge at connector B generated by the propagation of the signal through ver
//
//! reject unsupported module item
// EXPECT: error -- digital processes are owned by the digital backend.
module ch8_digital_process;
  integer state;
  always @(state) state = !state;
endmodule
