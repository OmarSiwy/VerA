// Annex C.7, verbatim: "The analog behavior defined in Clause 5 are applicable
// to both Verilog-AMS HDL and Verilog-A with the following exceptions: No
// digital behavior or events are supported in Verilog-A."
//
// A digital process -- an `always` block driven by a signal-valued event
// control -- is both of the excluded things at once, so refusing it is the
// CONFORMANT answer for a Verilog-A compiler, not a debt.
//
// The file is therefore a source-form inventory and pins nothing in 8.5: the
// module item is refused before its event control or its body is read, and
// Annex C.10 puts the digital and mixed-signal simulation cycles outside the
// language this tool compiles. The sibling
// annex_c_analog_subset/14_digital_always_rejected.va records the bare
// `always`; this one records the event-controlled form.
//
//! lrm C.7
//! reject E0205
//! reject always
module ch8_digital_process;
  integer state;
  always @(state) state = !state;
endmodule
