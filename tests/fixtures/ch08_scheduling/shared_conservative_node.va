// §8.4.3, verbatim: "A Verilog-AMS simulation consists of a number of analog
// and digital processes communicating via events, shared memory and
// conservative nodes. Analog processes that share conservative nodes are
// 'solved' jointly and can be viewed as a 'macro' process, there may be any
// number 'macro' processes, and it is left up to the implementation whether it
// solves them in a single matrix, multiple matrices or uses other techniques
// but it should abide by the accuracy stipulated in the disciplines and analog
// functions."
//
// "SOLVED JOINTLY" IS THE ONLY SENTENCE IN THE CLAUSE WITH A NUMBER BEHIND IT,
// and it needs TWO processes to say anything at all: one process on one node is
// §8.1's analog macro-process and has its own fixture. Here two modules, each
// with its own analog block, contribute to the SAME node, and the node's value
// is the solution of the two contributions TOGETHER:
//
//     ch8_shared_src:   I(mid) <+ 3.0 * V(mid)
//     ch8_shared_sink:  I(mid) <+ V(mid) - 5.0
//
// KFL sums the flows out of `mid`, so 3.0*V + (V - 5.0) = 0 and V = 1.25. Both
// contributions at that solution are asserted separately, and they are the
// clause's "communicating via ... conservative nodes" made arithmetic: the src
// process pulls 3.75 A in and the sink process pushes exactly 3.75 A back out,
// so the node has nothing left to move. A node that satisfied only one of the
// two would have to be at 0 (the src alone, I = 0) or at 5 (the sink alone).
//
// WHAT A WRONG IMPLEMENTATION PRINTS. This is not a tolerance question. A
// compiler that elaborated the two instances into separate devices — each
// module's analog block with its own private copy of the node — solves
// V = 0 from the src and V = 5 from the sink, and whichever copy the top's
// assertion reads, 0.0 or 5.0 is nowhere near 1.25. A compiler that evaluated
// one instance's block and reused the value for the other prints the same
// number twice, so the two contribution checks below cannot both hold.
//
// THE MATRIX COUNT IS NOT ASSERTED, because §8.4.3 says it is the
// implementation's business — "single matrix, multiple matrices or uses other
// techniques" — and a fixture that demanded one of them would fail a conforming
// compiler. The "accuracy stipulated in the disciplines" half of the sentence is
// a property of the RESOLVED node tolerance, which no expression in this
// language reports; the disciplines half is §6.5.8's and this file does not
// claim it.
//
// WHY THE SOLVE. `//! solve` unties `mid`, the one unknown no line names: the
// two contributions are its only equations, which is what "solved jointly"
// means. The system is linear in the single unknown, so one Newton step from
// the harness's seed lands on 1.25 exactly and CHECKX is the right comparison;
// 3.75 and -3.75 are exact for the same reason.
//
//! lrm 8.4.3
//! lrm 8.4.3:1
//! lrm 8.1
//! lrm 8.1:3
//! lrm 5.2:1
//! solve
//! print none
`include "check.vh"
module ch8_shared_top;
  electrical mid;

  ch8_shared_src u1(mid);
  ch8_shared_sink u2(mid);

  analog begin
    `CHECKX("the shared node satisfies both processes at once", V(mid), 1.25);
    `CHECKX("the src process's contribution at that solution", 3.0 * V(mid), 3.75);
    `CHECKX("and the sink process's, which cancels it", V(mid) - 5.0, -3.75);
  end
endmodule

module ch8_shared_src(p);
  inout p;
  electrical p;

  analog I(p) <+ 3.0 * V(p);
endmodule

module ch8_shared_sink(p);
  inout p;
  electrical p;

  analog I(p) <+ V(p) - 5.0;
endmodule
