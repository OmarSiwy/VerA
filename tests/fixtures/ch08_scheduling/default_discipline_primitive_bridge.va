// 3.8:1000: the default discrete discipline supplies the primitive's
// otherwise unknown lower connection to an electrical net. Only the logic
// connect rule can bridge that connection. The primitive's two logic states
// become distinct loaded analog voltages; an unrelated biased probe cannot
// satisfy these checks.
//
// WHY THE INPUTS ARE WRITTEN AFTER #0. The bridge's `always @(d)` only sees a
// change of `d` it is already waiting for. Written as `assign a = 1'b1;`, the
// gate output's time-zero change and the always block's first arrival at
// `@(d)` are both region-1 events of time 0, which §8.5.1 says "can be
// processed in any order" ("an essential source of nondeterminism"), so a
// conforming kernel that updates the net first leaves `level` at its 1'b0
// seed. §8.5.1: "An explicit zero delay (#0) requires that the process be
// suspended and added as an inactive event", so every process is waiting at
// its first event control when `sa`/`sb`, and through the assignments and
// the gates, `d` change. ch07_mixed_signal/both_halves_of_the_bridge_execute
// fixes its own selects the same way.
//! lrm 3.8:1000
//! solve
//! checks 2
`include "check.vh"
connectmodule default_primitive_d2a(d, e);
  input d; logic d;
  output e; electrical e;
  reg level;
  initial level = 0;
  always @(d) level = d;
  analog I(e) <+ (V(e) - ((level === 1'b1) ? 2.0 : 0.5))/1000.0;
endmodule
`default_discipline logic
module default_discipline_primitive_bridge;
  electrical high, low;
  wire a, b;
  reg sa, sb;
  assign a = sa;
  assign b = sb;
  initial begin #0; sa = 1'b1; sb = 1'b0; end
  and high_gate(high, a, a);
  and low_gate(low, a, b);
  analog begin
    I(high) <+ V(high)/1000.0;
    I(low) <+ V(low)/1000.0;
    `CHECK("default logic discipline bridges the high primitive output", V(high), 1.0, 1e-12);
    `CHECK("the low primitive output remains distinct", V(low), 0.25, 1e-12);
  end
endmodule
`default_discipline
connectrules default_primitive_rules;
  connect default_primitive_d2a;
endconnectrules
