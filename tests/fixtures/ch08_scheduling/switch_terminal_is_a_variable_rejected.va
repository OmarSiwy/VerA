// §8.5.3.5: "Switches provide bi-directional signal flow and require
// coordinated processing of nodes connected by switches. ... Switch processing
// shall consider all the devices in a bidirectional switch-connected NET before
// it can determine the appropriate value for any node on the net, because the
// inputs and outputs interact."
//
// What a pass switch joins is nets, and A.3.3 says so in the grammar this LRM
// prints for the instance:
//
//   pass_switch_instance ::= [ name_of_gate_instance ]
//                            ( inout_terminal , inout_terminal )
//   inout_terminal       ::= net_lvalue
//
// `r` is a `reg`. A variable is not a net_lvalue: it is not resolved from
// drivers, so there is no "switch-connected net" for the switch to be a device
// of, and the relaxation the clause describes has nothing to relax on that
// side. `tran t0(r, w)` is outside the grammar.
//
// The positive half is `switch_network_resolved_as_a_whole.va` in this
// directory, whose `tran` network joins `wire`s and asserts the resolved value.
//
// WHAT THIS PINS THAT NOTHING ELSE DID. Before 2026-09-24 VerA accepted this
// module (E0483 is new).
//
//! lrm 8.5.3.5
//! lrm A.3.3
//! lrm A.3.3:1000
//! reject-only E0483
//! neighbour switch_network_resolved_as_a_whole.va
`timescale 1ns/1ns
`include "disciplines.vams"
module ch8535_tran_reg(p);
  inout p;
  electrical p;
  reg r;
  wire w;

  initial r = 1'b1;

  tran t0(r, w);

  analog I(p) <+ V(p) / 1k;
endmodule
