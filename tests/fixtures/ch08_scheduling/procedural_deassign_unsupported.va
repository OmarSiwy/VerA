// A.6.2 `procedural_continuous_assignment ::= deassign variable_lvalue`. A
// deassign ends the procedural continuous assignment an `assign` began, after
// which the variable holds its last value until something drives it again — a
// statement about §8.5's simulation cycle from end to end.
//
// VerA'S CEILING, NAMED, and no longer annex C's. `reg` and the digital `initial`
// block are legal Verilog-AMS (A.2.1.3, A.6.2) and VerA accepts both now, so the
// C.7 subset argument this file used to make ("no digital behavior or events are
// supported in Verilog-A") is a rule of the SUBSET and not VerA's dialect. What is
// left belongs to this compiler: there is no statement production for `assign` or
// for `deassign`, so each keyword lands where an expression was expected. Both are
// reported — the parser resynchronises at the `;` — which is why the pin can still
// name the construct.
//
// The pin is the CODE plus the construct. `reject reg` and `reject initial` are
// what this file used to carry, and both matched only the prose of E0205's
// "found `reg`" message — a verdict resting on a diagnostic's wording rather than
// on which rule fired.
//
//! lrm 8.5
//! reject E0209
//! reject deassign
module ch8_procedural_deassign;
  reg source, target;
  initial begin
    assign target = source;
    deassign target;
  end
endmodule
