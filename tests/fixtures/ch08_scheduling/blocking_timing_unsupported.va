// A.6.4 `blocking_assignment ::= variable_lvalue = [ delay_or_event_control ]
// expression`, and A.6.5's `procedural_timing_control_statement` around one. All
// three lines below are §8.5 timing controls: a statement delay, an intra-
// assignment delay, and an event control. Each of them SUSPENDS the process, and
// suspending is the one thing that needs the digital event queue by definition —
// there is nowhere else to put a process that is waiting.
//
// VerA'S CEILING, NAMED, and no longer annex C's or the grammar's. A.6.2 makes
// the body of an `initial` block A.6.4's `statement`, whose timing forms are
// grammar in every module, so all three lines PARSE now (they used to be E0209,
// "expected an expression", which was a claim about the analog statement
// production and not about this block). What refuses them is E0433: an initial
// block VerA can lower on its own is a run of constant assignments, and each of
// these three suspends the process, which only §8.5's event queue can do. The
// code is the pin; it moves when the mixed-signal runner executes the block.
//
//! lrm 8.5
//! reject E0433
module ch8_blocking_timing;
  reg source, target;
  initial begin
    #1 target = source;
    target = #1 source;
    @(source) target = source;
  end
endmodule
