// §8.4.1 Circuit initialization, verbatim: "It is a one time execution of
// nodeset statements (3.6.3.2), then the procedural statements in analog
// initial block, and then the procedural statements in the Verilog initial
// block for time zero."
//
// THE OBSERVATION analog_digital_initial_order.va could not make. That file
// reads both initial blocks from the analog block and so can only show that
// both ran; §5.2.1 forbids the analog initial block to read a digital value,
// so the order cannot be seen from that side. It CAN be seen from the other:
// §7.3.3 "Continuous variables can be accessed for reading from any discrete
// context in the same module where these variables are declared."
//
// `av` is continuous: only the analog initial block assigns it, 2.5. `copy` is
// discrete: only the digital initial block assigns it, `copy = av`. In §8.4.1's
// order the analog initial block has already run when the digital one reads,
// so copy = 2.5. A tool that ran the digital initial block first would copy
// §3.2's 0.0 for an analog real that has not yet been assigned, and an initial
// block runs once, so copy would stay 0.0 for the whole analysis. Both the
// analog and the digital time are zero when the read happens, so §7.3.3's
// interpolation clause has nothing to interpolate. 2.5 is exact in binary.
//
// `tick` gives the module a second digital process with a delay, which makes
// it a mixed-signal one: a digital initial block reading a continuous variable
// has no constant reading and runs on the digital kernel. Nothing reads tick.
//
//! xfail `copy = av` now runs on the digital kernel (f14d4500), but reads av before the analog initial block assigns it: copy = 0 at every point, not 2.5. The mixed runner also solves at tick's events (3, 6, 9 ns), so the transcript has 6 points against `checks 3`, which counts the declared points only
//! lrm 8.4.1
//! lrm 8.4.1:1000
//! lrm 7.3.3
//! analysis tran
//! time 0, 5n, 10n
//! checks 3
`timescale 1ns/1ns
`include "check.vh"
module b3_analog_initial_before_digital_initial(p);
  inout p; electrical p;
  real av;                 // continuous: assigned only by the analog initial block
  real copy;               // discrete: assigned only by the digital initial block
  reg  tick;
  analog initial av = 2.5;
  initial begin
    copy = av;
    tick = 1'b0;
  end
  always #3 tick = ~tick;
  analog begin
    `CHECKX("the digital initial block read what the analog initial block assigned", copy, 2.5);
    I(p) <+ 0.0;
  end
endmodule
