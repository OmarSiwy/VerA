// LRM 4.5.4: "When used in DC or IC analyses, idt() returns the initial
// condition (ic) if specified." The integrator's internal state is therefore
// pinned by the ic and not by its argument at the operating point.
//
// The contributed integrator has ic = 0.0, so it contributes 0 A. The second
// probe carries ic = 2.5 with the SAME argument, which is what makes the rule
// falsifiable: an implementation that integrates the argument instead of
// honouring the ic would answer alike for both, and one that returned V(p)*t or
// V(p) would answer 0 or 1.0 rather than 2.5.
//
//! lrm 4.5.4
//! lrm 8.3.1
//! bias V(p) = 1.0
`include "check.vh"
module ch8_integrator(p);
  inout p; electrical p;
  analog begin
    `CHECKX("idt in dc returns its ic, not its integrand", idt(V(p), 2.5), 2.5);
    `CHECKX("and an ic of zero makes the dc contribution zero", idt(V(p), 0.0), 0.0);
    I(p) <+ idt(V(p), 0.0);
  end
endmodule
