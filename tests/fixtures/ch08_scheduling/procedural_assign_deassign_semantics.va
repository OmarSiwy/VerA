// §8.5.3.2, verbatim: "A procedural continuous assignment (which is the assign
// or force statement; see 9.3 of IEEE Std 1364 Verilog) corresponds to a
// process that is sensitive to the source elements in the expression." And:
// "A deassign or a release statement deactivates any corresponding assign or
// force statement(s)."
//
// procedural_continuous_semantics.va is the force/release half. This is the
// assign/deassign half, where IEEE 1364-2005 §9.3.1 adds the two rules that
// separate it from force: "The assign procedural continuous assignment
// statement shall override all procedural assignments to a variable", and
// after a deassign "the variable shall retain the assigned value until the
// variable is assigned a new value through a procedural assignment".
//
// DERIVATION, one `initial` block, no `timescale (so a unit is one second):
//
//     t = 0    source = 0; assign target = source;   target = 0
//     t = 5    source = 1                  the process follows: target = 1
//     t = 7    target = 0 (procedural)     overridden by the assign: still 1
//     t = 10   deassign target             deactivated; target keeps 1
//     t = 20   source = 0                  nothing follows it: still 1
//
// So target is 1 at every analysed time after t = 5. Each broken reading
// gives 0 somewhere: no process (target stays 0 from t = 0), a procedural
// write that beats the assign (0 at t = 8), a deassign that deactivates
// nothing (0 at t = 25). The `($abstime > 6.0)` guard keeps the t = 0 row,
// whose §8.4.1 interleaving is not fixed, out of the claim.
//
// This file replaces procedural_assign_unsupported.va and
// procedural_deassign_unsupported.va, which pinned VerA's E0209 on the two
// keywords while the parser had no statement production for them.
//
//! lrm 8.5.3.2
//! lrm 8.5.3.2:1000
//! analysis tran
//! time 0, 8, 25
`include "check.vh"
module ch8_procedural_assign_deassign(p);
  inout p;
  electrical p;

  reg source, target;

  initial begin
    source = 1'b0;
    assign target = source;
    #5 source = 1'b1;
    #2 target = 1'b0;
    #3 deassign target;
    #10 source = 1'b0;
  end

  analog begin
    `CHECKI("the assign followed its source over a procedural write, and the deassign kept its value",
            ($abstime > 6.0) ? target : 1'b1, 1);
    I(p) <+ V(p);
  end
endmodule
