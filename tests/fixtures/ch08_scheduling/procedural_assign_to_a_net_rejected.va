// §8.5.3.2: "A procedural continuous assignment (which is the assign or force
// statement; see 9.3 of IEEE Std 1364 Verilog) corresponds to a process that is
// sensitive to the source elements in the expression. When the value of the
// expression changes, it causes an active update event to be added to the event
// queue, using current values to determine the target. A deassign or a release
// statement deactivates any corresponding assign or force statement(s)."
//
// The clause names two statements and they do not take the same targets. A.6.2,
// as this LRM prints it:
//
//   procedural_continuous_assignments ::=
//           assign variable_assignment
//         | deassign variable_lvalue
//         | force variable_assignment
//         | force net_assignment
//         | release variable_lvalue
//         | release net_lvalue
//   variable_assignment ::= variable_lvalue = expression
//
// `force` and `release` reach a net; `assign` and `deassign` reach only a
// variable. `w` is a `wire`, so `assign w = ...` inside the `initial` block is
// outside the grammar: the procedural `assign` overrides a VARIABLE's
// procedural writes (IEEE 1364 §9.3.1), and a net has none to override — its
// value is its drivers' resolution. (The same statement with `force` in place of
// `assign` is legal, and is the reason the rule has to look at which keyword
// was written, not at the shape.)
//
// The positive half is `procedural_assign_deassign_semantics.va` in this
// directory, which assigns and deassigns a `reg` and asserts the values.
//
// WHAT THIS PINS THAT NOTHING ELSE DID. Before 2026-09-24 VerA accepted this
// module and handed the kernel a procedural assign to a net (E0482 is new).
//
//! lrm 8.5.3.2
//! lrm A.6.2
//! lrm A.6.2:1000
//! reject-only E0482
//! neighbour procedural_assign_deassign_semantics.va
`timescale 1ns/1ns
`include "disciplines.vams"
module ch8532_assign_wire(p);
  inout p;
  electrical p;
  wire w;
  reg d;

  initial begin
    d = 1'b1;
    #5 assign w = d;
  end

  analog I(p) <+ V(p) / 1k;
endmodule
