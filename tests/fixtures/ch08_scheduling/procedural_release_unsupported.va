// A.6.2 `procedural_continuous_assignment ::= release variable_lvalue`. A release
// drops a force and schedules whatever the ordinary drivers then resolve to —
// §8.5's event queue, twice over: the drop and the re-resolution.
//
// VerA'S CEILING, NAMED, and no longer annex C's. `reg` and the digital `initial`
// block are legal Verilog-AMS (A.2.1.3, A.6.2) and VerA accepts both now, so the
// C.7 subset argument this file used to make ("no digital behavior or events are
// supported in Verilog-A") is not the reason and never was VerA's dialect. What
// is left is narrower and belongs to this compiler: there is no statement
// production for `force` or for `release`, so each keyword lands where an
// expression was expected. Both are reported — the parser resynchronises at the
// `;` — which is why the pin can still name the construct.
//
// The pin is the CODE plus the construct. `reject reg` and `reject initial` are
// what this file used to carry, and both matched only the prose of E0205's
// "found `reg`" message: a verdict resting on a diagnostic's wording rather than
// on which rule fired, and one that changed the day the wording did.
//
//! lrm 8.5
//! reject E0209
//! reject release
module ch8_procedural_release;
  reg source, target;
  initial begin
    force target = source;
    release target;
  end
endmodule
