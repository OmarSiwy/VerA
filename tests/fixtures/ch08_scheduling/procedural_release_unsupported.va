//! reject unsupported module item
// EXPECT: error -- release removes a force and schedules the resulting value.
module ch8_procedural_release;
  reg source, target;
  initial begin
    force target = source;
    release target;
  end
endmodule
