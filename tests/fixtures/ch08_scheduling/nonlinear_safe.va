// LRM 8.3.3 convergence is why this operator exists: the behavioral description
// is evaluated iteratively and "models need to be written so they do something
// reasonable even when given unreasonable signal values". LRM 4.5.13 answers
// that for the exponential — limexp() limits how far its output may move per
// iteration, but "the apparent behavior of limexp() is not distinguishable from
// exp()", and "the simulator can only converge when the output of limexp()
// equals the exponential of the input".
//
// WHY THE IDENTITY AND NOT THE DIGITS. exp(0.5) = 1.6487212707001282, and an
// earlier version of this file pinned limexp() to it at a single bias
// evaluation. That over-specifies. 4.5.13 fixes the value only AT CONVERGENCE
// -- "the simulator can only converge when the output of limexp() equals the
// exponential of the input" -- and says outright that "there are different ways
// of implementing limiting algorithms for the exponential". A testbench that
// evaluates one bias point carries no Newton history, which is precisely the
// un-converged first iteration where a conformant limiter is entitled to damp
// its output. Writing 1.6487212707001282 here would fail any future
// implementation that actually limits, which is the one thing the operator is
// specified to do.
//
// So the assertion is the identity the clause states with no value attached --
// the README's stated use for CHECKEQ -- and the digits stay only on the
// literal the LRM does fix, the 1m scale factor of 2.5.1.
//
//! lrm 8.3.3
//! lrm 4.5.13
//! bias V(p) = 0.5
`include "check.vh"
module ch8_nonlinear(p, n);
  inout p, n; electrical p, n;
  parameter real scale = 1m;
  analog begin
    `CHECKX("the 1m scale factor", scale, 0.001);
    `CHECKEQ("limexp equals the exponential at the converged solution",
             limexp(V(p, n)), exp(V(p, n)), 1e-12);
    I(p, n) <+ scale * limexp(V(p, n));
  end
endmodule
