// LRM 8.3.3 convergence is why this operator exists: the behavioral description
// is evaluated iteratively and "models need to be written so they do something
// reasonable even when given unreasonable signal values". LRM 4.5.13 answers
// that for the exponential — limexp() limits how far its output may move per
// iteration, but "the apparent behavior of limexp() is not distinguishable from
// exp()", and "the simulator can only converge when the output of limexp()
// equals the exponential of the input".
//
// WHY THE DIGITS ARE WRITABLE HERE. Limiting damps INTERMEDIATE iterations
// only: 4.5.13 says that "on any iteration where the change in the output of
// the limexp() function is bounded, the simulator is prevented from
// terminating the iteration", so a damped output is by construction never a
// reported solution. Every number this harness prints IS the reported solution
// for its operating point, and at a solution 4.5.13 leaves the limiter no
// freedom at all -- limexp(x) equals exp(x). So the value is fixed by the
// clause and gets written out: exp(0.5) = 1.6487212707001282.
//
// An earlier version wrote this as `CHECKEQ(limexp(V(p,n)), exp(V(p,n)), 1e-12)`
// to leave room for a limiter. It does not: CHECKEQ is abs(GOT-WANT) <= TOL,
// and at 1e-12 (6e-13 relative) any implementation that damped its output here
// would fail it by exactly the margin the literal fails it by. The relational
// form bought no robustness and only dropped the derived digit, so it is back
// as a literal, with the tolerance sized for a conformant exp() that is a few
// ulp off the correctly-rounded double rather than bit-identical to it.
//
// The second literal is the 1m scale factor of 2.6.2 Table 2-1.
//
// The first criterion's last sentence is the one a model can read back: "reltol
// is set as a simulator option and typically has a value of 0.001." The host
// writes the §9.15 host field `reltol__` from `//! param` below, and
// `$simparam("reltol")` returns the option the iteration criterion consults. A
// tool with no reltol option, or one that answered something other than the
// host's value, fails the check. The per-iteration inequality itself has no
// source-level observer; it is asserted by the solver's acceptance-gate unit
// test registered as the specialized evidence for this sentence.
//
//! lrm 8.3.3
//! lrm 8.3.3:1
//! lrm 4.5.13
//! lrm 2.6.2
//! param reltol__ = 1e-3
//! bias V(p) = 0.5
`include "check.vh"
module ch8_nonlinear(p, n);
  inout p, n; electrical p, n;
  parameter real scale = 1m;
  analog begin
    `CHECKX("reltol is a simulator option, holding the host's value",
            $simparam("reltol"), 1e-3);
    `CHECKX("the 1m scale factor", scale, 0.001);
    `CHECK("limexp equals the exponential at the reported solution",
           limexp(V(p, n)), 1.6487212707001282, 1e-15);
    I(p, n) <+ scale * limexp(V(p, n));
  end
endmodule
