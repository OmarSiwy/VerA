// Host-only input: the discrete sample at 15 ns is taken while the actual
// analog kernel is at 18 ns, bracketed by accepted 10 ns and 18 ns solutions.
// Free x must interpolate to1.5; event-assigned held must retain1.0.
`timescale 1ns/1ns
`include "disciplines.vams"
module continuous_variable_interpolation_host(p);
  inout p; electrical p;
  real x, held, sampled_x, sampled_held;
  initial begin
    sampled_x = -1.0; sampled_held = -1.0;
    #15 begin
      sampled_x = x;
      sampled_held = held;
      $display("variable-interpolation x=%g held=%g", sampled_x, sampled_held);
    end
  end
  analog begin
    V(p) <+ $abstime * 1.0e8;
    x = V(p);
    @(timer(10n, 100n)) held = V(p);
  end
endmodule
