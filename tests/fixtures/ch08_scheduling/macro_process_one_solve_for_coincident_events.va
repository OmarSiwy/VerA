// §8.5.3.7: "An analog macro-process event is evaluated by calling the analog
// engine to solve the associated analog macro-process. Note that if multiple
// events for a particular analog macro-process are active, then a single
// evaluation of the analog macro-process shall consume all of these events
// from the queue."
//
// §8.5: a change of a digital variable the analog block reads unguarded is
// an implicit D2A event that causes a macro-process event, and §8.5.1 runs
// region 3b after region 1, so both blocking assignments of the tick below
// land before the solve. §8.4.7: "Digital to analog events shall cause an
// analog solution of the time where they occur."
//
// THE CONSTRUCTION. At tick 3 (`timescale 1ns/1ns`, not a declared point) one
// process sets q1 and then q2. Each change is an active macro-process event
// for the same analog block, so ONE evaluation at 3 ns consumes both. Counted
// by the evaluations the device reports (one CHECK per accepted solution):
//
//     declared 0, 2, 4, 6 ns   + the D2A solution at 3 ns   = 5 solutions
//
// and every one of them sees both or neither of the changes:
//
//     q1 + q2 = 0 before 3 ns, 2 from 3 ns on.
//
// A tool that evaluated the macro-process once per event would report two
// solutions at 3 ns (6 checks), the first one seeing q1 + q2 = 1 (ok=0).
// 0, 1 and 2 are exact, so the tolerance is CHECKX's.
//
//! lrm 8.5.3.7
//! lrm 8.5.3.7:1
//! lrm 8.4.7:1
//! analysis tran
//! time 0, 2n, 4n, 6n
//! checks 5
`timescale 1ns/1ns
`include "check.vh"
module macro_process_one_solve_for_coincident_events(vo);
  inout vo; electrical vo;
  reg q1, q2;
  initial begin
    q1 = 1'b0;
    q2 = 1'b0;
    #3 q1 = 1'b1;
    q2 = 1'b1;
  end
  analog begin
    `CHECKX("one evaluation at 3 ns consumes both events",
            (q1 ? 1.0 : 0.0) + (q2 ? 1.0 : 0.0), ($abstime < 3n) ? 0.0 : 2.0);
    V(vo) <+ (q1 ? 1.0 : 0.0) + (q2 ? 1.0 : 0.0);
  end
endmodule
