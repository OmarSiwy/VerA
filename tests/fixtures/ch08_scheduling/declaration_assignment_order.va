// LRM 8.2 simulation initialization, verbatim: "It is during this process that
// module-level variable declaration assignments are evaluated FOLLOWED BY the
// execution of analog initial blocks. Once analog initial blocks are evaluated,
// analog net declaration assignments and simulator nodeset values are then
// applied."
//
// That is an ordering with two edges, and the chapter's analog_initial_order.va
// pins only the second (analog initial before the ordinary analog block): it
// declares `real initialized;` with no initializer at all, so the first edge --
// declaration assignment before analog initial -- is not exercised there or
// anywhere else in the tree.
//
// This file pairs the two. `seed` carries a declaration assignment and the
// analog initial block READS it, so the order is observable in a single number:
//
//   correct order  seed = 2.5 evaluated first, then scaled = 2.5 * 2.0 = 5.0
//   reversed       analog initial runs first and reads the 3.2 default 0.0,
//                  so scaled = 0.0
//
// Both are exact in binary and 5.0 is nowhere near 0.0, so the discriminator is
// unambiguous. The second check pins that the initializer SURVIVED -- a tool
// that re-applied declaration assignments after the analog initial block would
// still show seed = 2.5, but one that never applied it at all shows 0.0 and is
// caught here rather than only by inference from the first line.
//
//! lrm 8.2
//! lrm 8.2:1
//! lrm 8.2:1001
`include "check.vh"
module ch8_decl_assign_order(p);
  inout p; electrical p;
  real seed = 2.5;
  real scaled;
  analog initial scaled = seed * 2.0;
  analog begin
    `CHECKX("the declaration assignment ran before the analog initial block", scaled, 5.0);
    `CHECKX("and the initializer itself is intact", seed, 2.5);
    I(p) <+ 0.0;
  end
endmodule
