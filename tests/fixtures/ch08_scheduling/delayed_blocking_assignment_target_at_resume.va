// §8.5.3.3, third sentence: "The values at the time the process resumes are
// used to determine the target(s)."
//
// The first sentence fixes the other half: a blocking assignment "with a delay
// computes the right-hand side value using the current values, then causes the
// executing process to be suspended and scheduled as a future event."
// blocking_assignment_delay.va pins the right-hand side with a fixed target.
// This fixture pins the TARGET: the index is read when the process resumes.
//
//   t = 0   v = 2'b00; i = 0; v[i] = #5 1'b1;  process 1 suspends until 5 ns
//   t = 1   i = 1;                             process 2 runs while 1 is pending
//   t = 5   process 1 resumes; the target index is read NOW, i == 1
//
// so v[1] becomes 1 and v[0] keeps 0. A tool that evaluates `v[i]` when the
// assignment is scheduled writes v[0] and leaves v[1] at 0 — the two checks
// swap.
//
// THE SECOND INITIAL IS A SEPARATE PROCESS ON PURPOSE. A blocking assignment
// with a delay suspends its own process, so an `i = 1` written after it in the
// same block would run at 5 ns, after the assignment had chosen its target.
//
// `reg [1:0] v` is read in the analog block, a discrete value carried into the
// continuous context (§7.3.2, Table 7-1). 0 and 1 are exact, so CHECKI.
//
//! lrm 8.5.3.3
//! lrm 8.5.3.3:1002
//! analysis tran
//! time 0, 5n, 6n, 10n
`timescale 1ns/1ns
`include "check.vh"
module ch8_delayed_blocking_target(p);
  inout p; electrical p;
  integer i;
  reg [1:0] v;

  initial begin
    v = 2'b00;
    i = 0;
    v[i] = #5 1'b1;
  end

  initial
    #1 i = 1;

  analog begin
    `CHECKI("the target index is evaluated when the assignment resumes",
            ($abstime >= 5n) ? v[1] : 0, ($abstime >= 5n) ? 1 : 0);
    `CHECKI("the index the target had when scheduled is not written",
            ($abstime >= 5n) ? v[0] : 0, 0);
    I(p) <+ V(p);
  end
endmodule
