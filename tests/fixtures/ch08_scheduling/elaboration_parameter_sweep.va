// LRM 8.2 has two sentences about elaboration, and this file is the pair of
// them:
//
//   "Elaboration is the process where the system is hierarchically
//    instantiated. During this process, as each design element is elaborated,
//    PARAMETER DECLARATION ASSIGNMENTS ARE EVALUATED and module-level generate
//    constructs expanded."
//
//   "It is important to note that for parametric sweep type analyses like dc
//    sweep, the tool SHALL RE-EVALUATE the Elaboration and Pre-simulation steps
//    as outlined in Figure 8-1 FOR EACH SWEEP POINT to ensure that all
//    parameter value changes are captured."
//
// So a DERIVED parameter -- one whose declaration assignment reads another
// parameter -- is final before pre-simulation begins, and is recomputed from
// scratch at every sub-task of a sweep. 6.3.4 is the parameter-value half of
// the same rule.
//
// The chapter's other sweep fixture, analog_initial_parameter_sweep.va, sweeps
// a parameter that nothing derives from, so it exercises the Pre-simulation
// step only. This one derives `area` from the swept `w` and asserts in the
// ORDINARY analog block, deliberately NOT in an analog initial block, so the
// file is independent of the initial-block re-execution defect that one
// documents. Elaboration is the only thing under test here.
//
//   w = 1.0  ->  area = 1.0
//   w = 2.0  ->  area = 4.0
//   w = 4.0  ->  area = 16.0
//
// All three exact in binary (squares of powers of two). The primary want is the
// sweep-INVARIANT literal area/(w*w) = 1.0, which holds at every sub-task and
// which an elaboration frozen at the first sweep point -- area stuck at 1.0 --
// answers 0.25 and then 0.0625. The second line is the row-invariant backstop:
// once w is past 1.5 the area cannot still be the first point's 1.0.
//
// 8.2:1002's other half is "module-level generate constructs expanded". The
// generate loop below makes two cells, each with its own parameter declaration
// assignment; they inject -1 A and -2 A into p and the top's 1 S load holds
// V(p) = 3 V. Zero expanded copies give 0 V, one gives 1 V, and a copy whose
// override was never evaluated gives 3 V less than its share. The overrides are
// constants (k + 1), so this check is about expansion and parameter assignment
// at elaboration, not the per-sweep re-derivation the two checks above cover;
// 3.0 is exact in the trivial linear solve.
//
//! lrm 8.2
//! lrm 8.2:2
//! lrm 8.2:1002
//! lrm 6.3.4
//! lrm 6.3.4:1000
//! psweep w = 1.0, 2.0, 4.0
// Three assertions at each of the three sweep points; omitting a point must fail.
//! checks 9
//! analysis dc
//! solve
//! print none
`include "check.vh"
module ch8_elaboration_psweep(p);
  inout p; electrical p;
  parameter real w = 1.0 from (0:inf);
  parameter real area = w * w;
  genvar k;
  generate
    for (k = 0; k < 2; k = k + 1) begin : g
      ch8_elab_psweep_cell #(.scale(k + 1.0)) u(.p(p));
    end
  endgenerate
  analog begin
    `CHECKX("a derived parameter is re-elaborated at every sweep sub-task", area / (w * w), 1.0);
    `CHECKI("the derived value is not frozen at the first sub-task", (w > 1.5) ? (area > 3.5) : 1, 1);
    `CHECKX("both generate copies expanded with their parameter assignments", V(p), 3.0);
    I(p) <+ V(p);
  end
endmodule

module ch8_elab_psweep_cell(p);
  inout p; electrical p;
  parameter real scale = 0.0;
  analog I(p) <+ -scale;
endmodule
