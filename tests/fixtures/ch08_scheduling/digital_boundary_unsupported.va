// Annex C.7, verbatim: "The analog behavior defined in Clause 5 are applicable
// to both Verilog-AMS HDL and Verilog-A with the following exceptions: No
// digital behavior or events are supported in Verilog-A."
//
// VerA is a Verilog-A compiler, so refusing the `always` module item here is
// the CONFORMANT answer, not a debt. This file is a source-form inventory: it
// records that the A/D boundary construct is refused, and nothing more.
//
// In particular it pins NOTHING in 8.4.3.3. The diagnostic fires on the module
// item before its body is read, so the cross() threshold, the 5.2e-9 -> 5.0e-9
// rounding and the 0.5 ns bound that are the whole content of that clause are
// never reached. 8.4.3.3 is AMS-only per Annex C.10 ("The mixed-signal
// simulation cycle from 8.2 is only applicable to Verilog-AMS HDL"), so there
// is no Verilog-A fixture to write for it.
//
//! lrm C.7
//! reject E0205
//! reject always
module ch8_boundary(p);
  inout p; electrical p; integer d;
  always @(cross(V(p) - 0.5, +1)) d = 1;
endmodule
