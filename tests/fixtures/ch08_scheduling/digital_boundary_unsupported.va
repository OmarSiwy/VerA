// DEBT — this rejection is NOT conformance.
// The LRM permits what VerA refuses here. The substrings below record
// CURRENT behavior so the suite stays green on it; they do not claim it
// is right. `zig build ledger` counts this rule against VerA.
//
// VAMS-8.4.3.3-01  (ch8-scheduling.html)
// Consequently an A2D event that results in a D2A event being scheduled with zero (0) delay, shall have its effect propagated back to the analog kernel
// VAMS-8.4.3.3-02  (ch8-scheduling.html)
// If the circuit shown in Figure 8-3 is being simulated with a digital time resolution of 1e-9 (one (1) nanosecond) then all digital events shall be rep
// VAMS-8.4.3.3-03  (ch8-scheduling.html)
// If connector A detects a positive threshold crossing, the resulting falling edge at connector B generated by the propagation of the signal through ver
// VAMS-8.4.3.3-04  (ch8-scheduling.html)
// Example: If A detects a positive crossing as a result of a transient solution at time 5.2e-9, the digital kernel shall report a rising edge at A at ti
// … and 2 more rule(s); see tests/lrm-rules/
//
//! reject unsupported module item
// EXPECT: error -- an A2D/D2A boundary needs a digital process.
module ch8_boundary(p);
  inout p; electrical p; integer d;
  always @(cross(V(p) - 0.5, +1)) d = 1;
endmodule
