// §7.3.6.1 / §8.4.3.3: an `always` block waiting on `cross()` is an A/D boundary
// — the digital process wakes at "the nearest digital time tick to the time of
// the analog event". This used to be refused as annex C.7 ("no digital behavior
// or events are supported in Verilog-A"), which is a rule of the Verilog-A
// SUBSET and not of the Verilog-AMS VerA compiles: `always` is a module item of
// every module (A.1.4) and parses now.
//
// VerA's CEILING, named by E0437: running the process needs §8.5's event queue
// and an analog-event monitor that posts the A2D event onto it. The fixture
// pins NOTHING in 8.4.3.3 — the refusal lands on the module item, before the
// threshold or the 5.2e-9 -> 5.0e-9 rounding is read. The positive rows for
// those are ch07_mixed_signal/m01_09 and m02_04.
//
//! lrm 8.5
//! reject E0437
module ch8_boundary(p);
  inout p; electrical p; integer d;
  always @(cross(V(p) - 0.5, +1)) d = 1;
endmodule
