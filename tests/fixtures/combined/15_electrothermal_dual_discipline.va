// Annex D.1: one module carrying TWO disciplines. `electrical` binds Voltage
// (access V) over Current (access I); `thermal` binds Temperature (access Temp,
// units K) over Power (access Pwr, units W). Each access function must reach
// its own nature on its own net — the point of the fixture is that they do not
// alias each other.
//
// The testbench holds the thermal net at 350 K and the electrical pair at 2 V,
// so Temp(heat) is 350 and V(p,n) is 2. Then the two flows are arithmetic:
//
//   I(p,n)   = 2 V / 1 kOhm            = 2 mA
//   Pwr(heat) = 2^2 / 1 kOhm           = 4 mW   (Joule heating, LRM 5.4.1)
//   plus     Temp(heat) / 1e3 = 350/1e3 = 0.35 W (the linear conductance to
//                                                 ambient this model uses)
//
// 2, 4 and 350 are exact in binary and 1e3 is a power of ten, so only the
// division introduces rounding; a relative tolerance at the ulp covers it.
//
//! bias V(p) = 2.0
//! bias heat = 350.0
`include "check.vh"
module combined_electrothermal_dual_discipline(p, n, heat);
  inout p, n; electrical p, n;
  inout heat; thermal heat;
  parameter real resistance = 1k from (0:inf);
  analog begin
    `CHECKX("Temp() probes the thermal net's potential, held at 350 K", Temp(heat), 350.0);
    `CHECKX("V() probes the electrical pair, held at 2 V", V(p,n), 2.0);
    `CHECKR("electrical flow: 2 V / 1 kOhm", V(p,n) / resistance, 2e-3, 1e-15);
    `CHECKR("Joule heating: 2^2 / 1 kOhm watts", V(p,n) * V(p,n) / resistance, 4e-3, 1e-15);
    `CHECKR("thermal conductance term: 350 K / 1e3", Temp(heat) / 1e3, 0.35, 1e-15);
    I(p,n) <+ V(p,n) / resistance;
    Pwr(heat) <+ V(p,n) * V(p,n) / resistance;
    Pwr(heat) <+ Temp(heat) / 1e3;
  end
endmodule
