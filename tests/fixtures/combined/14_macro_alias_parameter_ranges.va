// LRM 10.3 (`define with arguments) and 3.4.7 (aliasparam).
//
// The macro is TEXT substitution, so its parentheses are load-bearing. With the
// body as written, `SQUARE(1.0 + 2.0) expands to ((1.0 + 2.0) * (1.0 + 2.0)) =
// 9. Drop either pair and the same call expands to 1.0 + 2.0*1.0 + 2.0 = 5 — so
// 9, and not 5, is the assertion that substitution is textual and that the
// guarding parentheses survived it.
//
// §3.4.7 permits `gain` only as an override name: the host supplies gain=3,
// and equations must read the original `scale`, giving 3 rather than its
// default 2. The old alias reads were forbidden; their acceptance claim moves
// to ch03_data_types/aliasparam_equation_rejected.va.
//
// The contribution then follows: 3.0 * 1.5^2 + 0.1 = 6.75 + 0.1 = 6.85. 1.5 and
// 2.25 are exact in binary; 0.1 is not, hence the tolerance on the sum.
//
//! param gain = 3.0
//! bias V(p) = 1.5
`include "check.vh"
`define SQUARE(value) ((value) * (value))
module combined_macro_alias_parameter_ranges(p, n);
  inout p, n; electrical p, n;
  parameter real scale = 2.0 from (0:inf) exclude 10.0;
  aliasparam gain = scale;
  parameter real offset = 0.1 from [-1:1];
  analog begin
    `CHECKX("the alias override reaches the original scale", scale, 3.0);
    `CHECKX("textual expansion keeps its parens: SQUARE(1.0+2.0) is 9, not 5", `SQUARE(1.0 + 2.0), 9.0);
    `CHECKX("SQUARE squares the probe: 1.5 volts squared", `SQUARE(V(p,n)), 2.25);
    `CHECK("scale*V^2 + offset at 1.5 V", scale * `SQUARE(V(p,n)) + offset, 6.85, 1e-12);
    I(p,n) <+ scale * `SQUARE(V(p,n)) + offset;
  end
endmodule
