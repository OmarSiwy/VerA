// LRM 9.17.3 ($limit with the built-in "pnjlim" algorithm), 4.5.13 (limexp) and
// 9.10 ($vt).
//
// $vt is kT/q. At the declared 300 K that is 25.852 mV whichever annex D
// constant set is in force: the CODATA-1998 pair gives 0.0258520269 V and the
// 2018 pair 0.0258519998 V, which agree to 1e-5 relative — so 0.025852 pins it
// without picking a side.
//
// 9.17.3's "pnjlim" is SPICE's DEVpnjlim(vnew, vold, vte, vcrit). Its limiting
// branch is guarded by `vnew > vcrit`; the testbench biases the junction at
// 0.1 V against the vcrit of 0.7 V passed as the fourth argument, so that guard
// is false and pnjlim returns its argument UNCHANGED. 0.1 is therefore the
// value, and a limiter that clamped anyway would be caught here.
//
// 4.5.13: limexp is exp, differing only above a linearization knee chosen to
// stop the solver overflowing. 0.1/$vt is 3.868, far below any such knee, so
// limexp(3.868) is exp(3.868) = 47.8547 — again to 1e-5 across both constant
// sets — and the diode law 1e-14*(exp(V/$vt) - 1) is 4.68547e-13 A.
//
//! temp 300.0
//! bias V(p) = 0.1
`include "check.vh"
module combined_named_limiter_nonlinear(p, n);
  inout p, n; electrical p, n;
  parameter real saturation_current = 1e-14 from (0:inf);
  real limited;
  analog begin
    limited = $limit(V(p,n), "pnjlim", $vt, 0.7);
    `CHECKR("9.10: $vt is kT/q at 300 K", $vt, 0.025852, 1e-5);
    `CHECK("pnjlim leaves 0.1 V alone, it is below the 0.7 V critical voltage", limited, 0.1, 1e-15);
    `CHECKR("4.5.13: limexp is exp well below the knee, at 0.1/$vt", limexp(V(p,n) / $vt), 47.8547, 1e-5);
    `CHECKR("diode law at 100 mV with Is = 10 fA", saturation_current * (limexp(V(p,n) / $vt) - 1.0), 4.68547e-13, 1e-4);
    I(p,n) <+ saturation_current * (limexp(limited / $vt) - 1.0);
    $bound_step(1u);
  end
endmodule
