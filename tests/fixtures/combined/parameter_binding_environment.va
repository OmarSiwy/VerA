// LRM 9.19, both explicit-binding detection functions on one instance.
//
// "$param_given() ... shall be one (1) if the parameter was overridden, either
// by a defparam statement or by a module instance parameter value assignment,
// and zero (0) otherwise." The testbench overrides `gain` and leaves `fallback`
// alone, so the two calls must disagree: 1 for gain, 0 for fallback. Note that
// this is not a value comparison — a compiler that answered "given" by testing
// the parameter against its declared default would still say 1 here (2.5 is not
// 1.0) but would wrongly say 0 for a parameter overridden WITH its default.
//
// "$port_connected() ... shall be one (1) if the port was connected to a net
// ... and zero (0) otherwise." Every port of the instance under test is driven,
// so `aux` is connected and its arm runs; aux sits at ground, so it adds 0 and
// `effective` stays the given gain of 2.5 exactly.
//
// The stamp is then 2.5 * 2 V = 5 A, exact in binary.
//
//! param gain = 2.5
//! bias V(p) = 2.0
`include "check.vh"
module combined_parameter_binding_environment(p, n, aux);
  inout p, n, aux; electrical p, n, aux;
  parameter real gain = 1.0 from [0:inf);
  parameter real fallback = 0.5;
  real effective;
  analog begin
    effective = $param_given(gain) ? gain : fallback;
    if ($port_connected(aux)) effective = effective + V(aux,n);
    `CHECKI("9.19: gain was overridden, so $param_given is 1", $param_given(gain), 1);
    `CHECKI("9.19: fallback kept its declared default, so $param_given is 0", $param_given(fallback), 0);
    `CHECKI("9.19: aux is connected to a net", $port_connected(aux), 1);
    `CHECKX("the ternary took the given gain, and grounded aux added nothing", effective, 2.5);
    `CHECKX("stamp: 2.5 * 2 V", effective * V(p,n), 5.0);
    I(p,n) <+ effective * V(p,n);
  end
endmodule
