// LRM 4.6.1 Table 4-22 (analysis type) and 4.4.14 white_noise, on a resistor.
//
// The testbench declares a NOISE analysis, so Table 4-22's "Noise" row applies:
// "noise" matches and "dc" does not. That row is the whole reason the two noise
// contributions below are guarded, so pinning it pins the guard.
//
// The noise power itself is Nyquist's 4kT/R, which is a number and not a
// convention. No PHYSICAL_CONSTANTS_* selector is defined, so annex D.2's
// innermost `else` wins and `P_K is the CODATA-1998 Boltzmann constant
// 1.3806503e-23 J/K. At the declared 300 K into 10 kOhm:
//
//   4 * 1.3806503e-23 * 300 / 1e4 = 1.65678036e-24 A^2/Hz
//
// and the resistor's own current at 1 V is 1 V / 10 kOhm = 100 uA.
//
//! analysis noise
//! temp 300.0
//! bias V(p) = 1.0
`include "check.vh"
`include "constants.vams"
module combined_noise_temperature_analysis(p, n);
  inout p, n; electrical p, n;
  parameter real resistance = 10k from (0:inf);
  parameter real flicker_coefficient = 1e-20 from [0:inf);
  analog begin
    `CHECKI("Table 4-22: \"noise\" matches a noise analysis", analysis("noise"), 1);
    `CHECKI("Table 4-22: \"dc\" does not match a noise analysis", analysis("dc"), 0);
    `CHECKX("$temperature is the declared 300 K", $temperature, 300.0);
    `CHECKR("Nyquist 4kT/R at 300 K into 10 kOhm", 4.0 * `P_K * $temperature / resistance, 1.65678036e-24, 1e-9);
    `CHECKR("Ohm's law: 1 V across 10 kOhm", V(p,n) / resistance, 1e-4, 1e-15);
    I(p,n) <+ V(p,n) / resistance;
    if (analysis("noise")) begin
      I(p,n) <+ white_noise(4.0 * `P_K * $temperature / resistance, "thermal");
      I(p,n) <+ flicker_noise(flicker_coefficient, 1.0, "flicker");
    end
  end
endmodule
