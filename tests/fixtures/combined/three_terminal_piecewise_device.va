// LRM 4.2.5 (relational operators are INTEGER-valued) driving a 5.2 case
// statement, on a three-terminal device.
//
// `case (V(c,b) > 0.5)` only makes sense because 4.2.5 says a relational
// yields 1 when the relation holds and 0 when it does not — the case labels
// are those two integers. The testbench holds c at 1 V and b at ground, so the
// controlling expression is 1 and the `1:` arm is selected: `selected` is
// ghigh, the declared 2 mS default, not the 1 uS glow.
//
// The stamps that follow are then arithmetic. §2.6 scale factors: 2m is 2e-3
// and 1G is 1e9.
//
//   I(a,b) = ghigh * V(a,b) = 2e-3 * 2 V = 4 mA
//   I(c,b) = V(c,b) / 1G    = 1 V / 1e9  = 1 nA
//
//! bias V(c) = 1.0, V(a) = 2.0
`include "check.vh"
module combined_three_terminal_piecewise_device(a, b, c);
  inout a, b, c; electrical a, b, c;
  parameter real ghigh = 2m from [0:inf);
  parameter real glow = 1u from [0:inf);
  real selected;
  analog begin
    case (V(c,b) > 0.5)
      1: selected = ghigh;
      default: selected = glow;
    endcase
    `CHECKI("4.2.5: the relational yields the integer 1, since 1.0 > 0.5", (V(c,b) > 0.5), 1);
    `CHECKR("the `1:` arm ran, so selected is ghigh = 2 mS and not glow = 1 uS", selected, 2e-3, 1e-15);
    `CHECKR("main stamp: ghigh * 2 V", selected * V(a,b), 4e-3, 1e-15);
    `CHECKR("control stamp: 1 V / 1G ohm", V(c,b) / 1G, 1e-9, 1e-15);
    I(a,b) <+ selected * V(a,b);
    I(c,b) <+ V(c,b) / 1G;
  end
endmodule
