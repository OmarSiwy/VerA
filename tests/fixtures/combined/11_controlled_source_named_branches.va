// §5.4.2 named branches: `branch (cp, cn) control;` declares a branch between
// those two nets, and §4.4.1 makes V(control) the potential of that branch —
// i.e. V(cp) - V(cn), in the declared order. The bias is 0.75 and 0.25, both
// exactly representable and their difference exactly 0.5, so the check can be
// exact; a branch built in the wrong order would give -0.5, and one that
// silently referred to ground would give 0.75.
//
// The transconductance is `1m`, which §2.6.2 Table 2-1 fixes at 1e-3, so the
// controlled flow into output_path is 1e-3 * 0.5 = 5e-4 A exactly — a product
// of two powers of two times a power of ten, so no rounding enters.
//
// The output branch is biased at zero, which keeps the 1 G-ohm bleeder on the
// control branch out of the numbers being checked.
//
//! bias V(cp) = 0.75, V(cn) = 0.25, V(outp) = 0.0, V(outn) = 0.0
`include "check.vh"
module combined_controlled_source_named_branches(outp, outn, cp, cn);
  inout outp, outn, cp, cn;
  electrical outp, outn, cp, cn;
  branch (cp, cn) control;
  branch (outp, outn) output_path;
  parameter real gm = 1m from [0:inf);
  analog begin
    `CHECKX("a 1m scale factor is 1e-3 (Table 2-1)", gm, 0.001);
    `CHECKX("V(control) is V(cp) - V(cn), in declaration order", V(control), 0.5);
    `CHECKX("the transconductance flow gm*V(control)", gm * V(control), 0.0005);
    I(output_path) <+ gm * V(control);
    I(control) <+ V(control) / 1G;
  end
endmodule
