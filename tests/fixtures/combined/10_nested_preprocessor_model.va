// §10.4 `ifdef/`ifndef/`else/`endif, nested. FEATURE_A is defined and FEATURE_B
// is not, so the live text is the INNER true arm of `ifndef FEATURE_B, nested
// inside the true arm of `ifdef FEATURE_A: the $pow contribution.
//
// The check is written into all three arms with the SAME want, 9.0, but each
// arm asserts its own expression at the biased V(p,n) = 3.0:
//
//   $pow(V,2) = 9.0   the arm that must survive — §4.3.2 pow(x,y) is x**y
//   V         = 3.0   the `ifndef's else arm
//   0.0               the `ifdef's else arm
//
// so exactly one arm can print ok=1 and a preprocessor that mis-nested the
// `else / `endif pairing is caught by the value, not by a diff. Only the
// surviving arm is compiled at all, so this stays one unconditional check.
//
//! bias V(p) = 3.0
`include "check.vh"
`define FEATURE_A
module combined_nested_preprocessor_model(p, n);
  inout p, n; electrical p, n;
  analog begin
`ifdef FEATURE_A
`ifndef FEATURE_B
    `CHECKX("nested ifdef/ifndef selects the $pow arm", $pow(V(p,n), 2.0), 9.0);
    I(p,n) <+ $pow(V(p,n), 2.0);
`else
    `CHECKX("nested ifdef/ifndef selects the $pow arm", V(p,n), 9.0);
    I(p,n) <+ V(p,n);
`endif
`else
    `CHECKX("nested ifdef/ifndef selects the $pow arm", 0.0, 9.0);
    I(p,n) <+ 0.0;
`endif
  end
endmodule
