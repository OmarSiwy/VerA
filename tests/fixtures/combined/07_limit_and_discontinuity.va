// §9.17.3 $limit and §4.5.13 limexp, at a bias chosen so the limiter provably
// cannot engage.
//
// $limit's return is explicitly at the simulator's discretion — "the simulator
// may simply choose to have $limit() return the value of its first argument" —
// so in general there is no number to write down. But §9.17.3 pins the pnjlim
// case by giving the reference implementation itself, and that code limits only
//
//     if ((vnew > vcrit) && (abs(vnew - vold) > (vt + vt)))
//
// With vcrit = 0.7 as the fourth argument and the bias at V(p,n) = 0.3, the
// first conjunct is false whatever the internal previous-iteration state is, so
// every conforming answer — pnjlim's, or the "just return the argument" one the
// clause permits — is 0.3. A limiter that clamped unconditionally would not be.
//
// §4.5.13 then says limexp "returns a real value which is the exponential of
// its single real argument" and is "not distinguishable from exp()", so the
// contributed flow is exp(0.3) - 1 = 0.3498588075760032.
//
// $discontinuity is a hint to the solver (§9.17.1) and returns nothing, so it
// has no value to assert.
//
//! bias V(p) = 0.3
`include "check.vh"
module combined_limit_and_discontinuity(p, n);
  inout p, n; electrical p, n;
  real limited;
  analog begin
    $discontinuity(0);
    limited = $limit(V(p,n), "pnjlim", $vt, 0.7);
    `CHECK("pnjlim cannot limit below vcrit, so $limit passes 0.3 through", limited, 0.3, 1e-15);
    `CHECKR("limexp is the exponential of its argument", limexp(limited) - 1.0, 0.3498588075760032, 1e-13);
    I(p,n) <+ limexp(limited) - 1.0;
  end
endmodule
