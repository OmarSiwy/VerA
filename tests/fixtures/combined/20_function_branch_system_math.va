// LRM 5.4.1 (a named branch is the pair of nets it was declared over), 4.3.2
// ($tanh) and 4.3.1 ($min/$max), reached through a user analog function (4.7).
//
// The testbench holds p at 0.5 V and n at ground, so:
//
//   V(path)              = V(p,n)      = 0.5   (5.4.1, exact in binary)
//   soft_clip(V(path))   = tanh(0.5)   = 0.46211715726000974
//   $min(V(path), 0.0)   = 0.0                 (0 is the smaller)
//   $max(V(path), 0.0)   = 0.5                 (0.5 is the larger)
//   sum                                = 0.96211715726000974
//
// tanh(0.5) = (e - 1/e)/(e + 1/e) with e = exp(1); the digits above are that
// quotient in double precision. The sum is asserted too because 0.5 is exact,
// so the addition introduces no rounding beyond tanh's own.
//
//! bias V(p) = 0.5
`include "check.vh"
module combined_function_branch_system_math(p, n);
  inout p, n; electrical p, n;
  branch (p,n) path;
  analog function real soft_clip;
    input x; real x;
    soft_clip = $tanh(x);
  endfunction
  analog begin
    `CHECKX("5.4.1: the named branch probes the pair it was declared over", V(path), 0.5);
    `CHECKR("4.3.2: tanh(0.5), through the user function", soft_clip(V(path)), 0.46211715726000974, 1e-15);
    `CHECKX("4.3.1: $min takes the smaller of 0.5 and 0", $min(V(path), 0.0), 0.0);
    `CHECKX("4.3.1: $max takes the larger of 0.5 and 0", $max(V(path), 0.0), 0.5);
    `CHECKR("the contributed sum tanh(0.5) + 0 + 0.5", soft_clip(V(path)) + $min(V(path), 0.0) + $max(V(path), 0.0), 0.96211715726000974, 1e-15);
    I(path) <+ soft_clip(V(path)) + $min(V(path), 0.0) + $max(V(path), 0.0);
  end
endmodule
