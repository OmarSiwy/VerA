// LRM 4.6.1 Table 4-22, the whole "DC" column, plus the two prose rules the
// table does not contain.
//
// The testbench runs the default DC analysis, so Table 4-22 reads down that
// column: "dc" is 1, "static" is 1 ("any equilibrium point calculation,
// including a DC analysis"), "tran" is 0, "ac" is 0.
//
// Two rules from 4.6.1's text rather than its table:
//   - "returns one (1) if ANY argument matches the current analysis type", so
//     analysis("tran", "ac", "dc") is 1 even though two of the three miss;
//   - "Any unsupported type names are assumed to not be a match", so a name no
//     simulator defines is 0 rather than an error.
//
// The selected arm is then the first one, whose stamp is conductance*V: the
// default 1 mS into the declared 2 V is 2 mA. Both operands are exact in
// binary and 1e-3 rounds identically on each side, so a relative tolerance at
// the ulp is enough.
//
//! bias V(p) = 2.0
`include "check.vh"
module combined_analysis_modes_and_severity(p, n);
  inout p, n; electrical p, n;
  parameter real conductance = 1m from [0:inf);
  analog begin
    `CHECKI("Table 4-22: \"dc\" matches a DC analysis", analysis("dc"), 1);
    `CHECKI("Table 4-22: \"static\" also matches, it is an equilibrium point", analysis("static"), 1);
    `CHECKI("Table 4-22: \"tran\" does not match a DC analysis", analysis("tran"), 0);
    `CHECKI("Table 4-22: \"ac\" does not match a DC analysis", analysis("ac"), 0);
    `CHECKI("4.6.1: the argument list is an OR, so one hit out of three is 1", analysis("tran", "ac", "dc"), 1);
    `CHECKI("4.6.1: an unsupported type name is simply not a match", analysis("no_such_analysis"), 0);
    `CHECKR("the selected arm stamps conductance*V = 1 mS * 2 V", conductance * V(p,n), 2e-3, 1e-15);
    if (analysis("dc", "static"))
      I(p,n) <+ conductance * V(p,n);
    else if (analysis("tran"))
      I(p,n) <+ 2.0 * conductance * V(p,n);
    else
      I(p,n) <+ conductance * V(p,n);
    if (conductance == 0.0) $info("zero conductance selected");
  end
endmodule
