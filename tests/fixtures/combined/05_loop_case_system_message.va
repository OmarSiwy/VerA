// §5.2.4 `for` and §5.2.2.2 `case` over an integer control variable.
//
// The loop runs k = 0,1,2,3 and exits when the k<4 test first fails, so §5.2.4's
// "the step assignment happens after the body, then the condition is retested"
// leaves k == 4 on exit — not 3. That value is what the `case` below selects on,
// so the two checks together say the loop ran exactly four times.
//
// The accumulated sum is V(p,n) * (1/1 + 1/2 + 1/3 + 1/4) = V(p,n) * 25/12.
// The bias is chosen so that product is exact in decimal: 1.2 * 25/12 = 2.5.
// Summed left to right in double precision the four terms give
// 2.4999999999999996, 4.4e-16 below 2.5, so an absolute tolerance of 1e-15 is
// the right form here. Three iterations would give 2.2, five 2.74 — decades
// clear of the tolerance.
//
//! bias V(p) = 1.2
`include "check.vh"
module combined_loop_case_system_message(p, n);
  inout p, n; electrical p, n;
  integer k;
  real sum, d;
  analog begin
    sum = 0.0;
    // The loop bound is not carried into the divisor, so guard it explicitly
    // (LRM 4.2.4 leaves division by zero undefined).
    for (k=0; k<4; k=k+1) begin
      d = k + 1;
      if (d != 0.0) sum = sum + V(p,n)/d;
    end
    `CHECKI("the for loop leaves k one past its last body value", k, 4);
    `CHECK("1.2 * (1 + 1/2 + 1/3 + 1/4) = 1.2 * 25/12", sum, 2.5, 1e-15);
    case (k)
      4: $strobe("sum=%g at %g", sum, $abstime);
      default: $warning("unexpected loop count");
    endcase
    I(p,n) <+ sum;
  end
endmodule
