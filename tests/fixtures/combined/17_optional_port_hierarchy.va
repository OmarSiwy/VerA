// LRM 9.18 Table 9-29 (hierarchical system parameters) and 9.19
// ($port_connected).
//
// Table 9-29 gives each system parameter a TOP-LEVEL VALUE, and the resolved
// value for an instance is that value combined down the instantiation
// hierarchy. This module is elaborated flat, so it IS the top level and the
// table's column is the answer outright:
//
//   $mfactor    1.0   (shunt multiplicity)
//   $xposition  0     ($xposition_specified + $xposition_hier, meters)
//   $yposition  0
//
// so `environment` = 1 + 0 + 0 = 1, exactly. A compiler that defaulted $mfactor
// to 0, or that let the position offsets leak a non-zero, fails this.
//
// 9.19: $port_connected shall return 1 if the port was connected to a net when
// the module was instantiated. Every port of the instance under test is driven
// by the testbench, so `sense` is connected and the first arm is the live one:
// gain * V(sense,n) at the declared 0.5 V bias with the default unity gain.
//
//! bias V(sense) = 0.5
`include "check.vh"
module combined_optional_port_hierarchy(p, n, sense);
  inout p, n, sense; electrical p, n, sense;
  parameter real gain = 1.0;
  real environment;
  analog begin
    environment = $mfactor + $xposition + $yposition;
    `CHECKX("Table 9-29: $mfactor's top-level value is 1", $mfactor, 1.0);
    `CHECKX("Table 9-29: the position offsets are 0 m at the top level", $xposition + $yposition, 0.0);
    `CHECKX("so the environment sum is 1 + 0 + 0", environment, 1.0);
    `CHECKI("9.19: a connected port reads 1", $port_connected(sense), 1);
    `CHECKX("the connected arm drives gain*V(sense,n) = 1.0 * 0.5", gain * V(sense,n), 0.5);
    if ($port_connected(sense))
      I(p,n) <+ gain * V(sense,n) + environment * 0.0;
    else
      I(p,n) <+ gain * V(p,n) + environment * 0.0;
  end
endmodule
