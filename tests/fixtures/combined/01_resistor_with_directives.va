// §2.6.2 Table 2-1: a real constant may be written in SCALED notation, and the
// symbol `k` (or `K`) means 1e3. Here the `1k` arrives through a §10.3 `define,
// so one check pins both rules at once: text substitution happens before
// lexing, and the lexer then reads `1k` as the real number 1000.0 — not 1, and
// not the number 1 followed by an identifier.
//
// The second check is §5.4.1 Ohm's law over that value. At V(p,n) = 2.0 the
// contributed flow is 2.0 / 1000 = 0.002 A; IEEE-754 division is correctly
// rounded, so the quotient is bit-identical to the literal 0.002 and the
// comparison can be exact. A `k` dropped on the floor would give 2 A here.
//
// $bound_step is a hint to the time-step controller (§9.17.2) and returns
// nothing, so there is no value of its own to assert.
//
//! bias V(p) = 2.0
`include "check.vh"
`define DEFAULT_R 1k
module combined_resistor_with_directives(p, n);
  inout p, n; electrical p, n;
  parameter real resistance = `DEFAULT_R from (0:inf);
  analog begin
    `CHECKX("a define'd 1k is the real 1000.0 (Table 2-1)", resistance, 1000.0);
    `CHECKX("Ohm's law flow at 2 V across 1 kOhm", V(p,n)/resistance, 0.002);
    $bound_step(1u);
    I(p,n) <+ V(p,n)/resistance;
  end
endmodule
