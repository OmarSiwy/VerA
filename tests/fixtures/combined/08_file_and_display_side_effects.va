// §9.5.1: "$fopen opens the file specified as the filename argument and returns
// either a 32-bit multichannel descriptor or a 32-bit file descriptor,
// determined by the absence or presence of the type argument." The type "a" is
// present, so the result is an fd. §9.5.1 reserves fd 0 for failure — every
// successfully opened descriptor is non-zero (indeed the clause requires bit 31
// set, which would make it negative as a Verilog integer; this check only asks
// for non-zero so it does not depend on that encoding).
//
// The second check is §9.10: $abstime "returns the current simulation time" in
// seconds. The testbench declares no `//! time line, so the single operating
// point is at t = 0 and $abstime is exactly 0.0 — the same value $fdisplay
// prints on the line above. A build that seeded time from the wall clock, or
// answered in the timescale's integer ticks of something other than zero, fails.
//
//! bias V(p) = 0.25
//! lrm 9.5.1
//! lrm 9.10
//! xfail VerA has no file-descriptor surface: codegen.zig `void_tasks` lowers the whole §9.5 family to the constant `S.con(0.0)`, so $fopen answers the 0 that §9.5.1 reserves for failure, and $fdisplay/$fclose are no-ops. The two §9.10/§1.3.1 checks below already pass — only the descriptor is missing
`include "check.vh"
module combined_file_and_display_side_effects(p, n);
  inout p, n; electrical p, n;
  integer fd;
  analog begin
    fd = $fopen("combined.log", "a");
    `CHECKI("$fopen with a type returns a non-zero fd on success", fd != 0, 1);
    `CHECKX("$abstime at the single t=0 operating point", $abstime, 0.0);
    `CHECKX("the probe the display tasks print", V(p,n), 0.25);
    $fdisplay(fd, "t=%e v=%g", $abstime, V(p,n));
    $display("v=%g", V(p,n));
    $fclose(fd);
    I(p,n) <+ V(p,n);
  end
endmodule
