// §9.19: "$port_connected(port) shall return one (1) if the port was connected
// to a net (by order or by name) when the module was instantiated, and zero (0)
// otherwise." The testbench instantiates this device with both ports bound to
// solver unknowns, so the answer is 1 and the true arm below is the live one.
//
// §9.15 on $simparam: "If param_name is not known, and the optional expression
// is not supplied, then an error is generated. If the optional expression is
// supplied, its value is returned if param_name is not known and no error is
// generated." The second check names a parameter that cannot be in any
// simulator's Table 9-27 and asks for the default back — 2.5 is picked so it is
// nothing else in this file, so returning the parameter's real value, zero, or
// the first argument all fail. `gmin` itself is deliberately NOT asserted:
// Table 9-27 gives it no required value, and this module's `fallback` happens to
// equal the conventional 1e-12, so a check on it could not tell "the simulator
// knows gmin" from "the simulator fell back".
//
//! bias V(p) = 1.0
`include "check.vh"
module combined_optional_port_environment(p, n);
  inout p, n; electrical p, n;
  parameter real fallback = 1e-12;
  analog begin
    `CHECKI("$port_connected on a bound port", $port_connected(p), 1);
    `CHECKX("$simparam returns its default for an unknown parameter", $simparam("vera_no_such_sim_parameter", 2.5), 2.5);
    if ($port_connected(p)) I(p,n) <+ $simparam("gmin", fallback)*V(p,n);
    else I(p,n) <+ 0.0;
  end
endmodule
