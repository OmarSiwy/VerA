// §9.15: "$vt can optionally have temperature (in Kelvin units) as an input
// argument and returns the thermal voltage (kT/q) at the given temperature."
// With the ambient at the 300.15 K default,
//
//     kT/q = 1.3806503e-23 * 300.15 / 1.602176462e-19 = 0.025864952917090102 V
//
// using the NIST1998 k and q that Annex D.2 selects when no
// `PHYSICAL_CONSTANTS_* macro is defined. The LRM mandates no CODATA vintage,
// and the five sets D.2 offers spread by at most 3.1e-5 relative, so the check
// is written at rtol 1e-4 — four significant figures, blind to the choice.
//
// The second check is the Shockley equation this module actually builds. §4.5.13
// says limexp() "returns a real value which is the exponential of its single
// real argument" and that its apparent behavior "is not distinguishable from
// exp()". So at V(p,n) = 0.5 V,
//
//     I = 1e-14 * (exp(0.5 / 0.025864952917090102) - 1) = 2.4855573291413894e-6 A
//
// The exponent is 19.33, which amplifies the 3.1e-5 spread in kT/q to 6.1e-4
// relative in the current (the SPICE set); rtol 8e-4 covers every D.2
// constant set, still sees the 0.1% error a perturbed run moves the want by, and
// pins three digits. A limexp() that clamped its output, or a $vt
// answering in millivolts, misses by orders of magnitude.
//
//! temp 300.15
//! bias V(p) = 0.5
`include "check.vh"
module combined_temperature_diode(p, n);
  inout p, n; electrical p, n;
  parameter real saturation = 1e-14;
  real thermal_voltage;
  analog begin
    thermal_voltage = $vt($temperature);
    `CHECKR("kT/q at the 300.15 K ambient", thermal_voltage, 0.025864952917090102, 1e-4);
    `CHECKR("Shockley current at 0.5 V", saturation*(limexp(V(p,n)/thermal_voltage)-1.0), 2.4855573291413894e-6, 8e-4);
    I(p,n) <+ saturation*(limexp(V(p,n)/thermal_voltage)-1.0);
  end
endmodule
