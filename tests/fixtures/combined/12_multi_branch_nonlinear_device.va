// A two-branch nonlinear device: §4.3.2 max() as a threshold clamp, §4.3.2
// tanh() as the drain-side saturation, contributed onto two different branches
// of the same three-terminal module (§5.4.1).
//
// At V(g) = 1.7, V(s) = 0 the overdrive is max(1.7 - 0.7, 0) = 1.0. Both
// operands are doubles whose difference is exactly 1.0, so the clamp's arm is
// unambiguous: max returning its second argument instead would give 0.0, and a
// min in its place would give 0.0 too.
//
// With V(d) = 0.5 the drain flow is
//
//     beta * overdrive^2 * tanh(0.5)
//   = 1e-3 * 1 * 0.46211715726000974
//   = 4.6211715726000976e-4 A
//
// tanh(0.5) = (e - 1)/(e + 1) with e = exp(1); the want is the double nearest
// that, and rtol 1e-13 is about a hundred ulps — slack for any libm, and three
// decades tighter than confusing tanh with its argument (0.5, an 8% error) or
// with sinh (0.521, 13%).
//
//! bias V(g) = 1.7, V(d) = 0.5, V(s) = 0.0
`include "check.vh"
module combined_multi_branch_nonlinear_device(d, g, s);
  inout d, g, s;
  electrical d, g, s;
  parameter real beta = 1m from (0:inf);
  parameter real vth = 0.7;
  real overdrive;
  analog begin
    overdrive = max(V(g,s) - vth, 0.0);
    `CHECK("max() passes the positive overdrive through", overdrive, 1.0, 1e-15);
    `CHECKR("tanh at the drain bias", tanh(V(d,s)), 0.46211715726000974, 1e-13);
    `CHECKR("square-law drain flow", beta * overdrive * overdrive * tanh(V(d,s)), 4.6211715726000976e-4, 1e-13);
    I(d,s) <+ beta * overdrive * overdrive * tanh(V(d,s));
    I(g,s) <+ V(g,s) / 1T;
  end
endmodule
