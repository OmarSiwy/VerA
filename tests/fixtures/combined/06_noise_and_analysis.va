// §4.6.1 analysis() "takes one or more string arguments and returns one (1) if
// any argument matches the current analysis type. Otherwise it returns zero
// (0)." Table 4-22 gives the column for a DC analysis: "dc" and "static" are 1,
// "noise" and "tran" are 0. This testbench runs the default dc analysis, so the
// white_noise contribution below is guarded off — and the first two checks are
// what says so, in the LRM's own vocabulary rather than by inspecting the
// residual.
//
// The third check is Annex D.2: constants.vams defines `P_K by a chain of
// `ifdefs whose fall-through arm is "use NIST1998 values as in LRM 2.2 - 2.3 for
// backwards-compatibility", i.e. `P_K_NIST1998 = 1.3806503e-23. No
// `PHYSICAL_CONSTANTS_* macro is defined here, so that is the arm taken; the
// four other candidate values in D.2 differ in the fifth significant digit, so
// exact equality is the right claim for a macro that is pure text.
//
// The fourth is §2.6.2 plus §5.4.1: `1k` is 1e3, so at V(p,n) = 1.0 the linear
// branch carries 1.0/1000 = 0.001 A exactly.
//
//! bias V(p) = 1.0
`include "check.vh"
`include "constants.vams"
module combined_noise_and_analysis(p, n);
  inout p, n; electrical p, n;
  parameter real resistance = 1k from (0:inf);
  analog begin
    `CHECKI("Table 4-22: analysis(dc) is true in a dc analysis", analysis("dc"), 1);
    `CHECKI("Table 4-22: analysis(noise) is false in a dc analysis", analysis("noise"), 0);
    `CHECKX("Annex D.2 falls through to the NIST1998 Boltzmann constant", `P_K, 1.3806503e-23);
    `CHECKX("resistor flow at 1 V across 1 kOhm", V(p,n)/resistance, 0.001);
    I(p,n) <+ V(p,n)/resistance;
    if (analysis("noise"))
      I(p,n) <+ white_noise(4.0*`P_K*$temperature/resistance, "thermal");
  end
endmodule
