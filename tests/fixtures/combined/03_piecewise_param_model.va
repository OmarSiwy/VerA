// §9.19: "$param_given(p) shall return one (1) if the parameter was overridden,
// either by a defparam or by a module instance parameter value assignment, and
// zero (0) otherwise."
//
// This testbench deliberately declares NO `//! param` line, so `gain` holds its
// §3.4 declared default and $param_given(gain) must be 0 — even though the
// default (2.0) is a perfectly ordinary value. A $param_given that answered
// "the parameter has a value" rather than "the parameter was overridden" would
// return 1 here.
//
// That 0 then decides the piecewise arm. §4.2.5 makes `&&` yield an integer and
// §4.2 makes a zero left operand decide the conjunction regardless of the right
// one, so at V(p,n) = 1.0 — which IS above `threshold` = 0.5, so only
// $param_given can send it to the else arm — `response` is V(p,n) = 1.0 and not
// gain*V(p,n) = 2.0. The two arms are a factor of two apart, so the check
// distinguishes them.
//
//! bias V(p) = 1.0
`include "check.vh"
module combined_piecewise_param_model(p, n);
  inout p, n; electrical p, n;
  parameter real gain = 2.0;
  parameter real threshold = 0.5;
  real response;
  analog begin
    if ($param_given(gain) && V(p,n) > threshold)
      response = gain*V(p,n);
    else
      response = V(p,n);
    `CHECKI("$param_given on a parameter left at its default", $param_given(gain), 0);
    `CHECKI("the guard is above threshold, so only $param_given decides", V(p,n) > threshold, 1);
    `CHECKX("so the ungained arm is the one in force", response, 1.0);
    I(p,n) <+ response;
  end
endmodule
