// §10.3 macro with arguments, expanded inside a §4.7 analog function, over the
// §4.3.2 math functions in their `$`-prefixed spelling.
//
// CLAMP(x,-2,2) is min(max(x,-2),2), so it saturates in BOTH directions, and
// transfer(x) = exp of that. At the biased V(p,n) = 3.0:
//
//   transfer(+3) = exp(2)  = 7.38905609893065
//   transfer(-3) = exp(-2) = 0.1353352832366127
//
// Both wants are the double nearest the true exponential; rtol 1e-13 is roughly
// a hundred ulps, which is slack for any libm and far tighter than any of the
// ways this can go wrong. A macro whose arguments were not parenthesised, a
// $min/$max swapped for each other, or a clamp applied only on one side all
// land on exp(3) = 20.09 or exp(-3) = 0.0498 instead.
//
//! bias V(p) = 3.0
`include "check.vh"
`define CLAMP(x,lo,hi) ($min($max((x),(lo)),(hi)))
module combined_macro_function_math(p, n);
  inout p, n; electrical p, n;
  analog function real transfer;
    input x; real x;
    begin transfer = $exp(`CLAMP(x,-2.0,2.0)); end
  endfunction
  analog begin
    `CHECKR("CLAMP saturates at the upper bound: exp(2)", transfer(V(p,n)), 7.38905609893065, 1e-13);
    `CHECKR("and at the lower bound: exp(-2)", transfer(-V(p,n)), 0.1353352832366127, 1e-13);
    I(p,n) <+ transfer(V(p,n));
  end
endmodule
