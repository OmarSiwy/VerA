// E.2: "it shall also be possible to access subcircuits and models defined
// within SPICE netlists. The subcircuits and models contained within the SPICE
// netlist are TREATED AS MODULE DEFINITIONS."
//
// E.2.2.2 accesses one: the `.SUBCKT ECPOSC (OUT GND)` card set is referenced
// from Verilog-AMS as `ecpOsc Osc1 (out, gnd);`. Its port list is the card's —
// OUT and GND — exactly as a module's port list is its header's. Treated as a
// module definition, it then answers §6.2.2's port rules like any module
// (names arrive from the netlist lower-cased, and E.2.1 matches them
// case-blind, which is why `.out` and `.gnd` would bind).
//
// This file connects `.vcc`. ECPOSC's body has an INTERNAL node VCC (its `VA
// VCC GND 5` card), but an internal node is not a port — the subcircuit's
// interface is the two names on the `.SUBCKT` line and nothing else. A named
// connection to something that is not a port of the definition is the §6.2.2
// error a Verilog-AMS module would raise, and "treated as module definitions"
// gives the subcircuit no exemption. Connecting `.out(out), .gnd(gnd)` instead
// compiles (probed through the harness, which is what hands `//! spice` to the
// compiler).
//
// The netlist below is E.2.2.2's subcircuit cut to the two cards that make
// VCC an internal node; its ports are verbatim.
//
// VerA reports E0906 "port connections do not match the module's ports".
//
//! lrm E.2
//! lrm E.2.2.2
//! reject-only E0906
//! reject `vcc` is not a port
//! spice .SUBCKT ECPOSC OUT GND
//! spice VA VCC GND 5
//! spice R1 VCC OUT 10K
//! spice .ENDS ECPOSC
`include "disciplines.vams"
module e222_osc(out, gnd);
  inout out, gnd; electrical out, gnd;
  ecpOsc Osc1 (.out(out), .vcc(gnd));    // illegal: VCC is internal, not a port
endmodule
