// H04 — the second half of the netlist boundary: a subcircuit's SOURCE card has
// to drive its node and supply the current an external load draws. A subcircuit
// body that contributes only passives is still not a circuit.
//
// THE CLAUSE, TWICE. E.2: "The subcircuits and models contained within the SPICE
// netlist are treated as module definitions." E.2.2.2's subcircuit body opens
// with `VA VCC GND 5` and `IEE E GND 1MA` — a voltage source and a current
// source — and E.2.2.3 translates exactly those two lines as
//
//     vsine #(.dc(5)) Vcc (vcc, gnd);
//     isine #(.dc(1m)) Iee (e, gnd);
//
// That translation is the annex's own statement of two things at once: a bare
// `V<name> node node value` card is Table E.1's `vsine`, and the card's value
// lands on its `dc` parameter. Both are pinned here, on the smaller netlist
//
//     .SUBCKT VREF OUT GND
//     V1 OUT GND 2.5
//     .ENDS VREF
//
// WHY `dc` AND NOT `offset`. Table E.1 gives every independent source row the
// parameters `dc, mag, phase` ahead of the waveform parameters, and none of the
// three appears in that row's Behavior expression. §4.6.1 and Table 4-21 name
// the analyses those three belong to — `dc` is the ".OP or .DC analysis" value,
// `mag`/`phase` the AC stimulus — so the sine expression in the Behavior column
// is the TRANSIENT waveform and `dc` is the value the source holds at the
// operating point. `//! analysis dc` selects that regime, so the answer is `dc`
// and nothing from the waveform enters.
//
// THE DIGITS, BY HAND. The card gives 2.5, so dc = 2.5 V. `//! bias` holds gnd
// at 0.0 and `//! solve` frees `out`, which the source alone determines:
//
//     V(x1.out, x1.gnd) = 2.5 V   exactly — an ideal source imposes its value,
//                                 there is no division and no rounding
//
// and a 1 kohm load written in Verilog-AMS across the same pair, whose current
// the subcircuit's source has to supply:
//
//     I(load.p, load.n) = 2.5 / 1000 = 2.5e-3 A
//
// The load is the check that matters, because it is the one a NON-source cannot
// fake: a subcircuit that merely held a potential without sourcing current would
// leave the loop unsatisfied, and an empty body lets the load pull `out` to gnd.
//
// Three failures this separates. An empty subcircuit body (VerA today) leaves
// the node to the load alone and the solve puts it at 0.0, current 0.0. A body
// that instantiated the source but dropped the card's 2.5 answers whatever the
// prelude's waveform defaults give, which is not 2.5 for any of them. A tool
// that mapped the card to a CURRENT source instead answers 2.5 A through the
// load and 2500 V across it.
//
// FIXTURE 08 IS THE OTHER HALF and must be read with this one: it asserts the
// same 2.5 V on a `vsine #(.dc(2.5))` written directly in Verilog-AMS, so if
// both fail the `dc` parameter is the cause and if only this one fails the
// netlist boundary is.
//
//! lrm E.2
//! lrm E.2.2.2
//! lrm E.2.2.3
//! lrm 4.6.1
//! lrm 4.6.2
//! lrm 6.7.1
//! lrm 6.5.7.2
//! lrm 6.5.7.2:1000
//! lrm 6.7.1:1
//! lrm E.2:3
//! analysis dc
//! bias V(gnd) = 0.0
//! solve
//! spice .SUBCKT VREF OUT GND
//! spice V1 OUT GND 2.5
//! spice .ENDS VREF
`include "check.vh"
module h04_subckt_source(gnd);
  inout gnd; electrical gnd;
  vRef x1(out, gnd);
  resistor #(.r(1k), .tc1(0.0), .tc2(0.0)) load(out, gnd);
  analog begin
    `CHECK("E.2.2.3: `V1 OUT GND 2.5` is a vsine whose dc holds the node at 2.5",
           V(x1.out, x1.gnd), 2.5, 1e-12);
    // Table E.1 resistor with tc1 = tc2 = 0: I = V/r = 2.5/1000.
    `CHECKR("and it supplies the 1 kohm load's 2.5 mA",
            I(load.p, load.n), 2.5e-3, 1e-12);
  end
endmodule
