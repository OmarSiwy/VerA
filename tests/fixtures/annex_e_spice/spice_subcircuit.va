// E.2.2.2 Accessing SPICE subcircuits, transcribed. Given `.SUBCKT ECPOSC (OUT
// GND) ... .ENDS ECPOSC`, the LRM prints:
//
//     module osc (out, gnd);
//        electrical out, gnd;
//        ecpOsc Osc1 (out, gnd);
//     endmodule
//
// with the note "in Verilog-AMS HDL the name of the subcircuit instance is not
// constrained to start with X as it is in SPICE" — hence `osc1` below.
//
// WHAT IS PINNED. E.2: "The subcircuits and models contained within the SPICE
// netlist are treated as module definitions." A `.SUBCKT` is therefore an
// ordinary instantiable module name, and E.2.1 supplies the case rule that lets
// the mixed-case `ecpOsc` match the all-caps `ECPOSC` of the netlist. Nothing in
// this file declares `ecpOsc`, which is the point: the name resolves outside the
// Verilog-AMS source.
//
// THE OBSERVABLE IS THE INTERFACE THE .SUBCKT LINE DECLARES. "Treated as module
// definitions" means `(OUT GND)` is a two-port interface connected by order, and
// §6.7.1 lets the parent read a potential off the instance's ports
// hierarchically. The two nets are biased apart, so the check fails both if the
// ordered connection were reversed (it would read -0.75) and if the name
// resolved to some other object whose first port is not OUT. E.2.1 also governs
// the port spelling: `osc1.out` is the mixed-case form of the netlist's `OUT`,
// resolved by the same rule that let `ecpOsc` find `ECPOSC`.
//
// WHY NOTHING INSIDE THE SUBCIRCUIT IS ASSERTED. The body of E.2.2.2's netlist
// does fix values — `VA VCC GND 5` puts 5 V on an internal node, `R1 B1 GND 10K`
// a resistor on another — but those are potentials a SOLVE produces, and this
// harness imposes every unknown at a directive-supplied value instead of solving
// (tests/fixtures/README.md). An internal node of the subcircuit would read back
// zero, not 5, on a perfectly conforming tool, so an assertion on it would be
// wrong rather than strict.
//
// THIS IS A RUN FIXTURE, NOT A REJECT. An earlier revision demanded a diagnostic
// for the LRM's own worked example.
//
// WHOM IT BINDS, WHICH IS NOT VERA. E.1.1's sentence is one implication with this
// whole family inside its consequent: "it states IF a simulator which supports
// Verilog-AMS HDL is also able to read SPICE netlists of a particular flavor,
// THEN certain objects defined in that flavor of SPICE netlist can be referenced
// from within a Verilog-AMS HDL structural description." `ECPOSC` is an object
// defined in a netlist. VerA reads no netlist, so the antecedent is false and the
// consequent requires nothing of it — and E.1.2's first bullet says so outright:
// SPICE compatibility "is solely determined by the authors of the simulator".
// This file describes a SECOND INPUT LANGUAGE, not a rule VerA breaks. It stays,
// and stays `xfail`, because it does bind a tool that reads netlists (the marker
// is ignored for every compiler but VerA) and because XPASS still guards VerA
// against resolving an instance of a module declared nowhere. spice_model.va
// carries the argument in full; do not close it by writing a netlist reader.
//
//! lrm E.2.2.2
//! lrm E.2
//! lrm E.2.1
//! lrm E.1.1
//! lrm E.1.2
//! lrm 6.7.1
//! bias V(out) = 1.0, V(gnd) = 0.25
//! xfail NOT A DEBT — the clause is conditional and its condition is false for VerA: E.2's subcircuits are "defined within SPICE netlists", VerA reads one language and no netlist, so `.SUBCKT ECPOSC` is not an object that exists, `ecpOsc` is declared nowhere and E0904 is the right answer rather than a failure to meet a requirement (E.1.1's implication; E.1.2's "solely determined by the authors of the simulator"). Table E.1's primitives are shipped and are not what is missing — the subcircuit BODY is, and it is written in SPICE. Kept rather than removed because it still binds a tool that DOES read netlists and because XPASS guards VerA against silently resolving an undeclared module
`include "check.vh"
module annex_e_spice_subcircuit(out, gnd);
  inout out, gnd; electrical out, gnd;
  ecpOsc osc1(out, gnd);
  analog begin
    `CHECKX(".SUBCKT ECPOSC (OUT GND) is a two-port interface, OUT first",
            V(osc1.out, osc1.gnd), 0.75);
  end
endmodule
