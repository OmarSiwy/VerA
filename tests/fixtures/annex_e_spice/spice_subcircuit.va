// E.2.2.2 Accessing SPICE subcircuits, transcribed. Given `.SUBCKT ECPOSC (OUT
// GND) ... .ENDS ECPOSC`, the LRM prints:
//
//     module osc (out, gnd);
//        electrical out, gnd;
//        ecpOsc Osc1 (out, gnd);
//     endmodule
//
// with the note "in Verilog-AMS HDL the name of the subcircuit instance is not
// constrained to start with X as it is in SPICE" — hence `osc1` below.
//
// WHAT IS PINNED. E.2: "The subcircuits and models contained within the SPICE
// netlist are treated as module definitions." A `.SUBCKT` is therefore an
// ordinary instantiable module name, and E.2.1 supplies the case rule that lets
// the mixed-case `ecpOsc` match the all-caps `ECPOSC` of the netlist. Nothing in
// this file declares `ecpOsc`, which is the point: the name resolves outside the
// Verilog-AMS source.
//
// THE OBSERVABLE IS THE INTERFACE THE .SUBCKT LINE DECLARES. "Treated as module
// definitions" means `(OUT GND)` is a two-port interface connected by order, and
// §6.7.1 lets the parent read a potential off the instance's ports
// hierarchically. The two nets are biased apart, so the check fails both if the
// ordered connection were reversed (it would read -0.75) and if the name
// resolved to some other object whose first port is not OUT. E.2.1 also governs
// the port spelling: `osc1.out` is the mixed-case form of the netlist's `OUT`,
// resolved by the same rule that let `ecpOsc` find `ECPOSC`.
//
// WHY NOTHING INSIDE THE SUBCIRCUIT IS ASSERTED. The body of E.2.2.2's netlist
// does fix values — `VA VCC GND 5` puts 5 V on an internal node, `R1 B1 GND 10K`
// a resistor on another — but those are potentials a SOLVE produces, and this
// harness imposes every unknown at a directive-supplied value instead of solving
// (tests/fixtures/README.md). An internal node of the subcircuit would read back
// zero, not 5, on a perfectly conforming tool, so an assertion on it would be
// wrong rather than strict.
//
// THIS IS A RUN FIXTURE, NOT A REJECT. An earlier revision demanded a diagnostic
// for the LRM's own worked example.
//
// WHERE THE NETLIST COMES FROM. E.1.1 is one implication with this whole family
// inside its consequent: "IF a simulator which supports Verilog-AMS HDL is also
// able to read SPICE netlists of a particular flavor, THEN certain objects
// defined in that flavor of SPICE netlist can be referenced from within a
// Verilog-AMS HDL structural description." `ECPOSC` is an object defined in a
// netlist, so the fixture supplies one: the `//! spice` lines below are E.2.2.2's
// netlist verbatim — the .SUBCKT header with its parenthesised port list, the two
// device cards inside it, the .ENDS — and the compiler under test does the
// reading. E.1.2's first bullet leaves the recognised flavor to "the authors of
// the simulator", and the flavor read here is declarations only: the `.SUBCKT`
// header becomes the module, and `VA`/`R1` are SKIPPED rather than refused,
// because a reader that mines a netlist for interfaces is not claiming to
// simulate it.
//
// SO THE SYNTHESIZED MODULE HAS AN EMPTY BODY, and that is the ceiling this file
// sits exactly on top of. What E.2 requires is that the subcircuit be "treated as
// a module definition", and a definition is an interface plus a body; the
// interface is here, in order, and the body is written in SPICE. An instance of
// it therefore contributes no equations — under `//! solve` it would be an open
// circuit — which is precisely why this fixture imposes both potentials with
// `//! bias` and asserts nothing about the nodes inside. See the paragraph above:
// on a conforming tool those nodes would read 5 V and this harness would still
// read 0, so the assertion this file does NOT make is not one it is missing.
//
//! lrm E.2.2.2
//! lrm E.2
//! lrm E.2.1
//! lrm E.1.1
//! lrm E.1.2
//! lrm 6.7.1
//! lrm 6.2.2
//! lrm 6.2.2:2
//! lrm 6.5.4
//! lrm 6.5.4:1
//! lrm 6.7.1:1
//! lrm E.1.1:1000
//! lrm E.2:3
//! lrm E.2.1:1
//! bias V(out) = 1.0, V(gnd) = 0.25
//! spice .SUBCKT ECPOSC (OUT GND)
//! spice VA VCC GND 5
//! spice R1 B1 GND 10K
//! spice .ENDS ECPOSC
`include "check.vh"
module annex_e_spice_subcircuit(out, gnd);
  inout out, gnd; electrical out, gnd;
  ecpOsc osc1(out, gnd);
  analog begin
    `CHECKX(".SUBCKT ECPOSC (OUT GND) is a two-port interface, OUT first",
            V(osc1.out, osc1.gnd), 0.75);
  end
endmodule
