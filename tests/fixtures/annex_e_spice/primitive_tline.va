// Table E.1 row `tline`: ports t1, b1, t2, b2, parameters z0, td, f, nl,
// behaviour — the Behavior column of this row is blank in the published table.
//
// This row is the one passive whose behaviour is not even derivable from its
// parameter names: z0 with td is a delay line, z0 with f and nl is the same line
// specified by electrical length at a frequency, and Table E.1 says which of the
// two a given instance means nowhere. That is on top of E.2's blanket
// implementation dependence, not instead of it.
//
// WHAT IS PINNED. E.3: "Table E.1 shows the REQUIRED names for primitives,
// parameters, and ports which are otherwise unnamed in SPICE. For connection by
// order instead of by name, the ports and parameters shall be given in the order
// listed. The default discipline of the ports for these primitives shall be
// electrical and their descriptions shall be inout." E.1.2 adds that "when
// instantiating SPICE primitives in Verilog-AMS HDL, the primitives shall, and
// parameters and ports can, be named", and E.2 that a tool "expected to provide
// the basic set of Spice primitives" shall treat them "in the same manner in
// Verilog-AMS HDL as built-in primitives of gate- and switch-level modeling".
// So the instantiation below — every port and every parameter named, in the
// Table E.1 order — is source a SPICE-compatible Verilog-AMS tool must accept.
//
// THIS IS A RUN FIXTURE, NOT A REJECT. An earlier revision of this file demanded
// a diagnostic for the line below. That inverts the test: the LRM prints this
// syntax as legal, so a conforming compiler would FAIL and only a compiler with
// no SPICE support would pass. The requirement is that it compiles, and it does:
// VerA ships Table E.1 as ordinary module declarations in a prelude, the same
// shape as annex D's disciplines.vams (`Preprocessor.spice_primitives`).
//
// WHAT CANNOT BE PINNED, AND WHY THAT IS THE LRM'S DOING. Table E.1's Behavior
// column for this row is EMPTY, and E.2 says why: "while the Verilog-AMS HDL
// built-in primitives are standardized, the SPICE primitives are not. All aspects
// of SPICE primitives are implementation dependent." E.1.1 adds that "the
// mathematical description of the built-in primitives can differ". So there is no
// device law here to write digits for — a fixture that asserted one would be
// pinning a particular simulator's convention, and one that asserted the
// primitive contributes NOTHING would be pinning VerA's. Neither is a
// requirement. What Table E.1 does require of this row is its INTERFACE, and that
// is what the digits below are for.
//
// HOW IT IS OBSERVED. §6.7.1: "Potential and flow access for named and unnamed
// branches (including port branches) can be done hierarchically", and "access of
// parameters can be done hierarchically". So `V(x1.t1, x1.b1)` is the potential
// across the primitive's OWN port pair, reached by an out-of-module reference, and
// `x1.z0` is the parameter the override landed on. The bias values are all
// different and all dyadic, so every port carries a distinct exact digit: a tool
// that bound Table E.1's names to a different net, or read the positional list in
// another order, reads a different number. That is the claim, because E.3 fixes
// the port ORDER as well as the names and x2 below connects by order.
//
//! lrm E.3
//! lrm E.3:1
//! lrm E.3:2
//! lrm E.1.2
//! lrm E.1.2:1
//! lrm E.2
//! lrm E.2:2
//! lrm 6.7.1
//! lrm 6.2.2
//! lrm 6.2.2:2
//! lrm 6.3.2
//! lrm 6.3.2:1
//! lrm 6.5.4
//! lrm 6.5.4:1
//! lrm 6.7.1:1
//! bias V(t1) = 1.0, V(b1) = 0.25, V(t2) = 0.5, V(b2) = 0.125
`include "check.vh"
module annex_e_primitive_tline(t1, b1, t2, b2);
  inout t1, b1, t2, b2; electrical t1, b1, t2, b2;
  tline #(.z0(50.0), .td(1n), .f(1G), .nl(1.0)) x1(.t1(t1), .b1(b1), .t2(t2), .b2(b2));
  // E.3, "for connection by order instead of by name, the ports and parameters
  // shall be given in the order listed": the same primitive, nothing named.
  tline #(75.0, 2n, 2G, 0.5) x2(t1, b1, t2, b2);
  analog begin
    `CHECKX("Table E.1 pairs t1 with b1", V(x1.t1, x1.b1), 0.75);
    `CHECKX("and t2 with b2", V(x1.t2, x1.b2), 0.375);
    `CHECKX("connected by order, ports 1..2 are t1, b1", V(x2.t1, x2.b1), 0.75);
    `CHECKX("and ports 3..4 are t2, b2", V(x2.t2, x2.b2), 0.375);
    `CHECKX("the named overrides reach z0", x1.z0, 50.0);
    // §2.6.2 Table 2-1: `n` is 1e-9 and `G` is 1e9.
    `CHECKX("and td, in seconds", x1.td, 1.0e-9);
    `CHECKX("and f, in hertz", x1.f, 1.0e9);
    `CHECKX("and nl, a count of wavelengths", x1.nl, 1.0);
    `CHECKX("by order, parameter 1 is z0", x2.z0, 75.0);
    `CHECKX("parameter 2 is td", x2.td, 2.0e-9);
    `CHECKX("parameter 3 is f", x2.f, 2.0e9);
    `CHECKX("parameter 4 is nl", x2.nl, 0.5);
    I(t1, b1) <+ 0.0;
  end
endmodule
