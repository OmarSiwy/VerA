// E.3.2.1: port_discipline on ordinary modules and their ports is ignored.
// Unlike an analog primitive, these instances must not validate/apply either
// the numeric instance attribute or the nonexistent discipline on a connection.
// All ports explicitly remain electrical. With V(p)-V(n)=0.5 V, the two
// 1 kohm children carry 0.5 mA each; the shared branch carries 1 mA.
//! lrm E.3.2.1
//! lrm 2.9
//! lrm 6.7.1
//! lrm 6.7.1:1
//! lrm E.3.2.1:4
//! bias V(p) = 0.75, V(n) = 0.25
`include "check.vh"
module audit_e_ordinary_leaf(p,n);
  inout p,n; electrical p,n;
  analog I(p,n) <+ V(p,n)/1000.0;
endmodule
module audit_e_attribute_ignored(p,n);
  inout p,n; electrical p,n;
  (* port_discipline=23 *) audit_e_ordinary_leaf a(p,n);
  audit_e_ordinary_leaf b((* port_discipline="not_a_discipline" *) p,n);
  analog begin
    `CHECKX("ordinary instance attribute leaves electrical potential", V(a.p,a.n), 0.5);
    `CHECKX("ordinary connection attribute leaves electrical potential", V(b.p,b.n), 0.5);
    `CHECKR("both ordinary modules contribute", I(p,n), 1.0e-3, 1e-12);
  end
endmodule
