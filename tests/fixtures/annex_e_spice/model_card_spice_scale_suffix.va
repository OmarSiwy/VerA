// H04 — the number on a model card is written in SPICE's own scaled notation,
// and `10K` means ten thousand.
//
// THE CLAUSE, AND WHY THE SUFFIX IS NOT OPTIONAL. Annex E prints its own
// netlists, and every numeric literal in them carries a suffix. E.2.2.1's model
// card is
//
//     .MODEL VERTNPN NPN BF=80 IS=1E-18 RB=100 VAF=50
//     + CJE=3PF CJC=2PF CJS=2PF TF=0.3NS TR=6NS
//
// and E.2.2.2's subcircuit is `L1 VCC OUT 1UH`, `C1 VCC OUT 1P`,
// `C2 OUT B1 272.7PF`, `R1 B1 GND 10K`. E.1.1's premise is that the tool "is
// also able to READ SPICE netlists of a particular flavor"; a reader that
// cannot turn `10K` into 10000 cannot read the annex's own printed examples, so
// the antecedent E.1.1 conditions everything on is false for it.
//
// E.2.2.3 then translates that same netlist to Verilog-AMS and writes the
// resistor as `resistor #(.r(10k)) R1 (b1, gnd);` — `10k`, which §2.6.2 Table
// 2-1 makes 10 x 1e3 = 10000. The two spellings are the annex's own statement
// that they denote the same resistor, which is exactly what this fixture pins.
//
// THE DIGITS, BY HAND. The card is `.MODEL RK R R=10K`, so r = 10000 with the
// card's suffix read as SPICE's kilo. `//! bias` puts 1.0 V across the port
// branch; the card gives no tc1/tc2, so Table E.1's factor (1 + tc1*T + tc2*T^2)
// is 1 exactly and the row V = I*r inverts to
//
//     I(p, n) = 1.0 / 10000 = 1.0e-4 A
//
// A tool that read `10K` as the bare integer 10 would answer 0.1 A — a factor of
// a thousand, not a rounding — and one that dropped the assignment entirely
// answers 1.0 A against the primitive's own default. Both are caught.
//
// THE UNIT LETTER IS PART OF THE SUFFIX AND CARRIES NO VALUE. SPICE writes
// `3PF`, `1UH`, `0.3NS`: scale letter then unit letters, and the unit letters
// are noise. Only the scale is asserted here, on a row whose unit would be
// `OHM`; the reactive spelling is fixture 04's `C=1E-3`, deliberately written
// without a suffix so the two failures stay separable.
//
// WHAT VerA DOES TODAY. `lib/frontend/spice_cards.zig` does not read the value
// half of a `k=v` pair at all — `isSpiceName` rejects any token containing `=`
// and the card's parameters never leave the reader. So `r1.r` does not resolve
// and the instance is the prelude's 1 ohm.
//
//! lrm E.1.1
//! lrm E.2.2.1
//! lrm E.2.2.2
//! lrm E.2.2.3
//! lrm 2.6.2
//! bias V(a) = 1.0, V(b) = 0.0
//! spice .MODEL RK R R=10K
`include "check.vh"
module h04_model_card_suffix(a, b);
  inout a, b; electrical a, b;
  rk r1(a, b);
  analog begin
    `CHECKX("SPICE `10K` is E.2.2.3's `10k`, which 2.6.2 Table 2-1 makes 10000",
            r1.r, 10000.0);
    `CHECKR("Table E.1: I = V/r = 1.0/10000", I(r1.p, r1.n), 1.0e-4, 1e-15);
  end
endmodule
