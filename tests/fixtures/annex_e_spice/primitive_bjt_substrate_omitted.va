// E.2.2.1: "This bjt primitive has 3 mandatory ports (c, b, and e) and one
// optional port (s). In the instantiation of Q1, the ports are passed by
// order. With Q2, the ports are passed by name. In both cases, the optional
// substrate port s is defaulted by simply not giving it." Figure E.1 prints
// both forms; they are reproduced below on the Table E.1 `bjt` row
// (primitive_bjt.va connects all four ports).
//
// E.3 fixes the port order c, b, e, s, so x2's three ordered connections
// bind c, b and e and leave s off; x1 names three and leaves s off. Both must
// compile, and the three given ports must land where the names say: with the
// dyadic biases below, V(x.c, x.b) = 1.0 - 0.5 = 0.5 and
// V(x.b, x.e) = 0.5 - 0.25 = 0.25, exact (CHECKX). What the defaulted s
// connects to is the primitive's business (E.2: "All aspects of SPICE
// primitives are implementation dependent"), so nothing reads it.
//
// No refusal neighbour: the clause names no invalid form of the omission.
//
//! lrm E.2.2.1
//! lrm E.3
//! lrm 6.7.1
//! bias V(c) = 1.0, V(b) = 0.5, V(e) = 0.25
//! checks 4
`include "check.vh"
module annex_e_primitive_bjt_substrate_omitted(c, b, e);
  inout c, b, e; electrical c, b, e;
  bjt x1(.c(c), .b(b), .e(e));
  bjt x2(c, b, e);
  analog begin
    `CHECKX("Q2 form: named c and b land on c and b", V(x1.c, x1.b), 0.5);
    `CHECKX("Q2 form: named e lands on e", V(x1.b, x1.e), 0.25);
    `CHECKX("Q1 form: ordered ports 1, 2 are c, b", V(x2.c, x2.b), 0.5);
    `CHECKX("Q1 form: ordered port 3 is e", V(x2.b, x2.e), 0.25);
    I(c, e) <+ 0.0;
  end
endmodule
