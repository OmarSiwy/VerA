// §2.9 VerA's `vera_seed` whose value reads a probe.
//
// A `vera_seed` is the value a branch starts at BEFORE the first Newton
// iterate (SPICE MODEINITJCT, mos1load.c:397-408). VerA lets it go past §2.9's
// `constant_expression`, because a SPICE start value is computed from the
// card and the temperature (`tVto`), but no solution exists yet: it may never
// read a probe or anything computed from one. E0527 names that.
//! lrm 2.9
//! reject E0527
module reject_limit_vera_seed_reads_solution(p, n);
  inout p, n; electrical p, n, a;
  parameter real vt = 0.025, vcrit = 0.6;
  real v, vp;
  analog begin
    vp = 0.5 * V(p, n);
    (* vera_seed = vp *) v = $limit(V(a, n), "pnjlim", vt, vcrit);
    I(p, a) <+ V(p, a) / 10.0;
    I(a, n) <+ 1e-14 * (limexp(v / vt) - 1.0);
  end
endmodule
