// LRM E.1.2: "whether a particular Verilog-AMS simulator is SPICE compatible,
// and with which particular variant of SPICE it is compatible, is solely
// determined by the authors of the simulator." VerA claims SPICE3 card syntax
// for `.MODEL` and for flat `.SUBCKT` bodies of numeric-valued
// R/C/L/V/I/E/F/G/H cards (Vague_Decisions VD-012). Inside a definition,
// anything else is refused rather than skipped: a skipped card changes the
// circuit (a dropped R is an open), the silent wrong answer VerA
// forbids.
//
// An S card (a voltage-controlled switch) has no Table E.1 row and no reader
// in VerA, so the subcircuit cannot be the circuit its netlist describes.
// (This file used a Q card until Q, M, J and D cards became readable with a
// model: spice_fet_card_instantiates_model_module.va; a Q bound to a Table E.1
// `npn` model is reject_spice_fet_card_model_has_no_behaviour.va's E0953.)
//
// Legal neighbour: h04_06_subckt_body_contributes_equations.va, the same RDIV
// with two numeric R cards, which compiles and divides 1 V into 0.75/0.25.
//
//! lrm E.1.2
//! lrm E.2
//! bias V(in) = 1.0, V(gnd) = 0.0
//! reject-only E0928
//! reject device card is not one VerA reads
//! neighbour h04_06_subckt_body_contributes_equations.va
//! neighbour spice_fet_card_instantiates_model_module.va
//! spice .SUBCKT RDIV IN OUT GND
//! spice R1 IN OUT 1K
//! spice R2 OUT GND 3K
//! spice S1 OUT GND IN GND SWMOD
//! spice .ENDS RDIV
`include "check.vh"
module rdiv_user(in, gnd);
  inout in, gnd; electrical in, gnd;
  rdiv x1(in, mid, gnd);
endmodule
