// LRM E.1.2: "whether a particular Verilog-AMS simulator is SPICE compatible,
// and with which particular variant of SPICE it is compatible, is solely
// determined by the authors of the simulator." VerA claims SPICE3 card syntax
// for `.MODEL` and for flat `.SUBCKT` bodies of numeric-valued
// R/C/L/V/I/E/F/G/H cards (Vague_Decisions VD-012). Inside a definition,
// anything else is refused rather than skipped: a skipped card changes the
// circuit (a dropped R is an open), the silent wrong answer AGENTS.md §4
// forbids.
//
// A Q card has no Table E.1 equation VerA reads in a body (E.2 leaves the
// bjt's behaviour implementation dependent), so the subcircuit cannot be the
// circuit its netlist describes.
//
// Legal neighbour: h04_06_subckt_body_contributes_equations.va, the same RDIV
// with two numeric R cards, which compiles and divides 1 V into 0.75/0.25.
//
//! lrm E.1.2
//! lrm E.2
//! bias V(in) = 1.0, V(gnd) = 0.0
//! reject E0928
//! reject device card is not one VerA reads
//! spice .SUBCKT RDIV IN OUT GND
//! spice R1 IN OUT 1K
//! spice R2 OUT GND 3K
//! spice Q1 OUT IN GND QMOD
//! spice .ENDS RDIV
`include "check.vh"
module rdiv_user(in, gnd);
  inout in, gnd; electrical in, gnd;
  rdiv x1(in, mid, gnd);
endmodule
