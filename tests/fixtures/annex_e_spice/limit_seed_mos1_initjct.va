// §9.17.3 `$limit`'s seed argument: SPICE's MOS1 cold start.
//
// §9.17.3: "the simulator is responsible for determining if limiting should
// be applied and what the return value is on a given iteration." The first
// iteration included. ngspice MODEINITJCT (mos1load.c:397-408, the same in
// mos2/3/6/9) starts a MOSFET at BRANCH values, in the device frame:
//
//     vbs = -1;
//     vgs = model->MOS1type * here->MOS1tVto;
//     vds = 0;
//
// §9.17.3 names the arguments each string "requires" ("One additional
// argument ... is required when the second argument ... is the string
// "fetlim"") and lets "Simulators ... support other built-in functions", so
// what follows the required ones is the implementation's. VerA reads the
// algorithm's arguments, then the frame sign, then the seed: the value the
// site's branch starts at, in the frame of the sign. The host keeps NODE
// values, so VerA solves the branches into nodes as a tree rooted at 0 V:
// ground, else the lowest port, else the lowest net. The vgd and vbd legs are
// derived through vds and are not edges. The seed may read what the device
// computes from its card (here `vtox`, as mos1load.c reads the
// temperature-adjusted tVto), since `seed` runs after the card is set.
//
// U = d, g, s, b, di, si. The seeded nets are g, si, di, b; the lowest port
// among them is g, so g = 0. type = 1, vto = 0.7:
//   vgs = g - si = 0.7   ->  si = -0.7
//   vds = di - si = 0    ->  di = -0.7
//   vbs = b - si = -1    ->  b  = -1.7
// d and s carry no seed and stay null; every seeded lane is in limit_writes.
//
// The first `limit` after `seed` reads that image as `old`. With cur equal to
// it nothing clamps and g, a lane only `seed` writes, comes back as cur.
// At the bias the model evaluates, §9.17.3's "When the simulator has
// converged, the return value of the $limit() function is the value of the
// access function reference, within appropriate tolerances" is the CHECK
// (1e-6: Annex D's `nature Voltage` abstol, as limit_fet.va argues).
//! lrm 9.17.3
//! bias V(g) = 0.0, V(si) = -0.7, V(di) = -0.7, V(b) = -1.7
//! print none
//! seed V(g) = 0.0, V(si) = -0.7, V(di) = -0.7, V(b) = -1.7
//! limit -> V(g) = 0.0, V(si) = -0.7, V(di) = -0.7, V(b) = -1.7, converged = 1
`include "check.vh"
module limit_seed_mos1_initjct(d, g, s, b);
  inout d, g, s, b; electrical d, g, s, b, di, si;
  parameter real type = 1.0, vto = 0.7, vt = 0.025, vcrit = 0.6;
  real vtox, vgs, vgd, vds, vbs, vbd;
  analog begin
    vtox = type * vto;
    vgs = type * $limit(V(g, si), "fetlimds", type * vtox, type, type * vtox);
    vgd = type * $limit(V(g, di), "fetlimds", type * vtox, type);
    vds = type * $limit(V(di, si), "limvds", type, 0.0);
    vbs = type * $limit(V(b, si), "pnjlimds", vt, vcrit, type, -1.0);
    vbd = type * $limit(V(b, di), "pnjlimds", vt, vcrit, type);
    I(d, di) <+ V(d, di) / 10.0;
    I(s, si) <+ V(s, si) / 10.0;
    I(di, si) <+ type * 1e-3 * (vds + 0.1 * (vgs + vgd));
    I(b, si) <+ type * 1e-14 * (limexp(vbs / vt) - 1.0);
    I(b, di) <+ type * 1e-14 * (limexp(vbd / vt) - 1.0);
    `CHECK("$limit returns its access function at the answer", vgs, 0.7, 1e-6);
  end
endmodule
