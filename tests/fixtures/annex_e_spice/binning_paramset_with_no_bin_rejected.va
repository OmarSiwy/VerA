// E.4.2 Binning and libraries: "Some SPICE netlists provide mechanisms for
// mapping an instance to a group of models, with the final determination of
// which model to use being based on rules encapsulated in the SPICE netlist.
// Examples include model binning ... Similar functionality for Verilog-AMS is
// supported through use of the paramset, as described in 6.4. Instead of
// referencing a specific module, and instance may refer to a paramset
// identifier, and there may be several paramsets with the same identifier
// (name). The final determination of which paramset to use is made according
// to rules specified in 6.4.2."
//
// ("and instance" is the published wording.) So a length bin is two paramsets
// named `nch`, each admitting one range of `l`, and an instance of `nch` is
// assigned to whichever admits its length. §6.4.2: "During elaboration, the
// simulator shall choose an appropriate paramset from the set sharing a given
// name for every instance that references that name. When choosing an
// appropriate paramset, the following rules shall be enforced: ... The
// parameters of the paramset, with overrides and defaults, shall all be within
// the allowed ranges specified in the paramset parameter declaration."
//
// The bins below cover [0.25u, 1u) and [1u, 20u]. The instance asks for 50u,
// so the enforced range rule rules out both, and no appropriate paramset
// exists for the "shall choose" to choose — the binning failure a SPICE model
// library reports as "no model for this geometry". The clause's tie-breaking
// rules only order paramsets that are still applicable, so they cannot rescue
// an empty set. `#(.l(5u))` lands in the second bin and compiles (probed).
//
// VerA reports E0911 "no paramset admits this instance's parameter values".
//
//! lrm E.4.2
//! lrm 6.4.2
//! lrm 6.4.2:4
//! reject-only E0911
//! reject no paramset named `nch` admits these parameter values
`include "disciplines.vams"
module e42_top(p, n);
  inout p, n; electrical p, n;
  nch #(.l(50u)) m1(p, n);               // illegal: outside every bin
endmodule

module e42_mos(d, s);
  inout d, s; electrical d, s;
  parameter real l = 1u;
  analog I(d, s) <+ V(d, s) * 1.0e-6 / l;
endmodule

paramset nch e42_mos;
  parameter real l = 1u from [0.25u:1u);
  .l = l;
endparamset

paramset nch e42_mos;
  parameter real l = 1u from [1u:20u];
  .l = l;
endparamset
