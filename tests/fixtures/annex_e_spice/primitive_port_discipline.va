// E.3.2.1, second worked example, transcribed. The LRM prints:
//
//     resistor #(.r(1k)) r3
//        ((* port_discipline="rotational" *) node1,
//         (* port_discipline="rotational" *) node2);
//
// WHAT IS PINNED. The PER-PORT form of the attribute: E.3.2.1 says
// port_discipline "shall only apply to either the analog primitive itself or the
// port to which it is attached", and this is the second of those two positions.
// A.4.1.1 admits it there — `ordered_port_connection ::= {attribute_instance}
// [expression]` — which is why every E.3.2.1 example puts the attribute on an
// instantiation or a port connection and never on a module header port.
//
// HOW A DISCIPLINE IS MADE OBSERVABLE. A discipline is not a value any
// behavioural expression reads back. What it decides is which ACCESS FUNCTIONS
// the net has, and that is checkable: Annex D gives `rotational` the natures
// Angle and Angular_Force, accessed as `Theta` and `Tau`, where `electrical` has
// `V` and `I`. Both of r3's ports carry the attribute, so both are rotational
// and the primitive's own branch is probed as `Theta(r3.p, r3.n)` and
// `Tau(r3.p, r3.n)` — spellings that do not exist on an electrical net, so a
// tool that ignored the per-port attribute cannot get through this file.
// §6.7.1 is what allows the branch to be reached from the parent at all:
// "potential and flow access for named and unnamed branches (including port
// branches) can be done hierarchically".
//
// The digits are Table E.1's resistor row, V = I*r, whose V and I are the
// table's nature-neutral spelling of the port pair's potential and flow: with
// 2 rad imposed across the branch and r = 1k, the torque is 2.0/1000 N*m.
//
// node1 and node2 ARE DECLARED `rotational` here, where the LRM's snippet does
// not declare them at all. That is the declaration the attribute implies: both
// ports of the primitive are rotational, so an electrical net pair would be a
// §3.11 incompatibility. It also keeps the attribute load-bearing rather than
// redundant — a tool that dropped it would leave r3's ports at E.3.2's
// `electrical` default and hit that incompatibility from the other side.
//
// THIS IS A RUN FIXTURE, NOT A REJECT. An earlier revision demanded a diagnostic
// for an example the LRM prints.
//
//! lrm E.3.2.1
//! lrm E.3
//! lrm A.4.1.1
//! lrm 2.9
//! lrm 6.7.1
//! bias node1 = 2.0, node2 = 0.0
//! xfail VerA rejects module instantiation (E0204), so a primitive port carrying port_discipline cannot be reached
`include "check.vh"
module annex_e_primitive_port_discipline(node1, node2);
  inout node1, node2; rotational node1, node2;
  resistor #(.r(1k)) r3(
      (* port_discipline="rotational" *) node1,
      (* port_discipline="rotational" *) node2);
  analog begin
    `CHECKX("r3 keeps its 1k", r3.r, 1000.0);
    `CHECKX("the attributed ports are probed with Annex D's Theta",
            Theta(r3.p, r3.n), 2.0);
    // Table E.1 V = I*r, read in the rotational natures: Tau = 2.0/1000.
    `CHECKR("Table E.1 V = I*r on the rotational branch",
            Tau(r3.p, r3.n), 2.0e-3, 1e-15);
  end
endmodule
