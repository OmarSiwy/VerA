// E.3.1 "Verilog-AMS HDL does not support the concept of passing an instance
// name as a parameter. As such, the following primitives are not supported:
// ccvs, cccs, and mutual inductors; however, these primitives can be
// instantiated inside a SPICE subcircuit that itself is instantiated in
// Verilog-AMS."
//
// The positive half — the clause's "however". unsupported_cccs.va,
// unsupported_ccvs.va and unsupported_mutual_inductor.va pin the refusal of
// those primitives written in Verilog-AMS; this file puts a cccs where E.3.1
// says it CAN go: an `F` card inside a `.SUBCKT`, which the module instantiates
// (E.2: "The subcircuits and models contained within the SPICE netlist are
// treated as module definitions").
//
// THE NETLIST. A current-controlled current source mirroring the current
// through a zero-volt sense source:
//
//     .SUBCKT CMIRROR IN OUT GND
//     VS IN SNS 0        sense source: I(VS) flows IN -> SNS through it
//     RS SNS GND 1K
//     F1 GND OUT VS 2    2 * I(VS) flows from GND through F1 into OUT
//     RL OUT GND 1K
//     .ENDS CMIRROR
//
// THE DIGITS, BY HAND, with SPICE's F-element convention (current
// gain * I(Vcontrol) flows from n+ through the source to n-; I(Vcontrol) is the
// current entering the source's + terminal). `//! bias` holds in at 1.0 V and
// gnd at 0.0 V:
//
//     I(VS)      = V(in) / RS          = 1.0 / 1000   = 1.0e-3 A
//     F1         = 2 * 1.0e-3          = 2.0e-3 A, from GND into OUT
//     V(out,gnd) = 2.0e-3 * RL         = 2.0e-3 * 1000 = 2.0 V
//
// A cccs dropped or read as an open circuit leaves V(out) at 0; a sign error in
// the controlling current gives -2.0.
//
//! lrm E.3.1
//! lrm E.2
//! bias V(in) = 1.0, V(gnd) = 0.0
//! solve
//! xfail VerA's SPICE reader drops the F (cccs) card of a .SUBCKT body without a diagnostic (spice_cards.zig `device_cards` reads only R, C, L, V, I), so the mirror contributes nothing and V(out) reads 0 where E.3.1 says a cccs inside a subcircuit is instantiable
//! spice .SUBCKT CMIRROR IN OUT GND
//! spice VS IN SNS 0
//! spice RS SNS GND 1K
//! spice F1 GND OUT VS 2
//! spice RL OUT GND 1K
//! spice .ENDS CMIRROR
`include "check.vh"
module annex_e_cccs_inside_a_spice_subcircuit(in, gnd);
  inout in, gnd; electrical in, gnd;
  cmirror x1(in, out, gnd);
  analog begin
    `CHECK("E.3.1 a cccs inside a SPICE subcircuit mirrors 2x the sensed current into 1k",
           V(x1.out, x1.gnd), 2.0, 1e-9);
  end
endmodule
