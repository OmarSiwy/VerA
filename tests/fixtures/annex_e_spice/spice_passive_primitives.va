// E.3, on connection BY ORDER: "Table E.1 shows the required names for
// primitives, parameters, and ports which are otherwise unnamed in SPICE. For
// connection by order instead of by name, the ports and parameters shall be
// given in the order listed." E.2 makes the primitives themselves required of a
// SPICE-compatible tool: "SPICE primitives built into the simulator shall be
// treated in the same manner in Verilog-AMS HDL as built-in primitives of gate-
// and switch-level modeling."
//
// WHAT IS PINNED. Table E.1's `resistor` BEHAVIOR column, with digits:
//
//     V = I * r * (1 + tc1*T + tc2*T^2)
//
// tc1 and tc2 are given as zero, which collapses the temperature polynomial to
// exactly 1 at every T and leaves the equation with no free reading: I = V/r.
// With `//! bias` holding p at 1 V and n at 0 V and r = 1k, the primitive shall
// carry 1.0/1000 = 1.0e-3 A from p to n. passive_named_ports.va gives tc1 and
// tc2 NONZERO and therefore cannot pin a current — see its header — so this is
// the file where the row's behaviour column is evaluated.
//
// The ordered connection is what the digit tests: the sign of the current says
// which net the FIRST positional port went to. A tool that read the list as
// (n, p) stamps -1.0e-3 and fails.
//
// HOW THE PRIMITIVE IS OBSERVED. §6.7.1: "Potential and flow access for named
// and unnamed branches (including port branches) can be done hierarchically",
// and "access of parameters can be done hierarchically". So `I(r1.p, r1.n)` is
// the flow of the primitive's own p-n branch — the branch the behaviour column
// describes — reached by an out-of-module reference, and `r1.r` is the parameter
// the `.r(1k)` override landed on. Table E.1 is what gives those two names:
// E.1.2, "when instantiating SPICE primitives in Verilog-AMS HDL, the primitives
// shall, and parameters and ports can, be named".
//
// THIS IS A RUN FIXTURE, NOT A REJECT. An earlier revision demanded a diagnostic
// here; that inverts the test, because the LRM prints the syntax and only a tool
// with no SPICE support would pass. E.2.2.3 prints this primitive ordered —
// `resistor #(.r(10k)) R1 (b1, gnd);`.
//
//! lrm E.3
//! lrm E.2
//! lrm E.2.2.3
//! lrm 6.7.1
//! bias V(p) = 1.0, V(n) = 0.0
//! xfail VerA rejects module instantiation (E0204), so an ordered primitive connection cannot be reached
`include "check.vh"
module annex_e_spice_passive_primitives(p, n);
  inout p, n; electrical p, n;
  resistor #(.r(1k), .tc1(0.0), .tc2(0.0)) r1(p, n);
  analog begin
    // §2.6.2 Table 2-1 gives `k` the value 1e3, so `1k` is 1000.0.
    `CHECKX("the r override reaches Table E.1's r parameter", r1.r, 1000.0);
    `CHECKX("tc1 is zero, so the linear temperature term vanishes", r1.tc1, 0.0);
    `CHECKX("tc2 is zero, so the quadratic term vanishes", r1.tc2, 0.0);
    // V = I*r*(1 + 0*T + 0*T^2)  =>  I = 1.0/1000. 1e-15 relative is ~4 ulp,
    // the freedom a tool has in evaluating the polynomial factor and in
    // stamping a conductance rather than dividing.
    `CHECKR("Table E.1: I = V/r = 1.0/1000, p to n", I(r1.p, r1.n), 1.0e-3, 1e-15);
  end
endmodule
