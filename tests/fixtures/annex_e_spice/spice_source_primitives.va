// E.3 / Table E.1 row `vsine`, with every one of its fourteen parameters named:
// dc, mag, phase, offset, ampl, freq, td, damp, sinephase, ammodindex,
// ammodfreq, ammodphase, fmmodindex, fmmodfreq, in that order. E.1.2 is the
// reason the list has names at all — "many primitives, parameters, and ports are
// unnamed in SPICE... to reduce this, a list of what names shall be used for the
// more common components is shown in Table E.1" — and E.2.2.3 instantiates this
// very primitive: `vsine #(.dc(5)) Vcc (vcc, gnd);`.
//
// WHAT IS PINNED. That the full Table E.1 parameter set of the independent
// source is spelled AND LANDS WHERE THE TABLE SAYS. Giving all fourteen is the
// point: a tool that implemented a shorter SPICE-flavour parameter list fails
// here and passes a one-parameter instance. The fourteen values are all
// different from each other, and each is read back through the instance by name
// (§6.7.1, "access of parameters can be done hierarchically"), so no permutation
// of the fourteen — an ammodfreq taken for an fmmodfreq, a damp taken for a
// freq — survives. They are chosen exactly representable in binary, so every
// want is an exact equality rather than a tolerance.
//
// WHAT IS NOT ASSERTED, AND WHY NOT. The row's Behavior column is a full
// fourteen-parameter AM/FM expression, and it is a POTENTIAL the source forces.
// This harness imposes every unknown instead of solving (see
// tests/fixtures/README.md), so a probe of the sourced pair reads back whatever
// bias was handed in — an assertion on it would restate the directive and could
// not fail for a tool with the waveform wrong. The waveform therefore has no
// honest digit here; it needs a solver, not a bias. The port association does
// have one, and it is checked: the connection is written .n before .p, which
// §6.5.5 makes the same circuit, and the two nets are biased apart so a tool
// that read the named list positionally gets the sign wrong.
//
// THIS IS A RUN FIXTURE, NOT A REJECT. An earlier revision demanded a diagnostic
// for source E.2.2.3 prints.
//
//! lrm E.3
//! lrm E.1.2
//! lrm E.2.2.3
//! lrm 6.5.5
//! lrm 6.7.1
//! bias V(hi) = 1.0, V(lo) = 0.25
//! xfail VerA rejects module instantiation (E0204), so a Table E.1 source primitive cannot be reached
`include "check.vh"
module annex_e_spice_source_primitives(hi, lo);
  inout hi, lo; electrical hi, lo;
  vsine #(.dc(0.5), .mag(1.5), .phase(0.25), .offset(2.5), .ampl(3.5),
      .freq(1k), .td(1n), .damp(2.0), .sinephase(0.75),
      .ammodindex(0.125), .ammodfreq(10k), .ammodphase(0.375),
      .fmmodindex(0.625), .fmmodfreq(20k)) v1(.n(lo), .p(hi));
  analog begin
    // §2.6.2 Table 2-1: k = 1e3, n = 1e-9.
    `CHECKX("dc", v1.dc, 0.5);
    `CHECKX("mag", v1.mag, 1.5);
    `CHECKX("phase", v1.phase, 0.25);
    `CHECKX("offset", v1.offset, 2.5);
    `CHECKX("ampl", v1.ampl, 3.5);
    `CHECKX("freq", v1.freq, 1000.0);
    `CHECKX("td", v1.td, 1.0e-9);
    `CHECKX("damp", v1.damp, 2.0);
    `CHECKX("sinephase", v1.sinephase, 0.75);
    `CHECKX("ammodindex", v1.ammodindex, 0.125);
    `CHECKX("ammodfreq", v1.ammodfreq, 10000.0);
    `CHECKX("ammodphase", v1.ammodphase, 0.375);
    `CHECKX("fmmodindex", v1.fmmodindex, 0.625);
    `CHECKX("fmmodfreq, and it is not ammodfreq", v1.fmmodfreq, 20000.0);
    `CHECKX(".p(hi)/.n(lo) put the source across hi-lo, p first: 1.0 - 0.25",
            V(v1.p, v1.n), 0.75);
  end
endmodule
