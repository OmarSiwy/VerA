// Table E.1 row `vexp`: ports p, n, parameters dc, mag, phase, val0, val1, td0,
// tau0, td1, tau1, behaviour
//
//     V =  dc                                  for t <= td0
//          val1 - (val1 - dc)*e^((td0-t)/tau0) for td0 < t <= td1
//          val0 - (val0 - Vtd1)*e^((td1-t)/tau1) for td1 < t
//
// with Vtd1 the value of V at time t = td1. The iexp row with V for I, and `dc`
// rather than `val0` before td0.
//
// WHAT IS PINNED. E.3: "Table E.1 shows the REQUIRED names for primitives,
// parameters, and ports which are otherwise unnamed in SPICE. For connection by
// order instead of by name, the ports and parameters shall be given in the order
// listed. The default discipline of the ports for these primitives shall be
// electrical and their descriptions shall be inout." E.1.2 adds that "when
// instantiating SPICE primitives in Verilog-AMS HDL, the primitives shall, and
// parameters and ports can, be named", and E.2 that a tool "expected to provide
// the basic set of Spice primitives" shall treat them "in the same manner in
// Verilog-AMS HDL as built-in primitives of gate- and switch-level modeling".
// So the instantiation below — every port and every parameter named, in the
// Table E.1 order — is source a SPICE-compatible Verilog-AMS tool must accept.
//
// THIS IS A RUN FIXTURE, NOT A REJECT. An earlier revision of this file demanded
// a diagnostic for the line below. That inverts the test: the LRM prints this
// syntax as legal, so a conforming compiler would FAIL and only a compiler with
// no SPICE support would pass. The requirement is that it compiles, and it does:
// VerA ships Table E.1 as ordinary module declarations in a prelude, the same
// shape as annex D's disciplines.vams (`Preprocessor.spice_primitives`).
//
// THE DIGITS. Table E.1 gives this row three branches, and all three are pinned at
// ONE time point, t = 2 ns, by three instances whose td0/td1 put that instant in a
// different branch of each. e is the only transcendental involved and the exponents
// are exactly -1, so every want below is a decimal a reader can check against
// e = 2.718281828459045… by hand.
//
//   x1  td0 = 3n, so t <= td0        the FIRST branch
//   x2  td0 = 1n, td1 = 9n           the middle branch, exponent (td0-t)/tau0 = -1
//   x3  td0 = 0, td1 = 1n            the third branch, exponent (td1-t)/tau1 = -1
//
//   middle:  val1 - (val1-dc)*e^-1  =  1m - (1m - 5m)/e  =  2.4715177646857693e-3
//   third:   val0 - (val0 - X)*e^-1 with X the middle branch AT td1, which is the
//            same 2.4715177646857693e-3 because td1 - td0 = tau0 there too, so
//            7m - (7m - 2.4715177646857693e-3)/e = 5.334064485917797e-3
//
// `Xtd1` is "the value at time t = td1" — a CLOSED FORM, not a recurrence over the
// timestep, which is why x3's want is a number and not a tolerance band.
//
// dc AND val0 ARE DELIBERATELY DIFFERENT, 5m against 7m. The iexp row's first
// branch is val0 and the vexp row's is dc; they are otherwise the same three
// lines, so the ONLY thing separating the two rows of Table E.1 is which of those
// two parameters answers before td0. x1's want is what says which — swap the two
// rows' first branches and it reads the other number.
//
// HOW THE PRIMITIVE IS OBSERVED. §6.7.1: "Potential and flow access for named
// and unnamed branches (including port branches) can be done hierarchically",
// and "access of parameters can be done hierarchically". So `V(x1.p, x1.n)` is the
// potential of the primitive's own port pair — the branch Table E.1's Behavior
// column is written about — reached by an out-of-module reference, and `x1.dc` is
// the parameter an override landed on. Nothing else could observe the row: the
// Behavior column belongs to the primitive's branches, not to this module's.
//
// ONE INSTANCE PER NET PAIR, and that is load-bearing. Two unnamed branches over
// the same pair of nets share one accumulator in VerA today
// (ch05_analog_behavior/two_named_branches.va holds that gap), so two instances
// hung across the same two nets would each read the SUM of both. Every instance
// below therefore gets its own net, sharing only the common return.
//
//! lrm E.3
//! lrm E.3:1
//! lrm E.3:2
//! lrm E.1.2
//! lrm E.1.2:1
//! lrm E.2
//! lrm 6.7.1
//! lrm 6.7.1:1
//! analysis tran
//! time 2n
//! bias V(n) = 0.0
//! solve
`include "check.vh"
module annex_e_primitive_vexp(p, n);
  inout p, n; electrical p, n;
  electrical a1, a2, a3;
  vexp #(.dc(5m), .mag(1.0), .phase(0.0), .val0(7m), .val1(1m), .td0(3n), .tau0(1n), .td1(4n), .tau1(1n)) x1(.p(a1), .n(n));
  vexp #(.dc(5m), .mag(1.0), .phase(0.0), .val0(7m), .val1(1m), .td0(1n), .tau0(1n), .td1(9n), .tau1(1n)) x2(.p(a2), .n(n));
  vexp #(.dc(5m), .mag(1.0), .phase(0.0), .val0(7m), .val1(1m), .td0(0.0), .tau0(1n), .td1(1n), .tau1(1n)) x3(.p(a3), .n(n));
  analog begin
    `CHECKX("before td0 the vexp row is dc, not val0", V(x1.p, x1.n), 5.0e-3);
    `CHECKR("val1 - (val1-dc)/e, one tau0 past td0", V(x2.p, x2.n), 2.4715177646857693e-3, 1e-15);
    `CHECKR("val0 - (val0-Vtd1)/e, one tau1 past td1", V(x3.p, x3.n), 5.334064485917797e-3, 1e-15);
    `CHECKX("the dc override reaches Table E.1's dc", x1.dc, 5.0e-3);
    `CHECKX("and val0, which this row uses in its third branch only", x1.val0, 7.0e-3);
  end
endmodule
