// LRM E.1.2: "whether a particular Verilog-AMS simulator is SPICE compatible,
// and with which particular variant of SPICE it is compatible, is solely
// determined by the authors of the simulator." VerA's claim (VD-012) reads
// HSPICE's `PARAMS:` on a `.SUBCKT` and `{expr}` values, and an expression
// may call only the functions whose meaning SPICE and §4.3.1-4.3.2 share (sqrt,
// exp, abs, min, max, pow, the trigonometric and hyperbolic ones, floor,
// ceil). `log` is not one: SPICE's is the natural logarithm and §4.3.1's is
// base 10, so translating it either way silently would be wrong for one
// dialect. The default is refused at the card, never dropped (which would
// leave RBOT undefined) and never guessed.
//
// Legal neighbour: spice_subckt_params_expressions.va, the same RDIV whose
// RBOT default is `{RTOP+2K}`, which compiles and divides.
//
//! lrm E.1.2
//! lrm E.2
//! lrm 4.3.1
//! bias V(in) = 1.0, V(gnd) = 0.0
//! reject-only E0928
//! reject calls `log`
//! neighbour spice_subckt_params_expressions.va
//! spice .SUBCKT RDIV IN OUT GND PARAMS: RTOP=1K RBOT={LOG(RTOP)}
//! spice R1 IN OUT {RTOP}
//! spice R2 OUT GND 'RBOT'
//! spice .ENDS RDIV
`include "check.vh"
module rdiv_user(in, gnd);
  inout in, gnd; electrical in, gnd;
  rdiv x1(in, mid, gnd);
endmodule
