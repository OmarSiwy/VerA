//! reject module instantiation is not supported
// EXPECT: error -- Table E.1 primitive needs SPICE elaboration.
module annex_e_primitive_capacitor(p,n); inout p,n; electrical p,n; capacitor #(.c(1p),.ic(0.0)) x(.p(p),.n(n)); endmodule
