// Table E.1 row `capacitor`: ports p, n, parameters c, ic, behaviour
//
//     V = (1/c) * integral(0..t) I dtau  +  ic
//
// E.2.2.3 prints this primitive verbatim: `capacitor #(.c(1p), .ic(1)) C1 (vcc, out);`.
//
// WHAT IS PINNED. E.3: "Table E.1 shows the REQUIRED names for primitives,
// parameters, and ports which are otherwise unnamed in SPICE. For connection by
// order instead of by name, the ports and parameters shall be given in the order
// listed. The default discipline of the ports for these primitives shall be
// electrical and their descriptions shall be inout." E.1.2 adds that "when
// instantiating SPICE primitives in Verilog-AMS HDL, the primitives shall, and
// parameters and ports can, be named", and E.2 that a tool "expected to provide
// the basic set of Spice primitives" shall treat them "in the same manner in
// Verilog-AMS HDL as built-in primitives of gate- and switch-level modeling".
// So the instantiation below — every port and every parameter named, in the
// Table E.1 order — is source a SPICE-compatible Verilog-AMS tool must accept.
//
// THIS IS A RUN FIXTURE, NOT A REJECT. An earlier revision of this file demanded
// a diagnostic for the line below. That inverts the test: the LRM prints this
// syntax as legal, so a conforming compiler would FAIL and only a compiler with
// no SPICE support would pass. The requirement is that it compiles, and it does:
// VerA ships Table E.1 as ordinary module declarations in a prelude, the same
// shape as annex D's disciplines.vams (`Preprocessor.spice_primitives`).
//
// THE DIGITS. Both terms of the row, in one check. The analog block below drives
// a constant 1 mA into p through the port branch p-to-reference and the bias sinks
// it at n, so KCL leaves the capacitor's own branch carrying exactly that current,
// and c is given as 1m so that the integrand I/c is 1.0 EXACTLY — the same decimal
// literal over itself, which no rounding can perturb. A constant integrand makes
// the integral exact at every accepted step too, so
//
//     V(x1.p, x1.n)  =  1.0 * t  +  2.5   volts
//
// with the 2.5 straight off `ic`. Subtracting the t term leaves the constant, so
// the want is `ic` itself and one line pins both halves: a tool that dropped the
// integral fails at t = 0.5, and one that ignored `ic` — §4.5.5's second argument
// to idt is exactly what this column's `+ ic` is — fails at every point.
//
// A CAPACITOR IS A POTENTIAL RELATION, which is the other thing the check settles:
// the row says V = f(integral of I), so the branch's FLOW is the unknown and the
// harness has to solve for it (`//! solve`). A tool that read the row backwards,
// as a current contribution, cannot produce this number at all.
//
// HOW THE PRIMITIVE IS OBSERVED. §6.7.1: "Potential and flow access for named
// and unnamed branches (including port branches) can be done hierarchically",
// and "access of parameters can be done hierarchically". So `V(x1.p, x1.n)` is the
// potential of the primitive's own port pair — the branch Table E.1's Behavior
// column is written about — reached by an out-of-module reference, and `x1.c` is
// the parameter an override landed on. Nothing else could observe the row: the
// Behavior column belongs to the primitive's branches, not to this module's.
//
//! lrm E.3
//! lrm E.3:1
//! lrm E.3:2
//! lrm E.1.2
//! lrm E.1.2:1
//! lrm E.2
//! lrm E.2.2.3
//! lrm 4.5.5
//! lrm 6.7.1
//! lrm 6.7.1:1
//! analysis tran
//! time 0, 0.5, 1.0
//! bias V(n) = 0.0
//! solve
`include "check.vh"
module annex_e_primitive_capacitor(p, n);
  inout p, n; electrical p, n;
  capacitor #(.c(1m), .ic(2.5)) x1(.p(p), .n(n));
  analog begin
    // 1 mA in at p; the `//! bias` on n is where it leaves.
    I(p) <+ -1m;
    `CHECK("Table E.1: V = (1/c)*integral(I) + ic, so V - 1.0*t is ic", V(x1.p, x1.n) - 1.0*$abstime, 2.5, 1e-15);
    `CHECKX("the c override reaches Table E.1's c", x1.c, 1.0e-3);
    `CHECKX("and the ic override reaches ic", x1.ic, 2.5);
  end
endmodule
