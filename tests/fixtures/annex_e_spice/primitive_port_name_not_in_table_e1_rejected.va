// E.2.2.3 translates E.2.2.2's oscillator into native Verilog-AMS, one Table
// E.1 primitive per card:
//
//   resistor #(.r(10k)) R1 (b1, gnd);
//   capacitor #(.c(3n)) C3 (b1, gnd);
//
// by ORDER. E.3 fixes the names those orders stand for: "Table E.1 shows the
// required names for primitives, parameters, and ports which are otherwise
// unnamed in SPICE. For connection by order instead of by name, the ports and
// parameters shall be given in the order listed." The resistor row's port
// column reads `p, n`. So E.2.2.3's `R1 (b1, gnd)` is `R1 (.p(b1), .n(gnd))`
// and nothing else.
//
// This file writes R1 by name with the names a SPICE card never had and Table
// E.1 does not give — `.a`, `.b`. E.1.2 states why the table exists: "the
// primitives shall, and parameters and ports can, be named. Since there are
// no established standard names, there is a high likelihood of
// incompatibility ... To reduce this, a list of what names shall be used for
// the more common components is shown in Table E.1." `a` is not on the list,
// so the connection names no port of `resistor`. The same line with `.p(b1),
// .n(gnd)` compiles (probed; passive_named_ports.va runs named passives).
//
// VerA reports E0906 "port connections do not match the module's ports".
//
//! lrm E.2.2.3
//! lrm E.3
//! lrm E.1.2
//! lrm E.1.2:2
//! reject-only E0906
//! reject `a` is not a port of `resistor`
//! neighbour passive_named_ports.va
`include "disciplines.vams"
module e223_osc_fragment(b1, gnd);
  inout b1, gnd; electrical b1, gnd;
  capacitor #(.c(3n)) C3 (b1, gnd);
  resistor #(.r(10k)) R1 (.a(b1), .b(gnd));   // illegal: Table E.1 ports are p, n
endmodule
