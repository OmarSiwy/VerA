//! reject module instantiation is not supported
// EXPECT: error -- SPICE objects require hierarchy/SPICE elaboration.
module annex_e_spice_case_lookup_unsupported(p, n);
  inout p, n; electrical p, n;
  VeRtNpN mixed_case(p, p, n);
endmodule
