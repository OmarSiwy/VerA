// LRM E.1.2: "whether a particular Verilog-AMS simulator is SPICE compatible,
// and with which particular variant of SPICE it is compatible, is solely
// determined by the authors of the simulator." VerA reads an E, F, G or H
// card in its plain form only: two nodes, then a control node pair (E, G) or
// a V card (F, H), then the gain (Vague_Decisions VD-012).
//
// `E1 OUT GND POLY(1) 2` is a polynomial source: `POLY(1)` stands where the
// control nodes go. Read as nodes it would be a gain of 2 on V(poly, 1), two
// nets the netlist never names, and V(out) would sit at 0 with no
// diagnostic. So the POLY, VALUE, TABLE, LAPLACE and FREQ forms are refused
// by name.
//
// Legal neighbour: vcvs_inside_a_spice_subcircuit.va, the same amplifier
// with `E1 OUT GND IN GND 2`, which compiles and drives V(out) to 2.0.
//
//! lrm E.1.2
//! lrm E.3.1
//! bias V(in) = 1.0, V(gnd) = 0.0
//! reject-only E0928
//! reject `poly` form of a controlled source is not read
//! neighbour vcvs_inside_a_spice_subcircuit.va
//! spice .SUBCKT AMP IN OUT GND
//! spice RI IN GND 1K
//! spice E1 OUT GND POLY(1) 2
//! spice RL OUT GND 1K
//! spice .ENDS AMP
`include "check.vh"
module amp_user(in, gnd);
  inout in, gnd; electrical in, gnd;
  amp x1(in, out, gnd);
endmodule
