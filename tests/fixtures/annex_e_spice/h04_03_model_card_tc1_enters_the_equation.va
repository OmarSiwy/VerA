// H04 — a model-card parameter that is not the headline one still has to enter
// Table E.1's equation. `tc1` is the case that proves the binding is general
// rather than a special case for `r`.
//
// THE CLAUSE. Table E.1, `resistor` row, ports p, n, parameters r, tc1, tc2:
//
//     V = I * r * (1 + tc1 * T + tc2 * T^2)
//
// and E.3: "Table E.1 shows the REQUIRED names for primitives, parameters, and
// ports which are otherwise unnamed in SPICE." So `TC1` on a `.MODEL ... R`
// card is a name Table E.1 fixes, and E.2.2.1's "the parameters of the bjt are
// determined by the bjt primitive itself" says this instance's parameter set is
// {r, tc1, tc2} — which is precisely the set this card assigns into.
//
// WHY THE CURRENT IS NOT WRITTEN AS DIGITS. The published row writes a bare `T`
// and fixes neither a reference temperature nor whether the polynomial is in
// absolute temperature or in the rise above nominal. §9.15 (Analog Kernel
// Parameter System Functions) says only that `$temperature` "returns the
// circuit's ambient temperature in Kelvin units"; neither it nor anything in
// Annex E says Table E.1's `T` is that absolute number rather than
// `$temperature - tnom`, which is what every Berkeley SPICE resistor model
// means by these same two coefficient names. Both readings are defensible and
// they disagree here by 30%:
//
//     T read as absolute 300 K        factor = 1 + 1e-3*300 = 1.3  I = 7.6923e-4
//     T read as rise above tnom=300   factor = 1 + 1e-3*0   = 1.0  I = 1.0e-3
//
// An earlier revision of this fixture asserted 7.692307692307692e-4 outright.
// That fails a conforming tool taking the second reading, and the cheapest way
// to make it pass would be to force VerA's own `T` convention onto the netlist
// boundary — a change this row has no clause to demand. So the digits are NOT
// written. What is written instead is the identity Annex E does state: the
// card's `{r, tc1, tc2}` ARE Table E.1's `{r, tc1, tc2}` (E.3's required names,
// E.2.2.1's "determined by the primitive itself"), so a card-derived instance
// and the same three values written longhand as
// `resistor #(.r(1k), .tc1(1e-3), .tc2(0))` are the SAME device and must carry
// the SAME current under the same 1.0 V — whatever `T` the tool substitutes,
// because it substitutes the same one on both sides. `//! temp 300.0` is kept
// so both sides are evaluated at one stated temperature rather than at an
// unstated default.
//
// THE CHECKEQ BAND. Both branches sit at ~7.7e-4 A under the absolute reading
// and ~1.0e-3 A under the nominal-rise reading. 1e-14 A absolute is ~1e-11
// relative on either, which admits any order of evaluation of the three-term
// polynomial and whether the tool divides once or twice, and still fails every
// wrong binding in kind: drop the card's TC1 and one side reads 1.0e-3 while
// the other reads 7.69e-4, a gap of 2.3e-4 — eleven orders of magnitude above
// the band. Drop the card's R and one side reads 1.0 A.
//
// THE THREE `CHECKX` LINES DO CARRY DIGITS, because those are the card's own
// literals round-tripped, not a consequence of any equation: 1000, 1e-3, 0.
//
// WHAT THIS CATCHES THAT FIXTURE 01 DOES NOT. A tool could bind only the
// parameter whose name matches the primitive's first, or only the one SPICE
// spells positionally, and still pass 01. Here tc1 alone moves the answer by
// 30%, and the longhand control is what makes that movement attributable to
// tc1 rather than to the temperature convention.
//
//! lrm E.3
//! lrm E.2.2.1
//! lrm 9.15
//! bias V(a) = 1.0, V(b) = 0.0, V(c) = 1.0
//! temp 300.0
//! spice .MODEL RTC R R=1000 TC1=1E-3 TC2=0
`include "check.vh"
module h04_model_card_tc1(a, b, c);
  inout a, b, c; electrical a, b, c;
  rtc r1(a, b);
  // The longhand control: Table E.1's resistor with the card's three values
  // written out, under the same 1.0 V. Not a second claim — the reference the
  // CHECKEQ below is against.
  //
  // ON ITS OWN NODE PAIR, DELIBERATELY. Measured: two primitive instances
  // between the SAME two nodes both report the aggregate branch flow, so
  // `I(r1.p,r1.n)` and `I(ref.p,ref.n)` would be the identical expression and
  // the CHECKEQ would be vacuous — it passes even with the two given different
  // `r`. Verified by running the pair at .r(1k) against .r(2k): both sides read
  // 1.269e-3, the parallel sum, ok=1. Split across (a,b) and (c,b) with both
  // `a` and `c` biased to 1.0 V, the same experiment reads 7.692e-4 against
  // 1.0e-3, ok=0. The control is only a control on its own pair.
  resistor #(.r(1k), .tc1(1.0e-3), .tc2(0.0)) ref(c, b);
  analog begin
    `CHECKX("the card's R reaches Table E.1's r", r1.r, 1000.0);
    `CHECKX("and its TC1 reaches Table E.1's tc1", r1.tc1, 1.0e-3);
    `CHECKX("TC2=0 is bound as zero, not merely absent", r1.tc2, 0.0);
    // E.3 + E.2.2.1: same three parameter values, same primitive, same bias =>
    // same branch current, under whatever `T` Table E.1's bare symbol denotes.
    `CHECKEQ("the card-derived instance carries the same current as the longhand one",
             I(r1.p, r1.n), I(ref.p, ref.n), 1e-14);
  end
endmodule
