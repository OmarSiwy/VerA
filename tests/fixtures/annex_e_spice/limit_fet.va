// Annex E.3.4 / §9.17.3 $limit with the built-in "fetlim" algorithm. Table E.2
// gives fetlim exactly one extra argument, vth, and it limits a gate-to-source
// voltage.
//
// WHAT IS PINNED. §9.17.3: "When the simulator has converged, the return value
// of the $limit() function is the value of the access function reference, within
// appropriate tolerances." A limiter is a convergence aid, never a change to the
// circuit the netlist describes, so at the answer $limit() is TRANSPARENT: it
// returns its access function, and the stamped current is the one V(mid) implies
// rather than a damped fraction of it.
//
// WHAT THE HARNESS SUPPLIES, and why the digit still holds. §9.17.3 also says
// "in all cases, the simulator is responsible for determining if limiting should
// be applied and what the return value is on a given iteration" — and this
// harness does not iterate: `//! bias` imposes x and the device is evaluated
// ONCE, so the sentence above is not handed to the fixture for free. The digit
// therefore has to survive the worst single iteration a SPICE-family fetlim can
// produce here, and for this bias it does. DEVfetlim(vnew, vold, vth) with
// vnew = 0.3 and vth = 0.7 returns 0.3 unchanged for every stored vold below
// vth + 3.5 = 4.2 V: below vth both step clamps — vtsthi = |2*(vold-vth)|+2
// >= 2 V going off, the ceiling vth + 0.5 = 1.2 V going on — are slack by more
// than a volt at 0.3 V, and between vth and 4.2 V the falling branch is
// max(0.3, vth - 0.5) = 0.3. Only a tool whose previous iterate was already
// above 4.2 V would answer max(0.3, vth + 2) = 2.7, and there is no previous
// iterate here: a cold start is 0 V, which is where a channel is
// well-conditioned and is what SPICE's MODEINITJCT leaves fetlim at.
//
// WHY THE PROBE IS AN INTERNAL NET. A limiter corrects an unknown the device
// owns. Probing the module PORT instead makes the correction a write to a node
// the host imposes, and a simulator is entitled to decline it — VerA does,
// silently — so a port-probing form of this fixture would put the transparency
// question to a call the tool had already refused to limit. `mid` is private to
// the device, so a tool that installs the clamp at all installs it here. The
// bias directive holds `mid` at 0.3 V, and the branch to `p` is written in terms
// of the LIMITED value, so a clamp that fired would move the stamped current and
// not only the assertion.
//
// TOLERANCE. §9.17.3 fixes only "within appropriate tolerances". The only number
// the LRM supplies for a Voltage-natured quantity is Annex D disciplines.vams
// `nature Voltage ... abstol = 1e-6`, so that is the tolerance used. 1e-12 is the
// CURRENT abstol — six orders too tight for a volt, and a simulator converging to
// its own vntol would fail on it. It still discriminates: every clamp fetlim can
// reach from this bias moves the answer by more than 2 V.
//
//! lrm E.3.4
//! lrm 9.17.3
//! lrm 9.17.3:1
//! bias V(p) = 0.3, V(mid) = 0.3
`include "check.vh"
module annex_e_fetlim(p);
  inout p; electrical p; electrical mid; real limited;
  analog begin
    limited = $limit(V(mid), "fetlim", 0.7);
    I(mid, p) <+ (limited - V(p)) / 1.0;
    // 1e-6 is the Annex D `nature Voltage` abstol.
    `CHECK("fetlim returns the value of its access function", limited, 0.3, 1e-6);
  end
endmodule
