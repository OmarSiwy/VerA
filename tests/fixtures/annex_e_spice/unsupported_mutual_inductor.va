// E.3.1 Unsupported primitives: "Verilog-AMS HDL does not support the concept of
// passing an instance name as a parameter. As such, the following primitives are
// not supported: ccvs, cccs, and mutual inductors." A mutual inductor names the
// two inductor INSTANCES it couples, which is exactly the construct that
// sentence rules out. So unlike the rest of Annex E, a rejection here is what
// the LRM asks for.
//
// THE NAME IS THIS SUITE'S, NOT THE LRM's. E.3.1 says "mutual inductors" in
// prose only. Table E.1 has no mutual-inductor row and no clause of Annex E
// gives the construct an identifier — `ccvs` and `cccs` are spelled out, this
// one is not. `mutual_inductor` below is our own spelling, so the rejection
// attaches to the E.3.1 requirement by convention rather than by name.
//
// HONEST CEILING, doubled here. VerA answers with E0204 "module instantiation is
// not supported", cited to §6.2.2 — the flat-module limit, not E.3.1 — and since
// VerA rejects every instantiation the diagnostic would be identical for
// `foo k1(p, n);`. What this fixture buys is that the coupling form never
// compiles; separating "refused as an E.3.1 primitive" from "refused as
// hierarchy", or from "undefined module", needs a dedicated diagnostic code.
//
//! lrm E.3.1
//! reject E0204
module annex_e_unsupported_mutual_inductor(p, n);
  inout p, n; electrical p, n;
  mutual_inductor k1(p, n);
endmodule
