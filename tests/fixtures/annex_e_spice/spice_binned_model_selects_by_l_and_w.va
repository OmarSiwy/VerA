// E.4.2: "Some SPICE netlists provide mechanisms for mapping an instance to a
// group of models, with the final determination of which model to use being
// based on rules encapsulated in the SPICE netlist. Examples include model
// binning ... Support of SPICE model cards is implementation specific
// (including those using these mechanisms)." VerA reads SPICE's binning
// (VD-012): a card naming `NFET` when the netlist has `.MODEL NFET.1`,
// `.MODEL NFET.2`, ... takes the first bin, in card order, with
// LMIN <= L < LMAX and WMIN <= W < WMAX (an unwritten bound is open), and is
// then that bin's model card without the four bounds, which only select.
//
// THE NETLIST: two bins of the Verilog-A module LinFet, and three cards.
//
//     .MODEL NFET.1 LINFET KP=1E-3 LMIN=0 LMAX=0.5
//     .MODEL NFET.2 LINFET KP=3E-3 LMIN=0.5 LMAX=2
//     M1 D1 G S B NFET W=2 L=1      bin 2
//     M2 D2 G S B NFET W=2 L=0.5    bin 2: L = LMIN is in, L = LMAX is out
//     M3 D3 G S B NFET W=2 L=0.25   bin 1
//
// Each card has its own drain. A flow probe I(x1.m1.d, x1.m1.s) from this
// module names a net pair, and on a pair the three cards shared it would
// read their sum (§5.5.4: it is "a new unnamed branch ... in the module
// containing the access function call", not M1's own).
//
// THE DIGITS, BY HAND. V(d1) = V(d2) = V(d3) = 1, V(g) = 0.75, V(s) = 0.25:
// Vgs = 0.5, Vds = 0.75, I = KP * (W/L) * 0.375.
//
//     M1: 3e-3 * 2    * 0.375 = 2.25e-3     (bin 1 would give 0.75e-3)
//     M2: 3e-3 * 4    * 0.375 = 4.5e-3      (a closed LMAX on bin 1: 1.5e-3)
//     M3: 1e-3 * 8    * 0.375 = 3.0e-3      (bin 2 would give 9e-3)
//
// The invalid neighbour is reject_spice_binned_model.va: the same bins and a
// card whose L = 3 no bin holds, refused at the card.
//
//! lrm E.4.2
//! lrm E.4.2:1
//! lrm E.1.2
//! lrm 6.7.1
//! bias V(d1) = 1.0, V(d2) = 1.0, V(d3) = 1.0, V(g) = 0.75, V(s) = 0.25, V(b) = 0.0
//! spice .MODEL NFET.1 LINFET KP=1E-3 LMIN=0 LMAX=0.5
//! spice .MODEL NFET.2 LINFET KP=3E-3 LMIN=0.5 LMAX=2
//! spice .SUBCKT BINCELL D1 D2 D3 G S B
//! spice M1 D1 G S B NFET W=2 L=1
//! spice M2 D2 G S B NFET W=2 L=0.5
//! spice M3 D3 G S B NFET W=2 L=0.25
//! spice .ENDS BINCELL
//! checks 3
`include "check.vh"
module LinFet(d, g, s, b);
  inout d, g, s, b; electrical d, g, s, b;
  parameter real KP = 1e-3;
  parameter real W = 1.0;
  parameter real L = 1.0;
  analog I(d, s) <+ KP * (W / L) * V(g, s) * V(d, s);
endmodule

module annex_e_spice_binned_model(d1, d2, d3, g, s, b);
  inout d1, d2, d3, g, s, b; electrical d1, d2, d3, g, s, b;
  bincell x1(d1, d2, d3, g, s, b);
  analog begin
    `CHECKR("M1, L = 1: bin 2's KP 3e-3 * 2/1 * 0.375", I(x1.m1.d, x1.m1.s), 2.25e-3, 1e-12);
    `CHECKR("M2, L = 0.5 = bin 2's LMIN: KP 3e-3 * 2/0.5 * 0.375", I(x1.m2.d, x1.m2.s), 4.5e-3, 1e-12);
    `CHECKR("M3, L = 0.25: bin 1's KP 1e-3 * 2/0.25 * 0.375", I(x1.m3.d, x1.m3.s), 3.0e-3, 1e-12);
  end
endmodule
