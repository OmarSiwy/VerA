// Annex E.3.4 / §9.17.3 $limit with the built-in "pnjlim" algorithm. Table E.2
// gives pnjlim two extra arguments, vte and vcrit; §9.17.3 makes both REQUIRED
// when the string is "pnjlim", and names vcrit = vte*ln(vte/(sqrt(2)*Is)).
//
// WHAT IS PINNED. §9.17.3: the simulator is "prevented from terminating the
// iteration" while $limit()'s output differs from the value of its access
// function. A solved operating point is therefore one where the limiter is
// transparent: the junction current the model stamps is the one V(mid) implies,
// never a damped stand-in.
//
// WHY THE PROBE IS AN INTERNAL NET. A limiter corrects an unknown the device
// owns. Probing the module PORT instead makes the correction a write to a node
// the host imposes, and a simulator is entitled to decline it — VerA does,
// silently — so a port-probing form of this fixture asserts the transparency of
// the identity function and cannot fail. `mid` is private to the device, so the
// clamp really is installed. The bias directive holds `mid` at 0.5 V, and the
// branch to `p` is written in terms of the LIMITED value, so a clamp that fired
// would move the stamped current as well as the assertion.
//
// The bias makes the claim true even under SPICE's DEVpnjlim, which limits only
// when vnew > vcrit AND |vnew - vold| > 2*vte. Here vnew = 0.5 V is below the
// vcrit = 0.6 V passed in, so the first conjunct fails for ANY previous value
// and the function is the identity on every iteration, not merely the last.
//
// TOLERANCE. §9.17.3 fixes only "within appropriate tolerances". The only number
// the LRM supplies for a Voltage-natured quantity is Annex D disciplines.vams
// `nature Voltage ... abstol = 1e-6`. 1e-12 is the CURRENT abstol and is the
// wrong nature's number for a volt.
//
//! lrm E.3.4
//! lrm 9.17.3
//! bias V(p) = 0.5, V(mid) = 0.5
`include "check.vh"
module annex_e_pnjlim(p);
  inout p; electrical p; electrical mid; real limited;
  analog begin
    limited = $limit(V(mid), "pnjlim", 0.026, 0.6);
    I(mid, p) <+ (limited - V(p)) / 1.0;
    // 1e-6 is the Annex D `nature Voltage` abstol.
    `CHECK("pnjlim is transparent below vcrit", limited, 0.5, 1e-6);
  end
endmodule
