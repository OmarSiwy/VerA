// §9.17.3 a "pnjlimds" site with no partner is not applied: the probe comes
// back unchanged.
//
// "pnjlimds" is a RUNG (limit_pnjlimds_bulk_rung.va): two sites on one bulk
// node, one limvds across their channel nodes, and the limited vds picks which
// junction is clamped. One leg alone has no channel to pick by, and clamping it
// statically is the both-junctions bug the rung exists to fix. §9.17.3 lets
// the simulator decline: "the simulator may simply choose to have $limit()
// return the value of its first argument". VerA declines it (W0853) and keeps
// the limvds, so `limit` still exists and must leave the bulk alone.
//
// BIAS (cur) si = 0, di = 0.5, b = 1.5; old all 0. limvds(0.5, old 0):
// vold < 3.5 and vnew > vold, so min(0.5, 4) = 0.5, unchanged. The declined
// site would have clamped vbs = 1.5 (> vcrit, old 0) to 0.025 ln 60; declined,
// b stays 1.5. limvds never reports, so converged = 1.
// At the bias the model evaluates, §9.17.3's "When the simulator has
// converged, the return value of the $limit() function is the value of the
// access function reference, within appropriate tolerances" is the CHECK
// (1e-6: Annex D's `nature Voltage` abstol, as limit_fet.va argues).
//! lrm 9.17.3
//! warn W0853
//! bias V(si) = 0.0, V(di) = 0.5, V(b) = 1.5
//! print none
//! limit V(si) = 0, V(di) = 0, V(b) = 0 -> V(b) = 1.5, V(di) = 0.5, converged = 1
`include "check.vh"
module limit_pnjlimds_dangling_returns_probe(d, s, b);
  inout d, s, b; electrical d, s, b, di, si;
  parameter real vt = 0.025, vcrit = 0.6;
  real vds, vbs;
  analog begin
    vds = $limit(V(di, si), "limvds");
    vbs = $limit(V(b, si), "pnjlimds", vt, vcrit);
    I(d, di) <+ V(d, di) / 10.0;
    I(s, si) <+ V(s, si) / 10.0;
    I(di, si) <+ 1e-3 * vds;
    I(b, si) <+ 1e-14 * (limexp(vbs / vt) - 1.0);
    `CHECK("$limit returns its access function at the answer", vbs, 1.5, 1e-6);
  end
endmodule
