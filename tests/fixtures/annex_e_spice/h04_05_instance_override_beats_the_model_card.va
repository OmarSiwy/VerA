// H04 — the parameters of an instance of a SPICE model are the PRIMITIVE's, so
// they are overridable from Verilog-AMS with §6.3's ordinary `#(...)`, and an
// explicit override beats the value the model card supplied.
//
// THE CLAUSE. E.2.2.1, on the LRM's own `vertNPN Q1 (c1, b1, e);`:
//
//     "The ports and parameters of the bjt are determined by the bjt primitive
//      itself and not by the model statement for the bjt."
//
// Both halves of that sentence are load-bearing and they point in the same
// direction: the parameter SET of `Q1` is Table E.1's, and it is not the card's
// to restrict. E.4.2 says the same thing from the other end — an instance line
// is how the extra capability enters ("supporting these additional capabilities
// in Verilog-AMS HDL is supported via the instance line by default"). So an
// instance of a model-derived module must accept `#(.r(2500))`, and §6.3.3
// (Module instance parameter value assignment by name) is the ordinary rule
// that applies to it: "Parameter assignment by name explicitly links the
// parameter name and its value. The name shall be the name specified in the
// instantiated module." `.r` is such a name — E.2.2.1 is exactly the sentence
// that puts it there — so the value written on the instantiation is the value
// the parameter has, whatever default it would otherwise have taken. (§6.3.1 is
// the *defparam* statement, a different mechanism; an earlier revision of this
// file cited it by mistake. No `defparam` appears anywhere in this row.)
//
// The precedence itself is SPICE's too, and this is the one place the two
// languages already agree: a device line's parameter overrides the model card's
// for that instance. Nothing in Annex E revokes it, and the alternative — a
// card value that silently wins over the text the user wrote in front of them —
// would make every `#()` on a model-derived instance a lie.
//
// THE DIGITS, BY HAND. The card says R=10K, the instance says .r(2500), and the
// instance wins, so r = 2500 ohm. No tc1/tc2 anywhere, so Table E.1's factor
// (1 + tc1*T + tc2*T^2) is 1 exactly and V = I*r inverts under the 1.0 V that
// `//! bias` holds across the branch:
//
//     I(p, n) = 1.0 / 2500 = 4.0e-4 A
//
// Three wrong answers this separates: card-wins gives 1.0e-4, no-binding-at-all
// gives 1.0 (the prelude's 1 ohm default), and a tool that refuses the override
// because the model-derived module declares no parameters does not compile.
//
// THE SECOND CHECK IS THE ONE THAT IS ABOUT E.2.2.1 ALONE. `r1.r` is §6.7.1
// hierarchical parameter access; it reading 2500 says the parameter EXISTS on
// the model-derived instance, which is the sentence quoted above, independent of
// any equation.
//
//! lrm E.2.2.1
//! lrm E.4.2
//! lrm 6.3.3
//! lrm 6.3.3:1
//! lrm 6.7.1
//! lrm 6.7.1:1
//! bias V(a) = 1.0, V(b) = 0.0
//! spice .MODEL RMOD R R=10K
`include "check.vh"
module h04_instance_override(a, b);
  inout a, b; electrical a, b;
  rmod #(.r(2500)) r1(a, b);
  analog begin
    `CHECKX("6.3.3: the instance override wins over the card's R=10K",
            r1.r, 2500.0);
    `CHECKR("Table E.1: I = V/r = 1.0/2500", I(r1.p, r1.n), 4.0e-4, 1e-15);
  end
endmodule
