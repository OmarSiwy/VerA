// E.4.2 Binning and libraries: "Some SPICE netlists provide mechanisms for
// mapping an instance to a group of models, with the final determination of
// which model to use being based on rules encapsulated in the SPICE netlist.
// Examples include model binning or corners support... Similar functionality for
// Verilog-AMS is supported through use of the paramset... Instead of referencing
// a specific module, an instance may refer to a paramset identifier, and there
// may be several paramsets with the same identifier (name)."
//
// WHAT IS PINNED. Three things E.4.2 needs and this file writes:
//
//   Several paramsets share ONE identifier. §6.4.2: "Paramset identifiers need
//   not be unique: multiple paramsets can be declared using the same
//   paramset_identifier". Two `annex_e_bin` declarations below, so a tool that
//   treated a paramset name as a definition to be declared once would fail here
//   and pass a single-paramset file.
//
//   The bins are separated by RANGES, which is what makes the selection
//   mechanical: §6.4.2 requires that "the parameters of the paramset, with
//   overrides and defaults, shall be all within the allowed ranges specified in
//   the paramset parameter declaration", so l = 180n can satisfy only the first
//   and l = 500n only the second. That is model binning with no netlist syntax
//   for it — the point of the clause.
//
//   The underlying module is the Table E.1 primitive `mosfet`. E.3, last
//   paragraph: "although in a SPICE context the primitives for diode, bjt,
//   mosfet, jfet, and mesfet can be used only in a model definition, in
//   Verilog-AMS they may be used directly in a paramset statement". (Annex E
//   cross-references that clause as 7.5; the paramset chapter in this revision
//   is 6.4, which is where E.4.2 itself points.)
//
// WHICH BIN WAS PICKED IS THE ASSERTION, and `w` is what makes it visible. The
// instance overrides only `l`. The two bins give `w` DIFFERENT defaults — 1u in
// the one whose range holds 180n, 2u in the other — so the width that reaches
// the first mosfet is 1e-6 only when §6.4.2 selects the first paramset.
// A second instance sets l=500n and must instead receive the second bin's
// 2e-6 width. An always-first selector fails on m2; an always-last selector
// fails on m1. §6.7.1 is what reads it back: "access of parameters can be
// done hierarchically". The two candidate readings of `m1.w` — the paramset's
// own parameter, or the mosfet parameter its `.w = w` assignment drives — agree
// by construction, which is why the check does not have to choose between them.
//
// THIS IS A RUN FIXTURE, NOT A REJECT. An earlier revision demanded E0201 for a
// paramset. That inverts the test: §6.4 makes the construct legal and E.4.2
// makes it the required answer to SPICE binning, so a conforming compiler would
// FAIL and only one without paramsets would pass.
//
//! lrm E.4.2
//! lrm 6.4.2
//! lrm 6.4.2:1
//! lrm E.3
//! lrm E.3:3
//! lrm 6.7.1
//! lrm 6.4.2:2
//! lrm 6.4.2:4
//! lrm 6.4
//! lrm 6.4:4
//! lrm 6.7.1:1
//! lrm E.4.2:2
//! bias V(d) = 1.0, V(g) = 0.75, V(s) = 0.25, V(b) = 0.125
//! checks 5
`include "check.vh"
paramset annex_e_bin mosfet;
  parameter real l = 100n from [100n:250n);
  parameter real w = 1u from (0:inf);
  .l = l;
  .w = w;
endparamset

paramset annex_e_bin mosfet;
  parameter real l = 250n from [250n:1u];
  parameter real w = 2u from (0:inf);
  .l = l;
  .w = w;
endparamset

module annex_e_bin_user(d, g, s, b);
  inout d, g, s, b; electrical d, g, s, b;
  // l = 180n is in the first bin's range and outside the second's, so §6.4.2's
  // range rule alone determines the answer.
  annex_e_bin #(.l(180n)) m1(.d(d), .g(g), .s(s), .b(b));
  annex_e_bin #(.l(500n)) m2(.d(d), .g(g), .s(s), .b(b));
  analog begin
    // The first bin's w default is 1u; the second's is 2u. This digit IS the
    // bin selection.
    `CHECKX("6.4.2 picked the bin whose range holds l=180n, so w is its 1u",
            m1.w, 1.0e-6);
    // `180n` is 180 x 1e-9, which as a product lands one ulp off the double
    // nearest 1.8e-7; 1e-15 relative is ~4 ulp.
    `CHECKR("the l override survives the paramset's `.l = l`", m1.l, 1.8e-7, 1e-15);
    `CHECKX("the instance's ports reach the mosfet: 1.0 - 0.25",
            V(m1.d, m1.s), 0.75);
    `CHECKX("6.4.2 picked the other bin for l=500n, so w is its 2u",
            m2.w, 2.0e-6);
    `CHECKR("the second instance keeps its own length override", m2.l, 5.0e-7, 1e-15);
  end
endmodule
