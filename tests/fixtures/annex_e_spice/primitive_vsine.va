// Table E.1 row `vsine`: ports p, n, parameters dc, mag, phase, offset, ampl,
// freq, td, damp, sinephase, ammodindex, ammodfreq, ammodphase, fmmodindex,
// fmmodfreq, behaviour
//
//     V = offset + ampl * (1 - Fam*cos(2*pi*Fam_f*(t-td) - Pam))
//                       * (1 - damp*(t-td))
//                       * cos(2*pi*freq*(1 - Ffm*cos(2*pi*Ffm_f*(t-td)))*(t-td)
//                             - Psin)
//
// with Fam = ammodindex, Fam_f = ammodfreq, Pam = ammodphase, Ffm = fmmodindex,
// Ffm_f = fmmodfreq and Psin = sinephase. The published row labels the FM
// frequency f_AM in both source rows; it is fmmodfreq, as the parameter name says,
// and Annex E's source-fidelity note lists the duplicate label as a defect of the
// printed table.
//
// The isine row with V for I, which is the ONE line of it this file adds: E.2.2.3
// prints `vsine #(.dc(5)) Vcc (vcc, gnd);` and Table E.1 gives the row a POTENTIAL,
// so the branch flow is the unknown and the number below is one only a solve can
// produce. Everything else here is primitive_isine.va's derivation unchanged — the
// two rows are the same fourteen parameters and the same product — so a divergence
// between the two files is a divergence between the two prelude modules.
//
// WHAT IS PINNED. E.3: "Table E.1 shows the REQUIRED names for primitives,
// parameters, and ports which are otherwise unnamed in SPICE. For connection by
// order instead of by name, the ports and parameters shall be given in the order
// listed. The default discipline of the ports for these primitives shall be
// electrical and their descriptions shall be inout." E.1.2 adds that "when
// instantiating SPICE primitives in Verilog-AMS HDL, the primitives shall, and
// parameters and ports can, be named", and E.2 that a tool "expected to provide
// the basic set of Spice primitives" shall treat them "in the same manner in
// Verilog-AMS HDL as built-in primitives of gate- and switch-level modeling".
// So the instantiation below — every port and every parameter named, in the
// Table E.1 order — is source a SPICE-compatible Verilog-AMS tool must accept.
//
// THIS IS A RUN FIXTURE, NOT A REJECT. An earlier revision of this file demanded
// a diagnostic for the line below. That inverts the test: the LRM prints this
// syntax as legal, so a conforming compiler would FAIL and only a compiler with
// no SPICE support would pass. The requirement is that it compiles, and it does:
// VerA ships Table E.1 as ordinary module declarations in a prelude, the same
// shape as annex D's disciplines.vams (`Preprocessor.spice_primitives`).
//
// THE DIGITS. Every factor of the row is made to contribute a number that is not
// 1, at one time point, so that dropping any one of them changes the answer. All
// three instances take offset = 1m, ampl = 2m, freq = 0.75, td = 0, damp = 0.25,
// sinephase = 0, ammodindex = 0.5, ammodfreq = 0.5, ammodphase = 0,
// fmmodindex = 0.2, fmmodfreq = 1, and are read at t = 1 second:
//
//   AM factor    1 - 0.5*cos(2*pi*0.5*1)   = 1 - 0.5*cos(pi) = 1.5
//   damp factor  1 - 0.25*1                                  = 0.75
//   FM factor    1 - 0.2*cos(2*pi*1*1)     = 1 - 0.2         = 0.8
//   cosine       cos(2*pi*0.75*0.8*1) = cos(216 degrees) = -(1 + sqrt(5))/4
//
//     V = 1m + 2m * 1.5 * 0.75 * -(1+sqrt(5))/4 = -8.202882373436317e-4
//
// -(1+sqrt(5))/4 = -0.80901699437494742… is exact, so the want is a decimal a
// reader can check with a square root and nothing else. Relative tolerance because
// the argument 2*pi*0.75*0.8 is rounded before the cosine sees it.
//
// freq IS 0.75 AND NOT 1 FOR A REASON. The FM factor multiplies the phase, so at
// freq = 1 the correct factor 0.8 and the factor 1.2 that a tool reading the AM
// frequency in the FM slot would compute give arguments 2*pi*0.8 and 2*pi*1.2 —
// symmetric about a full turn, hence the SAME cosine. The mislabelled f_AM in the
// published row is exactly the mistake this file has to catch, so the operating
// point may not be one where the two readings coincide: at freq = 0.75 they are
// 2*pi*0.6 and 2*pi*0.9, and the cosine changes sign between them.
//
// x2 IS THE SAME NUMBER, and that is its claim. It differs from x1 only in
// dc = 9m, mag = 9 and phase = 9 — the three parameters that lead this row's list
// and appear in NONE of its Behavior expressions, because they are §4.6.1's
// analysis-dependent values (the DC operating point, and the AC magnitude and
// phase) rather than terms of the transient waveform. A tool that folded any of
// them into the waveform cannot answer -8.202882373436317e-4 twice.
//
// x3 IS THE ROW AT t = td, where every cosine argument is zero and the whole
// product collapses to offset + ampl*(1 - Fam)*1*1 = 1m + 2m*0.5 = 2.0e-3. That
// separates the AM factor from the rest: a tool that dropped it answers 3.0e-3.
//
// HOW THE PRIMITIVE IS OBSERVED. §6.7.1: "Potential and flow access for named
// and unnamed branches (including port branches) can be done hierarchically",
// and "access of parameters can be done hierarchically". So `V(x1.p, x1.n)` is the
// potential of the primitive's own port pair — the branch Table E.1's Behavior
// column is written about — reached by an out-of-module reference, and `x1.ampl` is
// the parameter an override landed on. Nothing else could observe the row: the
// Behavior column belongs to the primitive's branches, not to this module's.
//
// ONE INSTANCE PER NET PAIR, and that is load-bearing. Two unnamed branches over
// the same pair of nets share one accumulator in VerA today
// (ch05_analog_behavior/two_named_branches.va holds that gap), so two instances
// hung across the same two nets would each read the SUM of both. Every instance
// below therefore gets its own net, sharing only the common return.
//
//! lrm E.3
//! lrm E.3:1
//! lrm E.3:2
//! lrm E.1.2
//! lrm E.1.2:1
//! lrm E.2
//! lrm E.2.2.3
//! lrm 4.6.1
//! lrm 6.7.1
//! lrm 6.7.1:1
//! analysis tran
//! time 1.0
//! bias V(n) = 0.0
//! solve
`include "check.vh"
module annex_e_primitive_vsine(p, n);
  inout p, n; electrical p, n;
  electrical a1, a2, a3;
  vsine #(.dc(0.0), .mag(1.0), .phase(0.0), .offset(1m), .ampl(2m), .freq(0.75), .td(0.0), .damp(0.25), .sinephase(0.0), .ammodindex(0.5), .ammodfreq(0.5), .ammodphase(0.0), .fmmodindex(0.2), .fmmodfreq(1.0)) x1(.p(a1), .n(n));
  vsine #(.dc(9m), .mag(9.0), .phase(9.0), .offset(1m), .ampl(2m), .freq(0.75), .td(0.0), .damp(0.25), .sinephase(0.0), .ammodindex(0.5), .ammodfreq(0.5), .ammodphase(0.0), .fmmodindex(0.2), .fmmodfreq(1.0)) x2(.p(a2), .n(n));
  vsine #(.dc(0.0), .mag(1.0), .phase(0.0), .offset(1m), .ampl(2m), .freq(0.75), .td(1.0), .damp(0.25), .sinephase(0.0), .ammodindex(0.5), .ammodfreq(0.5), .ammodphase(0.0), .fmmodindex(0.2), .fmmodfreq(1.0)) x3(.p(a3), .n(n));
  analog begin
    `CHECKR("offset + ampl*AM*damp*cos, every factor away from 1", V(x1.p, x1.n), -8.202882373436317e-4, 1e-14);
    `CHECKR("dc, mag and phase are AC values and change no waveform", V(x2.p, x2.n), -8.202882373436317e-4, 1e-14);
    `CHECKR("at t = td the row is offset + ampl*(1 - ammodindex)", V(x3.p, x3.n), 2.0e-3, 1e-15);
    `CHECKX("the ampl override reaches Table E.1's ampl", x1.ampl, 2.0e-3);
    `CHECKX("and fmmodfreq, which the printed row mislabels f_AM", x1.fmmodfreq, 1.0);
  end
endmodule
