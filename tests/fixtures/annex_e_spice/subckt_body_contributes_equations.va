// H04 — a `.SUBCKT` instantiated from Verilog-AMS is a CIRCUIT, not an
// interface. Its device cards have to become equations, or the instance is an
// open circuit that happens to have the right port names.
//
// THE CLAUSE. E.2:
//
//     "In addition to SPICE primitives, it shall also be possible to access
//      subcircuits and models defined within SPICE netlists. The subcircuits and
//      models contained within the SPICE netlist are treated as module
//      definitions."
//
// A module DEFINITION is an interface plus a body (§6.2). E.2.2.2 then shows
// what a subcircuit body is: eleven device cards — `VA VCC GND 5`, `IEE E GND
// 1MA`, two transistors, an inductor, four capacitors, two resistors — and
// prints `ecpOsc Osc1 (out, gnd);` as the Verilog-AMS reference to the whole of
// it. It calls that subcircuit an OSCILLATOR. An oscillator whose body
// contributed nothing would be two floating pins, so E.2's "treated as module
// definitions" cannot be read as "treated as module headers".
//
// E.2.2.3 is the annex's own proof of the same point: it translates that
// subcircuit, card by card, into a Verilog-AMS module full of Table E.1
// primitive instances. The two texts are presented as the same circuit, which
// is only true if the cards inside the `.SUBCKT` carry their equations across.
//
// THE NETLIST HERE is E.2.2.2's shape reduced to the two cards whose behaviour
// Table E.1 does fix, so that the expected number is derivable rather than
// device-model-dependent — E.1.2's fourth bullet ("the mathematical description
// of the built-in primitives can differ") is why no transistor appears.
//
//     .SUBCKT RDIV IN OUT GND
//     R1 IN OUT 1K
//     R2 OUT GND 3K
//     .ENDS RDIV
//
// THE DIGITS, BY HAND. `//! bias` holds in at 1.0 V and gnd at 0.0 V; `//!
// solve` leaves the internal node `out` to the equations, which is the point —
// its value is the subcircuit's answer, not the harness's. Two resistors in
// series from 1.0 V to 0.0 V, so by the divider identity
//
//     V(out, gnd) = 1.0 * R2 / (R1 + R2) = 1.0 * 3000 / 4000 = 0.75 V
//     V(in, out)  = 1.0 - 0.75                              = 0.25 V
//
// and the series current is 1.0 / 4000 = 2.5e-4 A. 1k and 3k rather than two
// equal resistors: equal values would make 0.5 and 0.5 indistinguishable under a
// swap of the two cards, and 0.75/0.25 pins the ORDER of the nodes on each card
// as well as the values on them. An empty body — VerA today — leaves `out`
// unconstrained; the harness's solve then drives it to 0.0, so both checks fail
// with got=0 and got=1.
//
// WHAT VerA DOES TODAY, and why this fixture exists. `lib/frontend/spice_cards.zig`
// emits `module rdiv(in, out, gnd); inout ...; electrical ...; endmodule` and
// says so at the site: "EMPTY BODY. The subcircuit's contents are device cards
// written in SPICE, which this reader does not read ... under `//! solve` an
// instance of it is an open circuit." The existing
// tests/fixtures/annex_e_spice/spice_subcircuit.va sits exactly on that ceiling
// and declines to assert any internal node. This file is the assertion that was
// declined.
//
//! lrm E.2
//! lrm E.2:3
//! lrm E.2:1001
//! lrm E.2.2.2
//! lrm E.2.2.3
//! lrm E.1.1
//! lrm 6.7.1
//! lrm 6.7.1:1
//! bias V(in) = 1.0, V(gnd) = 0.0
//! solve
//! spice .SUBCKT RDIV IN OUT GND
//! spice R1 IN OUT 1K
//! spice R2 OUT GND 3K
//! spice .ENDS RDIV
`include "check.vh"
module h04_subckt_body(in, gnd);
  inout in, gnd; electrical in, gnd;
  rDiv x1(in, mid, gnd);
  analog begin
    // 1.0 * 3000/(1000+3000).
    `CHECK("R1/R2 in series divide the 1 V: V(out,gnd) = 3k/4k",
           V(x1.out, x1.gnd), 0.75, 1e-12);
    // The complement, so a body that contributed only R2 is caught too.
    `CHECK("and the top half takes the rest: V(in,out) = 1k/4k",
           V(x1.in, x1.out), 0.25, 1e-12);
  end
endmodule
