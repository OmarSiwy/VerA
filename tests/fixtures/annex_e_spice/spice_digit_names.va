// E.2: "The subcircuits and models contained within the SPICE netlist are
// treated as module definitions." SPICE has no identifier-shape rule to
// inherit: industry model names LEAD WITH DIGITS (`2N2222`, `1N4148` — the
// JEDEC registry itself numbers them so), and bare numbers are the DEFAULT
// node spelling, `.SUBCKT FLT A 1 B` being three nodes of which one is `1`.
// So "treated as module definitions" obliges the reader to carry names §2.7
// has no bare spelling for — and §2.8.1 is the LRM's own carrier: an escaped
// identifier "can include any printable ASCII character", and neither the
// backslash nor the terminating white space is part of the name, so the
// synthesized `\2n2222 ` IS the netlist's 2N2222 (lowered per E.2.1) and
// `\1 ` IS node 1.
//
// WHAT WENT WRONG WITHOUT THIS. VerA's card reader tested §2.7 SHAPE and
// silently dropped what failed it: `.MODEL 2N2222 NPN` contributed nothing
// (the later undefined-module diagnostic then pointed at the USER's
// instantiation line), and the port scan of `.SUBCKT FLT A 1 B` stopped at
// the `1`, truncating three ports to one — a silently WRONG ordered binding,
// which E.3 makes normative. Both failure modes are pinned here: the model
// name must resolve at all, and the subcircuit instance below connects THREE
// nets in order, so a one-port interface cannot even elaborate.
//
// THE OBSERVABLES, all §6.7.1 hierarchical port probes against `//! bias`
// (1.3.1-exact differences of exact operands):
//   V(q1.c, q1.e) = 0.75  — the model's interface comes from the bjt
//                           primitive (E.2.2.1), ordered c, b, e;
//   V(d1.a, d1.b) = 0.75  — .SUBCKT ports in card order, a first, b THIRD:
//                           truncation or re-ordering moves this;
//   V(d1.\1 , d1.b) = 0.5 — the numeric node is a real port, reachable by
//                           name through its §2.8.1 spelling.
// The device card inside the subcircuit is skipped, not read: the module body
// is empty, which is why every potential here is imposed, none solved.
//
//! lrm E.2
//! lrm E.2.1
//! lrm E.2.2.1
//! lrm E.2.2.2
//! lrm 2.8.1
//! lrm 6.7.1
//! lrm 6.2.2
//! lrm 6.2.2:2
//! lrm 6.5.4
//! lrm 6.5.4:1
//! lrm 6.7.1:1
//! lrm E.2:3
//! bias V(c1) = 1.0, V(b1) = 0.75, V(e1) = 0.25
//! spice .MODEL 2N2222 NPN BF=100 IS=1E-14
//! spice .SUBCKT FLT A 1 B
//! spice R1 A 1 10K
//! spice .ENDS FLT
`include "check.vh"
module annex_e_spice_digit_names(c1, b1, e1);
  inout c1, b1, e1; electrical c1, b1, e1;
  \2n2222 q1(c1, b1, e1);
  flt d1(c1, b1, e1);
  analog begin
    `CHECKX(".MODEL 2N2222 declares a module; ports are the bjt's c, b, e",
            V(q1.c, q1.e), 0.75);
    `CHECKX(".SUBCKT FLT A 1 B is a three-port interface in card order",
            V(d1.a, d1.b), 0.75);
    `CHECKX("numeric node 1 is the second port, named through its escape",
            V(d1.\1 , d1.b), 0.5);
  end
endmodule
