// LRM E.1.2: "whether a particular Verilog-AMS simulator is SPICE compatible,
// and with which particular variant of SPICE it is compatible, is solely
// determined by the authors of the simulator." VerA's claim (VD-012) reads
// `{expr}` values over a subcircuit's own `PARAMS:`, and refuses inside a
// definition what it does not read: a skipped card changes the circuit (a
// dropped R is an open), the silent wrong answer AGENTS.md §4 forbids.
//
// `{RTOP}` here reads a name the subcircuit does not declare. HSPICE would
// look for a global `.PARAM RTOP`, which VerA does not read, so the card is
// refused at its line rather than left to fail as an unknown identifier
// inside the synthesized module (or, before #9, skipped: `in` and `out`
// unconnected).
//
// Legal neighbour: spice_subckt_params_expressions.va, the same RDIV with
// `PARAMS: RTOP=1K ...` on its header, which compiles and divides.
//
//! lrm E.1.2
//! lrm E.2
//! bias V(in) = 1.0, V(gnd) = 0.0
//! reject-only E0928
//! reject expression value `{rtop}` reads `rtop`
//! neighbour spice_subckt_params_expressions.va
//! spice .SUBCKT RDIV IN OUT GND
//! spice R1 IN OUT {RTOP}
//! spice R2 OUT GND 3K
//! spice .ENDS RDIV
`include "check.vh"
module rdiv_user(in, gnd);
  inout in, gnd; electrical in, gnd;
  rdiv x1(in, mid, gnd);
endmodule
