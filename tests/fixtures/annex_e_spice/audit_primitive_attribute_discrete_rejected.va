// E.3.2.1 requires a continuous-domain discipline for an analog primitive.
// A declared discrete discipline satisfies the name rule but fails the domain rule.
//! lrm E.3.2.1
// Expected future diagnostic: this rule-specific wording is not emitted yet.
//! reject port_discipline requires a continuous discipline
//! xfail analog primitive port_discipline value validation is not implemented
discipline audit_e_discrete; domain discrete; enddiscipline
module audit_e_bad_attribute_discrete(p,n);
  inout p,n; electrical p,n;
  (* port_discipline="audit_e_discrete" *) resistor #(.r(1000.0)) r(p,n);
endmodule
