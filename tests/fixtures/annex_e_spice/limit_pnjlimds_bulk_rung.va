// §9.17.3 $limit with VerA's "pnjlimds" string: SPICE's MOS bulk rung.
//
// §9.17.3: "In all cases, the simulator is responsible for determining if
// limiting should be applied and what the return value is on a given
// iteration." The string is implementation-defined; "pnjlimds" is VerA's name
// for what ngspice's MOS loads do after the gate/channel ladder
// (mos1load.c:376-384, the same in mos2/3/6/9 and b1ld/b2ld/b3ld):
//
//     if(vds >= 0) {                           /* the LIMITED vds */
//         vbs = DEVpnjlim(vbs, state0.vbs, vt, sourceVcrit, &Check);
//         vbd = vbs-vds;
//     } else {
//         vbd = DEVpnjlim(vbd, state0.vbd, vt, drainVcrit, &Check);
//         vbs = vbd + vds;
//     }
//
// ONE junction is limited, from its raw value, and only the bulk moves. Two
// plain "pnjlim" sites instead limit both and write si and di, moving the vgs
// and vds the ladder just set. `//! limit` runs the device's published `limit`
// with the bias below as `cur` and the listed `old` lanes; ports are written
// too (b is one), which a host that masks ports may decline.
//
// BIAS (cur): g = 0.5, si = 0.5, di = 0, b = 1.5; so vgs = 0, vds = -0.5,
// vbs = 1.0, vbd = 1.5. vt = 0.025, vcrit = 0.6, vto = 0.7. devsup.c
// DEVpnjlim(vnew, vold): if vnew > vcrit and |vnew - vold| > 2 vt, then
// vold > 0 ? vold + vt (2 + ln((vnew - vold)/vt - 2)) : vt ln(vnew/vt).
//
// [0] old all 0. Old vds = 0 >= 0: normal mode. fetlim(vgs 0, old 0) and
//     limvds(-0.5, old 0) = max(-0.5, -0.5) leave the channel. The LIMITED
//     vds is -0.5 < 0, so the drain junction: vbd = 1.5, old 0, so
//     0.025 ln(1.5/0.025) = 0.025 ln 60 = 0.10235861405555252, and
//     b = di + that. Clamped: converged = 0.
// [1] old di = 4, g = 0.5, b = 0.8, si = 0. Old vds = 4: normal mode; fetlim
//     leaves vgs = 0 (off, vold 0.5 < vto, max(0, 0.5 - 2.4)); DEVlimvds with
//     vold >= 3.5 and vnew = -0.5 < 3.5 gives max(vnew, 2) = 2, so di =
//     si + 2 = 2.5. The limited vds is +2: the SOURCE junction, raw vbs = 1.0,
//     old 0.8 > 0: 0.8 + 0.025 (2 + ln(8 - 2)) = 0.8947939867307014, and
//     b = si + that = 1.3947939867307014. converged = 0.
// [2] old = cur: §9.17.3 "When the simulator has converged, the return value
//     of the $limit() function is the value of the access function
//     reference": nothing moves and converged = 1.
//
// SEED. A "pnjlimds" leg is a branch of VerA's seed tree (`vera_seed`), the
// vbs leg at its default vcrit (vbd is derived through vds). Its nets are b
// and si; b is the lowest port, so b = 0 and b - si = vcrit gives si = -0.6.
// At the bias the model evaluates, §9.17.3's "When the simulator has
// converged, the return value of the $limit() function is the value of the
// access function reference, within appropriate tolerances" is the CHECK
// (1e-6: Annex D's `nature Voltage` abstol, as limit_fet.va argues).
//! lrm 9.17.3
//! bias V(g) = 0.5, V(si) = 0.5, V(di) = 0.0, V(b) = 1.5
//! print none
//! seed V(b) = 0.0, V(si) = -0.6
//! limit V(g) = 0, V(si) = 0, V(di) = 0, V(b) = 0 -> V(b) = 0.10235861405555252, V(si) = 0.5, V(di) = 0.0, converged = 0
//! limit V(di) = 4.0, V(g) = 0.5, V(b) = 0.8, V(si) = 0 -> V(b) = 1.3947939867307014, V(di) = 2.5, V(si) = 0.5, converged = 0
//! limit -> V(b) = 1.5, V(si) = 0.5, V(di) = 0.0, V(g) = 0.5, converged = 1
`include "check.vh"
module limit_pnjlimds_bulk_rung(d, g, s, b);
  inout d, g, s, b; electrical d, g, s, b, di, si;
  parameter real vt = 0.025, vcrit = 0.6, vto = 0.7;
  real vgs, vgd, vds, vbs, vbd;
  analog begin
    vgs = $limit(V(g, si), "fetlimds", vto);
    vgd = $limit(V(g, di), "fetlimds", vto);
    vds = $limit(V(di, si), "limvds");
    vbs = $limit(V(b, si), "pnjlimds", vt, vcrit);
    vbd = $limit(V(b, di), "pnjlimds", vt, vcrit);
    I(d, di) <+ V(d, di) / 10.0;
    I(s, si) <+ V(s, si) / 10.0;
    I(di, si) <+ 1e-3 * (vds + 0.1 * (vgs + vgd));
    I(b, si) <+ 1e-14 * (limexp(vbs / vt) - 1.0);
    I(b, di) <+ 1e-14 * (limexp(vbd / vt) - 1.0);
    `CHECK("$limit returns its access function at the answer", vbs, 1.0, 1e-6);
  end
endmodule
