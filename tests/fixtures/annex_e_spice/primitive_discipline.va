// E.3.2.1, first worked example. The LRM prints:
//
//     (* port_discipline="electrical" *) resistor #(.r(1k))
//        r1 (node1, node2); // not needed as default
//     (* port_discipline="rotational" *) resistor #(.r(1k))
//        r2 (node1, node2);
//
// WHAT IS PINNED. "A new optional attribute shall be provided called
// port_discipline, which shall have as a value the desired discipline for the
// port of the analog primitive... The value shall be of type string and the
// value must be a valid discipline of domain continuous." Attached to the
// INSTANCE, as here, it sets the discipline of every port of that primitive —
// which E.3.2.1 contrasts with the per-port form in
// primitive_port_discipline.va. `rotational` is Annex D's, and of domain
// continuous, so the attribute is well-formed.
//
// The attribute sits on a `module_instantiation`, which A.4.1.1 admits as
// `{attribute_instance} module_instantiation` — unlike a bare port name in a
// non-ANSI header, which A.1.3 does not (see port_discipline_ignored_on_module).
//
// HOW A DISCIPLINE IS MADE OBSERVABLE. Nothing in a behavioural block reads a
// discipline back as a value. What a discipline decides is WHICH ACCESS
// FUNCTIONS EXIST on the net, and that is checkable: Annex D gives `rotational`
// the natures Angle and Angular_Force, whose access functions are `Theta` and
// `Tau`, where `electrical` has `V` and `I`. So `Tau(r2.p, r2.n)` names the flow
// of the rotational resistor's own branch and only type-checks if the attribute
// took effect; a tool that ignored port_discipline leaves r2's ports electrical,
// where `Tau` is not an access function at all. §6.7.1 is what allows the branch
// to be reached from here: "potential and flow access for named and unnamed
// branches (including port branches) can be done hierarchically".
//
// The digits come from Table E.1's resistor row, V = I*r, which is written in
// the nature-neutral V/I of the table and holds in whatever discipline the
// primitive's ports end up with: 1 V across r1 gives 1.0/1000 A, and 2 rad
// across r2 gives 2.0/1000 N*m. The two differ, so a build that crossed the
// instances fails both.
//
// THE TWO INSTANCES DO NOT SHARE A NET PAIR HERE, and the LRM's example does.
// As printed, r1 and r2 sit on node1 and node2 together while asking for
// incompatible continuous disciplines on them, which §3.11 makes an error on any
// tool that resolves disciplines at all — the example is illustrating attribute
// syntax, not a circuit. Giving r2 its own `rotational` pair is what makes the
// file elaborable, and it does not weaken the test: the attribute is still
// load-bearing in both directions, because a tool that ignored it would connect
// electrical primitive ports to rotational nets and have the §3.11 error back.
//
// THIS IS A RUN FIXTURE, NOT A REJECT. An earlier revision demanded a diagnostic
// for an example the LRM prints.
//
//! lrm E.3.2.1
//! lrm E.3.2
//! lrm E.3
//! lrm 2.9
//! lrm 6.7.1
//! bias V(node1) = 1.0, V(node2) = 0.0, shaft1 = 2.0, shaft2 = 0.0
//! xfail VerA rejects module instantiation (E0204), so a primitive carrying port_discipline cannot be reached
`include "check.vh"
module annex_e_primitive_discipline(node1, node2, shaft1, shaft2);
  inout node1, node2, shaft1, shaft2;
  electrical node1, node2;
  rotational shaft1, shaft2;
  (* port_discipline="electrical" *) resistor #(.r(1k)) r1(node1, node2); // not needed as default
  (* port_discipline="rotational" *) resistor #(.r(1k)) r2(shaft1, shaft2);
  analog begin
    `CHECKX("r1 keeps its 1k", r1.r, 1000.0);
    `CHECKX("r2 keeps its 1k", r2.r, 1000.0);
    // port_discipline="electrical": V and I are the access functions, and
    // Table E.1 gives I = V/r = 1.0/1000.
    `CHECKX("the electrical instance sees the bias p first", V(r1.p, r1.n), 1.0);
    `CHECKR("Table E.1 V = I*r on the electrical pair", I(r1.p, r1.n), 1.0e-3, 1e-15);
    // port_discipline="rotational": Annex D makes the access functions Theta
    // (Angle, rads) and Tau (Angular_Force, N*m). Table E.1's V = I*r reads
    // Theta = Tau*r, so Tau = 2.0/1000.
    `CHECKX("the rotational instance is probed with Theta, not V",
            Theta(r2.p, r2.n), 2.0);
    `CHECKR("Table E.1 V = I*r on the rotational pair", Tau(r2.p, r2.n), 2.0e-3, 1e-15);
  end
endmodule
