// DEBT — this rejection is NOT conformance.
// The LRM permits what VerA refuses here. The substrings below record
// CURRENT behavior so the suite stays green on it; they do not claim it
// is right. `zig build ledger` counts this rule against VerA.
//
// VAMS-E.1.2-02  (annex-e-spice.html)
// To reduce this, a list of what names shall be used for the more common components is shown in Table E.1.
//
//! reject module instantiation is not supported
// EXPECT: error -- SPICE objects require hierarchy/SPICE elaboration.
module annex_e_spice_semiconductor_primitives_unsupported(d, g, s, b);
  inout d, g, s, b; electrical d, g, s, b;
  mosfet #(.w(1u), .l(100n), .ad(2p), .as(2p), .pd(3u), .ps(3u),
      .nrd(1.0), .nrs(1.0)) m1(.d(d), .g(g), .s(s), .b(b));
endmodule
