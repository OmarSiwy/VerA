// E.3.2: "The discipline of analog primitives will be resolved based on
// instance specific attributes, the disciplines of other instances on the same
// net, or default to electrical if it cannot be determined." Its precedence
// list puts "The resolution of the discipline" second, and E.3.2.2 is that
// resolution:
//
//   "If no attribute exists on the instance of an analog primitive, then the
//    discipline may be determined by the disciplines of other instances
//    connected to the same net segment. The disciplines of the vpiLoConn of all
//    other instances on the net segment shall be evaluated to determine if they
//    are of domain continuous and compatible with each other. If they are, then
//    the discipline of the analog primitive shall be set to the same
//    discipline. IF THEY ARE NOT COMPATIBLE, THEN AN ERROR WILL OCCUR AS
//    DEFINED IN 3.11."
//
// Net `q` below carries three instances. `ea` binds it to an `electrical`
// port, `rb` to a `rotational` one, and `r1` is a Table E.1 resistor with no
// port_discipline attribute. The other instances' disciplines are both
// continuous and are NOT compatible — electrical and rotational share no
// nature (§3.11.1: potentials and flows of the two disciplines are of
// different natures). So the primitive has nothing to adopt, and E.3.2.2
// sends the net to §3.11's error rather than letting the primitive pick one
// side or fall back to electrical. The primitive is the case the clause is
// about: without it the conflict is §3.11's alone, with it a tool might have
// tried to use the resistor's default to "resolve" q.
//
// Replacing `rb`'s module with a second electrical one compiles (probed; the
// same three-instance shape with compatible neighbours is
// primitive_segment_discipline.va).
//
// VerA reports E0355 "incompatible disciplines".
//
//! lrm E.3.2
//! lrm E.3.2.2
//! lrm E.3.2.2:2
//! lrm 3.11
//! lrm 3.11:4
//! reject-only E0355
//! reject incompatible disciplines
//! neighbour primitive_segment_discipline.va
`include "disciplines.vams"
module e322_top(p, n);
  inout p, n; electrical p, n;
  e322_elec ea(q);
  e322_rot  rb(q);
  resistor #(.r(1k)) r1(q, n);           // no attribute: E.3.2.2 resolves from q
  analog I(p, n) <+ V(p, n);
endmodule

module e322_elec(x);
  inout x; electrical x;
  analog I(x) <+ V(x) / 1.0e3;
endmodule

module e322_rot(x);
  inout x; rotational x;
  analog Tau(x) <+ Theta(x);
endmodule
