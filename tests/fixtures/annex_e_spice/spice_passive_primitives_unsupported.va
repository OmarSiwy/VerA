// DEBT — this rejection is NOT conformance.
// The LRM permits what VerA refuses here. The substrings below record
// CURRENT behavior so the suite stays green on it; they do not claim it
// is right. `zig build ledger` counts this rule against VerA.
//
// VAMS-E.1.2-02  (annex-e-spice.html)
// To reduce this, a list of what names shall be used for the more common components is shown in Table E.1.
// VAMS-E.2-01  (annex-e-spice.html)
// SPICE primitives built into the simulator shall be treated in the same manner in Verilog-AMS HDL as built-in primitives of gate- and switch-level mode
// VAMS-E.3-01  (annex-e-spice.html)
// For connection by order instead of by name, the ports and parameters shall be given in the order listed.
//
//! reject module instantiation is not supported
// EXPECT: error -- SPICE objects require hierarchy/SPICE elaboration.
module annex_e_spice_passive_primitives_unsupported(p, n);
  inout p, n; electrical p, n;
  resistor #(.r(1k), .tc1(0.0), .tc2(0.0)) r1(p, n);
endmodule
