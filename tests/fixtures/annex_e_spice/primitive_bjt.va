// Table E.1 row `bjt`: ports c, b, e, s, parameters area, behaviour
// a bipolar junction transistor of the given area.
//
// E.2.2.1 also says of this row: "This bjt primitive has 3 mandatory ports (c, b,
// and e) and one optional port (s)", and prints an instance that leaves s off.
// That form is primitive_bjt_substrate_omitted.va; both instances below give
// all four ports.
//
// WHAT IS PINNED. E.3: "Table E.1 shows the REQUIRED names for primitives,
// parameters, and ports which are otherwise unnamed in SPICE. For connection by
// order instead of by name, the ports and parameters shall be given in the order
// listed. The default discipline of the ports for these primitives shall be
// electrical and their descriptions shall be inout." E.1.2 adds that "when
// instantiating SPICE primitives in Verilog-AMS HDL, the primitives shall, and
// parameters and ports can, be named", and E.2 that a tool "expected to provide
// the basic set of Spice primitives" shall treat them "in the same manner in
// Verilog-AMS HDL as built-in primitives of gate- and switch-level modeling".
// So the instantiation below — every port and every parameter named, in the
// Table E.1 order — is source a SPICE-compatible Verilog-AMS tool must accept.
//
// THIS IS A RUN FIXTURE, NOT A REJECT. An earlier revision of this file demanded
// a diagnostic for the line below. That inverts the test: the LRM prints this
// syntax as legal, so a conforming compiler would FAIL and only a compiler with
// no SPICE support would pass. The requirement is that it compiles, and it does:
// VerA ships Table E.1 as ordinary module declarations in a prelude, the same
// shape as annex D's disciplines.vams (`Preprocessor.spice_primitives`).
//
// WHAT CANNOT BE PINNED, AND WHY THAT IS THE LRM'S DOING. Table E.1's Behavior
// column for this row is EMPTY, and E.2 says why: "while the Verilog-AMS HDL
// built-in primitives are standardized, the SPICE primitives are not. All aspects
// of SPICE primitives are implementation dependent." E.1.1 adds that "the
// mathematical description of the built-in primitives can differ". So there is no
// device law here to write digits for — a fixture that asserted one would be
// pinning a particular simulator's convention, and one that asserted the
// primitive contributes NOTHING would be pinning VerA's. Neither is a
// requirement. What Table E.1 does require of this row is its INTERFACE, and that
// is what the digits below are for.
//
// HOW IT IS OBSERVED. §6.7.1: "Potential and flow access for named and unnamed
// branches (including port branches) can be done hierarchically", and "access of
// parameters can be done hierarchically". So `V(x1.c, x1.b)` is the potential
// across the primitive's OWN port pair, reached by an out-of-module reference, and
// `x1.area` is the parameter the override landed on. The bias values are all
// different and all dyadic, so every port carries a distinct exact digit: a tool
// that bound Table E.1's names to a different net, or read the positional list in
// another order, reads a different number. That is the claim, because E.3 fixes
// the port ORDER as well as the names and x2 below connects by order.
//
//! lrm E.3
//! lrm E.3:1
//! lrm E.3:2
//! lrm E.1.2
//! lrm E.1.2:1
//! lrm E.2
//! lrm E.2:2
//! lrm E.2.2.1
//! lrm 6.7.1
//! lrm 6.2.2
//! lrm 6.2.2:2
//! lrm 6.5.4
//! lrm 6.5.4:1
//! lrm 6.7.1:1
//! bias V(c) = 1.0, V(b) = 0.5, V(e) = 0.25, V(s) = 0.125
`include "check.vh"
module annex_e_primitive_bjt(c, b, e, s);
  inout c, b, e, s; electrical c, b, e, s;
  bjt #(.area(1.0)) x1(.c(c), .b(b), .e(e), .s(s));
  // E.3, "for connection by order instead of by name, the ports and parameters
  // shall be given in the order listed": the same primitive, nothing named.
  bjt #(3.0) x2(c, b, e, s);
  analog begin
    `CHECKX("Table E.1 names this row's ports c, b, e, s", V(x1.c, x1.b), 0.5);
    `CHECKX("and in that order: b then e", V(x1.b, x1.e), 0.25);
    `CHECKX("and s last", V(x1.e, x1.s), 0.125);
    `CHECKX("connected by order, port 1 is c and port 2 is b", V(x2.c, x2.b), 0.5);
    `CHECKX("by order, port 3 is e and port 4 is s", V(x2.e, x2.s), 0.125);
    `CHECKX("the named override reaches Table E.1's area", x1.area, 1.0);
    `CHECKX("by order, the first parameter in the list is area", x2.area, 3.0);
    I(c, e) <+ 0.0;
  end
endmodule
