//! reject module instantiation is not supported
// EXPECT: error -- Table E.1 primitive needs SPICE elaboration.
module annex_e_primitive_vpwl(p,n); inout p,n; electrical p,n; vpwl #(.dc(0.0),.mag(1.0),.phase(0.0),.wave('{0.0,0.0,1n,1.0})) x(.p(p),.n(n)); endmodule
