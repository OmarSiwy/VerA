// Table E.1 row `vpwl`: ports p, n, parameters dc, mag, phase, wave, behaviour —
// a piecewise linear voltage source over (time, value) pairs. The ipwl row with V
// for I; the published row's last line reads `I = wave[n-1]` where every other
// line of it reads V, and Annex E's source-fidelity note lists that as an apparent
// defect of the printed table. It is V, which is what x3 below pins.
//
// WHAT IS PINNED. E.3: "Table E.1 shows the REQUIRED names for primitives,
// parameters, and ports which are otherwise unnamed in SPICE. For connection by
// order instead of by name, the ports and parameters shall be given in the order
// listed. The default discipline of the ports for these primitives shall be
// electrical and their descriptions shall be inout." E.1.2 adds that "when
// instantiating SPICE primitives in Verilog-AMS HDL, the primitives shall, and
// parameters and ports can, be named", and E.2 that a tool "expected to provide
// the basic set of Spice primitives" shall treat them "in the same manner in
// Verilog-AMS HDL as built-in primitives of gate- and switch-level modeling".
// So the instantiation below — every port and every parameter named, in the
// Table E.1 order — is source a SPICE-compatible Verilog-AMS tool must accept.
//
// THIS IS A RUN FIXTURE, NOT A REJECT. An earlier revision of this file demanded
// a diagnostic for the line below. That inverts the test: the LRM prints this
// syntax as legal, so a conforming compiler would FAIL and only a compiler with
// no SPICE support would pass. The requirement is that it compiles, and it does:
// VerA ships Table E.1 as ordinary module declarations in a prelude, the same
// shape as annex D's disciplines.vams (`Preprocessor.spice_primitives`).
//
// THE DIGITS. Table E.1 gives this row an interpolation and a tail:
//
//     wave[i+1] + (wave[i+3] - wave[i+1]) * (t - wave[i]) / (wave[i+2] - wave[i])
//         for wave[i] <= t < wave[i+2],  0 <= i < n,  n = len(wave)
//     wave[n-1]
//         for wave[n-2] < t
//
// so `wave` is (time, value) pairs and i steps by two. All three instances are read
// at t = 1 ns and each puts that instant somewhere else in its own wave:
//
//   x1  {0, 1m, 2n, 5m}              half way along the only segment:
//                                    1m + (5m-1m)*1n/2n              3.0e-3
//   x2  {0, 9m, 0.5n, 5m, 2.5n, 1m}  a quarter along the SECOND segment:
//                                    5m + (1m-5m)*0.5n/2n            4.0e-3
//   x3  {0, 1m, 0.5n, 6m}            past wave[n-2], so the tail:
//                                    wave[n-1]                       6.0e-3
//
// x2 is the one that pins PAIRING. Its first pair is a decoy: 9m is the value at
// t = 0, and a tool that read the array as (value, time) instead of (time, value),
// or that interpolated the first segment whatever t was, answers nothing near
// 4.0e-3. x1 and x3 are the two ends of the row: the interpolation itself, and the
// "for wave[n-2] < t" clause that holds the LAST value rather than extrapolating
// the last slope.
//
// WHAT x2 DOES NOT PIN, said out loud: the STRIDE. Table E.1's i advances by two,
// but a walk that advanced by one would test wave[1] <= t < wave[3] — a current
// against a time, which cannot match at any t these digits are read at — and would
// then land on the same i = 2 segment last and answer the same 4.0e-3. Catching a
// one-at-a-time walk needs a wave whose odd entries are themselves plausible times,
// which is a wave no reader can check by eye. The stride is left uncovered rather
// than covered by an unreadable fixture.
//
// `nwave` IS NOT IN TABLE E.1, and x2 is the only instance that needs it. §3.4.4
// sizes an array parameter with a range and there is no unsized array parameter to
// declare, so VerA's prelude carries the length as its own parameter — the one
// place this row's interface is wider than the table's (see
// `Preprocessor.spice_primitives`). The four-entry default covers x1 and x3.
//
// HOW THE PRIMITIVE IS OBSERVED. §6.7.1: "Potential and flow access for named
// and unnamed branches (including port branches) can be done hierarchically",
// and "access of parameters can be done hierarchically". So `V(x1.p, x1.n)` is the
// potential of the primitive's own port pair — the branch Table E.1's Behavior
// column is written about — reached by an out-of-module reference, and `x1.wave` is
// the parameter an override landed on. Nothing else could observe the row: the
// Behavior column belongs to the primitive's branches, not to this module's.
//
// ONE INSTANCE PER NET PAIR, and that is load-bearing. Two unnamed branches over
// the same pair of nets share one accumulator in VerA today
// (ch05_analog_behavior/two_named_branches.va holds that gap), so two instances
// hung across the same two nets would each read the SUM of both. Every instance
// below therefore gets its own net, sharing only the common return.
//
//! lrm E.3
//! lrm E.3:1
//! lrm E.3:2
//! lrm E.1.2
//! lrm E.1.2:1
//! lrm E.2
//! lrm 3.4.4
//! lrm 6.7.1
//! lrm 6.7.1:1
//! analysis tran
//! time 1n
//! bias V(n) = 0.0
//! solve
`include "check.vh"
module annex_e_primitive_vpwl(p, n);
  inout p, n; electrical p, n;
  electrical a1, a2, a3;
  vpwl #(.dc(0.0), .mag(1.0), .phase(0.0), .wave('{0.0, 1m, 2n, 5m})) x1(.p(a1), .n(n));
  vpwl #(.dc(0.0), .mag(1.0), .phase(0.0), .nwave(6), .wave('{0.0, 9m, 0.5n, 5m, 2.5n, 1m})) x2(.p(a2), .n(n));
  vpwl #(.dc(0.0), .mag(1.0), .phase(0.0), .wave('{0.0, 1m, 0.5n, 6m})) x3(.p(a3), .n(n));
  analog begin
    `CHECKR("half way along one segment of wave", V(x1.p, x1.n), 3.0e-3, 1e-15);
    `CHECKR("a quarter along the SECOND segment, from a three-point wave", V(x2.p, x2.n), 4.0e-3, 1e-15);
    `CHECKX("past wave[n-2] the row holds wave[n-1], a POTENTIAL", V(x3.p, x3.n), 6.0e-3);
  end
endmodule
