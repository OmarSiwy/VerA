// §9.15 Table 9-27: `sourceScaleFactor`, "Multiplicative factor for
// independent sources for source stepping homotopy". E.2 makes "all aspects
// of SPICE primitives" implementation dependent; VerA's Annex E independent
// sources (the i* and v* rows of Table E.1) multiply their value by it
// (VD-108), as SPICE's source stepping scales every source (ngspice
// CKTsrcFact). It is a host-written `Model` field (`source_scale__`, VD-072),
// 1 unless a host steps it; `//! param` writes it as the host would, with a
// value no default has.
//
// THE DIGITS, BY HAND, with the factor at 0.25 in a dc analysis (§4.6.1:
// each source holds its `dc`):
//
//     vsine dc = 2:                V(a, n) = 0.25 * 2     = 0.5 V
//     isine dc = 4m into 1k:       0.25 * 4e-3 = 1e-3 A flows b -> n through
//                                  the source, so the resistor carries it back:
//                                  V(b, n) = -1e-3 * 1k   = -1.0 V
//
// The isine's current is read through the potential it develops, not as
// I(i1.p, i1.n): from this module that names the pair (b, n), which the load
// shares, and §5.5.4 makes such a probe "a new unnamed branch ... in the
// module containing the access function call", not the source's own branch.
// The potentials come out of the solve, so they get 1e-12. Without the
// factor they read 2.0 V and -4.0 V.
//
// No refusal neighbour: the factor is the host's to write, and no value of
// it is invalid.
//
//! lrm 9.15
//! lrm E.2
//! lrm 4.6.1
//! lrm 6.7.1
//! analysis dc
//! param source_scale__ = 0.25
//! bias V(n) = 0.0
//! solve
//! checks 2
`include "check.vh"
module annex_e_primitive_source_scale_factor(n);
  inout n; electrical n;
  electrical a, b;
  vsine #(.dc(2.0)) v1(a, n);
  isine #(.dc(4m)) i1(b, n);
  resistor #(.r(1k)) r1(b, n);
  analog begin
    `CHECK("vsine's dc times the host's factor", V(v1.p, v1.n), 0.5, 1e-12);
    `CHECK("isine's dc times the host's factor, carried back by the 1k load", V(r1.p, r1.n), -1.0, 1e-12);
  end
endmodule
