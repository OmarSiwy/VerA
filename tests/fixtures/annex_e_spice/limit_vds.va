// Annex E.3.4 / §9.17.3 $limit with the drain-to-source limiter, which Table E.2
// lists as taking NO arguments beyond the access function — which is why this
// call has two arguments where limit_pnj.va has four.
//
// THE NAME. Table E.2's preferred spelling is `vdslim`. VerA's built-in is
// spelled `limvds` (SPICE3's DEVlimvds), and an unrecognised string is not a
// conformance failure: §9.17.3 says "if the string refers to an unknown or
// unsupported function, the simulator is responsible for determining the
// appropriate limiting algorithm", and E.3.4 itself only offers "preferred names
// for three functions that MAY be available in a simulator". So there is no
// diagnostic to demand and no xfail to write. `limvds` is used here because it
// is the string that actually installs a clamp in the tool under test; that
// E.3.4's preferred `vdslim` reaches no built-in is a COVERAGE gap, not a bug.
// The transparency claim below is name-independent: it holds for a tool that
// recognises the string, and for one that substitutes its own limiter under the
// §9.17.3 escape clause.
//
// WHAT IS PINNED. §9.17.3: while $limit()'s output differs from the value of its
// access function the simulator may not terminate the iteration, so at a solved
// point the limiter is transparent and the stamped drain current is the one
// V(mid) implies.
//
// WHY THE PROBE IS AN INTERNAL NET. A limiter corrects an unknown the device
// owns. Probing the module PORT instead makes the correction a write to a node
// the host imposes, and a simulator is entitled to decline it — VerA does,
// silently — so a port-probing form of this fixture asserts the transparency of
// the identity function and cannot fail. The bias directive holds `mid` at
// 0.4 V, and the branch to `p` is written in terms of the LIMITED value, so a
// clamp that fired would move the stamped current as well as the assertion.
//
// 0.4 V keeps the claim true even for a simulator running SPICE's DEVlimvds: for
// any previous value below 3.5 V that function clamps only at +4 V (rising) and
// -0.5 V (falling), and 0.4 V is inside both.
//
// TOLERANCE. §9.17.3 fixes only "within appropriate tolerances". The only number
// the LRM supplies for a Voltage-natured quantity is Annex D disciplines.vams
// `nature Voltage ... abstol = 1e-6`. 1e-12 is the CURRENT abstol.
//
//! lrm E.3.4
//! lrm 9.17.3
//! bias V(p) = 0.4, V(mid) = 0.4
`include "check.vh"
module annex_e_vdslim(p);
  inout p; electrical p; electrical mid; real limited;
  analog begin
    limited = $limit(V(mid), "limvds");
    I(mid, p) <+ (limited - V(p)) / 1.0;
    // 1e-6 is the Annex D `nature Voltage` abstol.
    `CHECK("the drain-source limiter is transparent at the solution", limited, 0.4, 1e-6);
  end
endmodule
