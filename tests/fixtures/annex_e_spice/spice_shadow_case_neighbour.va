// E.2.1: "if no exact match is found, the mixed-case name shall match the
// same name defined within SPICE regardless of the case."
// E.3.3: the HDL names myMixed and myCard differ from
// the canonical SPICE names mymixed/mycard, so no same-name warning applies.
// At unit voltage the HDL module/paramset give 2 A and 3 A. Their uppercase
// spellings instead resolve the 4 ohm and 8 ohm SPICE cards, giving 1/4 A
// and 1/8 A. Independent nodes distinguish every selected definition.
// A.1.9: a paramset needs >= 1 paramset_item_declaration (corrected 2026-10-08)
//! lrm E.2.1
//! lrm E.3.3
//! lrm E.2.1:1
//! lrm E.3.3:1
//! nowarn
//! bias V(p) = 1, V(q) = 1, V(r) = 1, V(s) = 1, V(n) = 0
//! checks 4
//! spice .MODEL MYMIXED R R=4
//! spice .MODEL MYCARD R R=8
`include "check.vh"
module spice_shadow_case_neighbour(p,q,r,s,n);
  inout p,q,r,s,n; electrical p,q,r,s,n;
  myMixed hdl_module(p,n);
  MYMIXED spice_model(q,n);
  myCard hdl_paramset(r,n);
  MYCARD spice_card(s,n);
  analog begin
    `CHECKX("exact mixed-case HDL module", I(p,n), 2.0);
    `CHECKX("case-insensitive SPICE model fallback", I(q,n), 0.25);
    `CHECKX("exact mixed-case HDL paramset", I(r,n), 3.0);
    `CHECKX("case-insensitive SPICE card fallback", I(s,n), 0.125);
  end
endmodule
module myMixed(p,n);
  inout p,n; electrical p,n;
  analog I(p,n) <+ 2*V(p,n);
endmodule
paramset myCard case_leaf;
  parameter real unused_item = 0;
  .gain=3;
endparamset
module case_leaf(p,n);
  inout p,n; electrical p,n;
  parameter real gain=1;
  analog I(p,n) <+ gain*V(p,n);
endmodule
