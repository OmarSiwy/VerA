// Table E.1 row `inductor`: ports p, n, parameters l, ic, behaviour
//
//     I = l * integral(0..t) V dtau  +  ic
//
// E.2.2.3 prints this primitive verbatim: `inductor #(.l(1u)) L1 (vcc, out);`.
//
// WHAT IS PINNED. E.3: "Table E.1 shows the REQUIRED names for primitives,
// parameters, and ports which are otherwise unnamed in SPICE. For connection by
// order instead of by name, the ports and parameters shall be given in the order
// listed. The default discipline of the ports for these primitives shall be
// electrical and their descriptions shall be inout." E.1.2 adds that "when
// instantiating SPICE primitives in Verilog-AMS HDL, the primitives shall, and
// parameters and ports can, be named", and E.2 that a tool "expected to provide
// the basic set of Spice primitives" shall treat them "in the same manner in
// Verilog-AMS HDL as built-in primitives of gate- and switch-level modeling".
// So the instantiation below — every port and every parameter named, in the
// Table E.1 order — is source a SPICE-compatible Verilog-AMS tool must accept.
//
// THIS IS A RUN FIXTURE, NOT A REJECT. An earlier revision of this file demanded
// a diagnostic for the line below. That inverts the test: the LRM prints this
// syntax as legal, so a conforming compiler would FAIL and only a compiler with
// no SPICE support would pass. The requirement is that it compiles, and it does:
// VerA ships Table E.1 as ordinary module declarations in a prelude, the same
// shape as annex D's disciplines.vams (`Preprocessor.spice_primitives`).
//
// THE DIGITS, AND THE ONE THING THIS FIXTURE REFUSES TO DECIDE. The published row
// multiplies the integral by l where the physics divides by it; Annex E's own
// source-fidelity note lists that as an apparent defect of the printed table, and
// E.2 leaves "all aspects of SPICE primitives ... implementation dependent" on top
// of it. So l is given as 1.0 here, the one value at which l and 1/l coincide, and
// this fixture pins the INTEGRAL RELATION and the ic term without adopting either
// reading. A fixture that wrote a digit for l = 1u would be pinning a transcription
// choice as if the LRM had made it, which it did not.
//
// With 1 V held across the branch by `//! bias` and l = 1.0, the integrand is 1.0
// exactly and the integral of a constant is exact at every accepted step:
//
//     I(x1.p, x1.n)  =  1.0 * t  +  0.5   amperes
//
// Subtracting the t term leaves `ic`, so the want is 0.5 and one line pins both:
// drop the integral and t = 0.5 fails, ignore ic and every point fails.
//
// AN INDUCTOR IS A FLOW RELATION — the row gives I, not V — so the branch flow is
// what the primitive contributes and the two node potentials are the harness's to
// hold. That is the mirror image of the capacitor row, and the reason this file
// needs no `//! solve` while primitive_capacitor.va does.
//
// HOW THE PRIMITIVE IS OBSERVED. §6.7.1: "Potential and flow access for named
// and unnamed branches (including port branches) can be done hierarchically",
// and "access of parameters can be done hierarchically". So `I(x1.p, x1.n)` is the
// flow of the primitive's own port pair — the branch Table E.1's Behavior
// column is written about — reached by an out-of-module reference, and `x1.l` is
// the parameter an override landed on. Nothing else could observe the row: the
// Behavior column belongs to the primitive's branches, not to this module's.
//
//! lrm E.3
//! lrm E.3:1
//! lrm E.3:2
//! lrm E.1.2
//! lrm E.1.2:1
//! lrm E.2
//! lrm E.2.2.3
//! lrm 4.5.4
//! lrm 6.7.1
//! lrm 6.7.1:1
//! analysis tran
//! time 0, 0.5, 1.0
//! bias V(p) = 1.0, V(n) = 0.0
`include "check.vh"
module annex_e_primitive_inductor(p, n);
  inout p, n; electrical p, n;
  inductor #(.l(1.0), .ic(0.5)) x1(.p(p), .n(n));
  analog begin
    `CHECK("Table E.1: I is an integral of V plus ic, so I - 1.0*t is ic", I(x1.p, x1.n) - 1.0*$abstime, 0.5, 1e-15);
    `CHECKX("the l override reaches Table E.1's l", x1.l, 1.0);
    `CHECKX("and the ic override reaches ic", x1.ic, 0.5);
  end
endmodule
