// E.2.1 Case sensitivity, in full: "Some SPICE netlists are case insensitive,
// whereas Verilog-AMS HDL descriptions are case-sensitive. From within
// Verilog-AMS HDL, a mixed-case name matches the same name with an identical
// case (if one is defined in a Verilog-AMS HDL description). However, if no
// exact match is found, the mixed-case name shall match the same name defined
// WITHIN SPICE regardless of the case."
//
// The case-blind arm is scoped to SPICE objects. A Verilog-AMS module is
// matched only "with an identical case" — which is just §2.7's "Verilog-AMS
// HDL descriptions are case-sensitive" restated at the SPICE boundary. So
// `SUB` below:
//
//   * has no exact match — the only module of that spelling is `sub`, and
//     `sub` is not `SUB`;
//   * falls to the second arm, which looks in SPICE — and this file carries
//     no netlist and Table E.1 has no primitive called `sub`;
//   * therefore names nothing, and the instance is an error.
//
// A tool that let the fallback wander into Verilog-AMS modules would bind
// `SUB` to `sub` and compile the file. spice_case_lookup.va is the positive
// half of the same sentence: there the mixed-case name DOES find its object,
// because the object is a netlist `.MODEL`. Spelling the instance `sub`
// compiles (probed).
//
// The top module is written first so it is the one elaborated (a module no
// one instantiates is a root; `sub` is not instantiated by `SUB`).
//
// VerA reports E0904 "instance names no module".
//
//! lrm E.2.1
//! lrm E.2.1:1
//! lrm E.3.3
//! reject-only E0904
//! reject `SUB`
//! neighbour spice_case_lookup.va
`include "disciplines.vams"
module e21_case_fallback_top(p, n);
  inout p, n; electrical p, n;
  SUB x1(p, n);                          // illegal: `sub` is not `SUB`
endmodule

module sub(a, b);
  inout a, b; electrical a, b;
  analog I(a, b) <+ V(a, b) / 1.0e3;
endmodule
