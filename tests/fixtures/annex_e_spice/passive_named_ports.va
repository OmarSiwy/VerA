// E.1.2, on the third area of SPICE incompatibility: "When instantiating SPICE
// primitives in Verilog-AMS HDL, the primitives shall, and parameters and ports
// can, be named." Table E.1 supplies the names — for `resistor`, ports p and n
// and parameters r, tc1, tc2 — so a named connection to a passive primitive is
// exactly the syntax the annex exists to standardise, and E.2.2.3 prints the
// ordered form of the same instance (`resistor #(.r(10k)) R1 (b1, gnd);`).
//
// WHAT IS PINNED. Both halves of the naming rule at once, with digits:
//
//   Named PARAMETERS. Each of Table E.1's three resistor parameters is given by
//   name and read back by name through the instance (§6.7.1, "access of
//   parameters can be done hierarchically"). The three values are deliberately
//   distinct — 1000, 1e-3, 1e-6 — so a tool that bound `.tc1` to tc2, or dropped
//   a name and fell back on position, gets a different number on two of the
//   three checks.
//
//   Named PORTS. The bias puts 1 V across p and n, and the potential read out of
//   the PRIMITIVE's own branch, p first, must be +1.0. A tool that accepted the
//   names but crossed them answers -1.0.
//
// A tool that accepted only positional connection would fail this and pass
// spice_passive_primitives.va, which is why the two are separate files.
//
// WHY NO CURRENT IS ASSERTED HERE, though the ordered file does assert one.
// Table E.1's resistor behaviour is V = I*r*(1 + tc1*T + tc2*T^2), and with tc1
// and tc2 NONZERO the value of I turns on what T means. The annex writes a bare
// T and fixes neither a reference temperature nor whether the polynomial is in
// absolute temperature or in the rise above nominal; at the harness's 300.15 K
// default the two readings differ by a factor of 1.3902400225, so no honest
// digit can be written for the current. It is pinned in
// spice_passive_primitives.va instead, where tc1 = tc2 = 0 makes the polynomial
// exactly 1 at every T and the reading stops mattering. This file pins the
// naming rule, which is what its cites claim.
//
// THIS IS A RUN FIXTURE, NOT A REJECT. An earlier revision demanded a diagnostic
// here, which inverts the test: the LRM prints this syntax, so a conforming
// compiler would FAIL and only one without SPICE support would pass.
//
//! lrm E.1.2
//! lrm E.1.2:1
//! lrm E.3
//! lrm E.2.2.3
//! lrm 6.7.1
//! lrm 6.3.3
//! lrm 6.3.3:1
//! lrm 6.5.5
//! lrm 6.5.5:1
//! lrm 6.7.1:1
//! lrm E.1.2:2
//! bias V(p) = 1.0, V(n) = 0.0
`include "check.vh"
module annex_e_passive_named_ports(p, n);
  inout p, n; electrical p, n;
  resistor #(.r(1k), .tc1(1m), .tc2(1u)) r1(.p(p), .n(n));
  analog begin
    // §2.6.2 Table 2-1: k = 1e3, m = 1e-3, u = 1e-6.
    `CHECKX(".r(1k) binds Table E.1's r", r1.r, 1000.0);
    `CHECKX(".tc1(1m) binds tc1 and not tc2", r1.tc1, 0.001);
    `CHECKX(".tc2(1u) binds tc2 and not tc1", r1.tc2, 1.0e-6);
    `CHECKX(".p(p)/.n(n) put the bias across the primitive, p first",
            V(r1.p, r1.n), 1.0);
  end
endmodule
