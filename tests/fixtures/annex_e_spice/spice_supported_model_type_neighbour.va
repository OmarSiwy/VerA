// The legal neighbour of spice_unsupported_model_type_rejected.va (E.1.2):
// the same `.MODEL SW1` card with type `R`, a Table E.1 row, declares a
// module (E.2.2.1) whose interface is the resistor's, so the instance
// compiles and conducts. By hand: R = 4 ohm (Table E.1's `r`), V(p, n) = 1,
// so I(p, n) = 1/4 = 0.25 A, exact in binary.
//! lrm E.1.2
//! lrm E.2.2.1
//! bias V(p) = 1, V(n) = 0
//! checks 1
//! spice .MODEL SW1 R R=4
`include "check.vh"
module spice_supported_model_type_neighbour(p, n);
  inout p, n; electrical p, n;
  sw1 s1(p, n);
  analog `CHECKX("a Table E.1 model type instantiates: 1 V over 4 ohm", I(p, n), 0.25);
endmodule
