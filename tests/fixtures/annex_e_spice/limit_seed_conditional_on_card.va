// §9.17.3 `$limit`'s seed argument chosen by a §4.2.12 `?:` on the card: the
// legal neighbour of reject_limit_seed_reads_solution_through_conditional.va.
//
// AGENTS.md §6: a seed "may read card-derived variables, never the solution
// (E0527)". The condition `vt > 0.01` reads the parameter vt alone, so the
// seed is a function of the card and `seed` can compute it before any solve.
// vt = 0.025 > 0.01, so §4.2.12 takes expression2 and the seed is 0.3: not
// pnjlim's default start (its vcrit, 0.6) and not the other arm (0.0), so the
// seeded value tells the three apart.
//
// The pnjlim site's branch is V(ai, c); with sign 1 the seed is that branch's
// value. The seeded nets are ai and c; the tree roots at the lowest port among
// them, c = 0, so ai = 0.3. At the bias the model evaluates, §9.17.3's "When
// the simulator has converged, the return value of the $limit() function is
// the value of the access function reference, within appropriate tolerances"
// is the CHECK (1e-6: Annex D's `nature Voltage` abstol, as limit_fet.va
// argues).
//
// Verdicts: `//! seed` asserts each seeded net's value and that the net is in
// `limit_writes`, two per net over ai and c (4), and the CHECK runs at the one
// bias point (1): 5.
//! lrm 9.17.3
//! bias V(a) = 0.3, V(ai) = 0.3, V(c) = 0.0
//! print none
//! seed V(ai) = 0.3, V(c) = 0.0
//! checks 5
`include "check.vh"
module limit_seed_conditional_on_card(a, c);
  inout a, c; electrical a, c, ai;
  parameter real vt = 0.025, vcrit = 0.6;
  real vd;
  analog begin
    vd = $limit(V(ai, c), "pnjlim", vt, vcrit, 1.0, (vt > 0.01) ? 0.3 : 0.0);
    I(a, ai) <+ V(a, ai) / 10.0;
    I(ai, c) <+ 1e-14 * (limexp(vd / vt) - 1.0);
    `CHECK("$limit returns its access function at the answer", vd, 0.3, 1e-6);
  end
endmodule
