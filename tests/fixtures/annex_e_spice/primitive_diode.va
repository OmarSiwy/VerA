//! reject module instantiation is not supported
// EXPECT: error -- Table E.1 primitive needs SPICE elaboration.
module annex_e_primitive_diode(a,c); inout a,c; electrical a,c; diode #(.area(1.0)) x(.a(a),.c(c)); endmodule
