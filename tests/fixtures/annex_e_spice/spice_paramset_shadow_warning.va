// E.3.3: "a module or paramset defined in the Verilog-AMS will always be
// selected in favor of a SPICE primitive, model, or subcircuit using exactly
// the same name."
// A direct pmodel instance binds gain=2, and a chained instance binds it
// to 3*2=6. Unit voltage makes the two currents 2 A and 6 A; the losing
// SPICE card would yield 1/8 A instead. Both resolved paramset paths must
// execute, and the required warning identifies the shadowed model.
// There is no illegal source form here; spice_shadow_case_neighbour.va
// covers legal names that differ in case and do not hide the SPICE fallback.
//! lrm E.3.3
//! lrm 6.4
//! lrm E.3.3:3
//! warn W0951
//! bias V(p) = 1, V(q) = 1, V(n) = 0
//! checks 2
//! spice .MODEL PMODEL R R=8
`include "check.vh"
module spice_paramset_shadow_warning(p,q,n);
  inout p,q,n; electrical p,q,n;
  pmodel direct(p,n);
  shadow_outer #(.scale(3)) chained(q,n);
  analog begin
    `CHECKX("the direct paramset wins", I(p,n), 2.0);
    `CHECKX("the chained paramset wins", I(q,n), 6.0);
  end
endmodule
paramset shadow_outer pmodel;
  parameter real scale=1;
  .gain=2*scale;
endparamset
paramset pmodel shadow_leaf;
  parameter real gain=2;
  .gain=gain;
endparamset
module shadow_leaf(p,n);
  inout p,n; electrical p,n;
  parameter real gain=1;
  analog I(p,n) <+ gain*V(p,n);
endmodule
