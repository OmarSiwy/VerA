// E.1.2: "whether a particular Verilog-AMS simulator is SPICE compatible, and
// with which particular variant of SPICE it is compatible, is solely
// determined by the authors of the simulator." VerA's claim (VD-012) covers
// HSPICE's subcircuit parameters, `.SUBCKT name ports PARAMS: k=v ...`, and
// `{expr}` / `'expr'` values over them, so a subcircuit's device cards can be
// sized by its instance. E.2 makes the subcircuit "treated as module
// definitions": each `k=v` is a parameter of that module with `v` as its
// default (§6.3), so a Verilog-AMS instance overrides it like any other.
//
// THE NETLIST.
//
//     .SUBCKT RDIV IN OUT GND PARAMS: RTOP=1K RBOT={RTOP+2K}
//     R1 IN OUT {RTOP}
//     R2 OUT GND 'RBOT'
//     .ENDS RDIV
//
// RBOT's default is an expression of RTOP, so it follows an override of RTOP
// (§6.3: a parameter's default expression is evaluated with the values of
// the parameters it names).
//
// THE DIGITS, BY HAND. V(in) = 1, V(gnd) = 0, the divider's out solved:
//
//     x1, defaults:      RTOP = 1k, RBOT = 1k + 2k = 3k:  V(out) = 3/4 = 0.75
//     x2, .rtop(3k):     RTOP = 3k, RBOT = 3k + 2k = 5k:  V(out) = 5/8 = 0.625
//
// Wrong readings: PARAMS: dropped and the values unread (VerA before #9) is a
// refusal, not a number; RBOT frozen at its default 3k under the override
// gives 3/6 = 0.5; the override ignored gives 0.75 for x2.
//
// The invalid neighbours: reject_spice_expression_value.va (an expression
// reading a name that is no parameter) and reject_spice_subckt_params.va (an
// expression calling a function VerA does not read).
//
//! lrm E.1.2
//! lrm E.2
//! lrm 6.3
//! lrm 6.7.1
//! bias V(in) = 1.0, V(gnd) = 0.0
//! solve
//! spice .SUBCKT RDIV IN OUT GND PARAMS: RTOP=1K RBOT={RTOP+2K}
//! spice R1 IN OUT {RTOP}
//! spice R2 OUT GND 'RBOT'
//! spice .ENDS RDIV
//! checks 2
`include "check.vh"
module annex_e_spice_subckt_params(in, gnd);
  inout in, gnd; electrical in, gnd;
  rdiv x1(in, m1, gnd);
  rdiv #(.rtop(3k)) x2(in, m2, gnd);
  analog begin
    `CHECK("x1: RTOP 1k over RBOT {RTOP+2K} = 3k", V(x1.out, x1.gnd), 0.75, 1e-12);
    `CHECK("x2: .rtop(3k) moves RBOT's default to 5k too", V(x2.out, x2.gnd), 0.625, 1e-12);
  end
endmodule
