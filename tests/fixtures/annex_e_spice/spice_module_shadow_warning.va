// E.3.3 selects the same-named HDL module over a SPICE model and says the
// simulator "shall issue an warning message". The user model is 2 ohm,
// while its competing card is 4 ohm.
// The unshadowed 8 ohm card proves the netlist was read. With both nodes
// biased to 1 V, the selected currents are 1/2 A and 1/8 A respectively.
// spice_shadow_case_neighbour.va covers case-sensitive HDL lookup and
// case-insensitive SPICE fallback without a same-name declaration collision.
// The source is legal: this rule calls for a warning, not a rejection.
//! lrm E.3.3
//! lrm E.2.1
//! lrm E.3.3:3
//! warn W0951
//! bias V(p) = 1, V(q) = 1, V(n) = 0
//! checks 2
//! spice .MODEL SHADOWCARD R R=4
//! spice .MODEL PLAIN_CARD R R=8
`include "check.vh"
module shadowcard(p,n);
  inout p,n; electrical p,n;
  analog I(p,n) <+ V(p,n)/2.0;
endmodule
module spice_module_shadow_warning(p,q,n);
  inout p,q,n; electrical p,q,n;
  shadowcard selected(p,n);
  plain_card unshadowed(q,n);
  analog begin
    `CHECKX("the HDL module wins over the 4 ohm card", I(p,n), 0.5);
    `CHECKX("the unshadowed 8 ohm card still executes", I(q,n), 0.125);
  end
endmodule
