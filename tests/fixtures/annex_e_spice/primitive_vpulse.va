// Table E.1 row `vpulse`: ports p, n, parameters dc, mag, phase, val0, val1, td,
// rise, fall, width, period, behaviour — a trapezoidal periodic voltage source.
// The ipulse row with V for I.
//
// WHAT IS PINNED. E.3: "Table E.1 shows the REQUIRED names for primitives,
// parameters, and ports which are otherwise unnamed in SPICE. For connection by
// order instead of by name, the ports and parameters shall be given in the order
// listed. The default discipline of the ports for these primitives shall be
// electrical and their descriptions shall be inout." E.1.2 adds that "when
// instantiating SPICE primitives in Verilog-AMS HDL, the primitives shall, and
// parameters and ports can, be named", and E.2 that a tool "expected to provide
// the basic set of Spice primitives" shall treat them "in the same manner in
// Verilog-AMS HDL as built-in primitives of gate- and switch-level modeling".
// So the instantiation below — every port and every parameter named, in the
// Table E.1 order — is source a SPICE-compatible Verilog-AMS tool must accept.
//
// THIS IS A RUN FIXTURE, NOT A REJECT. An earlier revision of this file demanded
// a diagnostic for the line below. That inverts the test: the LRM prints this
// syntax as legal, so a conforming compiler would FAIL and only a compiler with
// no SPICE support would pass. The requirement is that it compiles, and it does:
// VerA ships Table E.1 as ordinary module declarations in a prelude, the same
// shape as annex D's disciplines.vams (`Preprocessor.spice_primitives`).
//
// THE DIGITS. Table E.1 gives this row five branches over one period, keyed to
//
//     t0 = td + n*period                      t1 = rise + t0
//     t2 = width + t1                         t3 = fall + t2
//     t4 = td + (n+1)*period
//
// All six instances below share the SHAPE — val0 = 1m, val1 = 5m, rise = 1n,
// width = 3n, fall = 2n — and differ only in td, so that at the single time point
// t = 10 ns each one sits in a different branch. period = 20n everywhere except
// the last, which is what keeps t4 beyond t3 and every branch's interval non-empty
// (with period = 0 the table's fifth interval t3 < t <= t4 is EMPTY and the row
// defines nothing at all past t3, so a fixture pinning a value there would be
// inventing one).
//
//   x1  td = 10n     t = t0        val0                            1.0e-3
//   x2  td = 9.75n   a quarter of the way up the rise:
//                    val0 + (val1-val0)*(t-t0)/rise = 1m + 4m*0.25 2.0e-3
//   x3  td = 8n      t1 < t <= t2  val1                            5.0e-3
//   x4  td = 5n      half way down the fall:
//                    val1 + (val0-val1)*(t-t2)/fall = 5m - 4m*0.5  3.0e-3
//   x5  td = 3n      t3 < t <= t4  val0                            1.0e-3
//
// The ramp digits are the point of the row and the two flats are its endpoints:
// a tool that interpolated over rise+fall instead of over each edge, or that
// measured the fall from t1 rather than from t2, misses 2.0e-3 and 3.0e-3 while
// still answering 1m and 5m correctly.
//
// x6 IS THE PERIOD. td = 0 and period = 4n put t = 10 ns in the THIRD period
// (n = 2, so t1 = 9n and t2 = 12n) and therefore on the plateau, 5.0e-3. Table
// E.1's "n is a non-negative integer" is the whole of the periodicity rule, and a
// tool that ignored it answers val0 there, having run off the end of one pulse.
//
// HOW THE PRIMITIVE IS OBSERVED. §6.7.1: "Potential and flow access for named
// and unnamed branches (including port branches) can be done hierarchically",
// and "access of parameters can be done hierarchically". So `V(x1.p, x1.n)` is the
// potential of the primitive's own port pair — the branch Table E.1's Behavior
// column is written about — reached by an out-of-module reference, and `x1.val1` is
// the parameter an override landed on. Nothing else could observe the row: the
// Behavior column belongs to the primitive's branches, not to this module's.
//
// ONE INSTANCE PER NET PAIR, and that is load-bearing. Two unnamed branches over
// the same pair of nets share one accumulator in VerA today
// (ch05_analog_behavior/two_named_branches.va holds that gap), so two instances
// hung across the same two nets would each read the SUM of both. Every instance
// below therefore gets its own net, sharing only the common return.
//
//! lrm E.3
//! lrm E.3:1
//! lrm E.3:2
//! lrm E.1.2
//! lrm E.1.2:1
//! lrm E.2
//! lrm 6.7.1
//! lrm 6.7.1:1
//! analysis tran
//! time 10n
//! bias V(n) = 0.0
//! solve
`include "check.vh"
module annex_e_primitive_vpulse(p, n);
  inout p, n; electrical p, n;
  electrical a1, a2, a3, a4, a5, a6;
  vpulse #(.dc(0.0), .mag(1.0), .phase(0.0), .val0(1m), .val1(5m), .td(10n), .rise(1n), .fall(2n), .width(3n), .period(20n)) x1(.p(a1), .n(n));
  vpulse #(.dc(0.0), .mag(1.0), .phase(0.0), .val0(1m), .val1(5m), .td(9.75n), .rise(1n), .fall(2n), .width(3n), .period(20n)) x2(.p(a2), .n(n));
  vpulse #(.dc(0.0), .mag(1.0), .phase(0.0), .val0(1m), .val1(5m), .td(8n), .rise(1n), .fall(2n), .width(3n), .period(20n)) x3(.p(a3), .n(n));
  vpulse #(.dc(0.0), .mag(1.0), .phase(0.0), .val0(1m), .val1(5m), .td(5n), .rise(1n), .fall(2n), .width(3n), .period(20n)) x4(.p(a4), .n(n));
  vpulse #(.dc(0.0), .mag(1.0), .phase(0.0), .val0(1m), .val1(5m), .td(3n), .rise(1n), .fall(2n), .width(3n), .period(20n)) x5(.p(a5), .n(n));
  vpulse #(.dc(0.0), .mag(1.0), .phase(0.0), .val0(1m), .val1(5m), .td(0.0), .rise(1n), .fall(2n), .width(3n), .period(4n)) x6(.p(a6), .n(n));
  analog begin
    `CHECKX("at t0 the row is still val0", V(x1.p, x1.n), 1.0e-3);
    // 1e-14 and not tighter on the two interpolating branches: (t - t0) is a
    // difference of two nanosecond-scale numbers, so 10n - 9.75n arrives with the
    // cancellation already in it. The edges themselves are exact.
    `CHECKR("a quarter up the rise: val0 + (val1-val0)*(t-t0)/rise", V(x2.p, x2.n), 2.0e-3, 1e-14);
    `CHECKX("between t1 and t2 the row is val1", V(x3.p, x3.n), 5.0e-3);
    `CHECKR("half way down the fall: val1 + (val0-val1)*(t-t2)/fall", V(x4.p, x4.n), 3.0e-3, 1e-14);
    `CHECKX("between t3 and t4 the row is val0 again", V(x5.p, x5.n), 1.0e-3);
    `CHECKX("t0..t4 repeat every period: t = 10n is the plateau of period 2", V(x6.p, x6.n), 5.0e-3);
    // Relative, and only because of the LEXER: VerA forms 3n as 3 * 1e-9, a
    // multiplication of two doubles that lands one ulp above the double nearest
    // 3e-9. 2.6.2's scale factor is a decimal exponent, so the two spellings name
    // the same real number; the digit here is that number, not what the
    // multiplication produced. 4n is exact because its multiplier is a power of 2.
    `CHECKR("the width override reaches Table E.1's width", x1.width, 3.0e-9, 1e-15);
    `CHECKX("and period", x6.period, 4.0e-9);
  end
endmodule
