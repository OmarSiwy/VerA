// E.2.1 Case sensitivity, in full: "Some SPICE netlists are case insensitive,
// whereas Verilog-AMS HDL descriptions are case-sensitive. From within
// Verilog-AMS HDL, a mixed-case name matches the same name with an identical
// case (if one is defined in a Verilog-AMS HDL description). However, if no
// exact match is found, the mixed-case name shall match the same name defined
// within SPICE regardless of the case."
//
// WHAT IS PINNED. The FALLBACK arm. `VeRtNpN` below is defined nowhere in this
// file, so there is no exact Verilog-AMS match and the rule sends the lookup to
// SPICE case-insensitively, where `.MODEL VERTNPN` of E.2.2.1 answers it. The
// spelling is deliberately mangled: an implementation that lower-cased or
// exact-matched only would resolve `vertNPN` (spice_model.va) and still fail
// this one. E.3.3 states the priority the first arm implies — "in case of a name
// match with differences in case, the module or paramset does not interfere with
// the SPICE primitive, model, or subcircuit, but the resolution method described
// in E.2.1 shall apply".
//
// WHAT THE ASSERTIONS REACH. If the fallback resolved, it resolved to the NPN of
// E.2.2.1, whose ports come from the `bjt` primitive of Table E.1 in the order
// c, b, e — so the object the name found has an observable shape, and the two
// checks read the collector-emitter and base-emitter potentials back out of the
// instance (§6.7.1, potential access to a branch of an instance may be
// hierarchical). Three nets held at three different potentials mean any other
// ordering, and any resolution to an object with different ports, moves at least
// one number. That is as far as a digit can honestly go: Table E.1's `bjt` row
// has an EMPTY Behavior column, E.2 says "all aspects of SPICE primitives are
// implementation dependent", and the model card's BF/IS/VAF have no equations in
// this annex, so no current is derivable. The rule under test is a NAME LOOKUP,
// and what a successful lookup exposes is the resolved object's ports.
//
// THIS IS A RUN FIXTURE, NOT A REJECT. An earlier revision demanded a diagnostic
// for a lookup E.2.1 requires to succeed.
//
// WHICH NAMESPACE THE FALLBACK FALLS INTO, AND HOW THIS FIXTURE SUPPLIES ONE.
// E.2.1's own words name it: "the mixed-case name shall match the same name
// DEFINED WITHIN SPICE regardless of the case", so the `shall` ranges over
// netlist objects and needs a netlist to range over. The `//! spice` line below
// is E.2.2.1's card, carried verbatim, which is the same card spice_model.va
// hands over — deliberately, because the two files then differ in exactly one
// thing: the CASE of the name written in Verilog-AMS. spice_model.va spells it
// `vertNPN`, this one `VeRtNpN`, neither matches `VERTNPN` exactly, and E.2.1
// resolves both. E.1.1's implication and E.1.2's "solely determined by the
// authors of the simulator" are what make the netlist the fixture's to supply
// rather than the tool's to assume; a tool that takes one on its command line
// reads these cards as the comment they are (§2.4).
//
// THE FIRST ARM IS NOT WHAT IS UNDER TEST, and it is worth saying which is which.
// "From within Verilog-AMS HDL, a mixed-case name matches the same name with an
// identical case (if one is defined in a Verilog-AMS HDL description)" is
// unconditional and is just §2.7 case sensitivity; every other fixture in the
// suite exercises it. This file pins the SECOND arm, and E.3.3 is what keeps the
// two from colliding: "in case of a name match with differences in case, the
// module or paramset does not interfere with the SPICE primitive, model, or
// subcircuit, but the resolution method described in E.2.1 shall apply." So the
// case-insensitive pass must come strictly AFTER both exact passes, never instead
// of one — an implementation that folded case up front would resolve this file
// and break every fixture that relies on two identifiers differing only in case.
//
//! lrm E.2.1
//! lrm E.2.1:1
//! lrm E.3.3
//! lrm E.3.3:1
//! lrm E.2.2.1
//! lrm E.1.1
//! lrm E.1.2
//! lrm 6.7.1
//! lrm 6.2.2
//! lrm 6.2.2:2
//! lrm 6.5.4
//! lrm 6.5.4:1
//! lrm 6.7.1:1
//! bias V(c1) = 1.0, V(b1) = 0.75, V(e1) = 0.25
//! spice .MODEL VERTNPN NPN BF=80 IS=1E-18 RB=100 VAF=50
//! spice + CJE=3PF CJC=2PF CJS=2PF TF=0.3NS TR=6NS
`include "check.vh"
module annex_e_spice_case_lookup(c1, b1, e1);
  inout c1, b1, e1; electrical c1, b1, e1;
  VeRtNpN mixed_case(c1, b1, e1);
  analog begin
    `CHECKX("the case-insensitive match found VERTNPN, whose port 1 is c",
            V(mixed_case.c, mixed_case.e), 0.75);
    `CHECKX("and whose port 2 is b", V(mixed_case.b, mixed_case.e), 0.5);
  end
endmodule

// This Verilog-AMS name differs in case from both VeRtNpN and the SPICE
// VERTNPN card. E.3.3 requires it not to intercept the case-insensitive SPICE
// lookup. Its deliberately different interface makes accidental selection
// fail before the hierarchical c/b/e port assertions could pass.
module VertNpn(unused);
  inout unused; electrical unused;
  analog I(unused) <+ V(unused);
endmodule
