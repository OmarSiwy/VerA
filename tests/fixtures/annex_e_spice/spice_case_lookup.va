// E.2.1 Case sensitivity, in full: "Some SPICE netlists are case insensitive,
// whereas Verilog-AMS HDL descriptions are case-sensitive. From within
// Verilog-AMS HDL, a mixed-case name matches the same name with an identical
// case (if one is defined in a Verilog-AMS HDL description). However, if no
// exact match is found, the mixed-case name shall match the same name defined
// within SPICE regardless of the case."
//
// WHAT IS PINNED. The FALLBACK arm. `VeRtNpN` below is defined nowhere in this
// file, so there is no exact Verilog-AMS match and the rule sends the lookup to
// SPICE case-insensitively, where `.MODEL VERTNPN` of E.2.2.1 answers it. The
// spelling is deliberately mangled: an implementation that lower-cased or
// exact-matched only would resolve `vertNPN` (spice_model.va) and still fail
// this one. E.3.3 states the priority the first arm implies — "in case of a name
// match with differences in case, the module or paramset does not interfere with
// the SPICE primitive, model, or subcircuit, but the resolution method described
// in E.2.1 shall apply".
//
// WHAT THE ASSERTIONS REACH. If the fallback resolved, it resolved to the NPN of
// E.2.2.1, whose ports come from the `bjt` primitive of Table E.1 in the order
// c, b, e — so the object the name found has an observable shape, and the two
// checks read the collector-emitter and base-emitter potentials back out of the
// instance (§6.7.1, potential access to a branch of an instance may be
// hierarchical). Three nets held at three different potentials mean any other
// ordering, and any resolution to an object with different ports, moves at least
// one number. That is as far as a digit can honestly go: Table E.1's `bjt` row
// has an EMPTY Behavior column, E.2 says "all aspects of SPICE primitives are
// implementation dependent", and the model card's BF/IS/VAF have no equations in
// this annex, so no current is derivable. The rule under test is a NAME LOOKUP,
// and what a successful lookup exposes is the resolved object's ports.
//
// THIS IS A RUN FIXTURE, NOT A REJECT. An earlier revision demanded a diagnostic
// for a lookup E.2.1 requires to succeed.
//
// WHOM IT BINDS, WHICH IS NOT VERA — AND THIS IS THE CLEAREST OF THE THREE,
// because E.2.1's own words name the namespace it falls back into: "the mixed-case
// name shall match the same name DEFINED WITHIN SPICE regardless of the case." A
// tool that reads no SPICE has no such namespace, so the `shall` has no object to
// range over. It sits inside E.1.1's consequent with the rest of the family ("IF a
// simulator ... is also able to read SPICE netlists of a particular flavor, THEN
// certain objects defined in that flavor of SPICE netlist can be referenced"), and
// E.1.2 hands the antecedent to the implementer: SPICE compatibility "is solely
// determined by the authors of the simulator". Note that the FIRST arm — exact
// case-sensitive match against a Verilog-AMS definition — is unconditional and
// VerA meets it; the fixture pins only the fallback. It stays, and stays `xfail`,
// because it does bind a tool that reads netlists (the marker is ignored for every
// compiler but VerA) and because XPASS still guards VerA against resolving an
// instance of a module declared nowhere. spice_model.va carries the argument in
// full; do not close it by writing a netlist reader.
//
//! lrm E.2.1
//! lrm E.3.3
//! lrm E.2.2.1
//! lrm E.1.1
//! lrm E.1.2
//! lrm 6.7.1
//! bias V(c1) = 1.0, V(b1) = 0.75, V(e1) = 0.25
//! xfail NOT A DEBT — the clause is conditional and its condition is false for VerA. E.2.1's fallback arm matches "the same name defined within SPICE", VerA reads no SPICE netlists, so there is no case-insensitive namespace to fall back INTO and the `shall` has no object to range over: `VeRtNpN` is E0904 for the same reason `vertNPN` is in spice_model.va, and that is the right answer rather than a failure to meet a requirement (E.1.1's implication; E.1.2's "solely determined by the authors of the simulator"). The unconditional first arm — exact case-sensitive match against a Verilog-AMS definition — works, and it is the fallback this fixture pins. Kept rather than removed because it still binds a tool that DOES read netlists and because XPASS guards VerA against silently resolving an undeclared module
`include "check.vh"
module annex_e_spice_case_lookup(c1, b1, e1);
  inout c1, b1, e1; electrical c1, b1, e1;
  VeRtNpN mixed_case(c1, b1, e1);
  analog begin
    `CHECKX("the case-insensitive match found VERTNPN, whose port 1 is c",
            V(mixed_case.c, mixed_case.e), 0.75);
    `CHECKX("and whose port 2 is b", V(mixed_case.b, mixed_case.e), 0.5);
  end
endmodule
