// E.3 / Table E.1 row `vcvs`: ports p, n, ps, ns and parameter gain, with the
// behaviour column V(p, n) = gain*V(ps, ns). E.3: "for connection by order
// instead of by name, the ports and parameters shall be given in the order
// listed", which for a controlled source is what fixes WHICH pair is the output
// and which is the control — an ordering error here silently transposes them.
//
// WHAT IS PINNED. The four-port ordered connection of a controlled source, with
// digits on both pairs. `out` and `gnd` are the first two positions and must
// therefore be the OUTPUT; `sense` and `sgnd` are the last two and must be the
// CONTROL. The sense pair is held at 0.5 V, so Table E.1 fixes the output at
// gain*0.5 = 2.0*0.5 = 1.0 V, and the two checks read 1.0 out of the primitive's
// (p, n) and 0.5 out of its (ps, ns). A tool that transposed the pairs — the one
// failure the ordering rule exists to prevent — answers 0.5 and 1.0 and fails
// both. Four distinct nets are used rather than one pair wired twice, because a
// degenerate connection makes gain unobservable: V(p,n) = gain*V(p,n) has only
// the trivial solution and every check on it would read back its own bias.
//
// §6.7.1 is what reaches the primitive: "potential and flow access for named and
// unnamed branches (including port branches) can be done hierarchically", and
// "access of parameters can be done hierarchically" for `e1.gain`.
//
// WHAT THIS DOES NOT CATCH. The harness imposes every unknown instead of solving
// (tests/fixtures/README.md), so the operating point below is the one that
// SATISFIES the row rather than one the row produced: a tool with a wrong gain
// would not be caught by the output check alone. `e1.gain` is checked separately
// against its literal for that, and the port ORDER — which is what E.3's
// sentence is about and what this fixture cites — is caught either way.
//
// THIS IS A RUN FIXTURE, NOT A REJECT. An earlier revision demanded a diagnostic
// for source Table E.1 prescribes.
//
//! lrm E.3
//! lrm E.2
//! lrm 6.7.1
//! bias V(out) = 1.0, V(gnd) = 0.0, V(sense) = 0.5, V(sgnd) = 0.0
//! xfail VerA rejects module instantiation (E0204), so a Table E.1 controlled source cannot be reached
`include "check.vh"
module annex_e_spice_network_primitives(out, gnd, sense, sgnd);
  inout out, gnd, sense, sgnd; electrical out, gnd, sense, sgnd;
  vcvs #(.gain(2.0)) e1(out, gnd, sense, sgnd);
  analog begin
    `CHECKX(".gain(2.0) binds Table E.1's gain", e1.gain, 2.0);
    `CHECKX("ordered positions 3 and 4 are the SENSE pair",
            V(e1.ps, e1.ns), 0.5);
    // Table E.1: V(p, n) = gain*V(ps, ns) = 2.0*0.5.
    `CHECKX("ordered positions 1 and 2 are the OUTPUT pair, at gain*V(ps,ns)",
            V(e1.p, e1.n), 1.0);
  end
endmodule
