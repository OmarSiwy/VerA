// §9.17.3 a BSIM-shaped PMOS: the fetlimds ladder against a body-effect
// threshold, then the "pnjlimds" bulk rung, both in the frame of `type`.
//
// §9.17.3: "the simulator is responsible for determining if limiting should
// be applied and what the return value is on a given iteration." ngspice's
// BSIM3 load (b3ld.c:343-367) is the MOS1 shape: `von = here->BSIM3von`, the
// threshold its PREVIOUS load stored (:615), fetlims the leg the old vds
// picks, then pnjlims one junction by the limited vds. So VerA evaluates a
// solve-dependent limiter argument at `old`, the previous iterate's limited
// point, and never at the unlimited `cur`.
//
// Device frame v = type * V, type = -1. vonp = vth0 - 0.2 vbs (a body-effect
// shape), vth0 = 0.5, vt = 0.025, vcrit = 0.6. Every emitted clamp runs on
// sg*v and hands back sg*result, sg = type.
//
// BIAS (cur, raw): g = -1.1, si = 0, di = -0.5, b = -1.0, so vgs = 1.1,
// vds = 0.5, vbs = 1.0. [0] old raw: all 0 except b = 1.0 (vbs = -1).
//   Threshold at old: 0.5 - 0.2 (-1) = 0.7. (At cur it would be 0.3.)
//   Old vds = 0: normal mode. devsup.c DEVfetlim(1.1, 0, 0.7): off (vold < vto),
//   rising: vtemp = vto + 0.5 = 1.2 and 1.1 <= 1.2, delv 1.1 < vtstlo =
//   (|2(0 - 0.7)| + 2)/2 + 2 = 3.7: unchanged, so si stays 0. (Against 0.3,
//   vtemp = 0.8 < 1.1 clamps vgs to 0.8 and moves si to -0.3.)
//   DEVlimvds(0.5, 0): min(0.5, 4), unchanged, di stays -0.5.
//   Limited vds 0.5 >= 0: the source junction. DEVpnjlim(1.0, -1, vt, vcrit):
//   1.0 > vcrit, |2.0| > 2 vt, vold <= 0: vt ln(1.0/vt) = 0.025 ln 40 =
//   0.09222198635284841, so b = si + type * that = -0.09222198635284841,
//   and pnjlim moved: converged = 0.
// [1] old = cur: §9.17.3 "When the simulator has converged, the return value
//   of the $limit() function is the value of the access function reference".
// At the bias the model evaluates, §9.17.3's "When the simulator has
// converged, the return value of the $limit() function is the value of the
// access function reference, within appropriate tolerances" is the CHECK
// (1e-6: Annex D's `nature Voltage` abstol, as limit_fet.va argues).
//! lrm 9.17.3
//! bias V(g) = -1.1, V(si) = 0.0, V(di) = -0.5, V(b) = -1.0
//! print none
//! limit V(g) = 0, V(si) = 0, V(di) = 0, V(b) = 1.0 -> V(si) = 0.0, V(di) = -0.5, V(g) = -1.1, V(b) = -0.09222198635284841, converged = 0
//! limit -> V(si) = 0.0, V(di) = -0.5, V(g) = -1.1, V(b) = -1.0, converged = 1
`include "check.vh"
module limit_pnjlimds_bsim_pmos_von_at_old(d, g, s, b);
  inout d, g, s, b; electrical d, g, s, b, di, si;
  parameter real type = -1.0, vth0 = 0.5, vt = 0.025, vcrit = 0.6;
  real vonp, vgs, vgd, vds, vbs, vbd;
  analog begin
    vonp = vth0 - 0.2 * type * V(b, si);
    vgs = type * $limit(V(g, si), "fetlimds", vonp, type);
    vgd = type * $limit(V(g, di), "fetlimds", vonp, type);
    vds = type * $limit(V(di, si), "limvds", type);
    vbs = type * $limit(V(b, si), "pnjlimds", vt, vcrit, type);
    vbd = type * $limit(V(b, di), "pnjlimds", vt, vcrit, type);
    I(d, di) <+ V(d, di) / 10.0;
    I(s, si) <+ V(s, si) / 10.0;
    I(di, si) <+ type * 1e-3 * (vds + 0.1 * (vgs + vgd));
    I(b, si) <+ type * 1e-14 * (limexp(vbs / vt) - 1.0);
    I(b, di) <+ type * 1e-14 * (limexp(vbd / vt) - 1.0);
    `CHECK("$limit returns its access function at the answer", vbs, 1.0, 1e-6);
  end
endmodule
