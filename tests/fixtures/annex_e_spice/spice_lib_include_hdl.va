// E.4.2: "Some SPICE netlists provide mechanisms for mapping an instance to a
// group of models ... Examples include model binning or corners support. From
// within an instance statement, it appears as if the instance is referencing a
// simple SPICE model ... Support of SPICE model cards is implementation
// specific (including those using these mechanisms)." E.1.2 leaves the dialect
// to "the authors of the simulator"; VerA reads the way a PDK ships its
// corners: `.LIB "file" entry` takes the lines between `.LIB entry` and
// `.ENDL` of that file, `.INCLUDE "file"` takes a whole file, and HSPICE's
// `.HDL "file"` adds a Verilog-A source to the design. Each relative name is
// looked for beside the file that names it (here, this fixture's directory).
//
// THE NETLIST, split over three files the way a PDK splits it:
//   spice_lib_models.lib  two entries, FF (KP = 9e-3) and TT (KP = 2e-3, and
//                         `.HDL "spice_lib_linfet.vh"`, the model's source)
//   spice_lib_cell.inc    `.SUBCKT CELL D G S B` / `M1 D G S B NFET W=2 L=0.25`
//   spice_lib_linfet.vh   module linfet: I(d,s) = KP * (W/L) * V(g,s) * V(d,s)
//
// THE DIGITS, BY HAND. V(d) = 1.0, V(g) = 0.75, V(s) = 0.25: Vgs 0.5, Vds 0.75.
// TT's model: I = 2e-3 * (2 / 0.25) * 0.5 * 0.75 = 0.006 A. Reading the FF
// entry too (its card first) gives 9e-3 * 8 * 0.375 = 0.027; with neither the
// `.HDL` nor the `.INCLUDE` the file does not elaborate at all.
//
// WHY `\cell`. The netlist names its subcircuit CELL, and `cell` is an annex B
// keyword (Table B.1; "an escaped identifier shall not be treated as a
// keyword"), so the instance spells the name as a §2.8.1 escaped identifier,
// as spice_keyword_names.va does for `\wire`. A bare `cell x1(...)` is a
// syntax error in any conforming reader.
//
//! lrm E.4.2
//! lrm E.4.2:1
//! lrm E.2
//! lrm E.1.2
//! lrm 6.7.1
//! bias V(d) = 1.0, V(g) = 0.75, V(s) = 0.25, V(b) = 0.0
//! spice .LIB "spice_lib_models.lib" TT
//! spice .INCLUDE "spice_lib_cell.inc"
//! checks 1
`include "check.vh"
module annex_e_spice_lib_include_hdl(d, g, s, b);
  inout d, g, s, b; electrical d, g, s, b;
  \cell x1(d, g, s, b);
  analog begin
    `CHECKR("TT's KP 2e-3 * W/L 8 * Vgs 0.5 * Vds 0.75, FF's entry unread",
            I(x1.m1.d, x1.m1.s), 0.006, 1e-12);
  end
endmodule
