// A module NAMED `resistor` — the Table E.1 primitive name — declaring its own
// parameter with a §2.6.2 scaled default.
//
// WHAT IS PINNED. Three things:
//
//   r == 1000 exactly. Table 2-1 of §2.6.2 gives `K, k` the value 1e3 and lists
//   `7k` among the valid real constants, so the §3.4 default written `1k` is
//   1000.0 — not 1.0, not 1024, and not a syntax error for want of a decimal
//   point (§2.6.2's "one digit on each side" rule constrains only numbers that
//   HAVE a decimal point).
//
//   V(p,n) == 1.0 at the biased operating point, i.e. the bias reaches the
//   branch p-first and the ordering of the port list is the ordering of the
//   potential difference.
//
//   The definition is ACCEPTED at all, which is E.3.3's first half. E.3.3: "a
//   module or paramset defined in the Verilog-AMS will always be selected in
//   favor of a SPICE primitive, model, or subcircuit using exactly the same
//   name", and specifically "in case of a SPICE primitive which is always
//   available in the Verilog-AMS simulator, a Verilog-AMS module or paramset
//   whose name exactly matches that of the primitive will be used". A tool with
//   `resistor` built in per Table E.1 therefore may not treat the name as
//   reserved: it must take this definition, and the `r` and V(p,n) digits below
//   are read out of THIS module rather than out of the primitive. `resistor` is
//   also not an Annex B keyword, so nothing else can refuse the name.
//
// HOW FAR THE E.3.3 CITE REACHES, and no further. The clause's second half is
// which of TWO definitions elaboration picks at an INSTANTIATION, and this suite
// can supply only one: the torture harness compiles a single .va and has no
// companion-SPICE-netlist input, so there is no SPICE `resistor` present for the
// module to be preferred over, and no instantiation site to observe the
// preference at. A tool that has never heard of SPICE passes that half by
// vacuity. Only the definition side above discriminates, and that is all the
// cite claims.
//
// TWO CLAIMS ALSO REMOVED, because they were unbacked:
//   - a third CHECK asserting V(p,n)/r == 1e-3. Both operands are pinned by the
//     two CHECKX lines above it, so 1.0/1000.0 is bit-identical to the literal
//     and the assertion could not fail once they passed.
//   - `//! temp 400`, and the paragraph arguing that a build "that kept a
//     temperature coefficient in scope would drift off it at 400 K". This module
//     declares no tc1/tc2 and no assertion reads $temperature, so there is no
//     temperature term for a coefficient to live in and the directive reached
//     nothing. Table E.1's V = I*r*(1 + tc1*T + tc2*T^2) is not modelled here.
//
//! lrm E.3.3
//! lrm 2.6.2
//! lrm 3.4
//! bias V(p) = 1.0, V(n) = 0.0
`include "check.vh"
module resistor(p, n);
  inout p, n; electrical p, n; parameter real r = 1k from (0:inf);
  analog begin
    `CHECKX("r default is the 1k scaled literal of 2.6.2", r, 1000.0);
    // Written against the branch POTENTIAL rather than a flow probe of the same
    // branch: VerA answers `I(p,n)` with 0 on a branch it is itself sourcing,
    // whichever side of the contribution the read sits on.
    `CHECKX("the bias reaches the branch, p first", V(p, n), 1.0);
    I(p, n) <+ V(p, n) / r;
  end
endmodule
