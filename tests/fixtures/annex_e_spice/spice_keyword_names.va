// E.2 with the one thing SPICE has that Verilog-AMS does not: no reserved
// words. "The subcircuits and models contained within the SPICE netlist are
// treated as module definitions" ranges over EVERY card in the netlist, and
// nothing in E.2 exempts a card whose name — or whose node names — happen to
// spell a Verilog-AMS keyword. `.SUBCKT AMP (INPUT OUTPUT)` and `.MODEL WIRE
// NPN` are both ordinary SPICE; `input`, `output` and `wire` are all annex B
// keywords.
//
// WHAT IS PINNED. That the two cards below become module definitions at all.
// The declaration a reader synthesizes for them is not source the user wrote,
// so a §2.7 spelling collision in it is the reader's problem to solve and not
// a defect to report against a file with no such text in it: VerA writes the
// names as §2.8.1 escaped identifiers, which "can include any printable ASCII
// character" and are never keywords (§2.8.2). The escape is a SPELLING, not a
// rename — §2.8.1 makes neither the backslash nor the terminating white space
// part of the identifier — so the module is still named `wire` and the ports
// are still named `input` and `output`, which is what keeps E.2.1's
// case-insensitive match and E.3's connection by order working on them.
//
// WHAT THE ASSERTIONS REACH. Both instances connect BY ORDER (E.3: "the ports
// of the SPICE primitive, model, or subcircuit are connected by order"), so
// neither check depends on the escaped spelling being typed anywhere in a
// connection. The first reads the subcircuit's two ports back hierarchically
// (§6.7.1) and so pins that `(INPUT OUTPUT)` is a two-port interface with
// INPUT first; the second does the same across the `bjt` collector and emitter
// of the model card, pinning that a model NAMED `wire` resolved to Table E.1's
// bjt row. Two nets held 0.75 V apart mean either ordering error moves a
// digit.
//
// WHY THE PROBE SPELLS THEM `\input` AND `\output`. A hierarchical reference is
// the one place a user must type a synthesized port name, and there §2.8.1 is
// how the LRM says to type an identifier that collides with a keyword — the
// same escape any hand-written `electrical \input ;` would need. E.3's ordered
// connection is why this is the ONLY place: the instance ports above are
// positional.
//
// WHAT IS NOT ASSERTED. Nothing inside either object. The subcircuit's body is
// a device card this reader does not read, and Table E.1's bjt row has an empty
// Behavior column — see spice_subcircuit.va and spice_model.va, which state
// that ceiling at length. Both instances are open circuits here, which is why
// every potential this file reads is one `//! bias` imposed.
//
//! lrm E.2
//! lrm E.2.1
//! lrm E.3
//! lrm 2.8.1
//! lrm 2.8.2
//! lrm 6.7.1
//! lrm 6.2.2
//! lrm 6.2.2:2
//! lrm 6.5.4
//! lrm 6.5.4:1
//! lrm 6.7.1:1
//! lrm E.2:3
//! bias V(hi) = 1.0, V(lo) = 0.25
//! spice .SUBCKT AMP (INPUT OUTPUT)
//! spice R1 INPUT OUTPUT 1K
//! spice .ENDS AMP
//! spice .MODEL WIRE NPN BF=80 IS=1E-18
`include "check.vh"
module annex_e_spice_keyword_names(hi, lo);
  inout hi, lo; electrical hi, lo;
  amp sub1(hi, lo);
  \wire mod1(hi, lo, lo, lo);
  analog begin
    `CHECKX("`.SUBCKT AMP (INPUT OUTPUT)` is a two-port interface, INPUT first",
            V(sub1.\input , sub1.\output ), 0.75);
    `CHECKX("`.MODEL WIRE NPN` resolved to the bjt of Table E.1, port 1 is c",
            V(mod1.c, mod1.e), 0.75);
  end
endmodule
