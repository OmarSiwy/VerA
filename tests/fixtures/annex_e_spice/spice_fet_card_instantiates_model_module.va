// E.2: "it shall also be possible to access subcircuits and models defined
// within SPICE netlists. The subcircuits and models contained within the SPICE
// netlist are treated as module definitions." E.1.1: "In general, anything
// that can be instantiated in the particular flavor of SPICE can also be
// instantiated within a Verilog-AMS HDL module." A `.SUBCKT` whose body holds a
// transistor card is a circuit like any other, so the card has to become an
// instance of what its model name means.
//
// WHAT THE MODEL NAME MEANS HERE. Table E.1 leaves the mosfet row's Behavior
// empty (E.2: "all aspects of SPICE primitives are implementation dependent"),
// so a `.MODEL NFET NMOS` has no equations in VerA and is refused at the card
// (reject_spice_fet_card_model_has_no_behaviour.va). What does have equations is
// a Verilog-A module, and the dialect VerA claims (E.1.2: "solely determined by
// the authors of the simulator") is HSPICE/Spectre's: the `.MODEL` card's type
// names the compiled model, `.MODEL NFET LINFET KP=2E-3 W=5`, its parameters
// are that module's, and the card's own parameters override them. A card may
// also name the module directly, as `D1` names `gdio`.
//
// THE NAMES CROSS CASE. The netlist writes LINFET, KP, W, L; the module is
// `LinFet` with KP, W, L. E.2.1 makes a name match "regardless of the case"
// across the SPICE/Verilog-AMS boundary, and a SPICE netlist is case-blind, so
// a tool that matched these names exactly fails to elaborate this file.
//
// THE DIGITS, BY HAND. All four ports are imposed, every one distinct:
// V(d) = 1.0, V(g) = 0.75, V(s) = 0.25, V(b) = 0, so Vgs = 0.5, Vds = 0.75.
//
//   M1: KP = 2e-3 (the model card's, over the module default 1e-3), W = 2 (the
//   card's, over the model card's 5), L = 0.25 (the card's), and M = 3, E.4.1's
//   multiplicity factor, which §6.3.6 applies to every flow as $mfactor:
//
//       I(d, s) = 3 * 2e-3 * (2 / 0.25) * 0.5 * 0.75 = 0.018 A
//
//   Each wrong reading moves it: the model card's W winning gives 0.045, the
//   module's KP 0.009, M ignored 0.006, L ignored (W/L = 2) 0.0045.
//
//   D1: `D1 G S GDIO 3`, no `.MODEL GDIO`: the module `gdio`, its positional
//   area 3 (Table E.1's diode `area`):  I(g, s) = 3 * 1e-3 * 0.5 = 0.0015 A.
//   Area ignored gives 0.0005.
//
// Both are read as §6.7.1 hierarchical flows of the instance's own branch.
//
// WHY `\cell`. The netlist names its subcircuit CELL, and `cell` is an annex B
// keyword (Table B.1; "an escaped identifier shall not be treated as a
// keyword"), so the instance spells the name as a §2.8.1 escaped identifier,
// as spice_keyword_names.va does for `\wire`. A bare `cell x1(...)` is a
// syntax error in any conforming reader.
//
//! lrm E.2
//! lrm E.2:2
//! lrm E.1.1
//! lrm E.2.1
//! lrm E.4.1
//! lrm 6.3.6
//! lrm 6.7.1
//! bias V(d) = 1.0, V(g) = 0.75, V(s) = 0.25, V(b) = 0.0
//! spice .MODEL NFET LINFET KP=2E-3 W=5
//! spice .SUBCKT CELL D G S B
//! spice M1 D G S B NFET W=2 L=0.25 M=3
//! spice D1 G S GDIO 3
//! spice .ENDS CELL
//! checks 2
`include "check.vh"
module LinFet(d, g, s, b);
  inout d, g, s, b; electrical d, g, s, b;
  parameter real KP = 1e-3;
  parameter real W = 1.0;
  parameter real L = 1.0;
  analog I(d, s) <+ KP * (W / L) * V(g, s) * V(d, s);
endmodule

module gdio(a, c);
  inout a, c; electrical a, c;
  parameter real area = 1.0;
  analog I(a, c) <+ area * 1e-3 * V(a, c);
endmodule

module annex_e_spice_fet_card(d, g, s, b);
  inout d, g, s, b; electrical d, g, s, b;
  \cell x1(d, g, s, b);
  analog begin
    `CHECKR("M1 = 3 * KP 2e-3 (model) * W/L 2/0.25 (card) * Vgs 0.5 * Vds 0.75",
            I(x1.m1.d, x1.m1.s), 0.018, 1e-12);
    `CHECKR("D1 names the module gdio, area 3 * 1e-3 * 0.5", I(x1.d1.a, x1.d1.c), 0.0015, 1e-12);
  end
endmodule
