//! reject module instantiation is not supported
// EXPECT: error -- Table E.1 primitive needs SPICE elaboration.
module annex_e_primitive_jfet(d,g,s); inout d,g,s; electrical d,g,s; jfet #(.area(1.0)) x(.d(d),.g(g),.s(s)); endmodule
