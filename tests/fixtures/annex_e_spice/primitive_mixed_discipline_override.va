// E.3.2.1, third worked example, transcribed. "The use of these attributes can
// be combined to change the basic discipline of all ports for the analog
// primitive, but overriding the discipline for specific ports." The LRM prints:
//
//     (* port_discipline="electrical" *) vcvs #(.gain(1.45e-3))
//        motor1 (n1, gnd_e,
//           (* port_discipline="rotational_omega" *) shaft1,
//           (* port_discipline="rotational_omega" *) gnd_rot);
//
// and explains it: "the above model uses a voltage-controlled voltage source to
// model a motor as a converter from electrical potential to rotational velocity."
//
// WHAT IS PINNED. Precedence between the two attribute positions: the instance
// attribute sets the default for all four Table E.1 vcvs ports (p, n, ps, ns),
// and the two per-port attributes override the last two. A tool that honoured
// only one of the two positions, or let the instance attribute win over the port
// one, would get a different circuit from the one E.3.2.1 describes.
//
// HOW THE MIXTURE IS OBSERVED. A discipline is not readable as a value; what it
// fixes is WHICH ACCESS FUNCTION each net has, and the two halves of this
// instance must answer differently. Annex D gives `electrical` V and I, and
// `rotational_omega` the natures Angular_Velocity and Angular_Force, accessed as
// `Omega` and `Tau`. So the output pair is spelled `V(motor1.p, motor1.n)` and
// the sense pair `Omega(motor1.ps, motor1.ns)` — each legal only on its own
// discipline. A tool that let the instance attribute win over the port one gives
// all four ports `electrical` and `Omega` does not exist; one that let the port
// attribute leak outwards gives all four `rotational_omega` and `V` does not.
// Both spellings therefore have to be right at once, which is exactly the
// combination the clause describes. §6.7.1 permits the two out-of-module
// potential accesses and the parameter read.
//
// THE DIGITS. Table E.1's vcvs row is V(p, n) = gain * V(ps, ns), read across
// the two natures here as electrical potential = gain * angular velocity, which
// is the conversion the LRM's sentence names. With the shaft at 100 rad/s and
// gain = 1.45m, the LRM fixes the output at 1.45e-3 * 100 = 0.145 V exactly, and
// the operating point below is the one that satisfies it — this harness imposes
// every unknown rather than solving for it (see tests/fixtures/README.md), so
// the output potential has to be handed in at the value the row requires. Note
// what that does and does not discriminate: it catches a transposed port list
// and a mis-resolved discipline, but not a tool that computed a different gain,
// because the harness never solves the vcvs constraint. `motor1.gain` is checked
// separately for that reason, and pins §2.6.2's `m` as 1e-3 into the bargain.
//
//! lrm E.3.2.1
//! lrm E.3.2
//! lrm E.3
//! lrm 2.6.2
//! lrm 6.7.1
//! bias V(n1) = 0.145, V(gnd_e) = 0.0, shaft1 = 100.0, gnd_rot = 0.0
//! xfail VerA rejects module instantiation (E0204), so the combined discipline override cannot be reached
`include "check.vh"
module annex_e_primitive_mixed_discipline(n1, gnd_e, shaft1, gnd_rot);
  inout n1, gnd_e, shaft1, gnd_rot;
  electrical n1, gnd_e; rotational_omega shaft1, gnd_rot;
  (* port_discipline="electrical" *) vcvs #(.gain(1.45m)) motor1(
      n1, gnd_e,
      (* port_discipline="rotational_omega" *) shaft1,
      (* port_discipline="rotational_omega" *) gnd_rot);
  analog begin
    // §2.6.2 Table 2-1: m = 1e-3, so `1.45m` is the LRM's own 1.45e-3.
    `CHECKX(".gain(1.45m) is the LRM's 1.45e-3", motor1.gain, 1.45e-3);
    // Ports 3 and 4 took the PER-PORT override: rotational_omega, so Omega.
    `CHECKX("the sense pair is rotational_omega and holds 100 rad/s",
            Omega(motor1.ps, motor1.ns), 100.0);
    // Ports 1 and 2 kept the INSTANCE attribute: electrical, so V. Table E.1
    // V(p,n) = gain*V(ps,ns) = 1.45e-3 * 100, which is 0.145 in double.
    `CHECKX("the output pair is electrical and carries gain*Omega",
            V(motor1.p, motor1.n), 0.145);
  end
endmodule
