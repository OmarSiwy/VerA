// Table E.1 row `vccs`: ports sink, src, ps, ns, parameter gm, behaviour
//
//     I(sink, src) = gm * V(ps, ns)
//
// The one row of Table E.1 whose Behavior column names its ports explicitly, so
// the port ORDER is not a separate convention to look up: the flow is out of sink
// and into src, controlled by the potential of ps above ns.
//
// WHAT IS PINNED. E.3: "Table E.1 shows the REQUIRED names for primitives,
// parameters, and ports which are otherwise unnamed in SPICE. For connection by
// order instead of by name, the ports and parameters shall be given in the order
// listed. The default discipline of the ports for these primitives shall be
// electrical and their descriptions shall be inout." E.1.2 adds that "when
// instantiating SPICE primitives in Verilog-AMS HDL, the primitives shall, and
// parameters and ports can, be named", and E.2 that a tool "expected to provide
// the basic set of Spice primitives" shall treat them "in the same manner in
// Verilog-AMS HDL as built-in primitives of gate- and switch-level modeling".
// So the instantiation below — every port and every parameter named, in the
// Table E.1 order — is source a SPICE-compatible Verilog-AMS tool must accept.
//
// THIS IS A RUN FIXTURE, NOT A REJECT. An earlier revision of this file demanded
// a diagnostic for the line below. That inverts the test: the LRM prints this
// syntax as legal, so a conforming compiler would FAIL and only a compiler with
// no SPICE support would pass. The requirement is that it compiles, and it does:
// VerA ships Table E.1 as ordinary module declarations in a prelude, the same
// shape as annex D's disciplines.vams (`Preprocessor.spice_primitives`).
//
// THE DIGITS. `//! bias` holds ps at 2 V and ns at 0.5 V, so V(ps, ns) is 1.5 V
// exactly — both values dyadic, so the difference is exact — and with gm = 1m the
// row gives 1.5e-3 A out of sink.
//
// x2 swaps the CONTROL pair and nothing else: ps and ns exchanged makes
// V(ps, ns) = -1.5 V and the current -1.5e-3 A. Two instances of one primitive
// differing only in which net controls it is the only way to pin the sign of the
// control pair, and the sign is the half of the row a tool gets wrong.
//
// x3 connects by order and overrides by order, so its 0.75e-3 A says that
// positional port 1 is sink and positional parameter 1 is gm: gm = 0.5 against the
// same 1.5 V control.
//
// HOW THE PRIMITIVE IS OBSERVED. §6.7.1: "Potential and flow access for named
// and unnamed branches (including port branches) can be done hierarchically",
// and "access of parameters can be done hierarchically". So `I(x1.sink, x1.src)` is the
// flow of the primitive's own port pair — the branch Table E.1's Behavior
// column is written about — reached by an out-of-module reference, and `x1.gm` is
// the parameter an override landed on. Nothing else could observe the row: the
// Behavior column belongs to the primitive's branches, not to this module's.
//
// ONE INSTANCE PER NET PAIR, and that is load-bearing. Two unnamed branches over
// the same pair of nets share one accumulator in VerA today
// (ch05_analog_behavior/two_named_branches.va holds that gap), so two instances
// hung across the same two nets would each read the SUM of both. Every instance
// below therefore gets its own net, sharing only the common return.
//
//! lrm E.3
//! lrm E.3:1
//! lrm E.3:2
//! lrm E.1.2
//! lrm E.1.2:1
//! lrm E.2
//! lrm 6.7.1
//! lrm 6.2.2
//! lrm 6.2.2:2
//! lrm 6.5.4
//! lrm 6.5.4:1
//! lrm 6.7.1:1
//! bias V(ps) = 2.0, V(ns) = 0.5
`include "check.vh"
module annex_e_primitive_vccs(sink, src, ps, ns);
  inout sink, src, ps, ns; electrical sink, src, ps, ns;
  electrical a2, a3;
  vccs #(.gm(1m)) x1(.sink(sink), .src(src), .ps(ps), .ns(ns));
  // The control pair, and only the control pair, reversed.
  vccs #(.gm(1m)) x2(.sink(a2), .src(src), .ps(ns), .ns(ps));
  // E.3, connection and override BY ORDER: sink, src, ps, ns and then gm.
  vccs #(0.5) x3(a3, src, ps, ns);
  analog begin
    `CHECKR("Table E.1: I(sink,src) = gm*V(ps,ns) = 1m*1.5", I(x1.sink, x1.src), 1.5e-3, 1e-15);
    `CHECKR("reversing ps and ns reverses the current", I(x2.sink, x2.src), -1.5e-3, 1e-15);
    `CHECKX("by order, port 1 is sink and parameter 1 is gm", I(x3.sink, x3.src), 0.75);
    `CHECKX("the gm override reaches Table E.1's gm", x1.gm, 1.0e-3);
  end
endmodule
