// E.3 / Table E.1 row `mosfet`: ports d, g, s, b and parameters w, l, ad, as,
// pd, ps, nrd, nrs. E.1.2 is why they have names: "the names of the built-in
// SPICE primitives, their parameters, or their ports can differ from simulator
// to simulator... to reduce this, a list of what names shall be used for the
// more common components is shown in Table E.1."
//
// WHAT IS PINNED. The geometry-parameter set of the MOS row specifically, each
// parameter read back through the instance by name (§6.7.1, "access of
// parameters can be done hierarchically") against its own literal. EVERY ONE OF
// THE EIGHT VALUES IS DISTINCT, and that is the whole design of the fixture: a
// tool that swapped the drain and source pair — ad/as, pd/ps, nrd/nrs, the three
// places this row invites it — moves six of the eight numbers, where a row
// written with equal drain and source geometry would notice nothing. Note also
// that `ps` is both a Table E.1 mosfet PARAMETER (source perimeter) and a Table
// E.1 vccs/vcvs PORT name; a tool that kept one flat namespace for Table E.1
// identifiers collides here.
//
// The four ports are given by name in REVERSE Table E.1 order. §6.5.5 makes a
// named list order-independent, so that is the same circuit; a tool that took
// the names as decoration and connected by position would tie the drain to `bulk`
// and the gate to `src`. The four nets are biased to four different potentials,
// so such a tool fails all three potential checks.
//
// WHY THE OBSERVABLE IS A POTENTIAL AND NOT A CURRENT. The Behavior column of
// Table E.1 is EMPTY for the `mosfet` row, as it is for diode, bjt, jfet and
// mesfet, and E.2 says "all aspects of SPICE primitives are implementation
// dependent". The annex fixes no drain current here and there is no honest digit
// for one. What it does fix is the parameter names, the port names and the
// association rule, and all three are observable.
//
// THIS IS A RUN FIXTURE, NOT A REJECT. An earlier revision demanded a diagnostic
// for source Table E.1 prescribes.
//
//! lrm E.3
//! lrm E.1.2
//! lrm 6.5.5
//! lrm 6.7.1
//! bias V(drn) = 1.0, V(gate) = 0.75, V(src) = 0.25, V(bulk) = 0.125
//! xfail VerA rejects module instantiation (E0204), so the Table E.1 mosfet row cannot be reached
`include "check.vh"
module annex_e_spice_semiconductor_primitives(drn, gate, src, bulk);
  inout drn, gate, src, bulk; electrical drn, gate, src, bulk;
  mosfet #(.w(1u), .l(100n), .ad(2p), .as(4p), .pd(3u), .ps(6u),
      .nrd(1.0), .nrs(2.0)) m1(.b(bulk), .s(src), .g(gate), .d(drn));
  analog begin
    // §2.6.2 Table 2-1: u = 1e-6, n = 1e-9, p = 1e-12.
    `CHECKX("w", m1.w, 1.0e-6);
    // `100n` is 100 x 1e-9. Rounded as a product it lands one ulp above the
    // double nearest 1e-7, so this is the one geometry value with a relative
    // tolerance rather than an exact one; 1e-15 is ~4 ulp.
    `CHECKR("l", m1.l, 1.0e-7, 1e-15);
    `CHECKX("ad is the DRAIN area", m1.ad, 2.0e-12);
    `CHECKX("as is the SOURCE area, and differs from ad", m1.as, 4.0e-12);
    `CHECKX("pd is the DRAIN perimeter", m1.pd, 3.0e-6);
    `CHECKX("ps is the mosfet PARAMETER, not the vcvs port", m1.ps, 6.0e-6);
    `CHECKX("nrd", m1.nrd, 1.0);
    `CHECKX("nrs, and it differs from nrd", m1.nrs, 2.0);
    // Named association, against a bias that makes every port distinct.
    `CHECKX(".d(drn) reaches the drain: 1.0 - 0.25", V(m1.d, m1.s), 0.75);
    `CHECKX(".g(gate) reaches the gate: 0.75 - 0.25", V(m1.g, m1.s), 0.5);
    `CHECKX(".b(bulk) reaches the bulk: 0.125 - 0.25", V(m1.b, m1.s), -0.125);
  end
endmodule
