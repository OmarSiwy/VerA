// Table E.1 row `vcvs`: ports p, n, ps, ns, parameter gain, behaviour
//
//     V(p, n) = gain * V(ps, ns)
//
// E.3.2.1's own example is a vcvs whose output pair is electrical and whose
// control pair is rotational_omega — one instance, two natures, one equation — so
// the row's V is "the potential of this port pair" and not a request for a
// particular access function.
//
// WHAT IS PINNED. E.3: "Table E.1 shows the REQUIRED names for primitives,
// parameters, and ports which are otherwise unnamed in SPICE. For connection by
// order instead of by name, the ports and parameters shall be given in the order
// listed. The default discipline of the ports for these primitives shall be
// electrical and their descriptions shall be inout." E.1.2 adds that "when
// instantiating SPICE primitives in Verilog-AMS HDL, the primitives shall, and
// parameters and ports can, be named", and E.2 that a tool "expected to provide
// the basic set of Spice primitives" shall treat them "in the same manner in
// Verilog-AMS HDL as built-in primitives of gate- and switch-level modeling".
// So the instantiation below — every port and every parameter named, in the
// Table E.1 order — is source a SPICE-compatible Verilog-AMS tool must accept.
//
// THIS IS A RUN FIXTURE, NOT A REJECT. An earlier revision of this file demanded
// a diagnostic for the line below. That inverts the test: the LRM prints this
// syntax as legal, so a conforming compiler would FAIL and only a compiler with
// no SPICE support would pass. The requirement is that it compiles, and it does:
// VerA ships Table E.1 as ordinary module declarations in a prelude, the same
// shape as annex D's disciplines.vams (`Preprocessor.spice_primitives`).
//
// THE DIGITS. `//! bias` holds ps at 1.25 V and ns at 0.25 V, so V(ps, ns) is 1 V
// exactly, and gain = 2 makes the output pair 2 V. n is biased to the reference and
// `//! solve` leaves the output nodes to the device, which is the point: a vcvs is
// a POTENTIAL relation, its branch flow is the unknown, and 2.0 is a number only a
// solve can produce.
//
// x2 swaps the CONTROL pair and nothing else, so its output is -2 V. x3 connects
// and overrides by order, so its 0.5 V says positional port 1 is p and positional
// parameter 1 is gain. Every want here is dyadic and therefore exact.
//
// HOW THE PRIMITIVE IS OBSERVED. §6.7.1: "Potential and flow access for named
// and unnamed branches (including port branches) can be done hierarchically",
// and "access of parameters can be done hierarchically". So `V(x1.p, x1.n)` is the
// potential of the primitive's own port pair — the branch Table E.1's Behavior
// column is written about — reached by an out-of-module reference, and `x1.gain` is
// the parameter an override landed on. Nothing else could observe the row: the
// Behavior column belongs to the primitive's branches, not to this module's.
//
// ONE INSTANCE PER NET PAIR, and that is load-bearing. Two unnamed branches over
// the same pair of nets share one accumulator in VerA today
// (ch05_analog_behavior/two_named_branches.va holds that gap), so two instances
// hung across the same two nets would each read the SUM of both. Every instance
// below therefore gets its own net, sharing only the common return.
//
//! lrm E.3
//! lrm E.3:1
//! lrm E.3:2
//! lrm E.1.2
//! lrm E.1.2:1
//! lrm E.2
//! lrm E.3.2.1
//! lrm 6.7.1
//! lrm 6.2.2
//! lrm 6.2.2:2
//! lrm 6.5.4
//! lrm 6.5.4:1
//! lrm 6.7.1:1
//! bias V(ps) = 1.25, V(ns) = 0.25, V(n) = 0.0
//! solve
`include "check.vh"
module annex_e_primitive_vcvs(p, n, ps, ns);
  inout p, n, ps, ns; electrical p, n, ps, ns;
  electrical a2, a3;
  vcvs #(.gain(2.0)) x1(.p(p), .n(n), .ps(ps), .ns(ns));
  // The control pair, and only the control pair, reversed.
  vcvs #(.gain(2.0)) x2(.p(a2), .n(n), .ps(ns), .ns(ps));
  // E.3, connection and override BY ORDER: p, n, ps, ns and then gain.
  vcvs #(0.5) x3(a3, n, ps, ns);
  analog begin
    `CHECKX("Table E.1: V(p,n) = gain*V(ps,ns) = 2*1.0", V(x1.p, x1.n), 2.0);
    `CHECKX("reversing ps and ns reverses the output", V(x2.p, x2.n), -2.0);
    `CHECKX("by order, port 1 is p and parameter 1 is gain", V(x3.p, x3.n), 0.5);
    `CHECKX("the gain override reaches Table E.1's gain", x1.gain, 2.0);
  end
endmodule
