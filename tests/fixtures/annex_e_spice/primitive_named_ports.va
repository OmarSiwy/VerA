// E.1.2: "When instantiating SPICE primitives in Verilog-AMS HDL, the primitives
// shall, and parameters and ports can, be named." E.2.2.1 prints the pair that
// makes the point — `vertNPN Q1 (c1, b1, e);` by order and
// `vertNPN Q2 (.c(c2), .b(b2), .e(e));` by name — and adds "in both cases, the
// optional substrate port s is defaulted by simply not giving it."
//
// WHAT IS PINNED. The by-name form on a four-port Table E.1 semiconductor row:
// `bjt` has ports c, b, e, s and parameter area. Named association is what makes
// the optional trailing port defaultable, so this is the syntax E.2.2.1's
// "defaulted by simply not giving it" depends on.
//
// THE FOUR CONNECTIONS ARE WRITTEN IN REVERSE TABLE E.1 ORDER, and that is the
// test. §6.5.5 makes a named list order-independent, so `.s`, `.e`, `.b`, `.c`
// is the same circuit as `.c`, `.b`, `.e`, `.s`; a tool that took the names as
// decoration and connected by position instead would tie the collector to s1 and
// the base to e1. Each of the four nets is biased to a different potential, so
// that tool fails every one of the three potential checks rather than none of
// them. Written in Table E.1 order the fixture could not tell the two apart.
//
// WHY THE OBSERVABLE IS A POTENTIAL AND NOT A CURRENT. Table E.1's Behavior
// column is EMPTY for the `bjt` row — as it is for diode, mosfet, jfet and
// mesfet — and E.2 says in terms that "all aspects of SPICE primitives are
// implementation dependent". So the annex fixes no current here and no honest
// digit for one exists. What it does fix is the port names and the association
// rule, and those are observable: §6.7.1 allows potential access to a branch of
// an instance hierarchically, and `V(q1.c, q1.e)` is the potential the
// connection forces onto the primitive's own collector-emitter pair. `q1.area`
// is the same clause's "access of parameters can be done hierarchically".
//
// THIS IS A RUN FIXTURE, NOT A REJECT. An earlier revision demanded a diagnostic
// for source the LRM prints; that inverts the test, since a conforming compiler
// would FAIL it and only one without SPICE support would pass.
//
//! lrm E.1.2
//! lrm E.2.2.1
//! lrm E.3
//! lrm 6.5.5
//! lrm 6.7.1
//! bias V(c1) = 1.0, V(b1) = 0.75, V(e1) = 0.25, V(s1) = 0.125
//! xfail VerA rejects module instantiation (E0204), so a named primitive connection cannot be reached
`include "check.vh"
module annex_e_primitive_named_ports(c1, b1, e1, s1);
  inout c1, b1, e1, s1; electrical c1, b1, e1, s1;
  bjt #(.area(2.0)) q1(.s(s1), .e(e1), .b(b1), .c(c1));
  analog begin
    `CHECKX(".area(2.0) binds Table E.1's bjt area", q1.area, 2.0);
    // Every want is a difference of two exactly representable biases.
    `CHECKX(".c(c1) reaches the collector: 1.0 - 0.25", V(q1.c, q1.e), 0.75);
    `CHECKX(".b(b1) reaches the base: 0.75 - 0.25", V(q1.b, q1.e), 0.5);
    `CHECKX(".s(s1) reaches the substrate: 0.125 - 0.25", V(q1.s, q1.e), -0.125);
  end
endmodule
