// DEBT — this rejection is NOT conformance.
// The LRM permits what VerA refuses here. The substrings below record
// CURRENT behavior so the suite stays green on it; they do not claim it
// is right. `zig build ledger` counts this rule against VerA.
//
// VAMS-E.3.2.1-03  (annex-e-spice.html)
// It shall only apply to either the analog primitive itself or the port to which it is attached.
// VAMS-E.3.2.1-05  (annex-e-spice.html)
// This attribute shall only apply to analog primitives or the ports of analog primitives.
//
//! reject module instantiation is not supported
// EXPECT: error -- an instance default and selected port overrides may be combined.
module annex_e_primitive_mixed_discipline(n1, gnd_e, shaft1, gnd_rot);
  inout n1, gnd_e, shaft1, gnd_rot;
  electrical n1, gnd_e; rotational_omega shaft1, gnd_rot;
  (* port_discipline="electrical" *) vcvs #(.gain(1.45m)) motor1(
      n1, gnd_e,
      (* port_discipline="rotational_omega" *) shaft1,
      (* port_discipline="rotational_omega" *) gnd_rot);
endmodule
