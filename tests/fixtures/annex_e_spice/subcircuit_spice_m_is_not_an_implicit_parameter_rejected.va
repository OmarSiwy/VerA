// E.4.1 Multiplicity factor on subcircuits: "Some SPICE simulators support a
// multiplicity factor (M) parameter on subcircuits WITHOUT THE PARAMETER BEING
// EXPLICITLY DECLARED. ... Starting with LRM Version 2.2, the multiplicity
// factor is supported for subcircuits defined as modules in Verilog-AMS using
// the hierarchical system parameter $mfactor, as described in 6.3.6."
//
// So the Verilog-AMS spelling of SPICE's implicit M is `.$mfactor(...)`, the
// §6.3.6 system parameter every module has, and NOT an implicit `m`. §6.3.6:
// "there are six system parameters that are implicitly declared for every
// module: $mfactor, $xposition, $yposition, $angle, $hflip, and $vflip" —
// `m` is not among them, and a module declares no other parameter it does not
// write. `.m(4)` on `rcell` therefore names nothing `rcell` declares — §6.3.3:
// "The name shall be the name specified in the instantiated module."
//
// A tool that carried SPICE's implicit M over would accept `.m(4)` and scale
// the cell; E.4.1 is the clause that says Verilog-AMS replaced that with
// $mfactor. The same instance with `.$mfactor(4)` compiles and scales
// (probed; mfactor_subcircuit.va and h04_09 run it).
//
// VerA reports E0907 "override names no parameter of the module".
//
//! lrm E.4.1
//! lrm 6.3.6
//! lrm 6.3.3
//! lrm 6.3.3:1
//! reject-only E0907
//! reject `m` is not a parameter of `rcell`
//! neighbour mfactor_subcircuit.va
`include "disciplines.vams"
module e41_top(p, n);
  inout p, n; electrical p, n;
  rcell #(.m(4)) x1(p, n);                // illegal: M is spelled .$mfactor
endmodule

module rcell(a, b);
  inout a, b; electrical a, b;
  analog I(a, b) <+ V(a, b) / 1.0e3;
endmodule
