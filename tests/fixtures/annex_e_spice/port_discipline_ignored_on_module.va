// E.3.2.1 Setting the discipline of analog primitives, final sentence: "This
// attribute shall only apply to analog primitives or the ports of analog
// primitives; for other modules as well as the ports of all other modules it
// shall be ignored."
//
// WHAT IS PINNED. `pd_ignored` is a plain behavioural module — not one of the
// Table E.1 analog primitives — so its ports are "the ports of all other
// modules" and `port_discipline` on one of them is required to be IGNORED. Not
// diagnosed, not honoured: ignored. The module therefore behaves exactly as if
// the attribute were absent, and the `electrical` in the declaration it prefixes
// is what fixes the discipline.
//
// WHY IT DISCRIMINATES. `rotational` is Annex D's mechanical discipline, whose
// natures are Angle and Angular_Force with access functions Theta() and Tau().
// A tool that HONOURED the attribute here would give `p` a discipline in which
// V() is not an access function at all, and this file would fail to compile
// (§4.4: the access function must belong to the net's discipline). A tool that
// diagnosed the attribute would also fail. Only "ignored" gets to ok=1.
//
// WHERE THE ATTRIBUTE MAY LEGALLY SIT, and why the header is ANSI. A.1.3 gives
// `port ::= [ port_expression ] | . port_identifier ( [ port_expression ] )` —
// no `{attribute_instance}` — so a bare identifier in a non-ANSI `list_of_ports`
// is NOT a legal attribute site and a compiler enforcing Annex A must refuse it.
// §2.9 agrees: an attribute_instance is "a prefix attached to a declaration, a
// module item, a statement, or a port connection", and a non-ANSI port name is
// none of the four. E.3.2.1's own three examples all attach the attribute to an
// instantiation or to an `ordered_port_connection` (A.4.1.1), which is the other
// legal site. The form used below is the first one: A.1.3 `port_declaration ::=
// {attribute_instance} inout_declaration`, with A.2.1.2's
// `inout [discipline_identifier] … list_of_port_identifiers` carrying the
// discipline. Same clause pinned, in a position the grammar admits.
//
// THE DIGITS. Nothing in E.3.2.1 fixes a voltage — the clause is about which
// discipline a port has, not what it carries — so the number asserted is the one
// the harness imposes, and the claim is that the attribute did not disturb it.
// 1.25 - 0.0 = 1.25, a dyadic rational and exact in binary64, hence CHECKX.
//
//! lrm E.3.2.1
//! lrm E.3.2.1:4
//! lrm 2.9
//! bias V(p) = 1.25, V(n) = 0.0
`include "check.vh"
module pd_ignored((* port_discipline="rotational" *) inout electrical p, n);
  analog begin
    `CHECKX("port_discipline on a non-primitive port is ignored", V(p, n), 1.25);
    I(p, n) <+ V(p, n) / 1000.0;
  end
endmodule
