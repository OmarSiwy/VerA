// E.3.3 Name scoping of SPICE primitives: "In the resolution hierarchy of
// names during elaboration a module or paramset defined in the Verilog-AMS
// will ALWAYS be selected in favor of a SPICE primitive, model, or subcircuit
// using exactly the same name." And for the built-in case: "In case of a SPICE
// primitive which is always available in the Verilog-AMS simulator, a
// Verilog-AMS module or paramset whose name exactly matches that of the
// primitive will be used in module instantiations."
//
// The module below is named `resistor`, exactly Table E.1's primitive, and it
// declares one parameter, `g` — not the primitive's `r, tc1, tc2`. The
// instance then overrides `r`:
//
//   * E.3.3 picks the Verilog-AMS `resistor`, so `.r` must name one of ITS
//     parameters, and it has none called `r` — §6.3.3: "The name shall be the
//     name specified in the instantiated module." Error.
//   * A tool that let the shipped primitive win the name race would find
//     Table E.1's `r` and compile the file.
//
// So the refusal is the evidence of which definition was selected — the
// rejection-side twin of h04_10 and spice_name_shadow.va, which show the
// Verilog-AMS body's VALUE. `#(.g(1m))` compiles (probed). The optional
// "may issue a warning" is not asserted either way.
//
// The top module is written first so it is the one elaborated.
//
// VerA reports E0907 "override names no parameter of the module".
//
//! lrm E.3.3
//! lrm 6.3.3
//! lrm 6.3.3:1
//! reject-only E0907
//! reject `r` is not a parameter of `resistor`
//! neighbour spice_name_shadow.va
`include "disciplines.vams"
module e33_shadow_top(p, n);
  inout p, n; electrical p, n;
  resistor #(.r(1k)) r1(p, n);           // illegal: the user `resistor` has no `r`
endmodule

module resistor(a, b);
  inout a, b; electrical a, b;
  parameter real g = 1.0e-3;
  analog I(a, b) <+ g * V(a, b);
endmodule
