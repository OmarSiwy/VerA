// DEBT — this rejection is NOT conformance.
// The LRM permits what VerA refuses here. The substrings below record
// CURRENT behavior so the suite stays green on it; they do not claim it
// is right. `zig build ledger` counts this rule against VerA.
//
// VAMS-E.3-02  (annex-e-spice.html)
// The default discipline of the ports for these primitives shall be electrical.
// VAMS-E.3-03  (annex-e-spice.html)
// [The default discipline of the ports for these primitives shall be electrical and] their descriptions shall be inout.
// VAMS-E.3.2.1-05  (annex-e-spice.html)
// This attribute shall only apply to analog primitives or the ports of analog primitives.
// VAMS-E.3.2.1-06  (annex-e-spice.html)
// [This attribute shall only apply to analog primitives...;] for other modules as well as the ports of all other modules it shall be ignored.
// … and 3 more rule(s); see tests/lrm-rules/
//
//! reject module instantiation is not supported
// EXPECT: error -- attributes are parsed, primitive instantiation remains unsupported.
module annex_e_primitive_discipline(p, n);
  inout p, n; electrical p, n;
  (* port_discipline="rotational" *) resistor #(.r(1k)) r1(p, n);
endmodule
