// §9.17.3 `$limit`'s seed argument on a BSIM3-shaped PMOS: the seed is in
// the frame of the site's sign argument, raw = type * seed.
//
// ngspice BSIM3 MODEINITJCT (b3ld.c:202-214) starts at different branch
// values from MOS1, in the device frame:
//
//     vbs = 0.0;
//     vgs = model->BSIM3type * here->BSIM3vth0 + 0.1;
//     vds = 0.1;
//
// §9.17.3 names the arguments each string "requires" and lets "Simulators
// ... support other built-in functions"; VerA reads the algorithm's
// arguments, then the sign, then the seed (limit_seed_mos1_initjct.va).
//
// U = d, g, s, b, di, si; the lowest seeded port is g, so g = 0. type = -1,
// vth0 = -0.6, so vgs = (-1)(-0.6) + 0.1 = 0.7:
//   type (g - si)  = 0.7  ->  si = 0.7
//   type (di - si) = 0.1  ->  di = 0.6
//   type (b - si)  = 0    ->  b  = 0.7
// The seed reads the card (vth0), which `seed` may: it runs before any
// solve, but after the card is set.
// At the bias the model evaluates, §9.17.3's "When the simulator has
// converged, the return value of the $limit() function is the value of the
// access function reference, within appropriate tolerances" is the CHECK
// (1e-6: Annex D's `nature Voltage` abstol, as limit_fet.va argues).
//! lrm 9.17.3
//! bias V(g) = 0.0, V(si) = 0.7, V(di) = 0.6, V(b) = 0.7
//! print none
//! seed V(g) = 0.0, V(si) = 0.7, V(di) = 0.6, V(b) = 0.7
`include "check.vh"
module limit_seed_bsim3_pmos_initjct(d, g, s, b);
  inout d, g, s, b; electrical d, g, s, b, di, si;
  parameter real type = -1.0, vth0 = -0.6, vt = 0.025, vcrit = 0.6;
  real vgs, vgd, vds, vbs, vbd;
  analog begin
    vgs = type * $limit(V(g, si), "fetlimds", type * vth0, type, type * vth0 + 0.1);
    vgd = type * $limit(V(g, di), "fetlimds", type * vth0, type);
    vds = type * $limit(V(di, si), "limvds", type, 0.1);
    vbs = type * $limit(V(b, si), "pnjlimds", vt, vcrit, type, 0.0);
    vbd = type * $limit(V(b, di), "pnjlimds", vt, vcrit, type);
    I(d, di) <+ V(d, di) / 10.0;
    I(s, si) <+ V(s, si) / 10.0;
    I(di, si) <+ type * 1e-3 * (vds + 0.1 * (vgs + vgd));
    I(b, si) <+ type * 1e-14 * (limexp(vbs / vt) - 1.0);
    I(b, di) <+ type * 1e-14 * (limexp(vbd / vt) - 1.0);
    `CHECK("$limit returns its access function at the answer", vgs, 0.7, 1e-6);
  end
endmodule
