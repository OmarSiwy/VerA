//! reject module instantiation is not supported
// EXPECT: error -- SPICE objects require hierarchy/SPICE elaboration.
module annex_e_spice_subcircuit_unsupported(p, n);
  inout p, n; electrical p, n;
  ecpOsc osc1(p, n);
endmodule
