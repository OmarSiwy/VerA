// H04 — a `.MODEL` card's parameter VALUE has to reach the Table E.1 parameter
// of the same name, or the netlist describes one circuit and the simulator
// solves another.
//
// THE CLAUSE. E.2.2.1 "Accessing SPICE models":
//
//     "The ports and parameters of the bjt are determined by the bjt primitive
//      itself and not by the model statement for the bjt."
//
// Read carefully, that sentence is about WHICH parameters EXIST — the interface
// is the primitive's, not the card's. It is not a licence to discard the values
// the card assigns to parameters the primitive does declare. Table E.1's
// `resistor` row declares exactly `r, tc1, tc2`; a `.MODEL RMOD R R=2000` card
// names one of those three and gives it a value. If that value is dropped, the
// instance silently takes the primitive's own default instead, and the annex's
// whole reason for existing — E.1's "there is a huge legacy of SPICE netlists"
// that Verilog-AMS must be able to reference — is defeated by a resistor that
// is 1 ohm when the netlist said two thousand.
//
// Table E.1 `resistor`, ports p, n, parameters r, tc1, tc2:
//
//     V = I * r * (1 + tc1*T + tc2*T^2)
//
// THE DIGITS, BY HAND. `//! bias` holds a at 1.0 V and b at 0.0 V, so the
// potential across the instance's port branch is exactly 1.0 V. The card gives
// no tc1 and no tc2, so Table E.1's temperature polynomial is 1 + 0 + 0 = 1
// exactly at every temperature and the row collapses to V = I*r. Inverting:
//
//     I(p, n) = V / r = 1.0 / 2000 = 5.0e-4 A
//
// exactly representable concerns aside, 1e-15 relative is ~4 ulp — the freedom
// a tool has to stamp a conductance rather than divide (the same tolerance
// tests/fixtures/annex_e_spice/spice_passive_primitives.va uses for the
// identical row).
//
// The first check is the parameter itself: E.2.2.1 makes the INSTANCE's
// parameters the primitive's, so `r1.r` is §6.7.1 hierarchical access ("access
// of parameters can be done hierarchically") to Table E.1's `r`, and it must
// read the card's 2000 and not the prelude's default. Two checks rather than
// one because they fail differently: a tool that never declared `r` on the
// model-derived module fails to compile at the first, and one that declares it
// but leaves the card's value behind fails the second with got=1.0.
//
// WHAT VerA DOES TODAY. `lib/frontend/spice_cards.zig` synthesizes
// `module rmod(p, n); inout p, n; electrical p, n; resistor prim(p, n);
// endmodule` — no parameter list at all, and a comment at the site saying the
// card's parameters "are NOT passed". So `r1.r` does not resolve and the branch
// carries 1.0 A.
//
// NO SPICE SUFFIX IS EXERCISED HERE. `R=2000` is a bare decimal on purpose, so
// that this fixture fails for exactly one reason. The annex's own `10K`
// spelling is fixture 02.
//
//! lrm E.2.2.1
//! lrm E.3
//! lrm E.1
//! lrm 6.7.1
//! lrm 6.7.1:1
//! lrm E.4.2
//! lrm E.4.2:1
//! bias V(a) = 1.0, V(b) = 0.0
//! spice .MODEL RMOD R R=2000
`include "check.vh"
module h04_model_card_r(a, b);
  inout a, b; electrical a, b;
  rmod r1(a, b);
  analog begin
    `CHECKX("E.2.2.1: the instance's parameters are the resistor primitive's, and the card set r",
            r1.r, 2000.0);
    `CHECKR("Table E.1: I = V/r = 1.0/2000 with tc1 = tc2 = 0",
            I(r1.p, r1.n), 5.0e-4, 1e-15);
  end
endmodule
