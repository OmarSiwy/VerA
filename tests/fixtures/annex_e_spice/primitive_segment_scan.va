// E.3.2.2's scan, which is the half of it no declaration can stand in for:
//
//     If no attribute exists on the instance of an analog primitive, then the
//     discipline may be determined by the disciplines of other instances
//     connected to the same net segment. The disciplines of the vpiLoConn of all
//     other instances on the net segment shall be evaluated to determine if they
//     are of domain continuous and compatible with each other. If they are, then
//     the discipline of the analog primitive shall be set to the same discipline.
//
// THE CIRCUIT is primitive_segment_discipline.va's with the declarations taken
// out:
//
//     (* port_discipline="rotational" *) resistor #(.r(1k)) r1(s1, s2);
//                                        resistor #(.r(2k)) r2(s1, s2);
//
// `s1` and `s2` occur nowhere but in those two instances, so nothing declares a
// discipline for the segment; `r1`'s attribute (E.3.2.1) is the only place one
// can come from. `r2` has no attribute of its own, so it is the instance the
// clause above is about, and its discipline is the discipline of `r1`'s
// vpiLoConn — `s2`, whose discipline E.3.2.1 has already fixed at rotational.
//
// WHY THE SENTENCE IS NOT OPTIONAL DESPITE THE "may". The first sentence is
// worded as permission, and a tool could read it as one — except that the last
// sentence makes `electrical` the fallback "if there are no continuous
// disciplines defined on the net segment", and here there ARE: r1's ports are
// rotational by its attribute. So a tool that skips the scan has no licensed
// answer left: it cannot default to electrical, since the condition for the
// default is false, and the third sentence says the discipline "shall be set to
// the same discipline" once the evaluation finds continuous, compatible ones.
// The only readings of a well-formed file are rotational or an error, and an
// error is not a reading: nothing here is ambiguous, and §3.11's error is for
// disciplines that are incompatible, which these are not.
//
// WHAT USED TO FAIL. VerA gave an undeclared net the primitive's own
// `electrical` as it bound the port, before any attribute was consulted, so
// E.3.2.2's scan never ran (E0501: `Theta` is not an access function of `s1`,
// measured 2026-09-20). Elaboration now binds every attributed primitive port
// of a level first and a primitive's `electrical` only to a net nothing else
// resolved (2026-09-24). The bias sets the effort of `s1` to 2.0 and `s2` to
// 0.0, so the pair differs by 2.0 in whichever accessor the segment ends up
// with, and `Theta` compiling at all is the scan's evidence.
//
//! lrm E.3.2.2
//! lrm E.3.2.2:1
//! lrm E.3.2.2:2
//! lrm E.3.2.2:3
//! lrm E.3.2
//! lrm E.3.2.1
//! lrm 3.8
//! lrm 6.7.1
//! lrm 6.5.7.2
//! lrm 6.5.7.2:1000
//! lrm 6.7.1:1
//! bias s1 = 2.0, s2 = 0.0
//! checks 2
`include "check.vh"
module annex_e_primitive_segment_scan;
  (* port_discipline="rotational" *) resistor #(.r(1k)) r1(s1, s2);
  resistor #(.r(2k)) r2(s1, s2);
  analog begin
    `CHECKX("r2 keeps its 2k", r2.r, 2000.0);
    // r1's attribute is the segment's only discipline; r2's ports must take it.
    // Table E.1's V = I*r in rotational reads Theta = Tau*r, and the bias puts
    // 2.0 across the pair.
    `CHECKX("the segment's discipline reaches r2", Theta(r2.p, r2.n), 2.0);
  end
endmodule
