// The analog design p04_06_analog_objects.c walks (LRM 11.6.2, 11.6.5,
// 11.6.6, 11.6.7), and a fixture in its own right for the one language fact
// the walk depends on.
//
// WHAT THE C APPLICATION READS. Two natures and a nature DERIVED from one of
// them (§3.6.1.1 `nature p04_fine_volt : p04_volt`), and two disciplines over
// them; three nodes of p04_elec and one of p04_fine; two named branches
// between p04_elec nodes. Every VPI answer about them is asserted from C.
//
// WHAT THIS FILE ASSERTS ON ITS OWN, which is §5.4.1: the potential of a
// branch is the difference of the potentials of its nodes. `b1` is (p, mid)
// and `b2` is (mid, n), so V(b1) + V(b2) = V(p, mid) + V(mid, n) = V(p, n)
// whatever `mid` holds — 0.75 - 0.125 = 0.625 under the bias. That is an
// identity of the probes, not a solution, so it is checked to rounding (two
// subtractions of doubles need not be bit-exact) rather than against a
// value mid would have to converge to.

// `$p04_tap(Vp(b1), 2.5)` is a user-defined analog system task call the C
// application registers (§12.32) and then finds in the object model
// (§11.6.16). Nothing registers it when this file runs as a fixture; the
// call then compiles and does nothing, as
// ch12_vpi_routines/01_analog_systf_resistor_call.va pins for $resistor.
//
// The access functions are the file's own natures', `Vp` and `Ip`: a
// derived nature inherits its parent's access (§3.6.1.1), so p04_fine's
// potential is read with `Vp` too.

//! lrm 5.4.1
//! bias V(p) = 0.75, V(n) = 0.125
`include "check.vh"

nature p04_volt;
  units = "V";
  access = Vp;
  abstol = 1e-6;
endnature

nature p04_amp;
  units = "A";
  access = Ip;
  abstol = 1e-12;
endnature

nature p04_fine_volt : p04_volt;
  abstol = 1e-9;
endnature

discipline p04_elec;
  potential p04_volt;
  flow p04_amp;
enddiscipline

discipline p04_fine;
  potential p04_fine_volt;
  flow p04_amp;
enddiscipline

module p04_analog(p, n);
  inout p, n;
  p04_elec p, n;
  p04_elec mid;
  p04_fine f;
  branch (p, mid) b1;
  branch (mid, n) b2;
  analog begin
    `CHECKEQ("the two branches sum to V(p, n)", Vp(b1) + Vp(b2), Vp(p, n), 1e-15);
    `CHECK("which is 0.75 - 0.125", Vp(p, n), 0.625, 1e-15);
    $p04_tap(Vp(b1), 2.5);
    Ip(b1) <+ Vp(b1) / 1k;
    Ip(b2) <+ Vp(b2) / 1k;
    Ip(f) <+ Vp(f) / 1k;
  end
endmodule
