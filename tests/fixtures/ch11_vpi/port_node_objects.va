// Source-audit correction: this HDL-only fixture does not execute VPI.
// Chapter 11's API and object model are exercised by the `.c` fixtures in
// build.zig's `vpi_runs`; only language clauses are credited here.
// §11.6.4/11.6.5 port and node objects: a port has a direction, and each port
// reaches one node. §6.5.2.2 is the clause that declares that direction (an
// earlier revision cited §3.5, which is Genvars), and the direction does not
// hide the node: the node behind an `input` port still carries a potential a
// probe can read.
//
// Three biases, all exact in binary: V(p) = 0.875, V(n) = 0.125, V(sense) =
// 0.625. So V(sense,n) = 0.5 while V(p,n) = 0.75. Two distinct numbers, so
// binding `sense` to the wrong node fails one of them.
//
//! lrm 6.5.2.2
//! bias V(p) = 0.875, V(n) = 0.125, V(sense) = 0.625
`include "check.vh"
module ch11_port_node_objects(p, n, sense);
  input sense;
  inout p, n;
  electrical p, n, sense;
  analog begin
    `CHECKX("the input port's node is probed, not the inout pair", V(sense, n), 0.5);
    `CHECKX("the inout pair is a different node pair", V(p, n), 0.75);
    I(p,n) <+ V(sense,n);
  end
endmodule
