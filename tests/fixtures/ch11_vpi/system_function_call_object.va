// Source-audit correction: this HDL-only fixture does not execute VPI.
// Chapter 11's API and object model are exercised by the `.c` fixtures in
// build.zig's `vpi_runs`; only language clauses are credited here.
// §11.6.16 system FUNCTION call object. The construct is not the one 05 uses:
// §2.8.3 Syntax 2-3 separates them,
//
//   analog_system_task_enable   ::= analog_system_task_identifier [ (...) ] ;
//   analog_system_function_call ::= analog_system_function_identifier [ (...) ]
//
// the first a statement (from A.6.9), the second an OPERAND (from A.8.2). A
// system function call therefore has to appear inside an expression and yield a
// value, which is what §11.6.16 gives the class as `-> value` and
// `-> sys func type — int: vpiSysFuncType`.
//
// An earlier revision wrote `$fixture_vpi_function(V(p,n));` standing alone as
// a statement. That is grammatically an analog_system_task_enable, identical in
// construct to 05, so it tested nothing a function call has; and the name was
// registered nowhere, which §2.8.3's five-place enumeration neither requires a
// compiler to accept nor to reject — a compiler that diagnosed it failed the
// fixture. This one calls $mfactor, which §9.18 defines as a hierarchical
// parameter system function returning a real, Table 9-29 fixing its top-level
// value at 1.0 when no instance override exists (nothing instantiates this
// module, so 1.0 is the resolved value).
//
// 1.0 is exact, and it sits in operand position twice: alone, and multiplying
// the probe. At V(p)=1.5, V(n)=0.25 the branch potential is 1.25 V — dyadic —
// so the scaled current is 1.0 * 1.25 = 1.25 exactly. A compiler that parsed
// the call as a valueless statement cannot compile line 2 of the checks at all,
// and one that typed it integer-zero answers 0.0.
//
// 20 is this object's other half: $temperature, off its default, pins that the
// returned value is a real the language declares rather than a rounded int.
//
// THE RESIDUAL DOES NOT CARRY THE CALL, and that is deliberate. It used to read
// `I(p,n) <+ $mfactor * V(p,n);`, which is §6.3.6's `badres` misuse letter for
// letter: a flow contribution explicitly multiplied by $mfactor is scaled by it
// twice, §6.3.6 says the simulator generates an error for it, and
// ch06_hierarchy/mfactor_double_scaling_rejected.va pins that diagnostic
// (E0912). Nothing about §11.6.16 needed the contribution to carry the call —
// operand position is what the two checks assert, and both of their wants are
// unchanged. The contribution is here only to give the device a residual.
//
//! lrm 6.3.6
//! lrm 2.8.3
//! lrm 9.18
//! bias V(p) = 1.5, V(n) = 0.25
`include "check.vh"
module ch11_system_function_call_object(p, n);
  inout p, n; electrical p, n;
  analog begin
    `CHECKX("a system function call is an operand with a value (9.18)", $mfactor, 1.0);
    `CHECKX("and it composes into the enclosing expression", $mfactor * V(p,n), 1.25);
    I(p,n) <+ V(p,n);
  end
endmodule
