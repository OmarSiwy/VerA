// Source-audit correction: this HDL-only fixture does not execute VPI.
// Chapter 11's API and object model are exercised by the `.c` fixtures in
// build.zig's `vpi_runs`; only language clauses are credited here.
// §11.6.7 quantity objects: a branch carries BOTH a potential quantity and a
// flow quantity, each reachable from the branch and each with a value.
//
// §5.4.1 gives V(path) = V(p) - V(n). Whether I(path) is a free unknown depends
// on the source kind: §5.4.2.2 makes a branch "a flow source if the branch flow
// is specified", and on a flow source the flow is fixed by the contribution
// itself, not solved for. `path` is therefore driven as a POTENTIAL source
// here, the case §5.6.3 describes — "the assignment to V(res) makes res a
// potential source branch and I(res) simply accesses the optional flow probe
// built into the potential source branch" — so its flow is a genuine unknown,
// held at 2 mA. (An earlier revision contributed `I(path) <+ v_value/1k` and
// still wanted the swept 2 mA, which §5.4.2.2 rules out: on that branch the
// flow is 0.75/1000 = 7.5e-4. Its dead `+ i_value*0.0` term existed only to
// make the probed value appear somewhere.)
//
// V(p) = 0.875, V(n) = 0.125 are exact in binary, so v_value = 0.75 V while
// i_value = 2e-3 A. Two quantities, two different numbers: confuse them and both
// assertions fail. The source relation 375*i_value = 0.75 = v_value, so the
// operating point satisfies the model rather than sitting off it. (The flow
// unknown is `flow(p,n)`, whose punctuation codegen escapes as Z28/Z2c/Z29 —
// `sweep` and not `bias` because a bias line splits on commas.)
//
// The two strengths differ on purpose: 0.75 is a difference of two dyadic
// biases and is exact to the last bit, so it is CHECKX; 0.002 is not dyadic and
// reaches the probe through the sweep, so it keeps an absolute tolerance of
// 1e-18, about 2 ulp at 2e-3.
//
//! lrm 5.4.1
//! lrm 5.4.2.2
//! bias V(p) = 0.875, V(n) = 0.125
//! sweep flowZ28pZ2cnZ29 = 0.002
`include "check.vh"
module ch11_quantity_objects(p, n);
  inout p, n; electrical p, n;
  branch (p,n) path;
  real v_value, i_value;
  analog begin
    v_value = V(path);
    i_value = I(path);
    `CHECKX("the branch's potential quantity", v_value, 0.75);
    `CHECK("the branch's flow quantity", i_value, 2.0e-3, 1e-18);
    `CHECKX("the potential source relation holds at that point", 375.0*i_value, 0.75);
    V(path) <+ 375.0 * i_value;
  end
endmodule
