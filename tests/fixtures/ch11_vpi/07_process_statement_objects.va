// §11.6.21/11.6.22/11.6.23 process, named block, for-loop, if-else and case
// objects. What the fixture can pin is the §5.2 execution the object model
// describes: the loop trip count, which arm of the if runs, and which case item
// matches the counter the loop left behind.
//
// V(p) = 0.75, V(n) = 0.25 give V(p,n) = 0.5 exactly. The for loop runs for
// k = 0,1,2 and exits with k = 3, so result = 3*0.5 = 1.5; 1.5 > 0 takes the
// true arm to 2.5; case(3) matches the `3:` item, not `default`, giving 5.5.
// One trip too few is 5.0, the else arm is 3.5, and `default` is 0.0.
//
//! bias V(p) = 0.75, V(n) = 0.25
`include "check.vh"
module ch11_process_statement_objects(p, n);
  inout p, n; electrical p, n;
  integer k;
  real result;
  analog begin : process_block
    result = 0.0;
    for (k=0; k<3; k=k+1) result = result + V(p,n);
    if (result > 0.0) result = result + 1.0;
    else result = result - 1.0;
    case (k)
      3: result = result + 3.0;
      default: result = 0.0;
    endcase
    `CHECKI("the for loop exits one past its bound", k, 3);
    `CHECK("three trips, the true arm, then the matching case item", result, 5.5, 1e-15);
    I(p,n) <+ result;
  end
endmodule
