// Source-audit correction: this HDL-only fixture does not execute VPI.
// Chapter 11's API and object model are exercised by the `.c` fixtures in
// build.zig's `vpi_runs`; only language clauses are credited here.
// §11.6.21/11.6.22/11.6.23 process, named block, for-loop, if-else and case
// objects. What the fixture can pin is the §5.2 execution the object model
// describes: the loop trip count, which arm of the if runs, and which case item
// matches the counter the loop left behind.
//
// V(p) = 0.75, V(n) = 0.25 give V(p,n) = 0.5 exactly. The for loop runs for
// k = 0,1,2 and exits with k = 3, so result = 3*0.5 = 1.5; 1.5 > 0 takes the
// true arm to 2.5; case(3) matches the `3:` item, not `default`, giving 5.5.
//
// The three mutations are separately distinguishable. A trip count off by one
// leaves k at 2 or 4, which the `k` check catches directly and which then falls
// through to `default` for a result of 0.0 either way. Taking the else arm at
// the same three trips gives 1.5 - 1.0 + 3.0 = 3.5. Matching `default` at
// k = 3 gives 0.0. So 5.5 is reachable only by the intended path.
//
//! lrm 5.3.1
//! bias V(p) = 0.75, V(n) = 0.25
`include "check.vh"
module ch11_process_statement_objects(p, n);
  inout p, n; electrical p, n;
  integer k;
  real result;
  analog begin : process_block
    result = 0.0;
    for (k=0; k<3; k=k+1) result = result + V(p,n);
    if (result > 0.0) result = result + 1.0;
    else result = result - 1.0;
    case (k)
      3: result = result + 3.0;
      default: result = 0.0;
    endcase
    `CHECKI("the for loop exits one past its bound", k, 3);
    `CHECKX("three trips, the true arm, then the matching case item", result, 5.5);
    I(p,n) <+ result;
  end
endmodule
