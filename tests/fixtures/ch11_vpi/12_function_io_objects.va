// Source-audit correction: this HDL-only fixture does not execute VPI.
// Chapter 11's API and object model are exercised by the `.c` fixtures in
// build.zig's `vpi_runs`; only language clauses are credited here.
// §11.6.3 io decl objects: a taskfunc reaches its arguments one-to-many, and the
// NOTE there says a function contains an object with the function's own name.
// The Verilog-A rules behind that are §4.7.1 — inputs are copied by value in
// declaration order, and the return travels in the implicit `affine` variable.
//
// V(p) = 0.875, V(n) = 0.125 are both exact in binary, so x = 0.75 and
// gain = 2.0 give affine = 2.0*0.75 + 1.0 = 2.5. Drop the `+ 1.0` and it is 1.5.
//
//! lrm 4.7.1
//! bias V(p) = 0.875, V(n) = 0.125
`include "check.vh"
module ch11_function_io_objects(p, n);
  inout p, n; electrical p, n;
  analog function real affine;
    input x, gain; real x, gain;
    affine = gain * x + 1.0;
  endfunction
  analog begin
    `CHECKX("both declared inputs bind, and the named result returns", affine(V(p,n), 2.0), 2.5);
    I(p,n) <+ affine(V(p,n), 2.0);
  end
endmodule
