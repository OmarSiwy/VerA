// Source-audit correction: this HDL-only fixture does not execute VPI.
// Chapter 11's API and object model are exercised by the `.c` fixtures in
// build.zig's `vpi_runs`; only language clauses are credited here.
// §11.6.12/11.6.10 parameter and variable objects. The language-level facts
// behind them: a parameter is overridable at instantiation (§3.4) and an integer
// variable promotes to real in a mixed-type sum (§4.2.1.3 Arithmetic
// conversion — an earlier revision cited §4.2.5, which is Relational
// operators).
//
// `gain` is overridden 2.0 -> 3.0, and V(p) = 0.75, V(n) = 0.25 give
// V(p,n) = 0.5 exactly, so result = 3.0 * 0.5 = 1.5 and result + mode = 2.5.
// Ignore the override and the numbers become 1.0 and 2.0.
//
//! lrm 3.4
//! lrm 4.2.1.3
//! param gain = 3.0
//! bias V(p) = 0.75, V(n) = 0.25
`include "check.vh"
module ch11_parameters_variables(p, n);
  inout p, n; electrical p, n;
  parameter real gain = 2.0;
  integer mode;
  real result;
  analog begin
    mode = 1;
    result = gain*V(p,n);
    `CHECKX("the parameter override reaches the expression", result, 1.5);
    `CHECKX("the integer variable promotes in the mixed sum", result + mode, 2.5);
    I(p,n) <+ result + mode;
  end
endmodule
