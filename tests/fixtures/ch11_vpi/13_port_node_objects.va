// §11.6.4/11.6.5 port and node objects: a port has a direction, and each port
// reaches one node. §3.5 makes direction on an analog port informational — the
// node behind an `input` port still carries a potential a probe can read.
//
// Three biases, all exact in binary: V(p) = 0.875, V(n) = 0.125, V(sense) =
// 0.625. So V(sense,n) = 0.5 while V(p,n) = 0.75. Two distinct numbers, so
// binding `sense` to the wrong node fails one of them.
//
//! bias V(p) = 0.875, V(n) = 0.125, V(sense) = 0.625
`include "check.vh"
module ch11_port_node_objects(p, n, sense);
  input sense;
  inout p, n;
  electrical p, n, sense;
  analog begin
    `CHECK("the input port's node is probed, not the inout pair", V(sense, n), 0.5, 1e-15);
    `CHECK("the inout pair is a different node pair", V(p, n), 0.75, 1e-15);
    I(p,n) <+ V(sense,n);
  end
endmodule
