// Source-audit correction: this HDL-only fixture does not execute VPI.
// Chapter 11's API and object model are exercised by the `.c` fixtures in
// build.zig's `vpi_runs`; only language clauses are credited here.
// §11.6.20 contrib: the right-hand side of `<+` is an ordinary expression, and
// its `1k` operand is a real constant in scaled notation — Table 2-1 of §2.6.2
// makes the symbol k exactly 1e3, so `1k` is 1000.0 and not 1.0 with a stray
// identifier. At V(p)=1.5, V(n)=0.25 the branch potential is 1.25 V, so the
// contributed flow is 1.25/1000 = 1.25 mA.
//
// Both are exact equalities, on 14's reasoning: 1.25 and 1000.0 are exact
// doubles and IEEE division is correctly rounded, so 1.25/1k is the double
// nearest 0.00125 — which is what the literal 1.25e-3 parses to. Same bits, so
// CHECKX and not a tolerance two ulp wide.
//
//! lrm 2.6.2
//! bias V(p) = 1.5, V(n) = 0.25
`include "check.vh"
module ch11_contribution_object(p, n);
  inout p, n; electrical p, n;
  analog begin
    `CHECKX("the k scale factor is 1e3 (Table 2-1)", 1k, 1000.0);
    `CHECKX("the contributed flow", V(p,n) / 1k, 1.25e-3);
    I(p,n) <+ V(p,n) / 1k;
  end
endmodule
