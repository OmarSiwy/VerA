// Source-audit correction: this HDL-only fixture does not execute VPI.
// Chapter 11's API and object model are exercised by the `.c` fixtures in
// build.zig's `vpi_runs`; only language clauses are credited here.
// §11.6.16 system task call object, on the statement side. §2.8.3 Syntax 2-3
// gives the construct:
//
//   analog_system_task_enable ::=
//     analog_system_task_identifier [ ( [ analog_expression ] {, ...} ) ] ;
//
// a STATEMENT (unlike 06's analog_system_function_call, which is an operand),
// whose arguments are analog expressions evaluated at the call site.
//
// An earlier revision spelled this with an unregistered `$fixture_vpi_task` and
// required the compiler to accept it silently. That is not derivable: §2.8.3
// enumerates the five places a `$name` "can be defined" — IEEE 1364 Clauses
// 17/18, the PLI, Clauses 4 and 9 of this standard, the VPI of Clauses 11/12,
// and software implementations — and a name registered in none of them has no
// clause requiring acceptance OR rejection. A conforming compiler that
// diagnoses it would have failed the fixture. This one calls $display, which
// §9.4.1 Syntax 9-1 lists among the display tasks legal in an analog block and
// gives "the same capabilities as $strobe", so the claim survives any compiler.
//
// What is asserted is §5.3.1 ordering across the call, with the task taking a
// live analog expression as an argument: `seq` is 1 before and +2 after, so a
// compiler that stopped at, reordered around, or swallowed the block tail at
// the task enable leaves 1 or 0 instead of 3. At V(p)=1.5, V(n)=0.25 the branch
// potential is 1.25 V — dyadic, hence exact — on both sides of the call.
//
//! lrm 2.8.3
//! lrm 9.4.1
//! lrm 5.3.1
//! bias V(p) = 1.5, V(n) = 0.25
`include "check.vh"
module ch11_system_task_call_object(p, n);
  inout p, n; electrical p, n;
  integer seq;
  analog begin
    seq = 1;
    $display("task enable with an analog expression argument: %g", V(p,n));
    seq = seq + 2;
    `CHECKI("the block continues past a system task enable", seq, 3);
    `CHECKX("and the probe is unchanged by it", V(p,n), 1.25);
    I(p,n) <+ V(p,n);
  end
endmodule
