//! reject E0512
//! reject vpi_get
// EXPECT: error
module ch11_c_vpi_get_not_va(p, n);
  inout p, n; electrical p, n;
  analog I(p,n) <+ vpi_get(1, 0);
endmodule
