// Source-audit correction: this HDL-only fixture does not execute VPI.
// Chapter 11 API/object-model obligations remain open in
// docs/conformance-ch11-review-draft.md; only language clauses are credited.
// §11.6.16 function call object. The Verilog-A rule it models is §4.7.1: an
// analog user-defined function returns through the implicit variable that shares
// its name, so `square = x*x` is the return value.
//
// V(p) = 1.5 against n at its default 0 makes x = 1.5, and 1.5*1.5 = 2.25 is
// exact in binary.
//
//! lrm 4.7.1
//! bias V(p) = 1.5
`include "check.vh"
module ch11_function_call_object(p, n);
  inout p, n; electrical p, n;
  analog function real square;
    input x; real x;
    begin square = x*x; end
  endfunction
  analog begin
    `CHECKX("the call returns the value assigned to the function name", square(V(p,n)), 2.25);
    I(p,n) <+ square(V(p,n));
  end
endmodule
