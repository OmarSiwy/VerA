// Source-audit correction: this HDL-only fixture does not execute VPI.
// Chapter 11's API and object model are exercised by the `.c` fixtures in
// build.zig's `vpi_runs`; only language clauses are credited here.
// §11.6.22 assignment and §5.9.2 for: the loop tests `k < 3` before each pass,
// so the body runs for k = 0, 1, 2 — three passes — and leaves k at the first
// value that failed the test, 3. Each pass adds the branch potential to the
// accumulator, so at V(p)=1.5, V(n)=0.25 (1.25 V) the total is 3 * 1.25 = 3.75
// exactly. An off-by-one would give 2.5 or 5.0.
//
//! lrm 5.9.2
//! bias V(p) = 1.5, V(n) = 0.25
`include "check.vh"
module ch11_assignment_loop_objects(p, n);
  inout p, n; electrical p, n;
  integer k; real total;
  analog begin
    total = 0.0;
    for (k = 0; k < 3; k = k + 1) total = total + V(p,n);
    `CHECKI("the loop variable stops at the first failing test", k, 3);
    `CHECKX("three accumulations of the probe", total, 3.75);
    I(p,n) <+ total;
  end
endmodule
