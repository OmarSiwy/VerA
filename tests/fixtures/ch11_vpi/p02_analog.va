// The analog design 11_systf_analog.c and 12_systf_domains.c register against.
//
// Shaped after LRM 12.22.2's own $resistor() example — a user-defined analog
// system TASK whose first argument is an output, second is the potential it
// depends on, and third is the resistance — because that example is the only
// normative code the LRM prints for derivtf() and vpi_handle_multi(). The name
// is $p02_resistor, not $resistor, so this file cannot be confused with the
// already-green acceptance fixture at
// tests/fixtures/ch12_vpi_routines/01_analog_systf_resistor_call.va, which
// pins what the COMPILER does with an unregistered call. This one exists to be
// run with a C application that actually registers it.
//
// TWO CALL SITES, with two different resistances, so:
//
//   - the compiletf and derivtf counts (per call site: 2) are distinguishable
//     from the calltf count (per evaluation, and an analog solver evaluates a
//     contribution as many times as its Newton iteration needs);
//   - the value read from the third argument differs per site, so a calltf that
//     cached the first site's argument handles is visible.
//
// LRM 2.6.2 (Real constants), Table 2-1 "Scaled Symbols and notation": the
// symbol "K, k" has the value 1e3, and 2.6.2's own example list prints `7k` as
// a valid real constant. So `1k` is 1e3 and `2k` is 2e3, and the two resistances
// are exactly 1000.0 and 2000.0 and the two conductances the application
// computes are exactly 1.0/1000.0 == 0.001 and 1.0/2000.0 == 0.0005 — both
// comparisons hold in binary64 without a tolerance, because IEEE division is
// correctly rounded and 0.001 and 0.0005 parse to those same rounded values.
//
// WHAT THIS FILE ASSERTS ON ITS OWN. Everything about $p02_resistor belongs to
// 11_systf_analog.c: with no application registered, §12.22's systf is not
// called at all, `curr1` and `curr2` keep their initial values, and a `CHECK`
// on either would be pinning what happens when nothing happens.
//
// What is this file's own is the THIRD ARGUMENT — the number the application
// reads back and the reason the two call sites are distinguishable in the first
// place. §2.6.2 Table 2-1 gives the scaled symbol "K, k" the value 1e3, and
// §2.6.2's own list prints `7k` among the valid real constants, so `1k` and
// `2k` are exactly 1000.0 and 2000.0 and nothing else. `CHECKX` and not `CHECK`
// because both are integral powers-of-ten times a small integer and land on an
// exact binary64 value; a tolerance here would hide a scale factor that was off
// by a thousand.
//
// The two conductances are asserted in the same exact form, because they are
// what 11_systf_analog.c compares its derivtf output against: IEEE division is
// correctly rounded, and 0.001 and 0.0005 are the correctly-rounded quotients,
// so the equality is the clause's arithmetic and not a coincidence of
// formatting. A `1k` that had been lowered as 1024, or a `2k` that shared
// storage with `1k`, fails these four lines before the C application is ever
// linked.

//! lrm 2.6.2
//! lrm 12.22.2
//! bias V(p) = 1.0
//! bias V(n) = 0.0
`include "check.vh"
module p02_analog(p, n);
  inout p, n;
  electrical p, n;

  parameter real r1 = 1k;
  parameter real r2 = 2k;

  real curr1;
  real curr2;

  analog begin
    `CHECKX("the scaled symbol k is 1e3, so 1k is exactly 1000.0", r1, 1000.0);
    `CHECKX("and 2k is exactly 2000.0", r2, 2000.0);
    `CHECKX("the conductance the application computes for the first call site",
        1.0 / r1, 0.001);
    `CHECKX("and for the second, which must not share the first's storage",
        1.0 / r2, 0.0005);

    $p02_resistor(curr1, V(p, n), r1);
    $p02_resistor(curr2, V(p, n), r2);
    I(p, n) <+ curr1 + curr2;
  end
endmodule
