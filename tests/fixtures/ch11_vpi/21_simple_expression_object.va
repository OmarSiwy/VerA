// Source-audit correction: this HDL-only fixture does not execute VPI.
// Chapter 11's API and object model are exercised by the `.c` fixtures in
// build.zig's `vpi_runs`; only language clauses are credited here.
// §11.6.18 simple expressions: the class is the LEAF, name-bearing operands —
// nets, regs, variables, parameter, memory, var select, memory word — each
// carrying `-> name` (vpiName, vpiFullName). `gain` is one of them, a
// parameter. What §11.6.18 is NOT is the operator node above it: an earlier
// revision labelled `gain + 1.0` the simple expr, but that is an operation over
// a simple expr and a constant, which is §11.6.19's `expr` reaching its
// operands through vpiOperand. Both objects appear here, in that nesting.
//
// §3.4 pins the leaf at its declared 2.0 default, so the operation over it is
// 3.0 at every operating point — neither operand changes during the solve. At
// V(p)=1.5, V(n)=0.25 the branch potential is 1.25 V and the current is
// 3.0 * 1.25 = 3.75 exactly (every value dyadic).
//
//! lrm 3.4
//! bias V(p) = 1.5, V(n) = 0.25
`include "check.vh"
module ch11_simple_expression_object(p, n);
  inout p, n; electrical p, n;
  parameter real gain = 2.0;
  analog begin
    `CHECKX("the simple-expr leaf is the parameter itself", gain, 2.0);
    `CHECKX("the operation above it (11.6.19) folds to a constant", gain + 1.0, 3.0);
    `CHECKX("the contributed flow", (gain + 1.0) * V(p,n), 3.75);
    I(p,n) <+ (gain + 1.0) * V(p,n);
  end
endmodule
