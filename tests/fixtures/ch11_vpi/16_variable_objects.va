// Source-audit correction: this HDL-only fixture does not execute VPI.
// Chapter 11's API and object model are exercised by the `.c` fixtures in
// build.zig's `vpi_runs`; only language clauses are credited here.
// §11.6.10 variables: an integer variable and a real variable are distinct
// objects, and §4.2.1.3 says an operator with one real operand converts the
// other, so `count * V(p,n)` is real arithmetic on 2 and the branch potential.
// At V(p)=1.5, V(n)=0.25 the branch potential is 1.25 V, so value = 2 * 1.25 =
// 2.5 exactly (every term is a dyadic rational). Truncating the product to the
// integer type of `count` would leave 2.0.
//
//! lrm 4.2.1.3
//! lrm 4.2.1.3:1000
//! bias V(p) = 1.5, V(n) = 0.25
`include "check.vh"
module ch11_variable_objects(p, n);
  inout p, n; electrical p, n;
  integer count;
  real value;
  analog begin
    count = 2;
    value = count * V(p,n);
    `CHECKI("the integer variable holds what was assigned to it", count, 2);
    `CHECKX("integer * real is real arithmetic (4.2.1.3)", value, 2.5);
    I(p,n) <+ value;
  end
endmodule
