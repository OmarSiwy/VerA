// Source-audit correction: this HDL-only fixture does not execute VPI.
// Chapter 11's API and object model are exercised by the `.c` fixtures in
// build.zig's `vpi_runs`; only language clauses are credited here.
// §11.6.25 callback: the class relates a callback to the `stmt` it fires, and
// §11.2.1 says "VPI callbacks shall be registered ... with vpi_register_cb()"
// — from C. There is no Verilog-A spelling that registers one, so the closest
// thing this chapter can pin in the language is the other kind of
// simulator-invoked call site: a statement the analog kernel runs when a global
// event occurs, rather than when control reaches it in program order.
//
// An earlier revision called an unregistered `$fixture_value_change_callback`
// and required silent acceptance. §2.8.3 enumerates the five places a `$name`
// "can be defined" and that name is in none of them, so no clause requires a
// compiler to accept it — a compiler that diagnosed the unknown system task
// failed the fixture. §12.32's compiletf hook is where an APPLICATION refuses a
// name, which says nothing about what a compiler must do with no application
// present. The claim has been moved onto a construct the LRM does define.
//
// §5.10.2 makes `initial_step` a global event generated on the FIRST point of
// an analysis, and with no analysis list it is active in every analysis. This
// testbench runs one dc point, which is that first point, so the guarded
// statement runs: `fired` goes 0 -> 2 (§3.2 starts a real at 0, so a call site
// that never fired is distinguishable). §5.3.1 still runs the block in order
// around it, which `seq` pins: 1 before, +2 after, giving 3.
//
// At V(p)=0.75, V(n)=0.25 the branch potential is 0.5 V — both biases are exact
// in binary, so exact equality is the right strength, and the callback-driven
// value 2.0 and the probe 0.5 are two different numbers.
//
//! lrm 5.10.2
//! lrm 5.3.1
//! bias V(p) = 0.75, V(n) = 0.25
`include "check.vh"
module ch11_callback_call_site(p, n);
  inout p, n; electrical p, n;
  integer seq;
  real fired;
  analog begin
    seq = 1;
    @(initial_step) fired = 2.0;
    seq = seq + 2;
    `CHECKX("the event-driven call site ran on the first analysis point", fired, 2.0);
    `CHECKI("and the block continues past it in order", seq, 3);
    `CHECKX("the probe is unchanged by it", V(p,n), 0.5);
    I(p,n) <+ V(p,n);
  end
endmodule
