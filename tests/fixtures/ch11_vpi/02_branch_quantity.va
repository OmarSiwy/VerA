// §11.6.7 quantities: the clause gives Quantities a tagged one-to-one to
// Branches and a double-headed relationship to Contribs — a branch owns a
// POTENTIAL quantity and a FLOW quantity, and they are two different objects.
// The previous revision asserted V(measured)/1000.0, which is the potential
// again (and character-for-character the contribution's own right-hand side),
// so a compiler with no flow quantity at all passed it. This one probes both.
//
// §5.4.1 fixes the potential of `branch (p,n) measured` as V(p) - V(n), and
// §5.4.2 makes I(measured) a probe of the flow THROUGH the branch — an
// independent unknown of the solve, which the testbench holds at 2 mA.
//
// V(p) = 0.75, V(n) = 0.25 are both dyadic, so V(measured) = 0.5 V exactly.
// I(measured) = 2.0e-3 A comes from the swept unknown, not from the potential:
// confuse the two quantities and 0.5 lands where 0.002 is wanted. (The flow
// unknown is `flow(p,n)`, whose punctuation codegen escapes as Z28/Z2c/Z29 —
// `sweep` and not `bias` because a bias line splits on commas.)
//
//! lrm 11.6.7
//! lrm 5.4.1
//! bias V(p) = 0.75, V(n) = 0.25
//! sweep flowZ28pZ2cnZ29 = 0.002
`include "check.vh"
module ch11_branch_quantity(p, n);
  inout p, n; electrical p, n;
  branch (p,n) measured;
  analog begin
    `CHECKX("named branch potential is its node pair", V(measured), 0.5);
    `CHECK("the branch's flow is a second, independent quantity", I(measured), 2.0e-3, 1e-18);
    I(measured) <+ V(measured)/1000.0;
  end
endmodule
