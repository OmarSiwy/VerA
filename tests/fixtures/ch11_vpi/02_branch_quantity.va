// Source-audit correction: this HDL-only fixture does not execute VPI.
// Chapter 11's API and object model are exercised by the `.c` fixtures in
// build.zig's `vpi_runs`; only language clauses are credited here.
// §11.6.7 quantities: the clause gives Quantities a tagged one-to-one to
// Branches and a double-headed relationship to Contribs — a branch owns a
// POTENTIAL quantity and a FLOW quantity, and they are two different objects.
// An earlier revision asserted V(measured)/1000.0, which is the potential again
// (and character-for-character the contribution's own right-hand side), so a
// compiler with no flow quantity at all passed it. This one probes both.
//
// The source kind decides whether the flow is a free unknown, and §5.4.2.2 is
// explicit: a branch "is a potential source if the branch potential is
// specified and is a flow source if the branch flow is specified", and "both
// the potential and the flow of a source branch are accessible in expressions".
// On a FLOW source the flow is fixed by the contribution itself — §5.6.3's dual
// worked example says of `V(res) <+ R*I(res)` that "the assignment to V(res)
// makes res a potential source branch and I(res) simply accesses the optional
// flow probe built into the potential source branch". So the flow is an unknown
// of the solve only on a POTENTIAL source, which is what `measured` is made
// here — the same shape as ch05_analog_behavior/flow_probe.va. A revision that
// contributed `I(measured) <+ V(measured)/1000` and still wanted the swept 2 mA
// asserted a number §5.4.2.2 rules out; on that branch the flow is 5.0e-4.
//
// §5.4.1 fixes the potential of `branch (p,n) measured` as V(p) - V(n).
// V(p) = 0.75, V(n) = 0.25 are dyadic, so V(measured) = 0.5 V exactly, and the
// branch-flow unknown is held at 2 mA. The two quantities read 0.5 and 0.002:
// confuse them and 0.5 lands where 0.002 is wanted. The source relation
// V(measured) <+ 250*I(measured) is satisfied AT that point (250 * 0.002 =
// 0.5), so the operating point is the model's own solution, not a pin off it.
// (The flow unknown is `flow(p,n)`, whose punctuation codegen escapes as
// Z28/Z2c/Z29 — `sweep` and not `bias` because a bias line splits on commas.)
//
//! lrm 5.4.1
//! lrm 5.4.2.2
//! bias V(p) = 0.75, V(n) = 0.25
//! sweep flowZ28pZ2cnZ29 = 0.002
`include "check.vh"
module ch11_branch_quantity(p, n);
  inout p, n; electrical p, n;
  branch (p,n) measured;
  analog begin
    `CHECKX("named branch potential is its node pair", V(measured), 0.5);
    `CHECK("the branch's flow is a second, independent quantity", I(measured), 2.0e-3, 1e-18);
    `CHECKX("the potential source relation holds at that point", 250.0*I(measured), 0.5);
    V(measured) <+ 250.0*I(measured);
  end
endmodule
