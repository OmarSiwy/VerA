// §11.6.7 quantity objects: a branch carries BOTH a potential quantity and a
// flow quantity, each reachable from the branch and each with a value. The
// Verilog-A rules are §5.4.1 (V(path) = V(p) - V(n)) and §5.4.2 (I(path) probes
// the flow through the branch, which the testbench holds at 2 mA).
//
// V(p) = 0.875, V(n) = 0.125 are exact in binary, so v_value = 0.75 V while
// i_value = 2e-3 A. Two quantities, two different numbers: confuse them and both
// assertions fail. (The flow unknown is `flow(p,n)`, whose punctuation codegen
// escapes as Z28/Z2c/Z29 — `sweep` and not `bias` because a bias line splits on
// commas.)
//
// The two strengths differ on purpose: 0.75 is a difference of two dyadic
// biases and is exact to the last bit, so it is CHECKX; 0.002 is not dyadic and
// reaches the probe through the sweep, so it keeps an absolute tolerance of
// 1e-18, about 2 ulp at 2e-3.
//
//! bias V(p) = 0.875, V(n) = 0.125
//! sweep flowZ28pZ2cnZ29 = 0.002
`include "check.vh"
module ch11_quantity_objects(p, n);
  inout p, n; electrical p, n;
  branch (p,n) path;
  real v_value, i_value;
  analog begin
    v_value = V(path);
    i_value = I(path);
    `CHECKX("the branch's potential quantity", v_value, 0.75);
    `CHECK("the branch's flow quantity", i_value, 2.0e-3, 1e-18);
    I(path) <+ v_value / 1k + i_value * 0.0;
  end
endmodule
