// Source-audit correction: this HDL-only fixture does not execute VPI.
// Chapter 11's API and object model are exercised by the `.c` fixtures in
// build.zig's `vpi_runs`; only language clauses are credited here.
// §11.6.20 contribs: the class carries `-> flow — bool: vpiFlow`, so the object
// model distinguishes a flow contribution from a potential one. Every other
// contribution in this chapter is `I(...) <+`, which can only ever make that
// boolean true; 23 is the flow representative and this is the potential one.
//
// §5.6.1 "Direct branch contribution statements" is the clause that gives the
// form (§5.6.2 is only its Examples). What the choice of `<+` left-hand side
// decides is the SOURCE KIND, §5.4.2.2: a branch "is a potential source if the
// branch potential is specified and is a flow source if the branch flow is
// specified", and the two are not interchangeable, because on a flow source the
// flow is fixed by the contribution while on a potential source it is a free
// unknown of the solve (§5.6.3: "the assignment to V(res) makes res a potential
// source branch and I(res) simply accesses the optional flow probe built into
// the potential source branch"). That is the one consequence of vpiFlow a
// Verilog-A source can observe, so it is what the third check pins.
//
// Two numbers, both chosen to move under the mutation this fixture guards:
//
//   V(p,n)  §5.4.1 makes the probe the NODE PAIR, 1.5 - 0.5 = 1.0 V, which is
//           deliberately NOT `vsrc`. A compiler that hands back the source
//           value where the probe belongs answers 1.25, and reads the mismatch
//           as 0.0 instead of 0.25. (An earlier revision biased V(n) = 0.25,
//           putting the probe exactly ON 1.25 so both spellings agreed and
//           nothing was discriminated; its first check was a bare §3.4
//           parameter default, which is already 17's claim.)
//
//   I(p,n)  the branch flow. `V(p,n) <+ vsrc` makes this an unknown, held at
//           0.125 A. Rewrite line 1 of the body as `I(p,n) <+ vsrc` — the exact
//           vpiFlow flip — and §5.4.2.2 makes the branch a flow source whose
//           flow IS the source value, 1.25 A. 0.125 and 1.25 are ten times
//           apart, so the two contribution kinds are told apart by a number.
//
// 1.5, 0.5, 1.25 and 0.125 are all dyadic, so every want is exact to the last
// bit. (The flow unknown is `flow(p,n)`, whose punctuation codegen escapes as
// Z28/Z2c/Z29 — `sweep` and not `bias` because a bias line splits on commas.)
//
//! lrm 5.6.1
//! lrm 5.4.1
//! lrm 5.4.2.2
//! lrm 5.4.2.2:1000
//! bias V(p) = 1.5, V(n) = 0.5
//! sweep flowZ28pZ2cnZ29 = 0.125
`include "check.vh"
module ch11_potential_contribution_object(p, n);
  inout p, n; electrical p, n;
  parameter real vsrc = 1.25;
  analog begin
    `CHECKX("the probe reads the node pair, not the driven source value", V(p,n), 1.0);
    `CHECKX("so probing away from the source measures the mismatch", vsrc - V(p,n), 0.25);
    `CHECKX("a potential source leaves its flow a free unknown (5.4.2.2)", I(p,n), 0.125);
    V(p,n) <+ vsrc;
  end
endmodule
