// Source-audit correction: this HDL-only fixture does not execute VPI.
// Chapter 11's API and object model are exercised by the `.c` fixtures in
// build.zig's `vpi_runs`; only language clauses are credited here.
// §11.6.16 task and function call: a SYSTEM TASK call is a tf-call object on
// the statement side. §9.4.1 gives $strobe no return value, so unlike the
// function call of 18 it yields nothing to its enclosing block — it is a
// statement, and §5.3.1 runs the statements of a sequential block in order,
// straight through it.
//
// `seq` pins exactly that: 1 is assigned before the call and 2 added after, so
// a compiler that stopped at, reordered around, or swallowed the block tail at
// the task call leaves 1 (or 0) instead of 3.
//
// The bias check is the second half — at V(p)=1.5, V(n)=0.25 the branch
// potential is 1.25 V and the contribution below still runs on it.
//
// 05, 06 and 08 make the same §5.3.1 ordering claim across an UNREGISTERED
// `$name`, which §2.8.3 makes legal source; this one makes it across $strobe,
// which §9.4.1 defines, so it holds even for a compiler that refuses
// unregistered names.
//
//! lrm 9.4.1
//! bias V(p) = 1.5, V(n) = 0.25
`include "check.vh"
module ch11_system_task_call_object_atomic(p, n);
  inout p, n; electrical p, n;
  integer seq;
  analog begin
    seq = 1;
    $strobe("tf call object");
    seq = seq + 2;
    `CHECKI("the block continues past a valueless system task call", seq, 3);
    `CHECKX("and the probe is unchanged by it", V(p,n), 1.25);
    I(p,n) <+ V(p,n);
  end
endmodule
