// §11.6.16 task and function call: a SYSTEM TASK call is a tf-call object on
// the statement side. §9.4.1 gives $strobe no return value, so unlike the
// function call of 18 it yields nothing to its enclosing block — it is a
// statement, and §5.3.1 runs the statements of a sequential block in order,
// straight through it.
//
// `seq` pins exactly that: 1 is assigned before the call and 2 added after, so
// a compiler that stopped at, reordered around, or swallowed the block tail at
// the task call leaves 1 (or 0) instead of 3.
//
// The bias check is the second half — at V(p)=1.5, V(n)=0.25 the branch
// potential is 1.25 V and the contribution below still runs on it.
//
// This fixture deliberately uses an LRM-DEFINED task. The unregistered VPI
// spelling (`$fixture_vpi_task`) belongs to 05/08/20, which require it to be
// REFUSED; asserting continuation across one of those would bake the opposite
// expectation into the suite.
//
//! bias V(p) = 1.5, V(n) = 0.25
`include "check.vh"
module ch11_system_task_call_object_atomic(p, n);
  inout p, n; electrical p, n;
  integer seq;
  analog begin
    seq = 1;
    $strobe("tf call object");
    seq = seq + 2;
    `CHECKI("the block continues past a valueless system task call", seq, 3);
    `CHECKX("and the probe is unchanged by it", V(p,n), 1.25);
    I(p,n) <+ V(p,n);
  end
endmodule
