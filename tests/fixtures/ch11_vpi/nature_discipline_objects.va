// Source-audit correction: this HDL-only fixture does not execute VPI.
// Chapter 11's API and object model are exercised by the `.c` fixtures in
// build.zig's `vpi_runs`; only language clauses are credited here.
// §11.6.2 nature and discipline objects: a discipline reaches its potential
// nature via vpiPotentialNature and its flow nature via vpiFlowNature. The
// language-level fact is Annex D's `electrical`, whose potential nature Voltage
// carries `access V` and whose flow nature Current carries `access I` — so `V`
// probes a potential difference and `I` a flow.
//
// V(p) = 0.75, V(n) = 0.25 (exact in binary) make V(p,n) = 0.5, and the
// potential of a reversed branch is its negation (§5.4.1), so V(n,p) = -0.5.
//
//! lrm 5.4.1
//! bias V(p) = 0.75, V(n) = 0.25
`include "disciplines.vams"
`include "check.vh"
module ch11_nature_discipline_objects(p, n);
  inout p, n; electrical p, n;
  analog begin
    `CHECKX("the discipline's potential access reads the node pair", V(p, n), 0.5);
    `CHECKX("the potential nature is antisymmetric in the branch", V(n, p), -0.5);
    I(p,n) <+ V(p,n);
  end
endmodule
