// Source-audit correction: this HDL-only fixture does not execute VPI.
// Chapter 11's API and object model are exercised by the `.c` fixtures in
// build.zig's `vpi_runs`; only language clauses are credited here.
// §11.6.16 function call: the call is an object whose value is the function's
// return. §4.7.2.1 says the return is the last value assigned to the implicitly
// declared variable named after the function, so `square` returns x*x with x
// bound by value to the argument at the call site.
// At V(p)=1.5, V(n)=0.25 the argument is 1.25 and 1.25^2 = 1.5625 exactly
// (1.25 = 5/4, so the square is 25/16, a dyadic rational).
//
//! lrm 4.7.2.1
//! bias V(p) = 1.5, V(n) = 0.25
`include "check.vh"
module ch11_function_call_object_atomic(p, n);
  inout p, n; electrical p, n;
  analog function real square;
    input x; real x;
    square = x * x;
  endfunction
  analog begin
    `CHECKX("the call returns the function identifier variable (4.7.2.1)", square(V(p,n)), 1.5625);
    `CHECKX("the argument is bound by value at the call site", square(-3.0), 9.0);
    I(p,n) <+ square(V(p,n));
  end
endmodule
