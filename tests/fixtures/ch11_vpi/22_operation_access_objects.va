// Source-audit correction: this HDL-only fixture does not execute VPI.
// Chapter 11's API and object model are exercised by the `.c` fixtures in
// build.zig's `vpi_runs`; only language clauses are credited here.
// §11.6.19 expressions: an operation object over access-function operands.
// §4.3.1 makes abs() the absolute value (real result for a real operand), so a
// NEGATIVE branch potential separates it from the identity: at V(p)=0.25,
// V(n)=1.5 the branch potential is -1.25 V, abs gives +1.25 and the product
// V*V gives (-1.25)^2 = 1.5625, so the sum is 2.8125 exactly. Dropping the abs
// would leave 0.3125.
//
//! lrm 4.3.1
//! bias V(p) = 0.25, V(n) = 1.5
`include "check.vh"
module ch11_operation_access_objects(p, n);
  inout p, n; electrical p, n;
  analog begin
    `CHECKX("the probe is negative here", V(p,n), -1.25);
    `CHECKX("abs() of a negative operand (4.3.1)", abs(V(p,n)), 1.25);
    `CHECKX("the whole operation tree", abs(V(p,n)) + V(p,n) * V(p,n), 2.8125);
    I(p,n) <+ abs(V(p,n)) + V(p,n) * V(p,n);
  end
endmodule
