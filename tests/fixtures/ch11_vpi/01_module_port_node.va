// Source-audit correction: this HDL-only fixture does not execute VPI.
// Chapter 11's API and object model are exercised by the `.c` fixtures in
// build.zig's `vpi_runs`; only language clauses are credited here.
// §11.6.1/11.6.4/11.6.5 module, port and node objects. VPI itself is a C API,
// so what a Verilog-A fixture can pin is the language-level fact the object
// model describes: each port in the header names its OWN node, and a branch
// potential is the difference of the two node potentials (§5.4.1).
//
// V(p) = 0.75 and V(n) = 0.25 are both exact in binary, so V(p,n) = 0.5 to the
// last bit. Swap the two port bindings and the number becomes -0.5.
//
//! lrm 5.4.1
//! bias V(p) = 0.75, V(n) = 0.25
`include "check.vh"
module ch11_module_port_node(p, n);
  inout p, n;
  electrical p, n;
  analog begin
    `CHECKX("each header port binds to its own node", V(p, n), 0.5);
    I(p,n) <+ V(p,n);
  end
endmodule
