// Source-audit correction: this HDL-only fixture does not execute VPI.
// Chapter 11's API and object model are exercised by the `.c` fixtures in
// build.zig's `vpi_runs`; only language clauses are credited here.
// §11.6.23 if-else and case. §4.2.5 makes a relational operator yield the
// INTEGER 0 when false, so a negative branch potential drives both the else arm
// and the case default. At V(p)=0.25, V(n)=1.5 the potential is -1.25 V:
//   mode   = (-1.25 > 0.0)        -> 0
//   else   : result = -(-1.25)    -> 1.25
//   default: result = 1.25 - 1.0  -> 0.25
// Taking the true arm and the `1:` item instead would give -0.25.
//
// §11.6.23 NOTES 1 — "The case item shall group all case conditions which
// branch to the same statement" — is the clause's one-to-many edge from case
// item to expr, and §5.8.3's grammar spells it
// `analog_expression { , analog_expression } : analog_statement_or_null`.
// The second `case` pins it: k = 2 matches the item `1, 2, 3:` on its SECOND
// condition, so a compiler that reads only the first expression of an item
// falls through to `default` and lands on -0.75 instead of 1.25.
// result2 starts at result (0.25) and the grouped item adds 1.0 -> 1.25.
//
//! lrm 5.8.3
//! bias V(p) = 0.25, V(n) = 1.5
`include "check.vh"
module ch11_conditional_case_objects(p, n);
  inout p, n; electrical p, n;
  integer mode; integer k; real result; real result2;
  analog begin
    mode = (V(p,n) > 0.0);
    if (mode) result = V(p,n); else result = -V(p,n);
    case (mode)
      1: result = result + 1.0;
      default: result = result - 1.0;
    endcase
    k = 2;
    result2 = result;
    case (k)
      1, 2, 3: result2 = result2 + 1.0;
      default: result2 = result2 - 1.0;
    endcase
    `CHECKI("a false relation yields the integer 0 (4.2.5)", mode, 0);
    `CHECKX("the else arm then the case default", result, 0.25);
    `CHECKX("a case item groups several conditions onto one statement (11.6.23 NOTE 1)", result2, 1.25);
    I(p,n) <+ result;
  end
endmodule
