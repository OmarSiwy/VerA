// Source-audit correction: this HDL-only fixture does not execute VPI.
// Chapter 11's API and object model are exercised by the `.c` fixtures in
// build.zig's `vpi_runs`; only language clauses are credited here.
// §11.6.16 sys func call, the half of the object that 06 cannot reach: the
// clause gives the sys task call / sys func call class the properties
// `-> value — vpi_put_value(), vpi_get_value()` and
// `-> sys func type — int: vpiSysFuncType`. An UNREGISTERED `$name` (05, 06,
// 08) has neither — nothing registered it, so nothing declared its type. A
// system function the LANGUAGE defines does, so this fixture calls one.
//
// §9.15 Syntax 9-10 lists $temperature among the environment parameter
// functions and says of the group "These functions return information about
// the current environment parameters as a real value", then "$temperature does
// not take any input arguments and returns the circuit's ambient temperature
// in Kelvin units". REAL is the load-bearing word: a compiler that types the
// call integer, or that rounds the host's ambient on the way in, answers 350
// instead of 350.25 and fails the first check.
//
// The ambient is set to 350.25 K — off the 300.15 K default, so a build that
// ignores the setting and answers with a hard-wired nominal fails too, and
// dyadic (350.25 = 1401/4) so exact equality is the right strength.
//
// At V(p)=1.5, V(n)=0.25 the branch potential is 1.5 - 0.25 = 1.25 V; the
// second check is that the valued system call alongside it disturbs nothing.
//
//! lrm 9.15
//! temp 350.25
//! bias V(p) = 1.5, V(n) = 0.25
`include "check.vh"
module ch11_system_function_call_object_atomic(p, n);
  inout p, n; electrical p, n;
  analog begin
    `CHECKX("$temperature is a real-valued system function (9.15)", $temperature, 350.25);
    `CHECKX("and the probe alongside it", V(p,n), 1.25);
    I(p,n) <+ V(p,n);
  end
endmodule
