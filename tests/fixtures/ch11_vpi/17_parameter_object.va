// Source-audit correction: this HDL-only fixture does not execute VPI.
// Chapter 11's API and object model are exercised by the `.c` fixtures in
// build.zig's `vpi_runs`; only language clauses are credited here.
// §11.6.12 parameter: a parameter is an object with a VALUE, and §3.4 fixes that
// value to the declared default when the instance overrides nothing. So `gain`
// is 2.0 here, not zero and not the range bound 0 from `from [0:inf)`.
// At V(p)=1.5, V(n)=0.25 the branch potential is 1.25 V and the transconductance
// current is 2.0 * 1.25 = 2.5 exactly.
//
//! lrm 3.4
//! bias V(p) = 1.5, V(n) = 0.25
`include "check.vh"
module ch11_parameter_object(p, n);
  inout p, n; electrical p, n;
  parameter real gain = 2.0 from [0:inf);
  analog begin
    `CHECKX("an un-overridden parameter takes its declared default (3.4)", gain, 2.0);
    `CHECKX("the contributed flow", gain * V(p,n), 2.5);
    I(p,n) <+ gain * V(p,n);
  end
endmodule
