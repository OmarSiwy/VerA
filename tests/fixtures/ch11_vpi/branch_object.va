// Source-audit correction: this HDL-only fixture does not execute VPI.
// Chapter 11's API and object model are exercised by the `.c` fixtures in
// build.zig's `vpi_runs`; only language clauses are credited here.
// §11.6.6 branch object: a branch reaches its two nodes and the quantities it
// carries. §5.4.1 fixes the potential of `branch (p,n) path` as V(p) - V(n), and
// Table 2-1 of §2.6.2 makes `1k` the real number 1 scaled by k = 1e3, 1000.0.
//
// V(p) = 0.875, V(n) = 0.125 (exact in binary) give V(path) = 0.75 V, so the
// contributed flow is 0.75/1000 = 750 uA. Read `k` as anything but 1e3 and the
// second number moves by orders of magnitude.
//
// Both are exact equalities. 0.75 and 1000.0 are exact doubles and IEEE
// division is correctly rounded, so 0.75/1k is the double nearest 0.00075 —
// which is what the literal 7.5e-4 parses to. Same bits, so CHECKX, not a
// tolerance nine ulp wide.
//
//! lrm 5.4.1
//! bias V(p) = 0.875, V(n) = 0.125
`include "check.vh"
module ch11_branch_object(p, n);
  inout p, n; electrical p, n;
  branch (p,n) path;
  analog begin
    `CHECKX("the branch potential is its declared node pair", V(path), 0.75);
    `CHECKX("the k scale factor is 1e3", V(path) / 1k, 7.5e-4);
    I(path) <+ V(path) / 1k;
  end
endmodule
