// Annex B: "Verilog-AMS reserves the keywords listed in Table B.1." A reserved
// spelling is therefore not available as an identifier, and `real <keyword>;`
// is a syntax error in any conforming compiler.
//
// The pass-transistor switches and the two XOR gate types of IEEE 1364-2005
// A.3.1. `tran` is in Table B.1 and was missing from the chapter entirely; it is
// pinned now, in 23_shadowed_spellings_inner.va (see below).
//
// This is a reservedness census, not a feature test: one declaration per line so
// the parser resynchronises at each `;` and reports every spelling separately,
// and one `//! reject` line per spelling so each keyword is proved individually
// rather than the file passing on whichever token the parser tripped over first.
//
// Four of this family's spellings are not declared here, because each is a
// substring of another one: `rtran`, `tranif0` and `tranif1` sit inside
// `rtranif0`/`rtranif1` and are censused in 22_shadowed_spellings.va, and `tran`
// sits inside all four of those and is censused in
// 23_shadowed_spellings_inner.va. 22 explains the mechanism.
//! lrm B
//! reject-only E0208
//! reject rtranif0
//! reject rtranif1
//! reject xnor
//! reject xor
module annex_b_reserved_pass_logic_primitive_keywords;
    real rtranif0;
    real rtranif1;
    real xnor;
    real xor;
endmodule
