// Annex B: "Verilog-AMS reserves the keywords listed in Table B.1." A reserved
// spelling is therefore not available as an identifier, and `real <keyword>;`
// is a syntax error in any conforming compiler.
//
// The pass-transistor and logic-gate family of IEEE 1364-2005 A.3.1. `tran` is in
// Table B.1 and was missing from the chapter entirely; it is included here.
//
// This is a reservedness census, not a feature test: one declaration per line so
// the parser resynchronises at each `;` and reports every spelling separately,
// and one `//! reject` line per spelling so each keyword is proved individually
// rather than the file passing on whichever token the parser tripped over first.
//! lrm B
//! reject E0208
//! reject rtran
//! reject rtranif0
//! reject rtranif1
//! reject tran
//! reject tranif0
//! reject tranif1
//! reject xnor
//! reject xor
module annex_b_reserved_pass_logic_primitive_keywords;
    real rtran;
    real rtranif0;
    real rtranif1;
    real tran;
    real tranif0;
    real tranif1;
    real xnor;
    real xor;
endmodule
