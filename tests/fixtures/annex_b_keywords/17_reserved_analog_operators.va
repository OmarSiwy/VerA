// Annex B: "Verilog-AMS reserves the keywords listed in Table B.1." A reserved
// spelling is therefore not available as an identifier, and `real <keyword>;`
// is a syntax error in any conforming compiler.
//
// The analog operators of §4.5, the analog events of §5.10 and the noise and
// analysis functions of §4.4/§4.6. Chapters 4 and 5 invoke these operators;
// invoking a name and reserving it are two different rules, and only the second
// one is Annex B.
//
// `absdelta` is the newest of these — Annex G item 4803 records it as ADDED in
// 2.4, with §5.10.3.4, §8.4.6 and a live `analog_event_functions` production in
// A.6.5 — and it is still the one an implementation is likeliest to miss:
// §5.10.3.4 allows it only in an `initial` or `always` block, i.e. outside the
// Verilog-A subset, so a tool that reserves the operator names it can actually
// lower will leave this one out. Table B.1 reserves it regardless.
//
// This is a reservedness census, not a feature test: one declaration per line so
// the parser resynchronises at each `;` and reports every spelling separately,
// and one `//! reject` line per spelling so each keyword is proved individually
// rather than the file passing on whichever token the parser tripped over first.
//
// `cross`, `idt` and `noise_table` are not declared here: they are substrings of
// `last_crossing`, `idtmod` and `noise_table_log`. They are censused in
// 22_shadowed_spellings.va, which explains the mechanism.
//! lrm B
//! reject-only E0208
//! reject absdelay
//! reject absdelta
//! reject above
//! reject ac_stim
//! reject analysis
//! reject ddt
//! reject ddx
//! reject flicker_noise
//! reject idtmod
//! reject laplace_nd
//! reject laplace_np
//! reject laplace_zd
//! reject laplace_zp
//! reject last_crossing
//! reject limexp
//! reject noise_table_log
//! reject slew
//! reject timer
//! reject transition
//! reject white_noise
//! reject zi_nd
//! reject zi_np
//! reject zi_zd
//! reject zi_zp
//! reject final_step
//! reject initial_step
module annex_b_reserved_analog_operators;
    real absdelay;
    real absdelta;
    real above;
    real ac_stim;
    real analysis;
    real ddt;
    real ddx;
    real flicker_noise;
    real idtmod;
    real laplace_nd;
    real laplace_np;
    real laplace_zd;
    real laplace_zp;
    real last_crossing;
    real limexp;
    real noise_table_log;
    real slew;
    real timer;
    real transition;
    real white_noise;
    real zi_nd;
    real zi_np;
    real zi_zd;
    real zi_zp;
    real final_step;
    real initial_step;
endmodule
