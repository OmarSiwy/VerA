// Annex B: "Keywords are predefined nonescaped identifiers ... Verilog-AMS
// reserves the keywords listed in Table B.1." `wait` is in Table B.1, so it
// cannot be the name of a branch (A.2.1.3 branch_declaration), whose production (A.9.3) bottoms out in
// `identifier`, which §2.8 defines to exclude keywords. The variable position
// is 04 and its siblings; this file pins the branch-name position. Legal
// neighbour: the same declaration with the escaped name `\wait `, which
// 26_escaped_keyword_name_positions.va runs.
//
//! lrm B
//! lrm 2.8
//! reject-only E0208
//! reject found `wait`
//! neighbour 26_escaped_keyword_name_positions.va
`include "disciplines.vams"
module annex_b_kw_branch(p, n);
  inout p, n; electrical p, n;
  branch (p, n) wait;
  analog I(p, n) <+ V(p, n);
endmodule
