// Annex B: "Verilog-AMS reserves the keywords listed in Table B.1." `or` is in
// Table B.1 — the event-`or` of A.6.5 and the `n_input_gatetype` of IEEE
// 1364-2005 A.3.1 — so the spelling is not available as an identifier.
//
// Its own file, and one declaration in it, because `or` is the one spelling in
// Table B.1 that NO substring arm can ever prove. `failureContains`
// (tests/torture.zig) tests the pattern against the failure's error name before
// it looks at any diagnostic, and every rejection in this suite is named
// `ParseError`, `DiagnosticsReported` or `GeneratedCompileError` — all three
// contain `or`. So `//! reject or` is true of any fixture that fails for any
// reason at all, in this file as much as in 19_reserved_core_keywords.va, where
// `for`/`forever` shadowed it as well.
//
// Here the file declares exactly one thing, so `//! reject E0208` can only have
// come from `real or;` and IS the proof. The `//! reject or` line below is kept
// because the chapter's census counts spellings by their reject lines
// (14_include_reserved.va), not because it discriminates — on its own it does
// not.
//
// The module name carries no keyword and no `or`, so a diagnostic quoting it
// cannot stand in for the declaration.
//! lrm B
//! lrm 2.8.2
//! reject-only E0208
//! reject or
module annex_b_reserved_spelling_25;
    real or;
endmodule
