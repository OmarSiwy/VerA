// Annex B: "Verilog-AMS reserves the keywords listed in Table B.1." A reserved
// spelling is therefore not available as an identifier, and `real <keyword>;`
// is a syntax error in any conforming compiler.
//
// The built-in mathematical functions of §4.3.1 and §4.3.2. A chapter 4 fixture
// CALLS `sin(x)`, which is a different claim: it shows the name resolves to the
// function, not that the name is unavailable for a variable. Only `sin` was
// pinned anywhere, and only under an explicit `begin_keywords set.
//
// `expm1` and `ln1p` are in the Table B.1 of this repo's Annex B but not in the
// 2.4.0 PDF table; see 20_reserved_2023_additions.va.
//
// This is a reservedness census, not a feature test: one declaration per line so
// the parser resynchronises at each `;` and reports every spelling separately,
// and one `//! reject` line per spelling so each keyword is proved individually
// rather than the file passing on whichever token the parser tripped over first.
//
// Eleven of these functions are not declared here, because each is a substring
// of a longer function name in the same family: `acos`, `asin`, `atan`, `cosh`,
// `ln`, `sinh` and `tanh` are censused in 22_shadowed_spellings.va, and `cos`,
// `sin` and `tan` — which sit inside those in turn — in
// 23_shadowed_spellings_inner.va. `exp` needs a file of its own,
// 24_reserved_exp.va: it is a substring of `expm1` AND of E0208's catalogue
// title "expected an identifier", which a `//! reject` pattern is also matched
// against. 22 explains the mechanism.
//! lrm B
//! reject-only E0208
//! reject abs
//! reject acosh
//! reject asinh
//! reject atan2
//! reject atanh
//! reject ceil
//! reject expm1
//! reject floor
//! reject hypot
//! reject ln1p
//! reject log
//! reject max
//! reject min
//! reject pow
//! reject sqrt
module annex_b_reserved_math_functions;
    real abs;
    real acosh;
    real asinh;
    real atan2;
    real atanh;
    real ceil;
    real expm1;
    real floor;
    real hypot;
    real ln1p;
    real log;
    real max;
    real min;
    real pow;
    real sqrt;
endmodule
