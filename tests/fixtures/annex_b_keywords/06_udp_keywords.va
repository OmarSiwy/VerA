// Annex B: "Verilog-AMS reserves the keywords listed in Table B.1." A reserved
// spelling is therefore not available as an identifier, and `real <keyword>;`
// is a syntax error in any conforming compiler.
//
// The user-defined-primitive family of IEEE 1364-2005 A.5.1. Not excluded by
// Annex C.16, so a well-formed `primitive`/`table` declaration is legal source
// and cannot be what this annex is tested with.
//
// This is a reservedness census, not a feature test: one declaration per line so
// the parser resynchronises at each `;` and reports every spelling separately,
// and one `//! reject` line per spelling so each keyword is proved individually
// rather than the file passing on whichever token the parser tripped over first.
//
// `primitive` and `table` are not declared here: they are substrings of
// `endprimitive` and `endtable`, so their arms would be satisfied by the longer
// spellings' diagnostics. They are censused in 22_shadowed_spellings.va and
// 23_shadowed_spellings_inner.va, which explain the mechanism.
//! lrm B
//! reject-only E0208
//! reject endprimitive
//! reject endtable
module annex_b_reserved_udp_keywords;
    real endprimitive;
    real endtable;
endmodule
