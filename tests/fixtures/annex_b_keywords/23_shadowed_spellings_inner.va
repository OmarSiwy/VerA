// Annex B: "Verilog-AMS reserves the keywords listed in Table B.1." A reserved
// spelling is therefore not available as an identifier, and `real <keyword>;`
// is a syntax error in any conforming compiler.
//
// The second tier of the split described in 22. These five are substrings of
// spellings that live in 22, so they cannot be censused there either:
//
//   cos    ⊂ acos, cosh      (both in 22)
//   sin    ⊂ asin, sinh      (both in 22)
//   tan    ⊂ atan, tanh      (both in 22)
//   tran   ⊂ rtran, tranif0, tranif1  (all in 22)
//   table  ⊂ noise_table     (in 22)
//
// They are pairwise non-containing, and none of them is a substring of the E0208
// title "expected an identifier" or of the phase labels `ParseError` /
// `DiagnosticsReported`, so in THIS file every arm is load-bearing.
//
// The module name is `annex_b_reserved_spelling_23` for the same reason 22's is:
// a diagnostic quoting the module name must not be able to satisfy an arm.
//! lrm B
//! lrm 2.8.2
//! reject-only E0208
//! reject cos
//! reject sin
//! reject table
//! reject tan
//! reject tran
module annex_b_reserved_spelling_23;
    real cos;
    real sin;
    real table;
    real tan;
    real tran;
endmodule
