// Annex B: "Keywords are predefined nonescaped identifiers ... Verilog-AMS
// reserves the keywords listed in Table B.1." `endcase` is in Table B.1, so it
// cannot be the name of a genvar (A.2.1.3 genvar_declaration), whose production (A.9.3) bottoms out in
// `identifier`, which §2.8 defines to exclude keywords. The variable position
// is 04 and its siblings; this file pins the genvar-name position. Legal
// neighbour: the same declaration with the escaped name `\endcase `, which
// 26_escaped_keyword_name_positions.va runs.
//
//! lrm B
//! lrm 2.8
//! reject-only E0208
//! reject found `endcase`
//! neighbour 26_escaped_keyword_name_positions.va
`include "disciplines.vams"
module annex_b_kw_genvar(p, n);
  inout p, n; electrical p, n;
  genvar endcase;
  analog I(p, n) <+ V(p, n);
endmodule
