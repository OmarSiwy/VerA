// Annex B: "An escaped identifier shall not be treated as a keyword." §2.8.1:
// the leading backslash and the terminating white space are not part of the
// identifier, so `\sin ` denotes the identifier `sin`.
//
// This puts the two rules in direct opposition on one name. `sin` is reserved
// by Table B.1 and is the sine function; ch10_directives/17 and /27 show a port
// named `sin` is an error under a Verilog-AMS keyword set. Escape it and the
// same port must be legal, and must be a port — not a call to sine.
//
// The bias directive names the node `sin`, not `\sin `, for the same reason
// 01_escaped_keyword.va reads `\total ` back as `total`: §2.8.1 makes them one
// identifier.
//
// want: V(sin, n) = 0.75 - 0.25 = 0.5, from the bias below. Both operands and
// the difference are exact in binary64, so CHECKX is right. Nothing here is
// sin(anything); a compiler that resolved `\sin ` to the function would not get
// this far, and if it did the branch probe would not be 0.5.
`include "check.vh"
//! lrm B
//! lrm B:1
//! lrm 2.8.1
//! bias V(sin) = 0.75, V(n) = 0.25
module annex_b_escaped_keyword_port(\sin , n);
    inout \sin , n;
    electrical \sin , n;

    analog begin
        `CHECKX("escaped sin is a port, not the sine function", V(\sin , n), 0.5);
        I(\sin , n) <+ V(\sin , n);
    end
endmodule
