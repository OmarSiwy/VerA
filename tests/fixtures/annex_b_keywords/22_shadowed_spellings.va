// Annex B: "Verilog-AMS reserves the keywords listed in Table B.1." A reserved
// spelling is therefore not available as an identifier, and `real <keyword>;`
// is a syntax error in any conforming compiler.
//
// These spellings belong to the family censuses 05-10 and 16-19, and are pulled
// out of them for one mechanical reason: a `//! reject` substring is matched
// against EVERY diagnostic of the file (tests/torture.zig failureContains), so
// where keyword A is a substring of keyword B declared in the SAME file, A's arm
// is satisfied by B's diagnostic and A is never proved. `//! reject tri` next to
// `real trireg;` passes whether or not `tri` is reserved. Same defect and same
// repair as annex_c_analog_subset/30_connect_reserved.va.
//
// Where each spelling comes from, and what shadowed it there:
//
//   config        endconfig                                   (05)
//   primitive     endprimitive                                (06)
//   buf           bufif0, bufif1                              (07)
//   nmos          rnmos                                       (07b)
//   pmos          rpmos                                       (07b)
//   rtran         rtranif0, rtranif1                          (07c)
//   tranif0       rtranif0                                    (07c)
//   tranif1       rtranif1                                    (07c)
//   signed        unsigned                                    (08)
//   tri           tri0, tri1, triand, trior, trireg           (08)
//   wire          uwire                                       (08)
//   showcancelled noshowcancelled                             (09)
//   specify       endspecify                                  (09)
//   task          endtask                                     (10)
//   time          realtime                                    (10)
//   acos          acosh                                       (16)
//   asin          asinh                                       (16)
//   atan          atan2, atanh                                (16)
//   cosh          acosh                                       (16)
//   ln            ln1p                                        (16)
//   sinh          asinh                                       (16)
//   tanh          atanh                                       (16)
//   cross         last_crossing                               (17)
//   idt           idtmod                                      (17)
//   noise_table   noise_table_log                             (17)
//   discipline    enddiscipline                               (18)
//   nature        ddt_nature, endnature, idt_nature           (18)
//   case          casex, casez, endcase                       (19)
//   end           endcase, endfunction, endgenerate, endmodule, endparamset (19)
//   for           forever                                     (19)
//   function      endfunction                                 (19)
//   generate      endgenerate                                 (19)
//   not           the E0201 title "construct is NOT in the supported subset",
//                 which 19 raises for the stray `;` after `real endmodule;`
//   paramset      endparamset                                 (19)
//
// The set above is pairwise non-containing, so in THIS file every arm is
// load-bearing. `table`, `cos`, `sin`, `tan` and `tran` are shadowed here too
// (by `noise_table`, `acos`/`cosh`, `asin`/`sinh`, `atan`/`tanh` and `rtran`)
// and are in 23. `exp` and `or` cannot be proved by a substring in any
// multi-declaration file at all; they are in 24 and 25.
//
// The module name is `annex_b_reserved_spelling_22`, not a description built out
// of keywords, so that a diagnostic quoting it cannot satisfy an arm.
//! lrm B
//! lrm 2.8.2
//! reject-only E0208
//! reject acos
//! reject asin
//! reject atan
//! reject buf
//! reject case
//! reject config
//! reject cosh
//! reject cross
//! reject discipline
//! reject end
//! reject for
//! reject function
//! reject generate
//! reject idt
//! reject ln
//! reject nature
//! reject nmos
//! reject noise_table
//! reject not
//! reject paramset
//! reject pmos
//! reject primitive
//! reject rtran
//! reject showcancelled
//! reject signed
//! reject sinh
//! reject specify
//! reject tanh
//! reject task
//! reject time
//! reject tranif0
//! reject tranif1
//! reject tri
//! reject wire
module annex_b_reserved_spelling_22;
    real acos;
    real asin;
    real atan;
    real buf;
    real case;
    real config;
    real cosh;
    real cross;
    real discipline;
    real end;
    real for;
    real function;
    real generate;
    real idt;
    real ln;
    real nature;
    real nmos;
    real noise_table;
    real not;
    real paramset;
    real pmos;
    real primitive;
    real rtran;
    real showcancelled;
    real signed;
    real sinh;
    real specify;
    real tanh;
    real task;
    real time;
    real tranif0;
    real tranif1;
    real tri;
    real wire;
endmodule
