// Annex B: "Keywords are predefined nonescaped identifiers that define
// Verilog-AMS language constructs. [...] Verilog-AMS reserves the keywords
// listed in Table B.1." `module` is in Table B.1, so the spelling is not
// available as an ordinary identifier anywhere the grammar wants one.
//
// This file pins the reservation at the DECLARATION-NAME position:
// `module_declaration ::= module_keyword module_identifier ...` (A.1.2) and
// `module_identifier ::= identifier` (A.9.3), so `module module;` puts a keyword
// where §2.8 admits only an identifier. 04_reserved_if_rejected.va pins the same
// rule at a variable-declaration position instead.
//
// The reject pins the diagnostic CODE, not the prose: `identifier` — what this
// file used to demand — is a fragment of the diagnostic's title, so rewording
// the catalogue entry would silently stop this fixture proving anything.
//! lrm B
//! lrm 2.8
//! lrm 2.8.2
//! lrm 2.8.2:1000
//! reject-only E0208
//! reject module
module module;
endmodule
