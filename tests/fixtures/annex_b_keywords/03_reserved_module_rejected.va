//! reject identifier
// EXPECT: error
module module;
endmodule
