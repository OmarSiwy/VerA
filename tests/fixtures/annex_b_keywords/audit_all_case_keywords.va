// Generated by tools/conformance.py keywords --fixture case
// Source: VAMS-2023 Table B.1, physical pages 400-401;
// the PDF's negedgenmos defect is split into negedge and nmos.
// Annex B and 2.8.2 reserve nonescaped lowercase spellings only.
// Each legal identifier is assigned its one-based inventory position.
// All assignments precede all observations: name aliasing cannot hide
// behind an immediate assignment/read pair. Each expected integer is
// independently fixed by the generator, not read from the compiler.
// This tests variable identifiers, not all identifier grammar positions.
// Reads use a plain temporary so macro-argument whitespace processing
// cannot hide the keyword-name test; see KEY-MACRO-001 in the audit.
//! lrm B
//! lrm 2.8.2
//! checks 430
//! print none
`include "check.vh"
module audit_all_case_keywords(p, n);
    inout p, n;
    electrical p, n;
    real ABOVE;
    real Above;
    real ABS;
    real Abs;
    real ABSDELAY;
    real Absdelay;
    real ABSDELTA;
    real Absdelta;
    real ABSTOL;
    real Abstol;
    real AC_STIM;
    real Ac_stim;
    real ACCESS;
    real Access;
    real ACOS;
    real Acos;
    real ACOSH;
    real Acosh;
    real ALIASPARAM;
    real Aliasparam;
    real ALWAYS;
    real Always;
    real ANALOG;
    real Analog;
    real ANALYSIS;
    real Analysis;
    real AND;
    real And;
    real ASIN;
    real Asin;
    real ASINH;
    real Asinh;
    real ASSIGN;
    real Assign;
    real ATAN;
    real Atan;
    real ATAN2;
    real Atan2;
    real ATANH;
    real Atanh;
    real AUTOMATIC;
    real Automatic;
    real BEGIN;
    real Begin;
    real BRANCH;
    real Branch;
    real BREAK;
    real Break;
    real BUF;
    real Buf;
    real BUFIF0;
    real Bufif0;
    real BUFIF1;
    real Bufif1;
    real CASE;
    real Case;
    real CASEX;
    real Casex;
    real CASEZ;
    real Casez;
    real CEIL;
    real Ceil;
    real CELL;
    real Cell;
    real CMOS;
    real Cmos;
    real CONFIG;
    real Config;
    real CONNECT;
    real Connect;
    real CONNECTMODULE;
    real Connectmodule;
    real CONNECTRULES;
    real Connectrules;
    real CONTINUE;
    real Continue;
    real CONTINUOUS;
    real Continuous;
    real COS;
    real Cos;
    real COSH;
    real Cosh;
    real CROSS;
    real Cross;
    real DDT;
    real Ddt;
    real DDT_NATURE;
    real Ddt_nature;
    real DDX;
    real Ddx;
    real DEASSIGN;
    real Deassign;
    real DEFAULT;
    real Default;
    real DEFPARAM;
    real Defparam;
    real DESIGN;
    real Design;
    real DISABLE;
    real Disable;
    real DISCIPLINE;
    real Discipline;
    real DISCRETE;
    real Discrete;
    real DOMAIN;
    real Domain;
    real DRIVER_UPDATE;
    real Driver_update;
    real EDGE;
    real Edge;
    real ELSE;
    real Else;
    real END;
    real End;
    real ENDCASE;
    real Endcase;
    real ENDCONFIG;
    real Endconfig;
    real ENDCONNECTRULES;
    real Endconnectrules;
    real ENDDISCIPLINE;
    real Enddiscipline;
    real ENDFUNCTION;
    real Endfunction;
    real ENDGENERATE;
    real Endgenerate;
    real ENDMODULE;
    real Endmodule;
    real ENDNATURE;
    real Endnature;
    real ENDPARAMSET;
    real Endparamset;
    real ENDPRIMITIVE;
    real Endprimitive;
    real ENDSPECIFY;
    real Endspecify;
    real ENDTABLE;
    real Endtable;
    real ENDTASK;
    real Endtask;
    real EVENT;
    real Event;
    real EXCLUDE;
    real Exclude;
    real EXP;
    real Exp;
    real EXPM1;
    real Expm1;
    real FINAL_STEP;
    real Final_step;
    real FLICKER_NOISE;
    real Flicker_noise;
    real FLOOR;
    real Floor;
    real FLOW;
    real Flow;
    real FOR;
    real For;
    real FORCE;
    real Force;
    real FOREVER;
    real Forever;
    real FORK;
    real Fork;
    real FROM;
    real From;
    real FUNCTION;
    real Function;
    real GENERATE;
    real Generate;
    real GENVAR;
    real Genvar;
    real GROUND;
    real Ground;
    real HIGHZ0;
    real Highz0;
    real HIGHZ1;
    real Highz1;
    real HYPOT;
    real Hypot;
    real IDT;
    real Idt;
    real IDT_NATURE;
    real Idt_nature;
    real IDTMOD;
    real Idtmod;
    real IF;
    real If;
    real IFNONE;
    real Ifnone;
    real INCDIR;
    real Incdir;
    real INCLUDE;
    real Include;
    real INF;
    real Inf;
    real INITIAL;
    real Initial;
    real INITIAL_STEP;
    real Initial_step;
    real INOUT;
    real Inout;
    real INPUT;
    real Input;
    real INSTANCE;
    real Instance;
    real INTEGER;
    real Integer;
    real JOIN;
    real Join;
    real LAPLACE_ND;
    real Laplace_nd;
    real LAPLACE_NP;
    real Laplace_np;
    real LAPLACE_ZD;
    real Laplace_zd;
    real LAPLACE_ZP;
    real Laplace_zp;
    real LARGE;
    real Large;
    real LAST_CROSSING;
    real Last_crossing;
    real LIBLIST;
    real Liblist;
    real LIBRARY;
    real Library;
    real LIMEXP;
    real Limexp;
    real LN;
    real Ln;
    real LN1P;
    real Ln1p;
    real LOCALPARAM;
    real Localparam;
    real LOG;
    real Log;
    real MACROMODULE;
    real Macromodule;
    real MAX;
    real Max;
    real MEDIUM;
    real Medium;
    real MERGED;
    real Merged;
    real MIN;
    real Min;
    real MODULE;
    real Module;
    real NAND;
    real Nand;
    real NATURE;
    real Nature;
    real NEGEDGE;
    real Negedge;
    real NMOS;
    real Nmos;
    real NOISE_TABLE;
    real Noise_table;
    real NOISE_TABLE_LOG;
    real Noise_table_log;
    real NOR;
    real Nor;
    real NOSHOWCANCELLED;
    real Noshowcancelled;
    real NOT;
    real Not;
    real NOTIF0;
    real Notif0;
    real NOTIF1;
    real Notif1;
    real OR;
    real Or;
    real OUTPUT;
    real Output;
    real PARAMETER;
    real Parameter;
    real PARAMSET;
    real Paramset;
    real PMOS;
    real Pmos;
    real POSEDGE;
    real Posedge;
    real POTENTIAL;
    real Potential;
    real POW;
    real Pow;
    real PRIMITIVE;
    real Primitive;
    real PULL0;
    real Pull0;
    real PULL1;
    real Pull1;
    real PULLDOWN;
    real Pulldown;
    real PULLUP;
    real Pullup;
    real PULSESTYLE_ONDETECT;
    real Pulsestyle_ondetect;
    real PULSESTYLE_ONEVENT;
    real Pulsestyle_onevent;
    real RCMOS;
    real Rcmos;
    real REAL;
    real Real;
    real REALTIME;
    real Realtime;
    real REG;
    real Reg;
    real RELEASE;
    real Release;
    real REPEAT;
    real Repeat;
    real RESOLVETO;
    real Resolveto;
    real RETURN;
    real Return;
    real RNMOS;
    real Rnmos;
    real RPMOS;
    real Rpmos;
    real RTRAN;
    real Rtran;
    real RTRANIF0;
    real Rtranif0;
    real RTRANIF1;
    real Rtranif1;
    real SCALARED;
    real Scalared;
    real SHOWCANCELLED;
    real Showcancelled;
    real SIGNED;
    real Signed;
    real SIN;
    real Sin;
    real SINH;
    real Sinh;
    real SLEW;
    real Slew;
    real SMALL;
    real Small;
    real SPECIFY;
    real Specify;
    real SPECPARAM;
    real Specparam;
    real SPLIT;
    real Split;
    real SQRT;
    real Sqrt;
    real STRING;
    real String;
    real STRONG0;
    real Strong0;
    real STRONG1;
    real Strong1;
    real SUPPLY0;
    real Supply0;
    real SUPPLY1;
    real Supply1;
    real TABLE;
    real Table;
    real TAN;
    real Tan;
    real TANH;
    real Tanh;
    real TASK;
    real Task;
    real TIME;
    real Time;
    real TIMER;
    real Timer;
    real TRAN;
    real Tran;
    real TRANIF0;
    real Tranif0;
    real TRANIF1;
    real Tranif1;
    real TRANSITION;
    real Transition;
    real TRI;
    real Tri;
    real TRI0;
    real Tri0;
    real TRI1;
    real Tri1;
    real TRIAND;
    real Triand;
    real TRIOR;
    real Trior;
    real TRIREG;
    real Trireg;
    real UNITS;
    real Units;
    real UNSIGNED;
    real Unsigned;
    real USE;
    real Use;
    real UWIRE;
    real Uwire;
    real VECTORED;
    real Vectored;
    real WAIT;
    real Wait;
    real WAND;
    real Wand;
    real WEAK0;
    real Weak0;
    real WEAK1;
    real Weak1;
    real WHILE;
    real While;
    real WHITE_NOISE;
    real White_noise;
    real WIRE;
    real Wire;
    real WOR;
    real Wor;
    real WREAL;
    real Wreal;
    real XNOR;
    real Xnor;
    real XOR;
    real Xor;
    real ZI_ND;
    real Zi_nd;
    real ZI_NP;
    real Zi_np;
    real ZI_ZD;
    real Zi_zd;
    real ZI_ZP;
    real Zi_zp;
    real observed;
    analog begin
        ABOVE = 1.0;
        Above = 2.0;
        ABS = 3.0;
        Abs = 4.0;
        ABSDELAY = 5.0;
        Absdelay = 6.0;
        ABSDELTA = 7.0;
        Absdelta = 8.0;
        ABSTOL = 9.0;
        Abstol = 10.0;
        AC_STIM = 11.0;
        Ac_stim = 12.0;
        ACCESS = 13.0;
        Access = 14.0;
        ACOS = 15.0;
        Acos = 16.0;
        ACOSH = 17.0;
        Acosh = 18.0;
        ALIASPARAM = 19.0;
        Aliasparam = 20.0;
        ALWAYS = 21.0;
        Always = 22.0;
        ANALOG = 23.0;
        Analog = 24.0;
        ANALYSIS = 25.0;
        Analysis = 26.0;
        AND = 27.0;
        And = 28.0;
        ASIN = 29.0;
        Asin = 30.0;
        ASINH = 31.0;
        Asinh = 32.0;
        ASSIGN = 33.0;
        Assign = 34.0;
        ATAN = 35.0;
        Atan = 36.0;
        ATAN2 = 37.0;
        Atan2 = 38.0;
        ATANH = 39.0;
        Atanh = 40.0;
        AUTOMATIC = 41.0;
        Automatic = 42.0;
        BEGIN = 43.0;
        Begin = 44.0;
        BRANCH = 45.0;
        Branch = 46.0;
        BREAK = 47.0;
        Break = 48.0;
        BUF = 49.0;
        Buf = 50.0;
        BUFIF0 = 51.0;
        Bufif0 = 52.0;
        BUFIF1 = 53.0;
        Bufif1 = 54.0;
        CASE = 55.0;
        Case = 56.0;
        CASEX = 57.0;
        Casex = 58.0;
        CASEZ = 59.0;
        Casez = 60.0;
        CEIL = 61.0;
        Ceil = 62.0;
        CELL = 63.0;
        Cell = 64.0;
        CMOS = 65.0;
        Cmos = 66.0;
        CONFIG = 67.0;
        Config = 68.0;
        CONNECT = 69.0;
        Connect = 70.0;
        CONNECTMODULE = 71.0;
        Connectmodule = 72.0;
        CONNECTRULES = 73.0;
        Connectrules = 74.0;
        CONTINUE = 75.0;
        Continue = 76.0;
        CONTINUOUS = 77.0;
        Continuous = 78.0;
        COS = 79.0;
        Cos = 80.0;
        COSH = 81.0;
        Cosh = 82.0;
        CROSS = 83.0;
        Cross = 84.0;
        DDT = 85.0;
        Ddt = 86.0;
        DDT_NATURE = 87.0;
        Ddt_nature = 88.0;
        DDX = 89.0;
        Ddx = 90.0;
        DEASSIGN = 91.0;
        Deassign = 92.0;
        DEFAULT = 93.0;
        Default = 94.0;
        DEFPARAM = 95.0;
        Defparam = 96.0;
        DESIGN = 97.0;
        Design = 98.0;
        DISABLE = 99.0;
        Disable = 100.0;
        DISCIPLINE = 101.0;
        Discipline = 102.0;
        DISCRETE = 103.0;
        Discrete = 104.0;
        DOMAIN = 105.0;
        Domain = 106.0;
        DRIVER_UPDATE = 107.0;
        Driver_update = 108.0;
        EDGE = 109.0;
        Edge = 110.0;
        ELSE = 111.0;
        Else = 112.0;
        END = 113.0;
        End = 114.0;
        ENDCASE = 115.0;
        Endcase = 116.0;
        ENDCONFIG = 117.0;
        Endconfig = 118.0;
        ENDCONNECTRULES = 119.0;
        Endconnectrules = 120.0;
        ENDDISCIPLINE = 121.0;
        Enddiscipline = 122.0;
        ENDFUNCTION = 123.0;
        Endfunction = 124.0;
        ENDGENERATE = 125.0;
        Endgenerate = 126.0;
        ENDMODULE = 127.0;
        Endmodule = 128.0;
        ENDNATURE = 129.0;
        Endnature = 130.0;
        ENDPARAMSET = 131.0;
        Endparamset = 132.0;
        ENDPRIMITIVE = 133.0;
        Endprimitive = 134.0;
        ENDSPECIFY = 135.0;
        Endspecify = 136.0;
        ENDTABLE = 137.0;
        Endtable = 138.0;
        ENDTASK = 139.0;
        Endtask = 140.0;
        EVENT = 141.0;
        Event = 142.0;
        EXCLUDE = 143.0;
        Exclude = 144.0;
        EXP = 145.0;
        Exp = 146.0;
        EXPM1 = 147.0;
        Expm1 = 148.0;
        FINAL_STEP = 149.0;
        Final_step = 150.0;
        FLICKER_NOISE = 151.0;
        Flicker_noise = 152.0;
        FLOOR = 153.0;
        Floor = 154.0;
        FLOW = 155.0;
        Flow = 156.0;
        FOR = 157.0;
        For = 158.0;
        FORCE = 159.0;
        Force = 160.0;
        FOREVER = 161.0;
        Forever = 162.0;
        FORK = 163.0;
        Fork = 164.0;
        FROM = 165.0;
        From = 166.0;
        FUNCTION = 167.0;
        Function = 168.0;
        GENERATE = 169.0;
        Generate = 170.0;
        GENVAR = 171.0;
        Genvar = 172.0;
        GROUND = 173.0;
        Ground = 174.0;
        HIGHZ0 = 175.0;
        Highz0 = 176.0;
        HIGHZ1 = 177.0;
        Highz1 = 178.0;
        HYPOT = 179.0;
        Hypot = 180.0;
        IDT = 181.0;
        Idt = 182.0;
        IDT_NATURE = 183.0;
        Idt_nature = 184.0;
        IDTMOD = 185.0;
        Idtmod = 186.0;
        IF = 187.0;
        If = 188.0;
        IFNONE = 189.0;
        Ifnone = 190.0;
        INCDIR = 191.0;
        Incdir = 192.0;
        INCLUDE = 193.0;
        Include = 194.0;
        INF = 195.0;
        Inf = 196.0;
        INITIAL = 197.0;
        Initial = 198.0;
        INITIAL_STEP = 199.0;
        Initial_step = 200.0;
        INOUT = 201.0;
        Inout = 202.0;
        INPUT = 203.0;
        Input = 204.0;
        INSTANCE = 205.0;
        Instance = 206.0;
        INTEGER = 207.0;
        Integer = 208.0;
        JOIN = 209.0;
        Join = 210.0;
        LAPLACE_ND = 211.0;
        Laplace_nd = 212.0;
        LAPLACE_NP = 213.0;
        Laplace_np = 214.0;
        LAPLACE_ZD = 215.0;
        Laplace_zd = 216.0;
        LAPLACE_ZP = 217.0;
        Laplace_zp = 218.0;
        LARGE = 219.0;
        Large = 220.0;
        LAST_CROSSING = 221.0;
        Last_crossing = 222.0;
        LIBLIST = 223.0;
        Liblist = 224.0;
        LIBRARY = 225.0;
        Library = 226.0;
        LIMEXP = 227.0;
        Limexp = 228.0;
        LN = 229.0;
        Ln = 230.0;
        LN1P = 231.0;
        Ln1p = 232.0;
        LOCALPARAM = 233.0;
        Localparam = 234.0;
        LOG = 235.0;
        Log = 236.0;
        MACROMODULE = 237.0;
        Macromodule = 238.0;
        MAX = 239.0;
        Max = 240.0;
        MEDIUM = 241.0;
        Medium = 242.0;
        MERGED = 243.0;
        Merged = 244.0;
        MIN = 245.0;
        Min = 246.0;
        MODULE = 247.0;
        Module = 248.0;
        NAND = 249.0;
        Nand = 250.0;
        NATURE = 251.0;
        Nature = 252.0;
        NEGEDGE = 253.0;
        Negedge = 254.0;
        NMOS = 255.0;
        Nmos = 256.0;
        NOISE_TABLE = 257.0;
        Noise_table = 258.0;
        NOISE_TABLE_LOG = 259.0;
        Noise_table_log = 260.0;
        NOR = 261.0;
        Nor = 262.0;
        NOSHOWCANCELLED = 263.0;
        Noshowcancelled = 264.0;
        NOT = 265.0;
        Not = 266.0;
        NOTIF0 = 267.0;
        Notif0 = 268.0;
        NOTIF1 = 269.0;
        Notif1 = 270.0;
        OR = 271.0;
        Or = 272.0;
        OUTPUT = 273.0;
        Output = 274.0;
        PARAMETER = 275.0;
        Parameter = 276.0;
        PARAMSET = 277.0;
        Paramset = 278.0;
        PMOS = 279.0;
        Pmos = 280.0;
        POSEDGE = 281.0;
        Posedge = 282.0;
        POTENTIAL = 283.0;
        Potential = 284.0;
        POW = 285.0;
        Pow = 286.0;
        PRIMITIVE = 287.0;
        Primitive = 288.0;
        PULL0 = 289.0;
        Pull0 = 290.0;
        PULL1 = 291.0;
        Pull1 = 292.0;
        PULLDOWN = 293.0;
        Pulldown = 294.0;
        PULLUP = 295.0;
        Pullup = 296.0;
        PULSESTYLE_ONDETECT = 297.0;
        Pulsestyle_ondetect = 298.0;
        PULSESTYLE_ONEVENT = 299.0;
        Pulsestyle_onevent = 300.0;
        RCMOS = 301.0;
        Rcmos = 302.0;
        REAL = 303.0;
        Real = 304.0;
        REALTIME = 305.0;
        Realtime = 306.0;
        REG = 307.0;
        Reg = 308.0;
        RELEASE = 309.0;
        Release = 310.0;
        REPEAT = 311.0;
        Repeat = 312.0;
        RESOLVETO = 313.0;
        Resolveto = 314.0;
        RETURN = 315.0;
        Return = 316.0;
        RNMOS = 317.0;
        Rnmos = 318.0;
        RPMOS = 319.0;
        Rpmos = 320.0;
        RTRAN = 321.0;
        Rtran = 322.0;
        RTRANIF0 = 323.0;
        Rtranif0 = 324.0;
        RTRANIF1 = 325.0;
        Rtranif1 = 326.0;
        SCALARED = 327.0;
        Scalared = 328.0;
        SHOWCANCELLED = 329.0;
        Showcancelled = 330.0;
        SIGNED = 331.0;
        Signed = 332.0;
        SIN = 333.0;
        Sin = 334.0;
        SINH = 335.0;
        Sinh = 336.0;
        SLEW = 337.0;
        Slew = 338.0;
        SMALL = 339.0;
        Small = 340.0;
        SPECIFY = 341.0;
        Specify = 342.0;
        SPECPARAM = 343.0;
        Specparam = 344.0;
        SPLIT = 345.0;
        Split = 346.0;
        SQRT = 347.0;
        Sqrt = 348.0;
        STRING = 349.0;
        String = 350.0;
        STRONG0 = 351.0;
        Strong0 = 352.0;
        STRONG1 = 353.0;
        Strong1 = 354.0;
        SUPPLY0 = 355.0;
        Supply0 = 356.0;
        SUPPLY1 = 357.0;
        Supply1 = 358.0;
        TABLE = 359.0;
        Table = 360.0;
        TAN = 361.0;
        Tan = 362.0;
        TANH = 363.0;
        Tanh = 364.0;
        TASK = 365.0;
        Task = 366.0;
        TIME = 367.0;
        Time = 368.0;
        TIMER = 369.0;
        Timer = 370.0;
        TRAN = 371.0;
        Tran = 372.0;
        TRANIF0 = 373.0;
        Tranif0 = 374.0;
        TRANIF1 = 375.0;
        Tranif1 = 376.0;
        TRANSITION = 377.0;
        Transition = 378.0;
        TRI = 379.0;
        Tri = 380.0;
        TRI0 = 381.0;
        Tri0 = 382.0;
        TRI1 = 383.0;
        Tri1 = 384.0;
        TRIAND = 385.0;
        Triand = 386.0;
        TRIOR = 387.0;
        Trior = 388.0;
        TRIREG = 389.0;
        Trireg = 390.0;
        UNITS = 391.0;
        Units = 392.0;
        UNSIGNED = 393.0;
        Unsigned = 394.0;
        USE = 395.0;
        Use = 396.0;
        UWIRE = 397.0;
        Uwire = 398.0;
        VECTORED = 399.0;
        Vectored = 400.0;
        WAIT = 401.0;
        Wait = 402.0;
        WAND = 403.0;
        Wand = 404.0;
        WEAK0 = 405.0;
        Weak0 = 406.0;
        WEAK1 = 407.0;
        Weak1 = 408.0;
        WHILE = 409.0;
        While = 410.0;
        WHITE_NOISE = 411.0;
        White_noise = 412.0;
        WIRE = 413.0;
        Wire = 414.0;
        WOR = 415.0;
        Wor = 416.0;
        WREAL = 417.0;
        Wreal = 418.0;
        XNOR = 419.0;
        Xnor = 420.0;
        XOR = 421.0;
        Xor = 422.0;
        ZI_ND = 423.0;
        Zi_nd = 424.0;
        ZI_NP = 425.0;
        Zi_np = 426.0;
        ZI_ZD = 427.0;
        Zi_zd = 428.0;
        ZI_ZP = 429.0;
        Zi_zp = 430.0;
        observed = ABOVE;
        `CHECKX("uppercase above", observed, 1.0);
        observed = Above;
        `CHECKX("initial-uppercase above", observed, 2.0);
        observed = ABS;
        `CHECKX("uppercase abs", observed, 3.0);
        observed = Abs;
        `CHECKX("initial-uppercase abs", observed, 4.0);
        observed = ABSDELAY;
        `CHECKX("uppercase absdelay", observed, 5.0);
        observed = Absdelay;
        `CHECKX("initial-uppercase absdelay", observed, 6.0);
        observed = ABSDELTA;
        `CHECKX("uppercase absdelta", observed, 7.0);
        observed = Absdelta;
        `CHECKX("initial-uppercase absdelta", observed, 8.0);
        observed = ABSTOL;
        `CHECKX("uppercase abstol", observed, 9.0);
        observed = Abstol;
        `CHECKX("initial-uppercase abstol", observed, 10.0);
        observed = AC_STIM;
        `CHECKX("uppercase ac_stim", observed, 11.0);
        observed = Ac_stim;
        `CHECKX("initial-uppercase ac_stim", observed, 12.0);
        observed = ACCESS;
        `CHECKX("uppercase access", observed, 13.0);
        observed = Access;
        `CHECKX("initial-uppercase access", observed, 14.0);
        observed = ACOS;
        `CHECKX("uppercase acos", observed, 15.0);
        observed = Acos;
        `CHECKX("initial-uppercase acos", observed, 16.0);
        observed = ACOSH;
        `CHECKX("uppercase acosh", observed, 17.0);
        observed = Acosh;
        `CHECKX("initial-uppercase acosh", observed, 18.0);
        observed = ALIASPARAM;
        `CHECKX("uppercase aliasparam", observed, 19.0);
        observed = Aliasparam;
        `CHECKX("initial-uppercase aliasparam", observed, 20.0);
        observed = ALWAYS;
        `CHECKX("uppercase always", observed, 21.0);
        observed = Always;
        `CHECKX("initial-uppercase always", observed, 22.0);
        observed = ANALOG;
        `CHECKX("uppercase analog", observed, 23.0);
        observed = Analog;
        `CHECKX("initial-uppercase analog", observed, 24.0);
        observed = ANALYSIS;
        `CHECKX("uppercase analysis", observed, 25.0);
        observed = Analysis;
        `CHECKX("initial-uppercase analysis", observed, 26.0);
        observed = AND;
        `CHECKX("uppercase and", observed, 27.0);
        observed = And;
        `CHECKX("initial-uppercase and", observed, 28.0);
        observed = ASIN;
        `CHECKX("uppercase asin", observed, 29.0);
        observed = Asin;
        `CHECKX("initial-uppercase asin", observed, 30.0);
        observed = ASINH;
        `CHECKX("uppercase asinh", observed, 31.0);
        observed = Asinh;
        `CHECKX("initial-uppercase asinh", observed, 32.0);
        observed = ASSIGN;
        `CHECKX("uppercase assign", observed, 33.0);
        observed = Assign;
        `CHECKX("initial-uppercase assign", observed, 34.0);
        observed = ATAN;
        `CHECKX("uppercase atan", observed, 35.0);
        observed = Atan;
        `CHECKX("initial-uppercase atan", observed, 36.0);
        observed = ATAN2;
        `CHECKX("uppercase atan2", observed, 37.0);
        observed = Atan2;
        `CHECKX("initial-uppercase atan2", observed, 38.0);
        observed = ATANH;
        `CHECKX("uppercase atanh", observed, 39.0);
        observed = Atanh;
        `CHECKX("initial-uppercase atanh", observed, 40.0);
        observed = AUTOMATIC;
        `CHECKX("uppercase automatic", observed, 41.0);
        observed = Automatic;
        `CHECKX("initial-uppercase automatic", observed, 42.0);
        observed = BEGIN;
        `CHECKX("uppercase begin", observed, 43.0);
        observed = Begin;
        `CHECKX("initial-uppercase begin", observed, 44.0);
        observed = BRANCH;
        `CHECKX("uppercase branch", observed, 45.0);
        observed = Branch;
        `CHECKX("initial-uppercase branch", observed, 46.0);
        observed = BREAK;
        `CHECKX("uppercase break", observed, 47.0);
        observed = Break;
        `CHECKX("initial-uppercase break", observed, 48.0);
        observed = BUF;
        `CHECKX("uppercase buf", observed, 49.0);
        observed = Buf;
        `CHECKX("initial-uppercase buf", observed, 50.0);
        observed = BUFIF0;
        `CHECKX("uppercase bufif0", observed, 51.0);
        observed = Bufif0;
        `CHECKX("initial-uppercase bufif0", observed, 52.0);
        observed = BUFIF1;
        `CHECKX("uppercase bufif1", observed, 53.0);
        observed = Bufif1;
        `CHECKX("initial-uppercase bufif1", observed, 54.0);
        observed = CASE;
        `CHECKX("uppercase case", observed, 55.0);
        observed = Case;
        `CHECKX("initial-uppercase case", observed, 56.0);
        observed = CASEX;
        `CHECKX("uppercase casex", observed, 57.0);
        observed = Casex;
        `CHECKX("initial-uppercase casex", observed, 58.0);
        observed = CASEZ;
        `CHECKX("uppercase casez", observed, 59.0);
        observed = Casez;
        `CHECKX("initial-uppercase casez", observed, 60.0);
        observed = CEIL;
        `CHECKX("uppercase ceil", observed, 61.0);
        observed = Ceil;
        `CHECKX("initial-uppercase ceil", observed, 62.0);
        observed = CELL;
        `CHECKX("uppercase cell", observed, 63.0);
        observed = Cell;
        `CHECKX("initial-uppercase cell", observed, 64.0);
        observed = CMOS;
        `CHECKX("uppercase cmos", observed, 65.0);
        observed = Cmos;
        `CHECKX("initial-uppercase cmos", observed, 66.0);
        observed = CONFIG;
        `CHECKX("uppercase config", observed, 67.0);
        observed = Config;
        `CHECKX("initial-uppercase config", observed, 68.0);
        observed = CONNECT;
        `CHECKX("uppercase connect", observed, 69.0);
        observed = Connect;
        `CHECKX("initial-uppercase connect", observed, 70.0);
        observed = CONNECTMODULE;
        `CHECKX("uppercase connectmodule", observed, 71.0);
        observed = Connectmodule;
        `CHECKX("initial-uppercase connectmodule", observed, 72.0);
        observed = CONNECTRULES;
        `CHECKX("uppercase connectrules", observed, 73.0);
        observed = Connectrules;
        `CHECKX("initial-uppercase connectrules", observed, 74.0);
        observed = CONTINUE;
        `CHECKX("uppercase continue", observed, 75.0);
        observed = Continue;
        `CHECKX("initial-uppercase continue", observed, 76.0);
        observed = CONTINUOUS;
        `CHECKX("uppercase continuous", observed, 77.0);
        observed = Continuous;
        `CHECKX("initial-uppercase continuous", observed, 78.0);
        observed = COS;
        `CHECKX("uppercase cos", observed, 79.0);
        observed = Cos;
        `CHECKX("initial-uppercase cos", observed, 80.0);
        observed = COSH;
        `CHECKX("uppercase cosh", observed, 81.0);
        observed = Cosh;
        `CHECKX("initial-uppercase cosh", observed, 82.0);
        observed = CROSS;
        `CHECKX("uppercase cross", observed, 83.0);
        observed = Cross;
        `CHECKX("initial-uppercase cross", observed, 84.0);
        observed = DDT;
        `CHECKX("uppercase ddt", observed, 85.0);
        observed = Ddt;
        `CHECKX("initial-uppercase ddt", observed, 86.0);
        observed = DDT_NATURE;
        `CHECKX("uppercase ddt_nature", observed, 87.0);
        observed = Ddt_nature;
        `CHECKX("initial-uppercase ddt_nature", observed, 88.0);
        observed = DDX;
        `CHECKX("uppercase ddx", observed, 89.0);
        observed = Ddx;
        `CHECKX("initial-uppercase ddx", observed, 90.0);
        observed = DEASSIGN;
        `CHECKX("uppercase deassign", observed, 91.0);
        observed = Deassign;
        `CHECKX("initial-uppercase deassign", observed, 92.0);
        observed = DEFAULT;
        `CHECKX("uppercase default", observed, 93.0);
        observed = Default;
        `CHECKX("initial-uppercase default", observed, 94.0);
        observed = DEFPARAM;
        `CHECKX("uppercase defparam", observed, 95.0);
        observed = Defparam;
        `CHECKX("initial-uppercase defparam", observed, 96.0);
        observed = DESIGN;
        `CHECKX("uppercase design", observed, 97.0);
        observed = Design;
        `CHECKX("initial-uppercase design", observed, 98.0);
        observed = DISABLE;
        `CHECKX("uppercase disable", observed, 99.0);
        observed = Disable;
        `CHECKX("initial-uppercase disable", observed, 100.0);
        observed = DISCIPLINE;
        `CHECKX("uppercase discipline", observed, 101.0);
        observed = Discipline;
        `CHECKX("initial-uppercase discipline", observed, 102.0);
        observed = DISCRETE;
        `CHECKX("uppercase discrete", observed, 103.0);
        observed = Discrete;
        `CHECKX("initial-uppercase discrete", observed, 104.0);
        observed = DOMAIN;
        `CHECKX("uppercase domain", observed, 105.0);
        observed = Domain;
        `CHECKX("initial-uppercase domain", observed, 106.0);
        observed = DRIVER_UPDATE;
        `CHECKX("uppercase driver_update", observed, 107.0);
        observed = Driver_update;
        `CHECKX("initial-uppercase driver_update", observed, 108.0);
        observed = EDGE;
        `CHECKX("uppercase edge", observed, 109.0);
        observed = Edge;
        `CHECKX("initial-uppercase edge", observed, 110.0);
        observed = ELSE;
        `CHECKX("uppercase else", observed, 111.0);
        observed = Else;
        `CHECKX("initial-uppercase else", observed, 112.0);
        observed = END;
        `CHECKX("uppercase end", observed, 113.0);
        observed = End;
        `CHECKX("initial-uppercase end", observed, 114.0);
        observed = ENDCASE;
        `CHECKX("uppercase endcase", observed, 115.0);
        observed = Endcase;
        `CHECKX("initial-uppercase endcase", observed, 116.0);
        observed = ENDCONFIG;
        `CHECKX("uppercase endconfig", observed, 117.0);
        observed = Endconfig;
        `CHECKX("initial-uppercase endconfig", observed, 118.0);
        observed = ENDCONNECTRULES;
        `CHECKX("uppercase endconnectrules", observed, 119.0);
        observed = Endconnectrules;
        `CHECKX("initial-uppercase endconnectrules", observed, 120.0);
        observed = ENDDISCIPLINE;
        `CHECKX("uppercase enddiscipline", observed, 121.0);
        observed = Enddiscipline;
        `CHECKX("initial-uppercase enddiscipline", observed, 122.0);
        observed = ENDFUNCTION;
        `CHECKX("uppercase endfunction", observed, 123.0);
        observed = Endfunction;
        `CHECKX("initial-uppercase endfunction", observed, 124.0);
        observed = ENDGENERATE;
        `CHECKX("uppercase endgenerate", observed, 125.0);
        observed = Endgenerate;
        `CHECKX("initial-uppercase endgenerate", observed, 126.0);
        observed = ENDMODULE;
        `CHECKX("uppercase endmodule", observed, 127.0);
        observed = Endmodule;
        `CHECKX("initial-uppercase endmodule", observed, 128.0);
        observed = ENDNATURE;
        `CHECKX("uppercase endnature", observed, 129.0);
        observed = Endnature;
        `CHECKX("initial-uppercase endnature", observed, 130.0);
        observed = ENDPARAMSET;
        `CHECKX("uppercase endparamset", observed, 131.0);
        observed = Endparamset;
        `CHECKX("initial-uppercase endparamset", observed, 132.0);
        observed = ENDPRIMITIVE;
        `CHECKX("uppercase endprimitive", observed, 133.0);
        observed = Endprimitive;
        `CHECKX("initial-uppercase endprimitive", observed, 134.0);
        observed = ENDSPECIFY;
        `CHECKX("uppercase endspecify", observed, 135.0);
        observed = Endspecify;
        `CHECKX("initial-uppercase endspecify", observed, 136.0);
        observed = ENDTABLE;
        `CHECKX("uppercase endtable", observed, 137.0);
        observed = Endtable;
        `CHECKX("initial-uppercase endtable", observed, 138.0);
        observed = ENDTASK;
        `CHECKX("uppercase endtask", observed, 139.0);
        observed = Endtask;
        `CHECKX("initial-uppercase endtask", observed, 140.0);
        observed = EVENT;
        `CHECKX("uppercase event", observed, 141.0);
        observed = Event;
        `CHECKX("initial-uppercase event", observed, 142.0);
        observed = EXCLUDE;
        `CHECKX("uppercase exclude", observed, 143.0);
        observed = Exclude;
        `CHECKX("initial-uppercase exclude", observed, 144.0);
        observed = EXP;
        `CHECKX("uppercase exp", observed, 145.0);
        observed = Exp;
        `CHECKX("initial-uppercase exp", observed, 146.0);
        observed = EXPM1;
        `CHECKX("uppercase expm1", observed, 147.0);
        observed = Expm1;
        `CHECKX("initial-uppercase expm1", observed, 148.0);
        observed = FINAL_STEP;
        `CHECKX("uppercase final_step", observed, 149.0);
        observed = Final_step;
        `CHECKX("initial-uppercase final_step", observed, 150.0);
        observed = FLICKER_NOISE;
        `CHECKX("uppercase flicker_noise", observed, 151.0);
        observed = Flicker_noise;
        `CHECKX("initial-uppercase flicker_noise", observed, 152.0);
        observed = FLOOR;
        `CHECKX("uppercase floor", observed, 153.0);
        observed = Floor;
        `CHECKX("initial-uppercase floor", observed, 154.0);
        observed = FLOW;
        `CHECKX("uppercase flow", observed, 155.0);
        observed = Flow;
        `CHECKX("initial-uppercase flow", observed, 156.0);
        observed = FOR;
        `CHECKX("uppercase for", observed, 157.0);
        observed = For;
        `CHECKX("initial-uppercase for", observed, 158.0);
        observed = FORCE;
        `CHECKX("uppercase force", observed, 159.0);
        observed = Force;
        `CHECKX("initial-uppercase force", observed, 160.0);
        observed = FOREVER;
        `CHECKX("uppercase forever", observed, 161.0);
        observed = Forever;
        `CHECKX("initial-uppercase forever", observed, 162.0);
        observed = FORK;
        `CHECKX("uppercase fork", observed, 163.0);
        observed = Fork;
        `CHECKX("initial-uppercase fork", observed, 164.0);
        observed = FROM;
        `CHECKX("uppercase from", observed, 165.0);
        observed = From;
        `CHECKX("initial-uppercase from", observed, 166.0);
        observed = FUNCTION;
        `CHECKX("uppercase function", observed, 167.0);
        observed = Function;
        `CHECKX("initial-uppercase function", observed, 168.0);
        observed = GENERATE;
        `CHECKX("uppercase generate", observed, 169.0);
        observed = Generate;
        `CHECKX("initial-uppercase generate", observed, 170.0);
        observed = GENVAR;
        `CHECKX("uppercase genvar", observed, 171.0);
        observed = Genvar;
        `CHECKX("initial-uppercase genvar", observed, 172.0);
        observed = GROUND;
        `CHECKX("uppercase ground", observed, 173.0);
        observed = Ground;
        `CHECKX("initial-uppercase ground", observed, 174.0);
        observed = HIGHZ0;
        `CHECKX("uppercase highz0", observed, 175.0);
        observed = Highz0;
        `CHECKX("initial-uppercase highz0", observed, 176.0);
        observed = HIGHZ1;
        `CHECKX("uppercase highz1", observed, 177.0);
        observed = Highz1;
        `CHECKX("initial-uppercase highz1", observed, 178.0);
        observed = HYPOT;
        `CHECKX("uppercase hypot", observed, 179.0);
        observed = Hypot;
        `CHECKX("initial-uppercase hypot", observed, 180.0);
        observed = IDT;
        `CHECKX("uppercase idt", observed, 181.0);
        observed = Idt;
        `CHECKX("initial-uppercase idt", observed, 182.0);
        observed = IDT_NATURE;
        `CHECKX("uppercase idt_nature", observed, 183.0);
        observed = Idt_nature;
        `CHECKX("initial-uppercase idt_nature", observed, 184.0);
        observed = IDTMOD;
        `CHECKX("uppercase idtmod", observed, 185.0);
        observed = Idtmod;
        `CHECKX("initial-uppercase idtmod", observed, 186.0);
        observed = IF;
        `CHECKX("uppercase if", observed, 187.0);
        observed = If;
        `CHECKX("initial-uppercase if", observed, 188.0);
        observed = IFNONE;
        `CHECKX("uppercase ifnone", observed, 189.0);
        observed = Ifnone;
        `CHECKX("initial-uppercase ifnone", observed, 190.0);
        observed = INCDIR;
        `CHECKX("uppercase incdir", observed, 191.0);
        observed = Incdir;
        `CHECKX("initial-uppercase incdir", observed, 192.0);
        observed = INCLUDE;
        `CHECKX("uppercase include", observed, 193.0);
        observed = Include;
        `CHECKX("initial-uppercase include", observed, 194.0);
        observed = INF;
        `CHECKX("uppercase inf", observed, 195.0);
        observed = Inf;
        `CHECKX("initial-uppercase inf", observed, 196.0);
        observed = INITIAL;
        `CHECKX("uppercase initial", observed, 197.0);
        observed = Initial;
        `CHECKX("initial-uppercase initial", observed, 198.0);
        observed = INITIAL_STEP;
        `CHECKX("uppercase initial_step", observed, 199.0);
        observed = Initial_step;
        `CHECKX("initial-uppercase initial_step", observed, 200.0);
        observed = INOUT;
        `CHECKX("uppercase inout", observed, 201.0);
        observed = Inout;
        `CHECKX("initial-uppercase inout", observed, 202.0);
        observed = INPUT;
        `CHECKX("uppercase input", observed, 203.0);
        observed = Input;
        `CHECKX("initial-uppercase input", observed, 204.0);
        observed = INSTANCE;
        `CHECKX("uppercase instance", observed, 205.0);
        observed = Instance;
        `CHECKX("initial-uppercase instance", observed, 206.0);
        observed = INTEGER;
        `CHECKX("uppercase integer", observed, 207.0);
        observed = Integer;
        `CHECKX("initial-uppercase integer", observed, 208.0);
        observed = JOIN;
        `CHECKX("uppercase join", observed, 209.0);
        observed = Join;
        `CHECKX("initial-uppercase join", observed, 210.0);
        observed = LAPLACE_ND;
        `CHECKX("uppercase laplace_nd", observed, 211.0);
        observed = Laplace_nd;
        `CHECKX("initial-uppercase laplace_nd", observed, 212.0);
        observed = LAPLACE_NP;
        `CHECKX("uppercase laplace_np", observed, 213.0);
        observed = Laplace_np;
        `CHECKX("initial-uppercase laplace_np", observed, 214.0);
        observed = LAPLACE_ZD;
        `CHECKX("uppercase laplace_zd", observed, 215.0);
        observed = Laplace_zd;
        `CHECKX("initial-uppercase laplace_zd", observed, 216.0);
        observed = LAPLACE_ZP;
        `CHECKX("uppercase laplace_zp", observed, 217.0);
        observed = Laplace_zp;
        `CHECKX("initial-uppercase laplace_zp", observed, 218.0);
        observed = LARGE;
        `CHECKX("uppercase large", observed, 219.0);
        observed = Large;
        `CHECKX("initial-uppercase large", observed, 220.0);
        observed = LAST_CROSSING;
        `CHECKX("uppercase last_crossing", observed, 221.0);
        observed = Last_crossing;
        `CHECKX("initial-uppercase last_crossing", observed, 222.0);
        observed = LIBLIST;
        `CHECKX("uppercase liblist", observed, 223.0);
        observed = Liblist;
        `CHECKX("initial-uppercase liblist", observed, 224.0);
        observed = LIBRARY;
        `CHECKX("uppercase library", observed, 225.0);
        observed = Library;
        `CHECKX("initial-uppercase library", observed, 226.0);
        observed = LIMEXP;
        `CHECKX("uppercase limexp", observed, 227.0);
        observed = Limexp;
        `CHECKX("initial-uppercase limexp", observed, 228.0);
        observed = LN;
        `CHECKX("uppercase ln", observed, 229.0);
        observed = Ln;
        `CHECKX("initial-uppercase ln", observed, 230.0);
        observed = LN1P;
        `CHECKX("uppercase ln1p", observed, 231.0);
        observed = Ln1p;
        `CHECKX("initial-uppercase ln1p", observed, 232.0);
        observed = LOCALPARAM;
        `CHECKX("uppercase localparam", observed, 233.0);
        observed = Localparam;
        `CHECKX("initial-uppercase localparam", observed, 234.0);
        observed = LOG;
        `CHECKX("uppercase log", observed, 235.0);
        observed = Log;
        `CHECKX("initial-uppercase log", observed, 236.0);
        observed = MACROMODULE;
        `CHECKX("uppercase macromodule", observed, 237.0);
        observed = Macromodule;
        `CHECKX("initial-uppercase macromodule", observed, 238.0);
        observed = MAX;
        `CHECKX("uppercase max", observed, 239.0);
        observed = Max;
        `CHECKX("initial-uppercase max", observed, 240.0);
        observed = MEDIUM;
        `CHECKX("uppercase medium", observed, 241.0);
        observed = Medium;
        `CHECKX("initial-uppercase medium", observed, 242.0);
        observed = MERGED;
        `CHECKX("uppercase merged", observed, 243.0);
        observed = Merged;
        `CHECKX("initial-uppercase merged", observed, 244.0);
        observed = MIN;
        `CHECKX("uppercase min", observed, 245.0);
        observed = Min;
        `CHECKX("initial-uppercase min", observed, 246.0);
        observed = MODULE;
        `CHECKX("uppercase module", observed, 247.0);
        observed = Module;
        `CHECKX("initial-uppercase module", observed, 248.0);
        observed = NAND;
        `CHECKX("uppercase nand", observed, 249.0);
        observed = Nand;
        `CHECKX("initial-uppercase nand", observed, 250.0);
        observed = NATURE;
        `CHECKX("uppercase nature", observed, 251.0);
        observed = Nature;
        `CHECKX("initial-uppercase nature", observed, 252.0);
        observed = NEGEDGE;
        `CHECKX("uppercase negedge", observed, 253.0);
        observed = Negedge;
        `CHECKX("initial-uppercase negedge", observed, 254.0);
        observed = NMOS;
        `CHECKX("uppercase nmos", observed, 255.0);
        observed = Nmos;
        `CHECKX("initial-uppercase nmos", observed, 256.0);
        observed = NOISE_TABLE;
        `CHECKX("uppercase noise_table", observed, 257.0);
        observed = Noise_table;
        `CHECKX("initial-uppercase noise_table", observed, 258.0);
        observed = NOISE_TABLE_LOG;
        `CHECKX("uppercase noise_table_log", observed, 259.0);
        observed = Noise_table_log;
        `CHECKX("initial-uppercase noise_table_log", observed, 260.0);
        observed = NOR;
        `CHECKX("uppercase nor", observed, 261.0);
        observed = Nor;
        `CHECKX("initial-uppercase nor", observed, 262.0);
        observed = NOSHOWCANCELLED;
        `CHECKX("uppercase noshowcancelled", observed, 263.0);
        observed = Noshowcancelled;
        `CHECKX("initial-uppercase noshowcancelled", observed, 264.0);
        observed = NOT;
        `CHECKX("uppercase not", observed, 265.0);
        observed = Not;
        `CHECKX("initial-uppercase not", observed, 266.0);
        observed = NOTIF0;
        `CHECKX("uppercase notif0", observed, 267.0);
        observed = Notif0;
        `CHECKX("initial-uppercase notif0", observed, 268.0);
        observed = NOTIF1;
        `CHECKX("uppercase notif1", observed, 269.0);
        observed = Notif1;
        `CHECKX("initial-uppercase notif1", observed, 270.0);
        observed = OR;
        `CHECKX("uppercase or", observed, 271.0);
        observed = Or;
        `CHECKX("initial-uppercase or", observed, 272.0);
        observed = OUTPUT;
        `CHECKX("uppercase output", observed, 273.0);
        observed = Output;
        `CHECKX("initial-uppercase output", observed, 274.0);
        observed = PARAMETER;
        `CHECKX("uppercase parameter", observed, 275.0);
        observed = Parameter;
        `CHECKX("initial-uppercase parameter", observed, 276.0);
        observed = PARAMSET;
        `CHECKX("uppercase paramset", observed, 277.0);
        observed = Paramset;
        `CHECKX("initial-uppercase paramset", observed, 278.0);
        observed = PMOS;
        `CHECKX("uppercase pmos", observed, 279.0);
        observed = Pmos;
        `CHECKX("initial-uppercase pmos", observed, 280.0);
        observed = POSEDGE;
        `CHECKX("uppercase posedge", observed, 281.0);
        observed = Posedge;
        `CHECKX("initial-uppercase posedge", observed, 282.0);
        observed = POTENTIAL;
        `CHECKX("uppercase potential", observed, 283.0);
        observed = Potential;
        `CHECKX("initial-uppercase potential", observed, 284.0);
        observed = POW;
        `CHECKX("uppercase pow", observed, 285.0);
        observed = Pow;
        `CHECKX("initial-uppercase pow", observed, 286.0);
        observed = PRIMITIVE;
        `CHECKX("uppercase primitive", observed, 287.0);
        observed = Primitive;
        `CHECKX("initial-uppercase primitive", observed, 288.0);
        observed = PULL0;
        `CHECKX("uppercase pull0", observed, 289.0);
        observed = Pull0;
        `CHECKX("initial-uppercase pull0", observed, 290.0);
        observed = PULL1;
        `CHECKX("uppercase pull1", observed, 291.0);
        observed = Pull1;
        `CHECKX("initial-uppercase pull1", observed, 292.0);
        observed = PULLDOWN;
        `CHECKX("uppercase pulldown", observed, 293.0);
        observed = Pulldown;
        `CHECKX("initial-uppercase pulldown", observed, 294.0);
        observed = PULLUP;
        `CHECKX("uppercase pullup", observed, 295.0);
        observed = Pullup;
        `CHECKX("initial-uppercase pullup", observed, 296.0);
        observed = PULSESTYLE_ONDETECT;
        `CHECKX("uppercase pulsestyle_ondetect", observed, 297.0);
        observed = Pulsestyle_ondetect;
        `CHECKX("initial-uppercase pulsestyle_ondetect", observed, 298.0);
        observed = PULSESTYLE_ONEVENT;
        `CHECKX("uppercase pulsestyle_onevent", observed, 299.0);
        observed = Pulsestyle_onevent;
        `CHECKX("initial-uppercase pulsestyle_onevent", observed, 300.0);
        observed = RCMOS;
        `CHECKX("uppercase rcmos", observed, 301.0);
        observed = Rcmos;
        `CHECKX("initial-uppercase rcmos", observed, 302.0);
        observed = REAL;
        `CHECKX("uppercase real", observed, 303.0);
        observed = Real;
        `CHECKX("initial-uppercase real", observed, 304.0);
        observed = REALTIME;
        `CHECKX("uppercase realtime", observed, 305.0);
        observed = Realtime;
        `CHECKX("initial-uppercase realtime", observed, 306.0);
        observed = REG;
        `CHECKX("uppercase reg", observed, 307.0);
        observed = Reg;
        `CHECKX("initial-uppercase reg", observed, 308.0);
        observed = RELEASE;
        `CHECKX("uppercase release", observed, 309.0);
        observed = Release;
        `CHECKX("initial-uppercase release", observed, 310.0);
        observed = REPEAT;
        `CHECKX("uppercase repeat", observed, 311.0);
        observed = Repeat;
        `CHECKX("initial-uppercase repeat", observed, 312.0);
        observed = RESOLVETO;
        `CHECKX("uppercase resolveto", observed, 313.0);
        observed = Resolveto;
        `CHECKX("initial-uppercase resolveto", observed, 314.0);
        observed = RETURN;
        `CHECKX("uppercase return", observed, 315.0);
        observed = Return;
        `CHECKX("initial-uppercase return", observed, 316.0);
        observed = RNMOS;
        `CHECKX("uppercase rnmos", observed, 317.0);
        observed = Rnmos;
        `CHECKX("initial-uppercase rnmos", observed, 318.0);
        observed = RPMOS;
        `CHECKX("uppercase rpmos", observed, 319.0);
        observed = Rpmos;
        `CHECKX("initial-uppercase rpmos", observed, 320.0);
        observed = RTRAN;
        `CHECKX("uppercase rtran", observed, 321.0);
        observed = Rtran;
        `CHECKX("initial-uppercase rtran", observed, 322.0);
        observed = RTRANIF0;
        `CHECKX("uppercase rtranif0", observed, 323.0);
        observed = Rtranif0;
        `CHECKX("initial-uppercase rtranif0", observed, 324.0);
        observed = RTRANIF1;
        `CHECKX("uppercase rtranif1", observed, 325.0);
        observed = Rtranif1;
        `CHECKX("initial-uppercase rtranif1", observed, 326.0);
        observed = SCALARED;
        `CHECKX("uppercase scalared", observed, 327.0);
        observed = Scalared;
        `CHECKX("initial-uppercase scalared", observed, 328.0);
        observed = SHOWCANCELLED;
        `CHECKX("uppercase showcancelled", observed, 329.0);
        observed = Showcancelled;
        `CHECKX("initial-uppercase showcancelled", observed, 330.0);
        observed = SIGNED;
        `CHECKX("uppercase signed", observed, 331.0);
        observed = Signed;
        `CHECKX("initial-uppercase signed", observed, 332.0);
        observed = SIN;
        `CHECKX("uppercase sin", observed, 333.0);
        observed = Sin;
        `CHECKX("initial-uppercase sin", observed, 334.0);
        observed = SINH;
        `CHECKX("uppercase sinh", observed, 335.0);
        observed = Sinh;
        `CHECKX("initial-uppercase sinh", observed, 336.0);
        observed = SLEW;
        `CHECKX("uppercase slew", observed, 337.0);
        observed = Slew;
        `CHECKX("initial-uppercase slew", observed, 338.0);
        observed = SMALL;
        `CHECKX("uppercase small", observed, 339.0);
        observed = Small;
        `CHECKX("initial-uppercase small", observed, 340.0);
        observed = SPECIFY;
        `CHECKX("uppercase specify", observed, 341.0);
        observed = Specify;
        `CHECKX("initial-uppercase specify", observed, 342.0);
        observed = SPECPARAM;
        `CHECKX("uppercase specparam", observed, 343.0);
        observed = Specparam;
        `CHECKX("initial-uppercase specparam", observed, 344.0);
        observed = SPLIT;
        `CHECKX("uppercase split", observed, 345.0);
        observed = Split;
        `CHECKX("initial-uppercase split", observed, 346.0);
        observed = SQRT;
        `CHECKX("uppercase sqrt", observed, 347.0);
        observed = Sqrt;
        `CHECKX("initial-uppercase sqrt", observed, 348.0);
        observed = STRING;
        `CHECKX("uppercase string", observed, 349.0);
        observed = String;
        `CHECKX("initial-uppercase string", observed, 350.0);
        observed = STRONG0;
        `CHECKX("uppercase strong0", observed, 351.0);
        observed = Strong0;
        `CHECKX("initial-uppercase strong0", observed, 352.0);
        observed = STRONG1;
        `CHECKX("uppercase strong1", observed, 353.0);
        observed = Strong1;
        `CHECKX("initial-uppercase strong1", observed, 354.0);
        observed = SUPPLY0;
        `CHECKX("uppercase supply0", observed, 355.0);
        observed = Supply0;
        `CHECKX("initial-uppercase supply0", observed, 356.0);
        observed = SUPPLY1;
        `CHECKX("uppercase supply1", observed, 357.0);
        observed = Supply1;
        `CHECKX("initial-uppercase supply1", observed, 358.0);
        observed = TABLE;
        `CHECKX("uppercase table", observed, 359.0);
        observed = Table;
        `CHECKX("initial-uppercase table", observed, 360.0);
        observed = TAN;
        `CHECKX("uppercase tan", observed, 361.0);
        observed = Tan;
        `CHECKX("initial-uppercase tan", observed, 362.0);
        observed = TANH;
        `CHECKX("uppercase tanh", observed, 363.0);
        observed = Tanh;
        `CHECKX("initial-uppercase tanh", observed, 364.0);
        observed = TASK;
        `CHECKX("uppercase task", observed, 365.0);
        observed = Task;
        `CHECKX("initial-uppercase task", observed, 366.0);
        observed = TIME;
        `CHECKX("uppercase time", observed, 367.0);
        observed = Time;
        `CHECKX("initial-uppercase time", observed, 368.0);
        observed = TIMER;
        `CHECKX("uppercase timer", observed, 369.0);
        observed = Timer;
        `CHECKX("initial-uppercase timer", observed, 370.0);
        observed = TRAN;
        `CHECKX("uppercase tran", observed, 371.0);
        observed = Tran;
        `CHECKX("initial-uppercase tran", observed, 372.0);
        observed = TRANIF0;
        `CHECKX("uppercase tranif0", observed, 373.0);
        observed = Tranif0;
        `CHECKX("initial-uppercase tranif0", observed, 374.0);
        observed = TRANIF1;
        `CHECKX("uppercase tranif1", observed, 375.0);
        observed = Tranif1;
        `CHECKX("initial-uppercase tranif1", observed, 376.0);
        observed = TRANSITION;
        `CHECKX("uppercase transition", observed, 377.0);
        observed = Transition;
        `CHECKX("initial-uppercase transition", observed, 378.0);
        observed = TRI;
        `CHECKX("uppercase tri", observed, 379.0);
        observed = Tri;
        `CHECKX("initial-uppercase tri", observed, 380.0);
        observed = TRI0;
        `CHECKX("uppercase tri0", observed, 381.0);
        observed = Tri0;
        `CHECKX("initial-uppercase tri0", observed, 382.0);
        observed = TRI1;
        `CHECKX("uppercase tri1", observed, 383.0);
        observed = Tri1;
        `CHECKX("initial-uppercase tri1", observed, 384.0);
        observed = TRIAND;
        `CHECKX("uppercase triand", observed, 385.0);
        observed = Triand;
        `CHECKX("initial-uppercase triand", observed, 386.0);
        observed = TRIOR;
        `CHECKX("uppercase trior", observed, 387.0);
        observed = Trior;
        `CHECKX("initial-uppercase trior", observed, 388.0);
        observed = TRIREG;
        `CHECKX("uppercase trireg", observed, 389.0);
        observed = Trireg;
        `CHECKX("initial-uppercase trireg", observed, 390.0);
        observed = UNITS;
        `CHECKX("uppercase units", observed, 391.0);
        observed = Units;
        `CHECKX("initial-uppercase units", observed, 392.0);
        observed = UNSIGNED;
        `CHECKX("uppercase unsigned", observed, 393.0);
        observed = Unsigned;
        `CHECKX("initial-uppercase unsigned", observed, 394.0);
        observed = USE;
        `CHECKX("uppercase use", observed, 395.0);
        observed = Use;
        `CHECKX("initial-uppercase use", observed, 396.0);
        observed = UWIRE;
        `CHECKX("uppercase uwire", observed, 397.0);
        observed = Uwire;
        `CHECKX("initial-uppercase uwire", observed, 398.0);
        observed = VECTORED;
        `CHECKX("uppercase vectored", observed, 399.0);
        observed = Vectored;
        `CHECKX("initial-uppercase vectored", observed, 400.0);
        observed = WAIT;
        `CHECKX("uppercase wait", observed, 401.0);
        observed = Wait;
        `CHECKX("initial-uppercase wait", observed, 402.0);
        observed = WAND;
        `CHECKX("uppercase wand", observed, 403.0);
        observed = Wand;
        `CHECKX("initial-uppercase wand", observed, 404.0);
        observed = WEAK0;
        `CHECKX("uppercase weak0", observed, 405.0);
        observed = Weak0;
        `CHECKX("initial-uppercase weak0", observed, 406.0);
        observed = WEAK1;
        `CHECKX("uppercase weak1", observed, 407.0);
        observed = Weak1;
        `CHECKX("initial-uppercase weak1", observed, 408.0);
        observed = WHILE;
        `CHECKX("uppercase while", observed, 409.0);
        observed = While;
        `CHECKX("initial-uppercase while", observed, 410.0);
        observed = WHITE_NOISE;
        `CHECKX("uppercase white_noise", observed, 411.0);
        observed = White_noise;
        `CHECKX("initial-uppercase white_noise", observed, 412.0);
        observed = WIRE;
        `CHECKX("uppercase wire", observed, 413.0);
        observed = Wire;
        `CHECKX("initial-uppercase wire", observed, 414.0);
        observed = WOR;
        `CHECKX("uppercase wor", observed, 415.0);
        observed = Wor;
        `CHECKX("initial-uppercase wor", observed, 416.0);
        observed = WREAL;
        `CHECKX("uppercase wreal", observed, 417.0);
        observed = Wreal;
        `CHECKX("initial-uppercase wreal", observed, 418.0);
        observed = XNOR;
        `CHECKX("uppercase xnor", observed, 419.0);
        observed = Xnor;
        `CHECKX("initial-uppercase xnor", observed, 420.0);
        observed = XOR;
        `CHECKX("uppercase xor", observed, 421.0);
        observed = Xor;
        `CHECKX("initial-uppercase xor", observed, 422.0);
        observed = ZI_ND;
        `CHECKX("uppercase zi_nd", observed, 423.0);
        observed = Zi_nd;
        `CHECKX("initial-uppercase zi_nd", observed, 424.0);
        observed = ZI_NP;
        `CHECKX("uppercase zi_np", observed, 425.0);
        observed = Zi_np;
        `CHECKX("initial-uppercase zi_np", observed, 426.0);
        observed = ZI_ZD;
        `CHECKX("uppercase zi_zd", observed, 427.0);
        observed = Zi_zd;
        `CHECKX("initial-uppercase zi_zd", observed, 428.0);
        observed = ZI_ZP;
        `CHECKX("uppercase zi_zp", observed, 429.0);
        observed = Zi_zp;
        `CHECKX("initial-uppercase zi_zp", observed, 430.0);
        I(p,n) <+ 0.0;
    end
endmodule
