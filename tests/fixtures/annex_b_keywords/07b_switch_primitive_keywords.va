// Annex B: "Verilog-AMS reserves the keywords listed in Table B.1." A reserved
// spelling is therefore not available as an identifier, and `real <keyword>;`
// is a syntax error in any conforming compiler.
//
// The MOS and CMOS switch types (`rnmos`, `rpmos`, `rcmos`) and the pull gates
// (`pulldown`, `pullup`) of IEEE 1364-2005 A.3.1, plus three spellings that are
// gate types rather than switches: `nor` is an `n_input_gatetype` and
// `notif0`/`notif1` are `enable_gatetype`s. Same reasoning as 07: the
// instantiations are legal source, the reservedness is the rule.
//
// This is a reservedness census, not a feature test: one declaration per line so
// the parser resynchronises at each `;` and reports every spelling separately,
// and one `//! reject` line per spelling so each keyword is proved individually
// rather than the file passing on whichever token the parser tripped over first.
//
// `nmos` and `pmos` are not declared here: they are substrings of `rnmos` and
// `rpmos`. They are censused in 22_shadowed_spellings.va, which explains the
// mechanism.
//! lrm B
//! reject-only E0208
//! reject nor
//! reject notif0
//! reject notif1
//! reject pulldown
//! reject pullup
//! reject rcmos
//! reject rnmos
//! reject rpmos
module annex_b_reserved_switch_primitive_keywords;
    real nor;
    real notif0;
    real notif1;
    real pulldown;
    real pullup;
    real rcmos;
    real rnmos;
    real rpmos;
endmodule
