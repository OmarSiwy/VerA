// Annex B: "Verilog-AMS reserves the keywords listed in Table B.1." A reserved
// spelling is therefore not available as an identifier, and `real <keyword>;`
// is a syntax error in any conforming compiler.
//
// The net-type, drive-strength and charge-strength family of IEEE 1364-2005
// A.2.1.3 / A.2.2.2. The earlier fixture here spelled 26 legal net declarations
// and got a diagnostic pointing at a strength parenthesis, naming no keyword at
// all. `wire` and `reg` are in Table B.1 and were missing; they are pinned now,
// elsewhere (see below).
//
// This is a reservedness census, not a feature test: one declaration per line so
// the parser resynchronises at each `;` and reports every spelling separately,
// and one `//! reject` line per spelling so each keyword is proved individually
// rather than the file passing on whichever token the parser tripped over first.
//
// `signed`, `tri` and `wire` are not declared here: they are substrings of
// `unsigned`, `tri0`/`tri1`/`triand`/`trior`/`trireg` and `uwire`, all declared
// here, so their arms would be satisfied by the longer spellings' diagnostics.
// They are censused in 22_shadowed_spellings.va, which explains the mechanism.
// `reg` is a substring of `trireg` for the same reason; it is already censused
// unshadowed in 19_reserved_core_keywords.va, so it needs no second home.
//! lrm B
//! reject-only E0208
//! reject highz0
//! reject highz1
//! reject large
//! reject medium
//! reject pull0
//! reject pull1
//! reject scalared
//! reject small
//! reject strong0
//! reject strong1
//! reject supply0
//! reject supply1
//! reject tri0
//! reject tri1
//! reject triand
//! reject trior
//! reject trireg
//! reject unsigned
//! reject uwire
//! reject vectored
//! reject wand
//! reject weak0
//! reject weak1
//! reject wor
module annex_b_reserved_net_strength_keywords;
    real highz0;
    real highz1;
    real large;
    real medium;
    real pull0;
    real pull1;
    real scalared;
    real small;
    real strong0;
    real strong1;
    real supply0;
    real supply1;
    real tri0;
    real tri1;
    real triand;
    real trior;
    real trireg;
    real unsigned;
    real uwire;
    real vectored;
    real wand;
    real weak0;
    real weak1;
    real wor;
endmodule
