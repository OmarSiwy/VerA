// Annex B: "Verilog-AMS reserves the keywords listed in Table B.1." A reserved
// spelling is therefore not available as an identifier, and `real <keyword>;`
// is a syntax error in any conforming compiler.
//
// The five spellings this repo's Table B.1 carries that the 2.4.0 PDF table does
// not. Diffing the two tables gives exactly these five, and nothing that is in
// the PDF but not the HTML.
//
// They are worth their own file because they are the portability trap: a tool
// built to the 2.4.0 printing accepts `real break;` and passes every other
// fixture in this chapter. `expm1`/`ln1p` and `return` are also censused with
// their families in 16 and 19; here they are pinned as table deltas.
//
// This is a reservedness census, not a feature test: one declaration per line so
// the parser resynchronises at each `;` and reports every spelling separately,
// and one `//! reject` line per spelling so each keyword is proved individually
// rather than the file passing on whichever token the parser tripped over first.
//! lrm B
//! reject-only E0208
//! reject break
//! reject continue
//! reject expm1
//! reject ln1p
//! reject return
module annex_b_reserved_2023_additions;
    real break;
    real continue;
    real expm1;
    real ln1p;
    real return;
endmodule
