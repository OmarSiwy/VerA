// Annex B: "Verilog-AMS reserves the keywords listed in Table B.1." A reserved
// spelling is therefore not available as an identifier, and `real <keyword>;`
// is a syntax error in any conforming compiler.
//
// `module_keyword ::= module | macromodule` (IEEE 1364-2005 A.1.2), so a
// `macromodule` declaration is legal source; nothing in Annex B or C.16 excludes
// it. Only the reservedness of the spelling is an Annex B rule.
//
// This is a reservedness census, not a feature test: one declaration per line so
// the parser resynchronises at each `;` and reports every spelling separately,
// and one `//! reject` line per spelling so each keyword is proved individually
// rather than the file passing on whichever token the parser tripped over first.
//! lrm B
//! reject-only E0208
//! reject macromodule
module annex_b_reserved_macromodule_keywords;
    real macromodule;
endmodule
