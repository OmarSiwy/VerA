// Annex B: "Keywords are predefined nonescaped identifiers... An escaped
// identifier shall not be treated as a keyword." So `\if ` is an ordinary
// variable, and `\if  = 2.0;` is an assignment, not a malformed if statement.
//
// §2.8.1: "Neither the leading backslash character nor the terminating white
// space is considered to be part of the identifier. Therefore, an escaped
// identifier \cpu3 is treated the same as a non-escaped identifier cpu3." So
// the storage declared as `\total ` is read back below by the plain name
// `total`, and 2.0 * 3.0 = 6.0 must come out of it.
`include "check.vh"
//! lrm B
//! lrm B:1
//! lrm 2.8.1
//! lrm 2.8.1:1
module annex_b_escaped_keyword(p, n);
    inout p, n;
    electrical p, n;
    real \if ;
    real \total ;

    analog begin
        \if  = 2.0;
        \total  = \if  * 3.0;
        `CHECKX("escaped keyword is a variable, read via its simple name", total, 6.0);
        I(p, n) <+ total;
    end
endmodule
