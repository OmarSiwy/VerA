// Annex B: "Verilog-AMS reserves the keywords listed in Table B.1." A reserved
// spelling is therefore not available as an identifier, and `real <keyword>;`
// is a syntax error in any conforming compiler.
//
// The core structural, declarative and control keywords. Reservedness of this
// whole group rested on two fixtures, 03 (`module`) and 04 (`if`); everything
// else was inventoried in prose only. No plausible compiler gets `module` right
// and `endmodule` wrong, so this is a low-yield census — but it is one file and
// it closes the row.
//
// This is a reservedness census, not a feature test: one declaration per line so
// the parser resynchronises at each `;` and reports every spelling separately,
// and one `//! reject` line per spelling so each keyword is proved individually
// rather than the file passing on whichever token the parser tripped over first.
//
// `real endmodule;` is LAST on purpose. It is the one spelling that does not
// resynchronise: the diagnostic fires, but the token also ends the module, so
// every declaration after it would be parsed at file scope and never reported.
// Placed last it costs only a trailing stray-`;`/`endmodule` diagnostic.
//! lrm B
//! reject E0208
//! reject always
//! reject analog
//! reject and
//! reject assign
//! reject begin
//! reject case
//! reject casex
//! reject casez
//! reject default
//! reject defparam
//! reject else
//! reject end
//! reject endcase
//! reject endfunction
//! reject endgenerate
//! reject endparamset
//! reject event
//! reject for
//! reject forever
//! reject function
//! reject generate
//! reject genvar
//! reject initial
//! reject inout
//! reject input
//! reject integer
//! reject localparam
//! reject not
//! reject or
//! reject output
//! reject parameter
//! reject paramset
//! reject real
//! reject reg
//! reject repeat
//! reject return
//! reject string
//! reject while
//! reject endmodule
module annex_b_reserved_core_keywords;
    real always;
    real analog;
    real and;
    real assign;
    real begin;
    real case;
    real casex;
    real casez;
    real default;
    real defparam;
    real else;
    real end;
    real endcase;
    real endfunction;
    real endgenerate;
    real endparamset;
    real event;
    real for;
    real forever;
    real function;
    real generate;
    real genvar;
    real initial;
    real inout;
    real input;
    real integer;
    real localparam;
    real not;
    real or;
    real output;
    real parameter;
    real paramset;
    real real;
    real reg;
    real repeat;
    real return;
    real string;
    real while;
    real endmodule;
endmodule
