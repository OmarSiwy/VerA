// Annex B: "Keywords are predefined nonescaped identifiers ... Verilog-AMS
// reserves the keywords listed in Table B.1." `repeat` is in Table B.1, so it
// cannot be the name of an analog function (A.2.6 analog_function_declaration), whose production (A.9.3) bottoms out in
// `identifier`, which §2.8 defines to exclude keywords. The variable position
// is 04 and its siblings; this file pins the function-name position. Legal
// neighbour: the same declaration with the escaped name `\repeat `, which
// 26_escaped_keyword_name_positions.va runs.
//
//! lrm B
//! lrm 2.8
//! reject E0208
//! reject found `repeat`
//! neighbour 26_escaped_keyword_name_positions.va
`include "disciplines.vams"
module annex_b_kw_function(p, n);
  inout p, n; electrical p, n;
  analog function real repeat;
    input x; real x;
    repeat = x;
  endfunction
  analog I(p, n) <+ V(p, n);
endmodule
