// Annex B: "Keywords are predefined nonescaped identifiers ... Verilog-AMS
// reserves the keywords listed in Table B.1." `inout` is in Table B.1, so it
// cannot be the name of a named block (A.6.3 block_identifier), whose production (A.9.3) bottoms out in
// `identifier`, which §2.8 defines to exclude keywords. The variable position
// is 04 and its siblings; this file pins the block-label position. Legal
// neighbour: the same declaration with the escaped name `\inout `, which
// 26_escaped_keyword_name_positions.va runs.
//
//! lrm B
//! lrm 2.8
//! reject E0208
//! reject found `inout`
//! neighbour 26_escaped_keyword_name_positions.va
`include "disciplines.vams"
module annex_b_kw_label(p, n);
  inout p, n; electrical p, n;
  analog begin : inout
    I(p, n) <+ V(p, n);
  end
endmodule
