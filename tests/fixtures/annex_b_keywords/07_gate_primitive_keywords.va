// Annex B: "Verilog-AMS reserves the keywords listed in Table B.1." A reserved
// spelling is therefore not available as an identifier, and `real <keyword>;`
// is a syntax error in any conforming compiler.
//
// The gate-primitive family of IEEE 1364-2005 A.3.1. A `gate_instantiation` is
// legal source, so the reservedness of the gate names is the only Annex B claim
// available here.
//
// This is a reservedness census, not a feature test: one declaration per line so
// the parser resynchronises at each `;` and reports every spelling separately,
// and one `//! reject` line per spelling so each keyword is proved individually
// rather than the file passing on whichever token the parser tripped over first.
//
// `buf` is not declared here: it is a substring of `bufif0` and `bufif1`, so a
// bare arm for it would be satisfied by their diagnostics. It is censused in
// 22_shadowed_spellings.va, which explains the mechanism.
//! lrm B
//! reject-only E0208
//! reject bufif0
//! reject bufif1
//! reject cmos
//! reject nand
module annex_b_reserved_gate_primitive_keywords;
    real bufif0;
    real bufif1;
    real cmos;
    real nand;
endmodule
