// Annex B: "Verilog-AMS reserves the keywords listed in Table B.1." A reserved
// spelling is therefore not available as an identifier, and `real <keyword>;`
// is a syntax error in any conforming compiler.
//
// The discipline and nature declarative keywords of §3.4 and §3.5, plus the
// parameter-range words of §3.4.4 (`from`, `exclude`, `inf`) and `aliasparam`
// (§3.4.3).
//
// This is the group most at risk in a real implementation: nature and discipline
// bodies are small enough to parse with an ad-hoc attribute-name lookup instead
// of the lexer, and `abstol`, `access`, `units`, `from`, `exclude` and `inf` all
// read perfectly well as ordinary identifiers. Table B.1 reserves them
// everywhere, not only inside a `nature` body.
//
// This is a reservedness census, not a feature test: one declaration per line so
// the parser resynchronises at each `;` and reports every spelling separately,
// and one `//! reject` line per spelling so each keyword is proved individually
// rather than the file passing on whichever token the parser tripped over first.
//! lrm B
//! reject E0208
//! reject abstol
//! reject access
//! reject branch
//! reject continuous
//! reject ddt_nature
//! reject discipline
//! reject discrete
//! reject domain
//! reject enddiscipline
//! reject endnature
//! reject flow
//! reject ground
//! reject idt_nature
//! reject nature
//! reject potential
//! reject units
//! reject aliasparam
//! reject exclude
//! reject from
//! reject inf
module annex_b_reserved_discipline_nature;
    real abstol;
    real access;
    real branch;
    real continuous;
    real ddt_nature;
    real discipline;
    real discrete;
    real domain;
    real enddiscipline;
    real endnature;
    real flow;
    real ground;
    real idt_nature;
    real nature;
    real potential;
    real units;
    real aliasparam;
    real exclude;
    real from;
    real inf;
endmodule
