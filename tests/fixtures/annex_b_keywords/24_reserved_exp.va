// Annex B: "Verilog-AMS reserves the keywords listed in Table B.1." `exp` is in
// Table B.1 (§4.3.2 gives it the natural-exponential function), so the spelling
// is not available as an identifier.
//
// Its own file, and one declaration in it, because `exp` cannot be proved by a
// message substring inside a census. A `//! reject` pattern is matched against
// the diagnostic's catalogue TITLE as well as its message (tests/torture.zig
// failureContains), and E0208's title is "EXPected an identifier" — the bare
// substring `exp` is satisfied by ANY E0208 anywhere in the file, so in
// 16_reserved_math_functions.va the arm passed whether or not `exp` was
// reserved. `expm1` shadowed it a second time.
//
// Here the file declares exactly one thing, so `//! reject E0208` can only have
// come from `real exp;` and IS the proof. The `//! reject exp` line below is
// kept because the chapter's census counts spellings by their reject lines
// (14_include_reserved.va), not because it discriminates — on its own it does
// not.
//
// The module name carries no keyword, so a diagnostic quoting it cannot stand in
// for the declaration.
//! lrm B
//! lrm 2.8.2
//! reject-only E0208
//! reject exp
module annex_b_reserved_spelling_24;
    real exp;
endmodule
