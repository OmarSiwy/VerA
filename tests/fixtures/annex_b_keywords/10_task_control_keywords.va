// Annex B: "Verilog-AMS reserves the keywords listed in Table B.1." A reserved
// spelling is therefore not available as an identifier, and `real <keyword>;`
// is a syntax error in any conforming compiler.
//
// The task, process and procedural-control family of IEEE 1364-2005 A.2.7 /
// A.6.  Annex C.7 separately excludes digital behaviour from Verilog-A, but that
// is a C.7 claim about statements; the Annex B claim is only that the spellings
// are reserved, which is what is tested here.
//
// This is a reservedness census, not a feature test: one declaration per line so
// the parser resynchronises at each `;` and reports every spelling separately,
// and one `//! reject` line per spelling so each keyword is proved individually
// rather than the file passing on whichever token the parser tripped over first.
//! lrm B
//! reject E0208
//! reject automatic
//! reject deassign
//! reject disable
//! reject endtask
//! reject force
//! reject fork
//! reject join
//! reject negedge
//! reject posedge
//! reject realtime
//! reject release
//! reject task
//! reject time
//! reject wait
module annex_b_reserved_task_control_keywords;
    real automatic;
    real deassign;
    real disable;
    real endtask;
    real force;
    real fork;
    real join;
    real negedge;
    real posedge;
    real realtime;
    real release;
    real task;
    real time;
    real wait;
endmodule
