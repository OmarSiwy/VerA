//! reject identifier
// EXPECT: error
module annex_b_reserved_if_rejected;
    real if;
endmodule
