// Annex B: "Keywords are predefined nonescaped identifiers that define
// Verilog-AMS language constructs. [...] Verilog-AMS reserves the keywords
// listed in Table B.1." `if` is in Table B.1, so the spelling is not available
// as an ordinary identifier.
//
// This file pins the reservation at the VARIABLE-NAME position: a real
// declaration's list of identifiers (A.2.1.3) bottoms out in `identifier`, which
// §2.8 defines to exclude the keywords. Same rule as
// 03_reserved_module_rejected.va, different grammar position — a compiler that
// special-cased only the module header would pass that one and fail this.
//
// The reject pins the diagnostic CODE, not the prose: `identifier` — what this
// file used to demand — is a fragment of the diagnostic's title, so rewording
// the catalogue entry would silently stop this fixture proving anything.
//! lrm B
//! lrm 2.8
//! reject E0208
//! reject if
module annex_b_reserved_if_rejected;
    real if;
endmodule
