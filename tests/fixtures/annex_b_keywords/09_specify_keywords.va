// Annex B: "Verilog-AMS reserves the keywords listed in Table B.1." A reserved
// spelling is therefore not available as an identifier, and `real <keyword>;`
// is a syntax error in any conforming compiler.
//
// The specify-block family of IEEE 1364-2005 A.7.1. A `specify_block` is legal
// source and is not excluded by Annex C.16.
//
// This is a reservedness census, not a feature test: one declaration per line so
// the parser resynchronises at each `;` and reports every spelling separately,
// and one `//! reject` line per spelling so each keyword is proved individually
// rather than the file passing on whichever token the parser tripped over first.
//
// `showcancelled` and `specify` are not declared here: they are substrings of
// `noshowcancelled` and `endspecify`. They are censused in
// 22_shadowed_spellings.va, which explains the mechanism.
//! lrm B
//! reject-only E0208
//! reject edge
//! reject endspecify
//! reject ifnone
//! reject noshowcancelled
//! reject pulsestyle_ondetect
//! reject pulsestyle_onevent
//! reject specparam
module annex_b_reserved_specify_keywords;
    real edge;
    real endspecify;
    real ifnone;
    real noshowcancelled;
    real pulsestyle_ondetect;
    real pulsestyle_onevent;
    real specparam;
endmodule
