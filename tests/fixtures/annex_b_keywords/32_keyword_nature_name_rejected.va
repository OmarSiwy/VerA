// Annex B: "Keywords are predefined nonescaped identifiers ... Verilog-AMS
// reserves the keywords listed in Table B.1." `while` is in Table B.1, so it
// cannot be the name of a nature (A.1.6 nature_declaration), whose production (A.9.3) bottoms out in
// `identifier`, which §2.8 defines to exclude keywords. The variable position
// is 04 and its siblings; this file pins the nature-name position. Legal
// neighbour: the same declaration with the escaped name `\while `, which
// 26_escaped_keyword_name_positions.va runs.
//
//! lrm B
//! lrm 2.8
//! reject-only E0208
//! reject found `while`
//! neighbour 26_escaped_keyword_name_positions.va
`include "disciplines.vams"
nature while;
  units = "V"; access = WhileV; abstol = 1e-6;
endnature
module annex_b_kw_nature(p);
  inout p; electrical p;
  analog I(p) <+ V(p);
endmodule
