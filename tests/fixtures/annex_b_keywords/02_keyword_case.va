// §2.8: "Identifiers shall be case sensitive." Annex B reserves the LOWERCASE
// spellings only, so `Module` and `Analog` are ordinary identifiers.
//
// The assertion is what case sensitivity buys: `Analog` and `ANALOG` are two
// distinct objects. `ANALOG` is assigned LAST, so a compiler that folded case
// would either reject the second declaration as a duplicate or leave `Analog`
// holding 2.0. It must read 1.0.
//
// This is only the permissive half. 15_uppercase_keyword_rejected.va tests the
// other: an upper-case spelling must not be able to ACT as its keyword.
`include "check.vh"
//! lrm B
//! lrm B:1001
//! lrm 2.8
//! lrm 2.8:5
module Module(p, n);
    inout p, n;
    electrical p, n;
    real Analog;
    real ANALOG;

    analog begin
        Analog = 1.0;
        ANALOG = 2.0;
        `CHECKX("Analog is not ANALOG", Analog, 1.0);
        I(p, n) <+ Analog + ANALOG;
    end
endmodule
