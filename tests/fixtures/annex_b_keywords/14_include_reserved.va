// Annex B: "Verilog-AMS reserves the keywords listed in Table B.1." A reserved
// spelling is therefore not available as an identifier, and `real <keyword>;`
// is a syntax error in any conforming compiler.
//
// `include` is in Table B.1 (2023, physical p.400, between `incdir` and `inf`).
// Nearly everywhere a Verilog-AMS source file can reach it, it appears as the
// compiler directive `` `include ``, behind a backtick that the lexer resolves
// before the identifier rule is ever reached. It is used bare in exactly one
// place, and not in a .va file: A.1.1's
// `include_statement ::= include file_path_spec ;`, a library map file. (An
// earlier header credited the same shape to `assert` and pointed at
// 13_assert_reserved.va. That spelling is nowhere in the 2023 Table B.1 — the
// table runs `asinh`, then `assign` — so no rule reserves it and no fixture
// should; both the file and the claim were removed.)
//
// That is the trap, and why this gets its own file: an implementation that
// reserves directive names only in the post-backtick position — the natural way
// to write a preprocessor — accepts `real include;` and passes every other
// fixture in this chapter. `include` is an IEEE 1364-2001 addition in the
// config/library group, so its family census is 05_config_library_keywords.va,
// which spells the other eight members that are not shadowed; the post-backtick
// trap is what earns it a file instead of a ninth line there.
//
// With this file the chapter's reject lines cover 206 of the 215 Table B.1
// spellings. The other nine are the words Annex C.16 marks "not used by
// Verilog-A"; they are censused where that clause lives —
// annex_c_analog_subset/16_unused_ams_words_rejected.va for seven of them, and
// .../30_connect_reserved.va and .../31_connectrules_reserved.va for the two
// that 16 cannot prove without shadowing them. All of them cite `//! lrm B`, so
// every Table B.1 spelling is pinned somewhere. (Both counts used to read one
// higher, and the list to carry a third file, .../20_net_resolution_reserved.va:
// the transcription this folder was keyed on had been contaminated with
// Verilog-AMS 2.4 text, which reserves `net_resolution`. The 2023 edition
// removed it from Annex B and C.16 together — Annex G item 5027 — so that
// fixture was deleted with its claim rather than repaired.)
//! lrm B
//! lrm 2.8
//! lrm 2.8.2
//! reject-only E0208
//! reject include
module annex_b_include_reserved;
    real include;
endmodule
