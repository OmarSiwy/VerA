// Annex B: "An escaped identifier shall not be treated as a keyword." The
// legal neighbour of 27-33: each of those writes a bare keyword as the name in
// one declaration position and is refused; here the same seven keywords,
// escaped, name the same seven things and the module runs. 01 and 21 cover the
// variable and port positions.
//
//   parameter      \ground   = 2.0
//   genvar         \endcase    unrolls k = 0, 1, so the sum adds 1 + 1 = 2
//   branch         \wait       (p, n)
//   analog function \repeat    returns its argument doubled
//   block label    \inout
//   nature         \while      a user nature with access WhileV
//   instance       \join       of annex_b_kw_leaf, a 1 ohm resistor on (p, n)
//
// Derivation at V(p) = 1, V(n) = 0: ground = 2.0; the genvar loop adds 1 per
// iteration, 2 iterations, so s = 2; \repeat (1.5) = 3.0; V(\wait ) = 1.0.
//
//! lrm B
//! lrm B:1
//! lrm 2.8.1
//! bias V(p) = 1.0, V(n) = 0.0
//! checks 4
`include "disciplines.vams"
`include "check.vh"
nature \while ;
  units = "V"; access = WhileV; abstol = 1e-6;
endnature
module annex_b_kw_leaf(a, b);
  inout a, b; electrical a, b;
  analog I(a, b) <+ V(a, b);
endmodule
module annex_b_escaped_keyword_name_positions(p, n);
  inout p, n; electrical p, n;
  parameter real \ground  = 2.0;
  genvar \endcase ;
  branch (p, n) \wait ;
  real s;
  analog function real \repeat ;
    input x; real x;
    \repeat  = 2.0 * x;
  endfunction
  annex_b_kw_leaf \join (p, n);
  analog begin : \inout
    s = 0.0;
    for (\endcase  = 0; \endcase  < 2; \endcase  = \endcase  + 1) s = s + 1.0;
    `CHECKX("an escaped keyword names a parameter", \ground , 2.0);
    `CHECKX("an escaped keyword names a genvar", s, 2.0);
    `CHECKX("an escaped keyword names an analog function", \repeat (1.5), 3.0);
    `CHECKX("an escaped keyword names a branch", V(\wait ), 1.0);
    I(p, n) <+ 0.0;
  end
endmodule
