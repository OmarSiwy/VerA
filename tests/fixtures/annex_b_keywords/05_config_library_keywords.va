// Annex B: "Verilog-AMS reserves the keywords listed in Table B.1." A reserved
// spelling is therefore not available as an identifier, and `real <keyword>;`
// is a syntax error in any conforming compiler.
//
// The `config`/`library` family of IEEE 1364-2005 A.1.1, made part of Verilog-AMS
// by §1.1. Annex C.16 lists the keywords Verilog-A does not use — connect,
// connectmodule, connectrules, driver_update, endconnectrules, merged,
// net_resolution, resolvedto, split, wreal — and none of these is on it. The
// earlier fixture here spelled a well-formed library/config source and demanded
// an error, which a conforming AMS tool would refuse to give.
//
// This is a reservedness census, not a feature test: one declaration per line so
// the parser resynchronises at each `;` and reports every spelling separately,
// and one `//! reject` line per spelling so each keyword is proved individually
// rather than the file passing on whichever token the parser tripped over first.
//
// `config` is not declared here: it is a substring of `endconfig`, so a bare
// `//! reject config` in this file would be satisfied by `endconfig`'s
// diagnostic. It is censused in 22_shadowed_spellings.va, which explains the
// mechanism. `include` is the tenth member of this A.1.1 family and has its own
// file, 14_include_reserved.va, for the preprocessor-position reason given
// there.
//! lrm B
//! reject E0208
//! reject cell
//! reject design
//! reject endconfig
//! reject incdir
//! reject instance
//! reject liblist
//! reject library
//! reject use
module annex_b_reserved_config_library_keywords;
    real cell;
    real design;
    real endconfig;
    real incdir;
    real instance;
    real liblist;
    real library;
    real use;
endmodule
