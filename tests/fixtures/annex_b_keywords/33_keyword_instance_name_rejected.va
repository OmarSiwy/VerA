// Annex B: "Keywords are predefined nonescaped identifiers ... Verilog-AMS
// reserves the keywords listed in Table B.1." `join` is in Table B.1, so it
// cannot be the name of a module instance (A.4.1 name_of_module_instance), whose production (A.9.3) bottoms out in
// `identifier`, which §2.8 defines to exclude keywords. The variable position
// is 04 and its siblings; this file pins the instance-name position. Legal
// neighbour: the same declaration with the escaped name `\join `, which
// 26_escaped_keyword_name_positions.va runs.
//
// The refusal is right; its wording is not specific. With a keyword where
// the instance name goes, VerA does not read the line as an instantiation at
// all and reports E0240 at the module name ("not a module item: found
// annex_b_kw_leaf") rather than E0208 at `join`. The pinned substring is the
// one that message carries; E0208 at the keyword would be the better
// diagnostic.
//
//! lrm B
//! lrm 2.8
//! reject-only E0240
//! reject found annex_b_kw_leaf
//! neighbour 26_escaped_keyword_name_positions.va
`include "disciplines.vams"
module annex_b_kw_leaf(a, b);
  inout a, b; electrical a, b;
  analog I(a, b) <+ V(a, b);
endmodule
module annex_b_kw_instance(p, n);
  inout p, n; electrical p, n;
  annex_b_kw_leaf join (p, n);
endmodule
