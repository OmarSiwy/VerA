// §4.5.13 limexp. Below the linearization threshold it IS exp; above it the LRM
// only requires a function whose value and slope are continuous, so the check is
// on the properties a solver depends on, not on a particular formula.
//
//! print none
`include "check.vh"
module ex044_limexp(p, n);
  inout p, n;
  electrical p, n;
  real a, b, h;
  analog begin
    `CHECKR("limexp matches exp at 0", limexp(0.0), 1.0, 1e-15);
    `CHECKR("limexp matches exp at 1", limexp(1.0), 2.718281828459045, 1e-15);
    `CHECKR("limexp matches exp at -5", limexp(-5.0), 0.006737946999085467, 1e-15);
    // Continuity across the limiting threshold: a one-sided difference either
    // side of the x=80 knee must agree to first order, or Newton sees a step.
    h = 1e-6;
    a = (limexp(80.0 + h) - limexp(80.0)) / h;
    b = (limexp(80.0) - limexp(80.0 - h)) / h;
    // The RATIO is the part with a value to write down: a continuous first
    // derivative means the two one-sided quotients agree, so a/b is 1. Written
    // that way the want is a literal, and it stays true wherever an
    // implementation chooses to put its knee.
    `CHECKR("limexp slope is continuous at the knee", a / b, 1.0, 1e-3);
    `CHECKI("limexp is monotone", limexp(100.0) > limexp(80.0), 1);
    `CHECKI("limexp is finite far above the knee", limexp(1000.0) < 1e300, 1);
    I(p, n) <+ 0.0;
  end
endmodule
