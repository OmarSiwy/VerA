// §5.10.5 `timer(start_time, period)` is the ONLY thing in Verilog-A that says
// "the simulator shall place a timepoint here": "the timer function schedules an
// event at start_time, and every period after that". §9.17.2 `$bound_step`
// bounds step SIZE, which is a bound and not a location, and §9.17.1
// `$discontinuity` only announces one after it has already been stepped over.
//
// So a module with a timer, and only such a module, gets the host's
// `nextBreakpoint(model, t)` hook (modules/devices/src/contract.zig). The hook
// has no `Instance`, so it cannot read the live `__next` counter `updateState`
// advances — it RECOMPUTES the schedule from the model, which is sound because
// §4.5.14 makes an operator control argument a constant or parameter expression.
// `tstart`/`tper` here are parameters exactly to exercise that path: the emitted
// function reads `model.tstart`, not a folded literal.
//
// The `//! time` points below ARE the fire times (2n, 5n, 8n) plus two points
// that are not, so the transcript pins down every case that matters:
//
//   t = 0     before the first fire      -> 2n
//   t = 1n    still before it            -> 2n
//   t = 2n    EXACTLY ON a fire time     -> 5n, never 2n again
//   t = 3n    between fires              -> 5n
//   t = 5n    EXACTLY ON a fire time     -> 8n
//   t = 8n    EXACTLY ON a fire time     -> 11n
//
// The t-on-a-fire-time rows are the whole point. `nextBreakpoint` must answer
// STRICTLY after `t`: modules/analysis/src/tran/matex.zig walks the breakpoint
// list by `t = bp; nextBreakpoint(t)`, so an answer equal to `t` is a loop that
// never advances.
//
// `fired` cross-checks the hook against the code that actually raises the
// event. §5.10.3.3 fixes WHEN it becomes observable: "The analog simulator
// places a time point within time_tol of an event. At that time point, the
// event evaluates to True." The count therefore steps ON the fire row, not
// after it — 0 at t = 0 and 1n, 1 from 2n, 2 from 5n, 3 from 8n.
//
// This file used to assert the count one row LATE, citing §4.5.2 for "event
// state advances on the ACCEPTED step". That citation does not survive reading:
// §4.5.2 is "Analog operators and equations", and the word "accepted" does not
// occur anywhere in clause 4. The late count was an artifact — VerA read a
// `__hit` flag that `updateState` wrote only after the point had already been
// evaluated — and it was frozen into this fixture's `.expected.txt` golden,
// with the citation fitted to it afterwards. Exactly the self-confirming oracle
// the golden files were deleted to stop.
//
//! bias V(p) = 0
//! time 0, 1n, 2n, 3n, 5n, 8n
//! analysis tran
//! print none
`include "check.vh"
module ex071_timer_periodic(p);
  inout p;
  electrical p;
  parameter real tstart = 2n from [0:inf);
  parameter real tper = 3n from (0:inf);
  integer fired;
  analog begin
    @(timer(tstart, tper)) fired = fired + 1;
    // RELATIONAL because the count STEPS at a time point, which is the claim:
    // 0, then 1, 2, 3 as each scheduled fire time is reached. The four branches
    // are the counts read off the schedule in the header; the ternary only
    // says which row of the transcript this is. The thresholds sit BETWEEN the
    // declared time points (1.5n, 4.5n, 7.5n) so a fire landing one row early
    // or one row late fails, rather than being absorbed by a loose bound.
    `CHECKEQ("timer fires once per breakpoint, on the breakpoint", fired,
             ($abstime < 1.5n) ? 0 : (($abstime < 4.5n) ? 1 : (($abstime < 7.5n) ? 2 : 3)), 0.0);
    // The schedule itself, in digits: the first fire and the period.
    `CHECK("first fire time", tstart, 2e-9, 0.0);
    // Not exact: VerA lowers the §2.6 scale factor as a MULTIPLICATION, so the
    // declared default `3n` is 3.0 * 1e-9 = 3.0000000000000004e-9 rather than
    // the decimal 3e-9 — one ulp apart. `2n` above happens to land exactly.
    `CHECK("period", tper, 3e-9, 1e-24);
    I(p) <+ 0.0;
  end
endmodule
