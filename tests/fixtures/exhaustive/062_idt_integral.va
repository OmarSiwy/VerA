// §4.5.4 idt — the time integral, and the first fixture that needs the runner to
// commit accepted steps (`updateState`). Without that every point would read
// zero history and idt would answer `v*dt` forever.
//
// The kernel accumulates on ACCEPTED steps: `eval` returns `v*dt + acc` and
// `updateState` sets `acc += v*dt`. For a constant input that is exact, so the
// want at t = k*dt is v*t with NO tolerance for discretization. With no `ic`,
// Table 4-18 adds "c ... the initial starting point as determined by the
// simulator"; VerA's c is 0 (specification/Vague_Decisions.md), which the first check
// pins:
//
//   t=0     dt=0   -> the initial condition (§4.5.4: idt is `ic` in DC)
//   t=1ns          -> 2.0 * 1e-9 = 2e-9
//   t=4ns          -> 2.0 * 4e-9 = 8e-9
//
//! param k = 2.0
//! bias V(n) = 0
//! bias V(p) = 1
//! time 0, 1n, 2n, 3n, 4n
//! analysis tran
//! print none
`include "check.vh"
module ex062_idt(p, n);
  inout p, n;
  electrical p, n;
  parameter real k = 1.0;
  analog begin
    // A constant integrand, so the exact integral is k*t and the accumulated
    // sum has to match it step for step.
    //
    // RELATIONAL, and it has to be: the want is a different number at every one
    // of the five time points, and a stateful operator shown a single point
    // says nothing at all (dt = 0 puts its state straight onto the input). The
    // closed form k*t is §4.5.4's definition for a constant integrand, so the
    // only VerA machinery the two sides share is `k` and `$abstime` — both
    // pinned by literal checks elsewhere in this suite.
    `CHECKEQ("idt(k) == k*t", idt(k), k * $abstime, 1e-24);
    // §4.5.4 the initial-condition form: idt(x, ic) starts from `ic`, so it
    // stays `ic` above the analytic integral. Looser tolerance here than above:
    // the accumulator adds 2e-9 to 5.0 once per step, and summing in that order
    // is a last-bit different from the closed form (1e-16 fails by exactly one
    // ulp of 5). That is the summation, not the operator.
    `CHECKEQ("idt(k, ic) == ic + k*t", idt(k, 5.0), 5.0 + k * $abstime, 1e-15);
    // The one part of the claim that IS a number at every point: the ic form
    // sits exactly `ic` above the plain one, forever.
    `CHECK("the ic form is offset by exactly ic", idt(k, 5.0) - idt(k), 5.0, 1e-15);
    // And the parameter both wants above are built from.
    `CHECK("k took the override", k, 2.0, 0.0);
    I(p, n) <+ 0.0;
  end
endmodule
