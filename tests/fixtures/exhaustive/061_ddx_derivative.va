// §4.5.14 ddx(f, V(node)) — the symbolic partial derivative of an expression
// with respect to an unknown, available to the MODEL rather than only to the
// solver. Checked against the derivative worked out by hand.
//
// The bias is a single POINT rather than a sweep so that every want below is a
// number: at V(p,n) = 2 the derivative of the square is 4, and a swept bias
// would leave nothing to write down but `2*V(p,n)` — which is VerA's own
// arithmetic on both sides of the comparison.
//
//! bias V(n) = 0
//! bias V(p) = 2
`include "check.vh"
module ex061_ddx(p, n);
  inout p, n;
  electrical p, n;
  parameter real g = 3.0;
  analog begin
    // d/dV(p) of g*V(p,n) is g.
    `CHECK("ddx of a linear term", ddx(g * V(p, n), V(p)), 3.0, 1e-15);
    // d/dV(p) of V(p,n)^2 is 2*V(p,n), and V(p,n) = 2 here, so 4.
    `CHECK("ddx of a square", ddx(V(p, n) * V(p, n), V(p)), 4.0, 1e-15);
    // d/dV(n) of the same is -2*V(p,n): the branch is p MINUS n.
    `CHECK("ddx wrt the other node", ddx(V(p, n) * V(p, n), V(n)), -4.0, 1e-15);
    // The bias itself, so the two wants above rest on a checked V and not on
    // whatever the runner happened to place at the node.
    `CHECK("the bias the wants above assume", V(p, n), 2.0, 0.0);
    // A term that does not depend on the node has zero partial.
    `CHECK("ddx of a constant", ddx(g, V(p)), 0.0, 0.0);
    I(p, n) <+ g * V(p, n);
  end
endmodule
