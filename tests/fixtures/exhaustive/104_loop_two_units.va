// §5.9 a procedural loop feeding TWO units, with an x-dependent accumulator —
// checked by value, and by the derivative taken THROUGH the loop.
//
// `i` is an `integer`, not a `genvar`, so this is a real CFG loop and not an
// elaboration-time unroll (lower.zig `lowerFor` vs `tryUnroll`; §6.6.1 unrolling
// is the genvar form only). Both contributions slice that loop, so codegen
// hoists it into the one shared core, and the §9.4 display unit re-materializes
// it — the shape that exercises codegen's `loop_recompute` fixpoint in
// `analyzeUnit`.
//
// codegen.zig already tests the STRUCTURE of this shape ("§5.9 a loop the unit
// re-runs is not read out of the shared core"): no cached `c.f*` may be read
// inside the re-materialized loop, because a cache holds a loop-carried value at
// its FINAL value and the re-run would then execute zero times. Nothing checked
// the NUMBERS, and nothing anywhere differentiates through a loop-carried
// accumulator at all.
//
// So `a` is loop-carried and constant, while `b` is loop-carried and DEPENDS ON
// A NODE VOLTAGE: b = V(c) * (1 + 1/2 + 1/3 + 1/4 + 1/5). That makes
// `d res[p]/d x[c]` the harmonic sum itself, accumulated across five iterations
// of the CFG loop, which is the entry a broken unroll or a broken derivative
// chain gets wrong while every `ok=1` above it still passes.
//
// `V(c)` is biased rather than swept, so `b` is invariant across the operating
// points and can carry a fixed `want`; `c` draws a small conductive current so
// its matrix row is not empty (cf. 083).
//
//! param k = 3
//! bias V(n) = 0
//! bias V(c) = 0.4
//! sweep V(p) = 0.5, 1.5
`include "check.vh"
module ex104_loop_two_units(p, n, c);
  inout p, n, c;
  electrical p, n, c;
  parameter real k = 1.0 from (0:inf);
  integer i;
  real a;
  real b;
  analog begin
    a = 0.0;
    b = 0.0;
    for (i = 1; i <= 5; i = i + 1) begin
      a = a + i;
      b = b + V(c) / i;
    end
    `CHECKX("loop-carried constant a is 1+2+3+4+5", a, 15.0);
    // 0.4 * H(5) = 0.4 * 137/60. Accumulated in loop order, so the tolerance
    // covers the one-ulp difference from evaluating the closed form.
    `CHECK("loop-carried x-dependent b is V(c)*H(5)", b, 0.9133333333333333, 1e-15);
    `CHECKI("the counter leaves the loop one past the bound", i, 6);

    // Two units, both slicing the loop: `a` reaches one, `b` the other. Neither
    // may read the other's loop-carried value out of the core at its exit state.
    I(p, n) <+ k * a * V(p, n) * 1m;
    I(p) <+ b * V(p) * 1m;
    I(c) <+ V(c) * 1u;
  end
endmodule
