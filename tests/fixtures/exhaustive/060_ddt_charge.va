// §4.5.3 ddt and §5.6.1.2 the reactive residual. A `ddt` of a charge is NOT
// evaluated as a finite difference by the device: FastVAF splits it out into
// `q()`, and the host differentiates that. So the observable claim is the
// CHARGE and the capacitance matrix dq/dV, which is what the transcript shows —
// and the resistive residual must be identically zero.
//
//! param c = 2p
//! bias V(n) = 0
//! sweep V(p) = 0, 1
`include "check.vh"
module ex060_ddt_charge(p, n);
  inout p, n;
  electrical p, n;
  parameter real c = 1p;
  analog begin
    // q = c*V(p,n), so every number in the charge is `c`: it is the dq/dV the
    // transcript prints as the reactive Jacobian, and §2.6's `p` scale factor
    // makes the `2p` on the //! line 2e-12 exactly. Asserting `c` rather than
    // `c*V(p,n)` also stops the V = 0 sweep point from being vacuous.
    `CHECK("dq/dV is the capacitance", c, 2e-12, 0.0);
    // §4.5.3: `ddt` returns zero in a DC analysis, and there is no `//! analysis`
    // line here so this sweep is DC. Exactly zero — a capacitor conducts nothing
    // at DC no matter what the bias is, at both sweep points.
    `CHECK("ddt is zero at a DC operating point", ddt(c * V(p, n)), 0.0, 0.0);
    I(p, n) <+ ddt(c * V(p, n));
  end
endmodule
