// §4.5.7 absdelay — a pure transport delay. The input is a RAMP of one volt per
// nanosecond, so the delayed output has a closed form that makes an off-by-one
// sample impossible to miss: out(t) = in(t - td) = (t - td)/1n.
//
// Before the delay has elapsed the history ring holds only the samples taken so
// far; the LRM leaves that startup unspecified, so the checks below only claim
// the delayed identity from t >= td onward.
//
//! bias V(n) = 0
//! wave V(in) = 0, 1, 2, 3, 4, 5, 6
//! time 0, 1n, 2n, 3n, 4n, 5n, 6n
//! analysis tran
//! print none
`include "check.vh"
module ex065_absdelay(in, n);
  inout in, n;
  electrical in, n;
  analog begin
    $strobe("t=%g in=%g delayed=%g", $abstime / 1n, V(in, n), absdelay(V(in, n), 2n));
    // Written WITHOUT a runtime conditional on purpose: LRM 5.8 forbids one
    // around an analog operator ("if any of the conditionally-executed
    // statements contains an analog operator, the conditional expression shall
    // be an analysis_or_constant_expression"), and FastVAF does not yet
    // diagnose the violation — it feeds the operator 0 on the steps its branch
    // is off, silently corrupting the history. See tests/fixtures/TODO.md.
    //
    // `max(0, t - td)` covers the startup as well as the steady state: before
    // the ring reaches back td seconds the kernel returns 0, which is what the
    // clamp says.
    // RELATIONAL: a transport delay compared at ONE time point cannot show a
    // delay, and over the seven points the want walks 0,0,0,1,2,3,4. The want
    // is the ramp's own closed form, shifted by td — §4.5.7's definition with
    // the numbers from the //! lines substituted by hand.
    `CHECKEQ("delayed by exactly td", absdelay(V(in, n), 2n),
             max(0.0, $abstime / 1n - 2.0), 1e-15);
    // Row-INVARIANT and literal, so the file does not rest on one relational
    // line: on a strictly rising input a delay can only LAG. Zero delay — the
    // classic way to get an absdelay wrong — makes the difference 0 at every
    // point after the first and fails this. The floor is 1.999 rather than a
    // flat 2 because §2.6's scale factor is lowered as a MULTIPLY, so `3n` and
    // `6n` in the //! time list are one ulp off the decimal and the interpolated
    // input lands ~2e-16 low. A missing delay is off by 2, not by 1e-16.
    `CHECKI("the delayed value lags the input", absdelay(V(in, n), 2n) <= V(in, n), 1);
    `CHECKI("and by two full nanoseconds once the ring is full",
            (V(in, n) - absdelay(V(in, n), 2n)) >= ($abstime >= 2n ? 1.999 : 0.0), 1);
    I(in, n) <+ 0.0;
  end
endmodule
