// §4.5.12 zi_nd — a z-domain filter on its OWN timebase: "acts like a simple
// sample-and-hold which samples every T seconds". With H(z) = 1 (a pure
// sample-and-hold) and T = 2 ns, the output must be piecewise CONSTANT between
// samples even though the input changes every nanosecond.
//
// Between samples the output does not depend on the current unknowns, so it
// enters the residual as a constant — which is also why its Jacobian row is
// empty and `print none` costs nothing here.
//
// The optional τ / t0 arguments are omitted deliberately: this is the abrupt,
// t0 = 0 form. ch04_expressions/zi_transition_time_and_first_transition.va
// runs both.
//
// Corrected 2026-10-08 (construct only, the wants are unchanged): the
// coefficient vectors were VAMS 2.x concatenations, `{...}`. A.8.2's
// analog_filter_function_arg is a parameter, a part of one or a `'{...}`
// assignment pattern (annex G: "Add apostrophe before opening { in list of
// values"), and a concatenation there is E0572
// (reject_4_5_11_concatenation_coefficients.va), so each is now `'{...}`.
//
//! bias V(n) = 0
//! wave V(in) = 0, 1, 2, 3, 4, 5, 6
//! time 0, 1n, 2n, 3n, 4n, 5n, 6n
//! analysis tran
//! print none
`include "check.vh"
module ex067_zi(in, n);
  inout in, n;
  electrical in, n;
  real y;
  analog begin
    y = zi_nd(V(in, n), '{1.0}, '{1.0}, 2n);
    $strobe("t=%g in=%g held=%g", $abstime / 1n, V(in, n), y);
    // A sample-and-hold can only ever produce a value the input actually had.
    `CHECKI("output is a past input sample", (y >= 0.0) && (y <= V(in, n)), 1);
    I(in, n) <+ 0.0;
  end
endmodule
