// §5.6 the simplest conserved device: a flow contribution between two nodes.
// The transcript's residual IS the KCL stamp (§1.3.2) and its derivative IS the
// conductance the solver puts in the Jacobian, so this fixture pins the whole
// contribution-to-stamp path with numbers anyone can verify by Ohm's law.
//
//! param r = 2k
//! bias V(n) = 0
//! sweep V(p) = -1, 0, 1
`include "check.vh"
module ex080_resistor(p, n);
  inout p, n;
  electrical p, n;
  parameter real r = 1k from (0:inf);
  analog begin
    // RELATIONAL: the sweep runs three biases, so Ohm's law has three different
    // answers and no single one of them can be written down. What CAN be
    // written down is the slope, and the next two lines do exactly that — this
    // one is left in only because it is the shape the residual is built from.
    `CHECKEQ("I = V/R", V(p, n) / r, V(p, n) / 2000.0, 1e-18);
    // The slope IS the whole numeric content of a resistor, and 1/r is the same
    // number at every sweep point: `//! param r = 2k` with §2.6's `k` scale
    // factor is 2000 ohms, so the conductance is 5e-4 S.
    `CHECK("conductance", 1.0 / r, 5e-4, 1e-18);
    I(p, n) <+ V(p, n) / r;
  end
endmodule
