// §4.5.13 limexp. The clause: it "returns a real value which is the
// exponential of its single real argument; however, it internally limits the
// change of its output from iteration to iteration", "the simulator can only
// converge when the output of limexp() equals the exponential of the input",
// and "The apparent behavior of limexp() is not distinguishable from exp()".
//
// So at every point a solver can accept, limexp(x) IS exp(x), for every x: no
// argument is exempt. Until #52 this fixture asserted the opposite: it took the
// clause to allow any continuous continuation above a knee, and pinned
// `limexp(1000) < 1e300`, which only VerA's old tangent (e^80 * (1 + x - 80)
// above 80) passed. A conforming limexp gives exp(1000) = +inf there, so the
// check tested for the bug. It is withdrawn; the identities below replace it.
//
// The wants, from mpmath at 40 digits:
//   exp(1)   = 2.718281828459045235...  -> 2.718281828459045
//   exp(-5)  = 0.006737946999085467097... -> 0.006737946999085467
//   exp(100) = 2.688117141816135448e43  -> 2.6881171418161356e43, 0.33 ulp
//              from the true value; one ulp is 1.84e-16 relative, so RTOL
//              1e-15 admits a faithful exp (<= 1 ulp) and nothing near the old
//              tangent's 1.1635307007226e36 (7 orders of magnitude off).
//   limexp(x) == exp(x) at 100 and 700 (exp(700) = 1.0142320547350045e304):
//              §4.5.13 states the identity with no digits, so CHECKEQ (tolerance 0) compares
//              the two VerA expressions bit for bit.
//
//! lrm 4.5.13
//! print none
`include "check.vh"
module ex044_limexp(p, n);
  inout p, n;
  electrical p, n;
  analog begin
    `CHECKR("limexp matches exp at 0", limexp(0.0), 1.0, 1e-15);
    `CHECKR("limexp matches exp at 1", limexp(1.0), 2.718281828459045, 1e-15);
    `CHECKR("limexp matches exp at -5", limexp(-5.0), 0.006737946999085467, 1e-15);
    `CHECKR("limexp(100) is e^100, not a tangent above 80", limexp(100.0), 2.6881171418161356e43, 1e-15);
    `CHECKEQ("limexp(100) is exp(100)", limexp(100.0), exp(100.0), 0.0);
    `CHECKEQ("limexp(700) is exp(700)", limexp(700.0), exp(700.0), 0.0);
    `CHECKI("limexp is monotone", limexp(100.0) > limexp(80.0), 1);
    I(p, n) <+ 0.0;
  end
endmodule
