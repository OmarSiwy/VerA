// §4.2.1 implicit conversions. Real→integer ROUNDS (§4.2.1.1), ties away from
// zero; integer→real is exact. Both signs distinguish rounding from truncation
// and pin the direction of a half-integer tie.
//
//! print none
`include "check.vh"
module ex025_type_conversions(p, n);
  inout p, n;
  electrical p, n;
  integer i;
  real r;
  analog begin
    i = 2.5;
    `CHECKI("real->int rounds half away from zero", i, 3);
    i = -2.5;
    `CHECKI("real->int rounds half away from zero, negative", i, -3);
    i = 2.4;
    `CHECKI("real->int rounds down", i, 2);
    i = 2.6;
    `CHECKI("real->int rounds up", i, 3);
    r = 3;
    `CHECKX("int->real is exact", r, 3.0);
    // §4.2.1.3: mixing operands promotes to real.
    `CHECKX("mixed arithmetic promotes", 1 + 0.5, 1.5);
    `CHECKX("integer division stays integer", 7 / 2 + 0.0, 3.0);
    `CHECKX("one real operand makes it real division", 7 / 2.0, 3.5);
    // §9.11's explicit $rtoi truncates, while $itor converts to real. Both
    // are implemented and tested in ch09_system_tasks/15_conversion_functions.va
    // and audit_conversion_truncation_signed.va. This file covers implicit
    // conversions and mixed arithmetic.
    I(p, n) <+ 0.0;
  end
endmodule
