// §4.2.1 implicit conversions. Real→integer ROUNDS (§4.2.1.1), ties away from
// zero; integer→real is exact. A backend that truncated instead would pass a
// test written only on positive halves, so both signs are here.
//
//! print none
`include "check.vh"
module ex025_type_conversions(p, n);
  inout p, n;
  electrical p, n;
  integer i;
  real r;
  analog begin
    i = 2.5;
    `CHECKI("real->int rounds half away from zero", i, 3);
    i = -2.5;
    `CHECKI("real->int rounds half away from zero, negative", i, -3);
    i = 2.4;
    `CHECKI("real->int rounds down", i, 2);
    i = 2.6;
    `CHECKI("real->int rounds up", i, 3);
    r = 3;
    `CHECKX("int->real is exact", r, 3.0);
    // §4.2.1.3: mixing operands promotes to real.
    `CHECKX("mixed arithmetic promotes", 1 + 0.5, 1.5);
    `CHECKX("integer division stays integer", 7 / 2 + 0.0, 3.0);
    `CHECKX("one real operand makes it real division", 7 / 2.0, 3.5);
    // A contrast with the §9.11 explicit conversions belongs here — $rtoi
    // TRUNCATES where the implicit conversion above rounds — but VerA
    // implements neither $rtoi nor $itor, so there is nothing to contrast yet.
    // Neither is illegal: §9.11 extends "$bitstoreal and $realtobits, $rtoi and
    // $itor" into the analog context and Table 9-8 reads `$rtoi Yes Yes`,
    // `$itor Yes Yes`. (This comment used to say the opposite and to point at
    // ch09_system_tasks/061/062, which asserted the same false rule on
    // 2.4-contaminated text; those fixtures have been deleted. The gap is in
    // the compiler and is pinned by the M04 row
    // (tests/fixtures/ch07_mixed_signal/m04_SPEC.md at 8b1514d4).)
    I(p, n) <+ 0.0;
  end
endmodule
