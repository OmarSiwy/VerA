// §4.2.1 implicit conversions. Real→integer ROUNDS (§4.2.1.1), ties away from
// zero; integer→real is exact. A backend that truncated instead would pass a
// test written only on positive halves, so both signs are here.
//
//! print none
`include "check.vh"
module ex025_type_conversions(p, n);
  inout p, n;
  electrical p, n;
  integer i;
  real r;
  analog begin
    i = 2.5;
    `CHECKI("real->int rounds half away from zero", i, 3);
    i = -2.5;
    `CHECKI("real->int rounds half away from zero, negative", i, -3);
    i = 2.4;
    `CHECKI("real->int rounds down", i, 2);
    i = 2.6;
    `CHECKI("real->int rounds up", i, 3);
    r = 3;
    `CHECKX("int->real is exact", r, 3.0);
    // §4.2.1.3: mixing operands promotes to real.
    `CHECKX("mixed arithmetic promotes", 1 + 0.5, 1.5);
    `CHECKX("integer division stays integer", 7 / 2 + 0.0, 3.0);
    `CHECKX("one real operand makes it real division", 7 / 2.0, 3.5);
    // The §9.11 explicit conversions used to be contrasted here — $rtoi
    // TRUNCATES where the implicit conversion above rounds. They are gone
    // because Table 9-8 marks $rtoi and $itor "supported in analog context:
    // No", so an `analog` block is not a legal call site for either and this
    // file cannot host the contrast. ch09_system_tasks/061_rtoi_analog_-
    // rejected.va and 062_itor_analog_rejected.va own that rule now.
    I(p, n) <+ 0.0;
  end
endmodule
