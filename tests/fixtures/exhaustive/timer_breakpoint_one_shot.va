// §5.10.5 the ONE-SHOT form: "if period is not specified, or is not greater
// than zero, only a single event is scheduled". So `nextBreakpoint` has exactly
// one breakpoint to offer and must answer `none` for every `t` at or after it —
// re-offering the fire time forever would pin modules/analysis/src/tran at 3n.
//
//   t = 0     -> 3n
//   t = 1n    -> 3n
//   t = 3n    EXACTLY ON the fire time -> none (not 3n)
//   t = 4n    past it                  -> none
//
// Both control arguments are literals here, so the emitted function must take
// `_: *const Model` — an unused `model` parameter is a hard error in Zig, and
// this is the fixture that would catch the emitter naming it unconditionally.
// (071 is the mirror case: parameters, so `model` IS read.)
//
//! bias V(p) = 0
//! time 0, 1n, 3n, 4n
//! analysis tran
//! print none
`include "check.vh"
module ex072_timer_one_shot(p);
  inout p;
  electrical p;
  integer fired;
  analog begin
    @(timer(3n, 0.0)) fired = fired + 1;
    // §5.10.3.3: "The analog simulator places a time point within time_tol of an
    // event. At that time point, the event evaluates to True." The count steps
    // ON the fire row, not one point after it. (This file used to assert the
    // late form citing §4.5.2; that citation does not survive reading the
    // clause — see 071 for the full account.)
    // RELATIONAL because the count STEPS at a time point, which is the claim:
    // 0 before the fire, 1 from the fire row on, never 2. Both branches are
    // digits; the ternary only selects the row. The 2.5n threshold sits between
    // declared points, so a fire one row either side of 3n fails.
    `CHECKEQ("the one-shot fires exactly once, and never again", fired,
             ($abstime < 2.5n) ? 0 : 1, 0.0);
    // Row-INVARIANT and literal, so the file does not rest on the ternary: "one
    // shot" is exactly `fired <= 1` at every point. A `nextBreakpoint` that
    // re-offers 3n forever counts 2 at t = 4n and fails this line.
    `CHECKI("never fires more than once", fired <= 1, 1);
    I(p) <+ 0.0;
  end
endmodule
