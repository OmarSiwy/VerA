// §9.10/§9.15 the environment functions: what the model can ask the simulator
// about the operating conditions. `$vt` is the thermal voltage that every
// junction model divides by, so its exact value matters more than most.
//
//! temp 350
//! print none
`include "check.vh"
module ex120_environment(p, n);
  inout p, n;
  electrical p, n;
  analog begin
    `CHECK("$temperature follows the directive", $temperature, 350.0, 0.0);
    // §9.10: $vt = k*T/q with k/q = 8.617333262145179e-5 V/K, so at 350 K that
    // is 350 * 8.617333262145179e-5 = 0.030160666417508124 and at 300 K it is
    // 0.025851999786435535. Multiplied out here rather than left as a product
    // so the want is a number a reviewer can check against the LRM constant.
    `CHECKR("$vt with no argument uses $temperature", $vt,
            0.030160666417508124, 1e-15);
    `CHECKR("$vt(T) uses its argument", $vt(300.0),
            0.025851999786435535, 1e-15);
    `CHECKX("$abstime at the DC point", $abstime, 0.0);
    // §9.15 $simparam defaults, which a simulator-free device answers itself.
    `CHECKX("$simparam gmin default", $simparam("gmin"), 1e-12);
    // Table 9-27 gives tnom's units as DEGREES CELSIUS ("Default value of
    // temperature at which model parameters were extracted"), unlike
    // $temperature (§9.10) which is kelvin. 27 C is the industry-standard
    // extraction temperature; this file used to assert 300.15, which is the
    // same physical temperature written in the wrong unit.
    `CHECKX("$simparam tnom default is in Celsius, not kelvin", $simparam("tnom"), 27.0);
    `CHECKX("$simparam scale default", $simparam("scale"), 1.0);
    `CHECKX("$simparam with an explicit default", $simparam("nosuch", 4.5), 4.5);
    I(p, n) <+ 0.0;
  end
endmodule
