// §5.10 a variable assigned under an event control PERSISTS between analog
// evaluations. That is the entire point of `@(cross(...)) x = V(p);` — the
// event is active on one step out of thousands, and the value it captured has
// to still be there on all the others. A module variable is otherwise
// re-initialised from its declaration at the top of every evaluation, so
// without a persistent slot the capture collapses back to 0 on the very next
// step and the model silently computes with the initializer.
//
// Both types matter: `real` for a sampled level, `integer` because a counter or
// an FSM code is the natural way to write the state an event advances.
//
// V(c) crosses zero upward between t = 1n and t = 2n, so t = 2n is the first
// declared point at which the crossing has happened and the guarded body runs
// during THAT evaluation: §5.10.3.1 has cross() "control the timestep to
// accurately resolve the crossing", and §5.10.3.3 states the rule for the
// resulting point outright — "At that time point, the event evaluates to True."
// So `held` takes V(p) = 4 at t = 2n, and `fired` counts its one event there.
// At t = 3n and 4n the event is long gone and V(p) has moved to 5 then 6: BOTH
// must still read exactly what the event left behind. That is the test — the
// bug this file was written for read `held = 0`, `fired = 0` at those points.
//
// WHY 4 AND NOT 5. This file used to expect the capture one row later, citing
// §4.5.2 for "event state advances on the ACCEPTED step" — but §4.5.2 is
// "Analog operators and equations" and "accepted" appears nowhere in clause 4.
// The late row was VerA's own behavior (a `__hit` flag written by `updateState`
// after the point was evaluated), recorded into this fixture's `.expected.txt`
// golden and given a citation afterwards.
//
// Be clear about what 4 is, though: it is the value at the first DECLARED point
// past the crossing, not the value AT the crossing. A host that resolves the
// crossing properly lands a time point near t = 1.5n and would capture ~3.5.
// The generated testbench only evaluates the `//! time` rows, so the exact
// number here is a property of that grid. What this fixture actually pins is
// PERSISTENCE — that whatever the event captured survives the points after it —
// and that claim is independent of which row the capture happens on.
//
//! bias V(n) = 0
//! wave V(c) = -1, -1, 1, 1, 1
//! wave V(p) = 2, 3, 4, 5, 6
//! time 0, 1n, 2n, 3n, 4n
//! analysis tran
//! print none
`include "check.vh"
module ex070_event_hold(p, c, n);
  inout p, c, n;
  electrical p, c, n;
  real held;
  integer fired;
  analog begin
    @(cross(V(c, n), +1)) begin
      held = V(p, n);
      fired = fired + 1;
    end
    // RELATIONAL because the value CHANGES at a time point and the whole claim
    // is about persistence across points: 0 before the event, 4 from the
    // crossing row on. Both branches are digits derived above — the ternary
    // only selects which point of the transient this row is. The 1.5n threshold
    // sits between the declared points either side of the crossing, so a
    // capture one row early or late fails instead of being absorbed.
    `CHECKEQ("real captured by the event, held once it stops firing", held,
             ($abstime < 1.5n) ? 0.0 : 4.0, 1e-15);
    `CHECKEQ("integer counts the one event and does not reset", fired,
             ($abstime < 1.5n) ? 0 : 1, 0.0);
    I(p, n) <+ 0.0;
    I(c, n) <+ 0.0;
  end
endmodule
