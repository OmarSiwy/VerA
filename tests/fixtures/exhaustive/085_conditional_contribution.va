// §5.8 a contribution under an `if`. §5.6.1.3 makes `<+` an accumulation into a
// place, so a conditional contribution is "the accumulator's value at the end of
// the analog block" — a phi, not a second device. The sweep crosses the
// threshold so the transcript shows both arms and the slope discontinuity.
//
//! param vth = 0.5, g_on = 1m, g_off = 1n
//! bias V(n) = 0
//! sweep V(p) = 0, 0.4, 0.6, 1
`include "check.vh"
module ex085_conditional(p, n);
  inout p, n;
  electrical p, n;
  parameter real vth = 0.5;
  parameter real g_on = 1m;
  parameter real g_off = 1n;
  analog begin
    // The verdict is an operand, not a branch: see check.vh for why an
    // assertion that only prints on one arm is not an assertion.
    //
    // The comparison is asked at FIXED voltages, not at the swept bias: that
    // keeps the want a number at every sweep point, and it pins `vth` into
    // (0.4, 0.6] rather than merely restating the compiler's own answer.
    `CHECKI("0.4 V is below the threshold", 0.4 > vth, 0);
    `CHECKI("0.6 V is above the threshold", 0.6 > vth, 1);
    // The same selection the `if` below performs, with the arm's conductance
    // written out — this is the whole numeric content of the two arms.
    `CHECK("the conductance 0.6 V selects", (0.6 > vth) ? g_on : g_off, 1e-3, 0.0);
    `CHECK("the conductance 0.4 V selects", (0.4 > vth) ? g_on : g_off, 1e-9, 0.0);
    if (V(p, n) > vth)
      I(p, n) <+ g_on * V(p, n);
    else
      I(p, n) <+ g_off * V(p, n);
  end
endmodule
