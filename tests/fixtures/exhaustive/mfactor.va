// §9.18 $mfactor: the instance multiplicity the host sets. It is the one
// hierarchical parameter with a specialized backend path, and getting it wrong
// silently scales every current in a multi-finger device.
//
//! bias V(n) = 0
//! sweep V(p) = 1
`include "check.vh"
module ex088_mfactor(p, n);
  inout p, n;
  electrical p, n;
  parameter real g = 1m;
  analog begin
    // The runner leaves Instance.mfactor at its default of 1, so the model sees
    // exactly one device and the residual is the unscaled current.
    `CHECK("$mfactor default", $mfactor, 1.0, 0.0);
    // The sweep is a single point at V(p,n) = 1 V, so the per-device current
    // has a value: g = 1m = 1e-3 S (§2.6) times one volt. Digits, not
    // `1e-3 * V(p, n)` — with mfactor at 1 the residual IS this number.
    `CHECK("current per device", g * V(p, n), 1e-3, 1e-18);
    I(p, n) <+ g * V(p, n);
  end
endmodule
