// §9.4.2/§9.4.3 display formats: every conversion FastVAF translates, plus the
// width/precision/escape forms. This fixture is about the TRANSCRIPT, not the
// physics, so `print none` leaves the output to $strobe alone.
//
// Verilog-A cannot read a formatted string back as a value, so the conversions
// themselves are pinned by the golden transcript. What the CHECKs pin is the
// arithmetic a reviewer needs in order to READ that transcript: the two values
// being formatted, and the radix identity behind each digit string Table 9-22's
// %h/%o/%b must produce for k=42. Hand-converted, base by base:
//
//   %d -> 42
//   %h -> 2a      0x2a  = 2*16 + 10        = 42
//   %o -> 52      0o52  = 5*8  + 2         = 42
//   %b -> 101010  0b101010 = 32 + 8 + 2    = 42
//
//! print none
`include "check.vh"
module ex010_display_formats(p, n);
  inout p, n;
  electrical p, n;

  parameter real r = 1.5;
  parameter integer k = 42;

  analog begin
    $strobe("real  %%g  -> %g", r);
    $strobe("real  %%e  -> %e", r);
    $strobe("real  %%f  -> %f", r);
    $strobe("real  %%.3f-> %.3f", r);
    $strobe("real  %%10.4f -> [%10.4f]", r);
    $strobe("real  %%-10.4f-> [%-10.4f]", r);
    $strobe("int   %%d  -> %d", k);
    $strobe("int   %%h  -> %h", k);
    $strobe("int   %%o  -> %o", k);
    $strobe("int   %%b  -> %b", k);
    $strobe("int   %%5d -> [%5d]", k);
    $strobe("int   %%05d-> [%05d]", k);
    $strobe("str   %%s  -> %s", "hello");
    $strobe("mod   %%m  -> %m");
    $strobe("escapes-> tab[\t] nl-next quote[\"] backslash[\\]");
    $write("write does not end the line: ");
    $strobe("<- and this $strobe finished it");
    $strobe("extra operands with no conversion:", r, k);

    // The value every %g/%e/%f/%.3f/%10.4f line above renders.
    `CHECKX("r, the real the e/f/g lines format", r, 1.5);
    // The value every %d/%h/%o/%b line above renders, then the digit string
    // each radix must have printed for it, read back as a number.
    `CHECKI("k, the integer the d line formats", k, 42);
    `CHECKI("the hex digits 2a denote k", 8'h2a, 42);
    `CHECKI("the octal digits 52 denote k", 8'o52, 42);
    `CHECKI("the binary digits 101010 denote k", 8'b101010, 42);

    I(p, n) <+ 0.0;
  end
endmodule
