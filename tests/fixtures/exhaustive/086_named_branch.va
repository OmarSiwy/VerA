// §3.12 a named branch. `branch (a,b) br;` gives the (a,b) node pair a name;
// contributing through it must produce the same topology as contributing to the
// pair directly, which the residual and its Jacobian show.
//
//! param g = 4m
//! bias V(b) = 0.25
//! sweep V(a) = 0, 1
`include "check.vh"
module ex086_named_branch(a, b);
  inout a, b;
  electrical a, b;
  parameter real g = 1m;
  branch (a, b) br;
  analog begin
    // RELATIONAL by nature: §3.12 states this one as an identity — the named
    // branch IS the (a,b) pair — and there is no value to write down, least of
    // all at a swept bias.
    `CHECKEQ("branch probe equals the node pair", V(br), V(a, b), 0.0);
    `CHECKEQ("branch current", g * V(br), 4e-3 * V(a, b), 1e-18);
    // What the two lines above cannot say, in digits: `//! param g = 4m` is
    // 4e-3 S (§2.6 `m`), and `b` is held at 0.25 V at every sweep point.
    `CHECK("g took the override", g, 4e-3, 0.0);
    `CHECK("the fixed side of the branch", V(b), 0.25, 0.0);
    I(br) <+ g * V(br);
  end
endmodule
