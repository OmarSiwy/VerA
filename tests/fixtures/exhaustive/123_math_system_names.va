// §9.14 the IEEE 1364 §17.11 math functions carried into Verilog-AMS: `$ln`,
// `$exp`, `$pow` … are the SAME functions as their bare spellings, not a second
// implementation. Checking them against each other is the whole claim.
//
//! print none
`include "check.vh"
module ex123_math_system_names(p, n);
  inout p, n;
  electrical p, n;
  analog begin
    // RELATIONAL on purpose, and this is the file the form exists for: §9.14
    // says the two spellings are the SAME function, an identity with no value
    // to write down. The tolerance is 0.0 — "same function" means the same
    // bits, not merely the same number to fifteen digits.
    `CHECKEQ("$ln == ln", $ln(2.0), ln(2.0), 0.0);
    `CHECKEQ("$log10 == log", $log10(1000.0), log(1000.0), 0.0);
    `CHECKEQ("$exp == exp", $exp(1.0), exp(1.0), 0.0);
    `CHECKEQ("$sqrt == sqrt", $sqrt(2.0), sqrt(2.0), 0.0);
    `CHECKEQ("$pow == pow", $pow(2.0, 10.0), pow(2.0, 10.0), 0.0);
    `CHECKEQ("$floor == floor", $floor(2.7), floor(2.7), 0.0);
    `CHECKEQ("$ceil == ceil", $ceil(2.1), ceil(2.1), 0.0);
    `CHECKEQ("$sin == sin", $sin(0.5), sin(0.5), 0.0);
    `CHECKEQ("$cos == cos", $cos(0.5), cos(0.5), 0.0);
    `CHECKEQ("$tan == tan", $tan(0.5), tan(0.5), 0.0);
    `CHECKEQ("$atan2 == atan2", $atan2(1.0, -1.0), atan2(1.0, -1.0), 0.0);
    `CHECKEQ("$hypot == hypot", $hypot(3.0, 4.0), hypot(3.0, 4.0), 0.0);
    `CHECKEQ("$tanh == tanh", $tanh(0.5), tanh(0.5), 0.0);
    `CHECKEQ("$abs == abs", $abs(-3), abs(-3), 0.0);
    `CHECKEQ("$min == min", $min(3, 5), min(3, 5), 0.0);
    `CHECKEQ("$max == max", $max(3, 5), max(3, 5), 0.0);

    // An identity passes if BOTH spellings are wrong the same way, so the
    // $-forms are also pinned against digits wherever the answer is exact in
    // binary and the LRM fixes it: §4.3.1 defines floor/ceil/abs/min/max, an
    // integer power of two is exact, and hypot(3,4) is the 3-4-5 triangle.
    `CHECKX("$pow(2,10)", $pow(2.0, 10.0), 1024.0);
    `CHECKX("$floor(2.7)", $floor(2.7), 2.0);
    `CHECKX("$ceil(2.1)", $ceil(2.1), 3.0);
    `CHECKX("$hypot(3,4)", $hypot(3.0, 4.0), 5.0);
    `CHECKX("$sqrt(4)", $sqrt(4.0), 2.0);
    `CHECKX("$log10(1000)", $log10(1000.0), 3.0);
    `CHECKI("$abs(-3)", $abs(-3), 3);
    `CHECKI("$min(3,5)", $min(3, 5), 3);
    `CHECKI("$max(3,5)", $max(3, 5), 5);
    I(p, n) <+ 0.0;
  end
endmodule
