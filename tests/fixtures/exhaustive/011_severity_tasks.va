// §9.7.3 severity tasks. Their whole content is the message plus the severity,
// which a reader cannot recover from the text — so the generated print carries
// the level as a prefix.
//
// §9.7.1/§9.7.2 `$finish` and `$stop` stay void even here: stopping is the
// SIMULATOR's action, and this artifact is a transcript, not a solve.
//
// The severity LEVEL is text, and the golden transcript is what pins it. The
// one thing §9.7.3 states as an observable is which of these four tasks ends
// the block: only `$fatal` does. "$error shall be a run-time error ... the
// message is issued and the initialization continues", and "$warning and $info
// only output their text message but do not affect the rest of the
// initialization and the simulation". So `reached` must have been bumped once
// past each of the three non-fatal tasks -> 3. Asserted BEFORE `$fatal`, which
// is the one that "terminates the simulation" and so has no `after` to observe.
//
//! print none
`include "check.vh"
module ex011_severity(p, n);
  inout p, n;
  electrical p, n;
  integer reached;
  analog begin
    reached = 0;
    $info("informational, value=%g", 1.25);
    reached = reached + 1;
    $warning("something is unusual: %d", 7);
    reached = reached + 1;
    $error("a diagnosed condition: %s", "bad bias");
    reached = reached + 1;

    `CHECKI("9.7.3 info/warning/error do not end the block", reached, 3);

    $fatal(1, "a fatal condition: %g", 0.5);
    $finish;
    $stop;
    I(p, n) <+ 0.0;
  end
endmodule
