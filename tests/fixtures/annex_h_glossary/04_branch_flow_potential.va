// Annex H "branch": "A relationship between two nodes and their attached
// quantities... Each branch has two quantities, a value and a flow, WITH A
// REFERENCE DIRECTION FOR EACH." Annex H "reference direction": the convention
// deciding whether the value across a branch is positive or negative.
//
// So the fixture has to reverse something. §5.4.1, Example 2: "V(n1, n2)
// creates an unnamed branch from n1 to n2 ... and then accesses the branch
// potential", and §4.4, Table 4-16: "V(n1,n2) Accesses the voltage difference
// between n1 and n2" — which makes the reversal a negation. All three
// assertions are probes, not contributions, so §4.4 and §5.4.1 are the clauses
// they pin; the "directed from the first net to the second" sentence is
// §5.6.1.1 and governs only the trailing `<+`, which nothing here asserts.
//
// The named branch is not a second name for the unnamed pair: §3.12 and §5.4.1
// make them DISTINCT branches between the same two nets — "at most one unnamed
// branch between any two nets ... in addition to any number of named branches".
// What must coincide is their potential, both being the difference across the
// same node pair; a compiler that gave the named form an unknown of its own
// reads 0. At V(p) = 0.75 and V(n) = 0.25 all three numbers are exact in
// binary64 — 0.5, 0.5, -0.5 — so CHECKX and not a tolerance.
//
// (Annex H "reference direction" also covers "the flow through a branch", and
// that half is deliberately not asserted here: it already has a fixture,
// ch01_intro/23_flow_antisymmetry.va, which carries the `//! xfail`. VerA mints
// a SECOND unknown `flowZ28nZ2cpZ29` for the reversed pair instead of negating
// the branch flow, so I(n,p) reads 0 rather than -I(p,n). Repeating the claim
// here would drag these three green assertions into an XFAIL verdict for a gap
// that is already written down.)
//! lrm H
//! lrm 3.12
//! lrm 4.4
//! lrm 5.4.1
//! bias V(p) = 0.75, V(n) = 0.25
`include "check.vh"
module glossary_branch_flow_potential(p, n);
  inout p, n; electrical p, n;
  branch (p,n) b;
  analog begin
    `CHECKX("named branch potential", V(b), 0.5);
    `CHECKX("the unnamed pair reads the same potential", V(p,n), 0.5);
    `CHECKX("reversing the reference direction negates the value", V(n,p), -0.5);
    I(b) <+ V(b)/1000.0;
  end
endmodule
