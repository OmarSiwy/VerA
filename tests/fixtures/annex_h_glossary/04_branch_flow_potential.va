// Annex H "branch": "A relationship between two nodes and their attached
// quantities... Each branch has two quantities, a value and a flow, WITH A
// REFERENCE DIRECTION FOR EACH." Annex H "reference direction": the convention
// deciding whether the value across a branch is positive or negative.
//
// So the fixture has to reverse something. §5.6.1 directs an unnamed branch
// from the first net to the second, which makes the reversal a negation, and
// naming the pair is only a name: the named branch and the unnamed pair must
// report the same value. At V(p) = 0.75 and V(n) = 0.25 all three numbers are
// exact in binary64 — 0.5, 0.5, -0.5 — so CHECKX and not a tolerance.
//
// (The flow half of the reference direction is deliberately not asserted here:
// VerA gives I(n,p) a solver unknown of its own instead of the negation of
// I(p,n), so that claim needs its own `//! xfail` fixture rather than dragging
// these three green assertions into an XFAIL verdict.)
//! lrm H
//! lrm 5.6.1
//! bias V(p) = 0.75, V(n) = 0.25
`include "check.vh"
module glossary_branch_flow_potential(p, n);
  inout p, n; electrical p, n;
  branch (p,n) b;
  analog begin
    `CHECKX("named branch potential", V(b), 0.5);
    `CHECKX("the name does not change the branch", V(p,n), 0.5);
    `CHECKX("reversing the reference direction negates the value", V(n,p), -0.5);
    I(b) <+ V(b)/1000.0;
  end
endmodule
