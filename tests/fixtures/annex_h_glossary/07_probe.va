// Annex H "probe": "A branch in a circuit (or system), which DOES NOT ALTER
// ITS BEHAVIOR, but lets the simulator read out the potential OR FLOW at that
// point." The disjunction is normative, not stylistic. §5.4.2.1: "If no value
// is specified for either the potential or the flow, the branch is a probe. If
// the flow of the branch appears in an expression anywhere in the module, the
// branch is a flow probe, otherwise the branch is a potential probe. Using both
// the potential and the flow of a probe branch is ILLEGAL." §1.3.1 says the
// same and adds the consequence: "if the branch flow appears in an expression,
// the branch potential is forced to zero (0)".
//
// So one fixture pins one half, and this is the potential half. The previous
// revision read V() and I() off the same uncontributed branch — exactly the
// illegal pair — and wanted 0.5 V from a branch whose potential §5.4.2.1 fixes
// at 0. A conforming compiler rejects that source; the rule is already pinned
// as an error by ch01_intro/20_probe_branch_both_quantities.va, so this file
// demanding it run green contradicted it. The flow half is
// ch01_intro/10_flow_probe.va.
//
// `probe_branch` is never on the left of a `<+`, so it is a probe, and I() is
// never applied to it anywhere in the module, so it is a POTENTIAL probe. That
// is what makes Annex H's "does not alter its behavior" clause true here rather
// than merely asserted: §5.4.2.1's model for a potential probe is an open
// circuit — "the branch flow of a potential probe is zero (0)" — so the probe
// stamps nothing into the KCL rows of p and n, and the module's only source
// sits on the disjoint branch (out, ground). A FLOW probe is the other model, a
// short, which does alter the network; that is a second reason the flow half
// cannot share this file.
//
// Held at V(p) = 0.75 and V(n) = 0.25 the probe reads 0.75 - 0.25 = 0.5 V,
// exact in binary64, so CHECKX and not a tolerance.
//! lrm H
//! lrm 1.3.1
//! lrm 4.4
//! lrm 5.4.2.1
//! bias V(p) = 0.75, V(n) = 0.25, V(out) = 0.0
`include "check.vh"
module glossary_probe(p, n, out);
  inout p, n, out; electrical p, n, out;
  branch (p,n) probe_branch;
  analog begin
    `CHECKX("the probe reads the potential", V(probe_branch), 0.5);
    I(out) <+ V(probe_branch)/1000.0;
  end
endmodule
