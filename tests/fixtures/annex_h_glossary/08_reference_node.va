// Annex H "reference node" carries the only `shall` in the whole annex: "The
// global node (which equals zero (0)) against whose potentials all node values
// are measured. Nets declared as ground shall be bound to the reference node."
// §3.6.4 says the same normatively — "The node associated with the net will be
// THE global reference node in the circuit" — and the article is singular, so
// two ground declarations name one node, not two.
//
// Both claims are separated by biasing the ground nets OFF zero. A compiler
// that binds `ground` to the reference node reads both back as 0, so V(p,g1)
// and V(p,g2) are both V(p) = 0.5 and V(g1,g2) is exactly 0. A compiler that
// made a ground net an ordinary unknown reads its bias instead and would print
// 0.5 - 0.25 = 0.25, 0.5 - (-0.125) = 0.625 and 0.375. Every subtraction is
// against an exact zero, so CHECKX and not a tolerance.
//
// The one-argument form V(p) is the branch to the reference node (§4.4,
// Table 4-16), so it must agree with the explicit pair.
//! lrm H
//! lrm H:1
//! lrm 3.6.4
//! lrm 4.4
//! lrm 1.3.1.1
//! lrm 1.3.1.1:1
//! lrm 4.4:1
//! bias V(p) = 0.5, V(g1) = 0.25, V(g2) = -0.125
`include "check.vh"
module glossary_reference_node(p);
  inout p; electrical p;
  electrical g1, g2;
  ground g1;
  ground g2;
  analog begin
    `CHECKX("both ground nets are the one reference node", V(g1,g2), 0.0);
    `CHECKX("potential to the first ground", V(p,g1), 0.5);
    `CHECKX("potential to the second ground", V(p,g2), 0.5);
    `CHECKX("the one-argument form is the reference branch", V(p), 0.5);
    I(p,g1) <+ V(p,g1)/1000.0;
  end
endmodule
