// Annex H "behavioral description": "A mathematical mapping of inputs to
// outputs for a module, including INTERMEDIATE VARIABLES and control flow."
// This fixture pins the intermediate-variable half only; the control-flow half
// of the same sentence is 03_block_control_flow.va's subject, so the quote is
// cut there rather than silently truncated.
//
// The check is that the
// intermediate carries the mapping: at V(p)-V(n) = 0.75-0.25 = 0.5 the variable
// must hold 2*0.5 = 1.0 before the contribution reads it (§4.4, Table 4-16: the
// potential probe is the node-pair difference; §5.7: analog procedural
// assignment. §4.4 has no subsections and §5.2 is the analog procedural block,
// so the earlier cites to §4.4.1 and §5.2 were both wrong.) Both values are
// exact in binary64.
//! lrm H
//! lrm 4.4
//! lrm 5.7
//! bias V(p) = 0.75, V(n) = 0.25
`include "check.vh"
module glossary_behavioral_description(p, n);
  inout p, n; electrical p, n;
  real intermediate;
  analog begin
    intermediate = 2.0*V(p,n);
    `CHECKX("probe is the node-pair difference", V(p,n), 0.5);
    `CHECKX("intermediate variable carries the mapping", intermediate, 1.0);
    I(p,n) <+ intermediate;
  end
endmodule
