// Annex H "parameter": a constant characterizing an INSTANCE, specifiable each
// time the module is instantiated. What a single compiled device can show of
// that is the override half: the value seen inside the analog block must be the
// overridden 2.5, not the declaration's 3.0 default, and the flow must follow
// it: 2.5 * 0.25 = 0.625. §3.4 is the normative home — "parameters can be
// modified at compilation time to have values which are different from those
// specified in the declaration assignment ... This allows customization of
// module instances." `//! param` is that compilation-time override, not a
// per-instance one: there is no instantiation here to attach one to, so the
// assertion below says "override" and not "instance override".
//
//! lrm H
//! lrm 3.4
//! param gain = 2.5
//! bias V(p) = 0.25
`include "check.vh"
module glossary_module_parameter(p, n);
  inout p, n; electrical p, n;
  parameter real gain = 3.0;
  analog begin
    `CHECKX("the override replaces the declared default", gain, 2.5);
    `CHECKX("flow follows the overridden parameter", gain*V(p,n), 0.625);
    I(p,n) <+ gain*V(p,n);
  end
endmodule
