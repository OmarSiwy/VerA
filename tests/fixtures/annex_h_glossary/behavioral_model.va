// Annex H "behavioral model": a version of a module with a unique set of
// parameters. The override is the point — with resistance overridden to 2k the
// §2.6.2 scale factor (Table 2-1: k = 1e3) makes it 2000 exactly, and Ohm's law
// at V(p,n) = 0.5 gives 0.5/2000 = 250 uA, not the 500 uA the 1k default gives.
// 2.5e-4 is not a dyadic rational, but both operands are exact and IEEE-754
// division is correctly rounded, so 0.5/2000.0 lands on the same double the
// literal 2.5e-4 parses to (0x1.0624dd2f1a9fcp-12). CHECKX, not a tolerance.
// §3.4: "parameters can be modified at compilation time to have values which are
// different from those specified in the declaration assignment."
//
//! lrm H
//! lrm 3.4
//! lrm 2.6.2
//! param resistance = 2k
//! bias V(p) = 0.5
`include "check.vh"
module glossary_behavioral_model(p, n);
  inout p, n; electrical p, n;
  parameter real resistance = 1k from (0:inf);
  analog begin
    `CHECKX("overridden parameter, 2k = 2000", resistance, 2000.0);
    `CHECKX("Ohm's law at 0.5 V", V(p,n)/resistance, 2.5e-4);
    I(p,n) <+ V(p,n)/resistance;
  end
endmodule
