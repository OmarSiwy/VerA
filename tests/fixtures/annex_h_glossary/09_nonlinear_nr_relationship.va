// Annex H "NR method": Newton-Raphson solves a NONLINEAR relationship by
// linearizing it, so the exponential's value has to be right before its slope
// can be. The nonlinearity here is the diode law, driven by limexp so the
// contribution behaves the way §4.5.13 wants; both ASSERTIONS are written on
// exp(), because that is the function the LRM pins pointwise. §4.5.13 says
// limexp "has internal state containing information about the argument on
// previous iterations", that it "internally limits the change of its output
// from iteration to iteration", and that "the simulator can only converge when
// the output of limexp() equals the exponential of the input" — the identity is
// a property of the CONVERGED point, and "there are different ways of
// implementing limiting algorithms". The runner evaluates the residual once,
// cold, so a conforming implementation with SPICE-style pnjlim seeding may
// return a limited value on that first evaluation — at ANY argument, zero
// included, since nothing in the clause excludes a limiter seeded from a
// nonzero critical voltage. §4.5.13 also says "the apparent behavior of
// limexp() is not distinguishable from exp()", which reads the other way; a
// fixture that has to pass on every conforming compiler takes the
// intersection, so no pointwise want is written on limexp. limexp stays where
// the LRM wants it, in the contribution.
//
// $vt is kT/q (§9.15, Syntax 9-10). Annex D (D.2, constants.vams) offers FOUR
// constant sets — SPICE, OLD (LRM 1.0), NIST1998 and NIST2010; VerA adds a
// fifth, NIST2018, as its default. The window is the same either way: both
// extremes are Annex D sets (SPICE at one end, NIST1998 at the other) and
// NIST2018 falls inside. At 300 K:
//
//   $vt   0.025851241113725592 .. 0.025852026903638286   (midpoint 0.0258516340)
//   I     4.685466712454161e-13 .. 4.686029416818741e-13 (midpoint 4.6857481e-13)
//
// so each want below is that midpoint at five significant digits, not a value
// from one set. Measured against those rounded wants, the worst-case relative
// error a conforming set can show is 2.9355e-5 for $vt and 7.0303e-5 for the
// current, so the rtols are pinned at the next round number above each
// — 3.0e-5 and 8.0e-5. (The previous revision wrote 4.6855e-13, two units low,
// which pushed the current's floor to 1.1299e-4 against a stated 1.2e-4: a
// tolerance 50% looser than the method above allows, on 6% headroom.)
// Tightening either past its floor fails a compiler that picked a different,
// equally legal Annex D constant set; loosening it past the floor stops the
// assertion discriminating at all.
//! lrm H
//! lrm 9.15
//! lrm 4.5.13
//! lrm D.2
//! temp 300.0
//! bias V(p) = 0.1
`include "check.vh"
module glossary_nonlinear_nr_relationship(p, n);
  inout p, n; electrical p, n;
  parameter real saturation = 1e-14;
  analog begin
    `CHECKR("$vt is kT/q at 300 K", $vt, 0.025852, 3.0e-5);
    `CHECKX("zero bias draws no current", saturation*(exp(0.0/$vt) - 1.0), 0.0);
    `CHECKR("diode law at 100 mV", saturation*(exp(V(p,n)/$vt) - 1.0), 4.6857e-13, 8.0e-5);
    I(p,n) <+ saturation*(limexp(V(p,n)/$vt) - 1.0);
  end
endmodule
