// Annex H "NR method": Newton-Raphson solves a NONLINEAR relationship by
// linearizing it, so the exponential's value has to be right before its slope
// can be. The nonlinearity here is the diode law, driven by limexp so the
// contribution behaves the way §4.5.13 wants; the ASSERTION is written on
// exp(), because that is the function the LRM pins pointwise. §4.5.13 says
// limexp "has internal state containing information about the argument on
// previous iterations", that it "internally limits the change of its output
// from iteration to iteration", and that "the simulator can only converge when
// the output of limexp() equals the exponential of the input" — the identity is
// a property of the CONVERGED point, and "there are different ways of
// implementing limiting algorithms". The runner evaluates the residual once,
// cold, so a conforming implementation with SPICE-style pnjlim seeding is
// entitled to return a limited value on that first evaluation. Only the zero
// case survives any limiter unchanged: exp(0) - 1 is zero to the last bit
// however the output is clamped, so line 3 may keep limexp.
//
// $vt is kT/q (§9.15, Syntax 9-10). At 300 K the five constant sets Annex D
// offers — SPICE, LRM 1.0, NIST 1998/2010/2018 — give
//
//   $vt   0.025851241113725592 .. 0.025852026903638286   (midpoint 0.0258516340)
//   I     4.685466712454161e-13 .. 4.686029416818741e-13 (midpoint 4.685748e-13)
//
// so each want below is that spread ROUNDED to the digits worth printing, not
// a value from one set. Measured against those rounded wants, the worst-case
// relative error a conforming set can show is 2.9355e-5 for $vt and 1.1299e-4
// for the current, so the rtols are pinned at the next round number above each
// — 3.0e-5 and 1.2e-4. Tightening either past its floor fails a compiler that
// picked a different, equally legal Annex D constant set; loosening it past
// the floor stops the assertion discriminating at all.
//! lrm H
//! lrm 9.15
//! lrm 4.5.13
//! lrm D.2
//! temp 300.0
//! bias V(p) = 0.1
`include "check.vh"
module glossary_nonlinear_nr_relationship(p, n);
  inout p, n; electrical p, n;
  parameter real saturation = 1e-14;
  analog begin
    `CHECKR("$vt is kT/q at 300 K", $vt, 0.025852, 3.0e-5);
    `CHECKX("zero bias draws no current", saturation*(limexp(0.0/$vt) - 1.0), 0.0);
    `CHECKR("diode law at 100 mV", saturation*(exp(V(p,n)/$vt) - 1.0), 4.6855e-13, 1.2e-4);
    I(p,n) <+ saturation*(limexp(V(p,n)/$vt) - 1.0);
  end
endmodule
