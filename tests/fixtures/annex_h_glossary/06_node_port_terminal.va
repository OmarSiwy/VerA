// Annex H "port": "An external connection point for a module (also known as a
// terminal)." Annex H "node": "A connection point in the system, with access
// functions for potential and/or flow through an underlying discipline" — which
// an internal net (here `electrical`) is too. So every
// port is a node and not every node is a port, and the distinction is
// observable: `internal_node` appears in no port list yet is a solver unknown
// of its own that V() can read (§4.4, Table 4-16).
//
// The bias is a SOLUTION of the module, not just an arithmetically consistent
// triple: the value source says V(internal_node,terminal_n) = 0.5*0.375
// = 0.1875, so internal_node sits at 0.125 + 0.1875 = 0.3125 and the branch
// residual is zero. (The previous revision biased it at 0.25 against a source
// demanding 0.375 and printed ok=1 next to a residual of -0.25 — a point its
// own constitutive relation forbids.) 0.3125 differs from both terminals, so
// the claim still discriminates: a compiler that aliased an internal net onto
// either port would print 0.375 or 0.0 instead of 0.1875. Every value is a
// dyadic rational, exact in binary64.
//! lrm H
//! lrm 3.6
//! lrm 4.4
//! lrm 3.6:1000
//! bias V(terminal_p) = 0.5, V(terminal_n) = 0.125, V(internal_node) = 0.3125
`include "check.vh"
module glossary_node_port_terminal(terminal_p, terminal_n);
  inout terminal_p, terminal_n;
  electrical terminal_p, terminal_n;
  electrical internal_node;
  analog begin
    `CHECKX("the port pair's potential", V(terminal_p,terminal_n), 0.375);
    `CHECKX("an internal node is an unknown of its own", V(internal_node,terminal_n), 0.1875);
    V(internal_node,terminal_n) <+ 0.5*V(terminal_p,terminal_n);
    I(terminal_p,terminal_n) <+ V(internal_node,terminal_n);
  end
endmodule
