// Annex H "block": "A level within the behavioral description of a module,
// delimited by begin and end" (§5.3). Annex H "control flow": "The CONDITIONAL
// AND ITERATIVE statements controlling the behavior of a module. These
// statements evaluate arbitrary variables (counters, flags, and tokens) to
// control the operation of different sections of a behavioral description."
//
// What this fixture pins: the conditional half (§5.8) inside a named begin-end
// block (§5.3). The if/else computes |V(p,n)|, so at a bias of -0.4 V the guard
// must be false (§4.2.5: a comparison is an integer, 0 here) and the else arm
// must leave 0.4 behind, visible after the arms rejoin.
//
// What it does NOT pin, deliberately:
//   - the iterative half of "control flow" (§5.9) — ch05_analog_behavior's
//     for_loop.va, while_loop.va, repeat_loop.va and analog_genvar_loop.va;
//   - the broader delimitation in Annex H "level"/"nesting level", which is "a
//     pair of matching keywords SUCH AS begin-end OR discipline-enddiscipline".
//     Only begin-end is exercised here; discipline-enddiscipline is §3.6/§7.
//
//! lrm H
//! lrm 5.3
//! lrm 5.3:1
//! lrm 5.8
//! lrm 4.2.5
//! lrm 5.8.1
//! lrm 5.8.1:4
//! bias V(p) = -0.4
//! checks 3
`include "check.vh"
module glossary_block_control_flow(p, n);
  inout p, n; electrical p, n;
  real result, sequential;
  analog begin : constitutive_block
    if (V(p,n) > 0.0) result = V(p,n);
    else result = -V(p,n);
    sequential = 1.0;
    sequential = sequential + 2.0;
    sequential = sequential * 3.0;
    // The verdict is an operand, never a branch: check.vh explains why.
    `CHECKI("guard is false at negative bias", V(p,n) > 0.0, 0);
    `CHECKX("the else arm's value survives the block", result, 0.4);
    `CHECKX("the block executes dependent assignments in written order", sequential, 9.0);
    I(p,n) <+ result;
  end
endmodule
