// A.2.1.1's fourth production, the only one of the four that 48_parameter_declarations.va
// does not reach:
//
//     specparam_declaration ::= specparam [ range ] list_of_specparam_assignments ;
//
// It is a MODULE ITEM and not only a specify-block item, and §6.2's own Syntax
// 6-1 says so in the list this file is derivable from:
//
//     non_port_module_item ::=
//             module_or_generate_item
//             | generate_region
//             | specify_block
//             | { attribute_instance } parameter_declaration ;
//             | { attribute_instance } specparam_declaration
//             | aliasparam_declaration
//
// (that list is reproduced under §6.2 Modules; A.7.1 repeats the production as a
// `specify_item`, which is the other place a specparam may be written). §1.1
// makes the complete IEEE Std 1364 Verilog part of Verilog-AMS HDL, and
// `specparam` — the *parameter* of a specify block, as distinct from the
// `parameter` of a module — is 1364's, together with the `specify` section that
// consumes it (62/63/64 record the rest of that family).
//
// A CONFORMING FULL-AMS COMPILER MUST ACCEPT IT, so this file was an xfail
// rather than a `//! reject`: the fixture pins the clause's requirement, and
// the marker recorded that VerA did not meet it. The diagnostic was E0205
// "unsupported module item: found specparam" — a subset refusal at the
// module-item dispatch, so the token was recognised and the construct declined.
//
// WHAT IT BECOMES. A `localparam`, with A.2.4's mandatory default as its value
// and §3.4.1's inference for its type. That is not a coincidence of
// convenience: A.2.4 makes `specparam_assignment ::= specparam_identifier =
// constant_mintypmax_expression` — a constant with a default that no
// `parameter_value_assignment` can name — which is §3.4.5's `localparam` in
// every respect VerA can observe. The edge it approximates is 1364's: a
// specparam is what an SDF back-annotation overrides, and a localparam is
// overridable by nothing. VerA reads no SDF, so the two are indistinguishable
// here, and the day it does this declaration needs storage of its own.
//
// NOT THE SAME EVENT AS 63/64. `specparam` as a module item elaborates; the
// same declaration inside a `specify` block is scoped to a block VerA reads and
// discards (W0251), so it reaches nothing. One production, two homes, and only
// this one is a constant the rest of the module can see.
//
// `tdr` is not a decoration: it is the `t_path_delay_expression` a
// `simple_path_declaration` would name (A.7.2/A.7.4), which is what a specparam
// is FOR, and `real` is one of A.2.2.1's types. The assertion below reads the
// bias back, so the day the declaration was accepted this file XPASSed loudly
// instead of decaying into `unasserted` — which is what happened.
//
//! lrm A.2.1.1
//! lrm 6.2
//! lrm 1.1
//! bias V(p) = 0.75, V(n) = 0.25
`include "check.vh"
module annex_a_specparam(p, n);
    inout p, n;
    electrical p, n;

    specparam tdr = 1.5;

    analog begin
        `CHECKX("the file carrying the A.2.1.1 specparam declaration compiles and runs",
                V(p, n), 0.5);
        I(p, n) <+ V(p, n);
    end
endmodule
