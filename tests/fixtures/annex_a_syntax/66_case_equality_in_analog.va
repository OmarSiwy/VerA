// A.8.6's `binary_operator` lists `===` and `!==` beside `==` and `!=`, and two
// other clauses say what they do in the analog context:
//
//     binary_operator ::= … | == | != | === | !== | …               // A.8.6
//
//     "The case equality operators share the same level of precedence as the
//      logical equality operators. These operators have limited support in the
//      analog block (see 7.3.2)."                                     §4.2.6
//
//     "Verilog-AMS HDL supports accessing of 4-state logic values within the
//      analog context. … The language supports the following specific features,
//      which provide a mechanism to perform this conversion.
//          the case equality operator ( === )
//          the case inequality operator ( !== )
//          the case, casex, and casez statements
//          binary, octal and hexadecimal numeric constants which can contain x
//          and z as digits."
//     "The case equality and case inequality operators have the same precedence
//      as the equality operator."                                     §7.3.2
//
// THOSE ARE NOT A LICENCE TO REFUSE. §7.3.2 is a list of four things the
// language supports IN the analog context, and the first two are these two
// operators. §4.2.6's "limited support" points AT §7.3.2, and §7.3.2's
// limitation is on the operands — 4-state values translated to real or integer
// — not on the spelling. So a full-AMS compiler must accept `===` in an analog
// block. Annex C.5 ("not supported in Verilog-A") removes them from the
// Verilog-A SUBSET only, and VerA targets full Verilog-AMS
// (tests/fixtures/annex_c_analog_subset/COVERAGE.md at 8b1514d4).
//
// WHAT VERA DOES: on two-state operands a case comparison IS the logical one
// (IEEE 1364 §5.1.8 differs from `==` only on x and z bits), so lowering emits
// `==`/`!=`. The one refusal left is §4.2.1's — a real operand, E0369 — pinned
// by ch04_expressions/29_case_equality.va.
//
// WHY THE OPERANDS ARE BARE LITERALS. §7.3.2's own example compares a
// `ddiscrete` net, where the x and z states the clause is about can arise. VerA
// refuses that source earlier and for unrelated reasons — E0315 "net must be
// read through an access function" for the net read, and E0130 "literal
// requires digital value support in the execution backend" for the `1'bx` it is
// compared against — so spelling it would produce an xfail whose stated reason
// names a diagnostic that never fires. `4'b1010 === 4'b1011` is the same
// operator on the same 4-state type with none of those earlier walls in front
// of it, and the three values below are the ones Clause 4's tables give: two
// equal vectors are 1, two unequal ones are 0, `!==` is the exact negation.
//
// THE NEXT FIXTURES, still open: `x` and `z` as digits (E0130) and a
// four-state net read in the analog context (E0315) are two more gaps in the
// same clause, each with its own diagnostic, and neither is measured here.
//
//! lrm A.8.6
//! lrm 4.2.6
//! lrm 7.3.2
//! lrm 4.2.6:1000
//! lrm A.8.6:1000
//! bias V(p) = 0.75, V(n) = 0.25
`include "check.vh"
module annex_a_case_equality(p, n);
    inout p, n;
    electrical p, n;

    integer equal, unequal, negated;

    analog begin
        equal   = (4'b1010 === 4'b1010);
        unequal = (4'b1010 === 4'b1011);
        negated = (4'b1010 !== 4'b1011);

        `CHECKI("case equality of two equal 4-state vectors is 1", equal, 1);
        `CHECKI("case equality of two unequal vectors is 0", unequal, 0);
        `CHECKI("case inequality is its exact negation", negated, 1);
        I(p, n) <+ V(p, n);
    end
endmodule
