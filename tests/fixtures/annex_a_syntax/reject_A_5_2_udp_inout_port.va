// A.5.2:
//
//     udp_port_declaration ::=
//             udp_output_declaration ;
//             | udp_input_declaration ;
//             | udp_reg_declaration ;
//
// A UDP port is an output, an input, or the output's reg; there is no inout
// form. `inout a;` is not derivable. With `input a;` the primitive parses.
//
// VerA reports E0207 "unexpected token: found `inout`".
//
//! lrm A.5.2
//! lrm A.5.2:1000
//! reject-only E0207
//! reject found `inout`
//! neighbour b8_udp_declared_and_instantiated.va
primitive annex_a_udp_inout(o, a);
  output o;
  inout a;                   // illegal: a UDP has no inout ports
  table
    0 : 1;
    1 : 0;
  endtable
endprimitive

// A module, so the file is a complete design without instantiating the UDP.
module annex_a_udp_inout_host(o, a);
  output o;
  input a;
  wire o, a;
  buf g1(o, a);
endmodule
