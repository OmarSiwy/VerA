// A.9.4, and the paragraph it disagrees with:
//
//     white_space ::= space | tab | newline | eof                     // A.9.4
//
//     "White space shall contain the characters for spaces, tabs, newlines, and
//      formfeeds. These characters shall be ignored except when they serve to
//      separate other lexical tokens. However, spaces and tabs shall be
//      considered significant characters in strings (see 2.7)."     §2.3
//
// TWO DIFFERENT LISTS OF THE SAME THING, and this file is written to take both
// literally. The annex's production ends in `eof` and never mentions formfeed;
// §2.3 names formfeed and never mentions `eof`. Neither is wrong — `eof` is the
// token-stream sentinel that lets the grammar say "a token may end the file
// here", and formfeed is a character §2.3's prose admits — but a reader who
// trusted one list alone would write a lexer that rejects the other.
//
// THE FILE IS ITS OWN EVIDENCE, so the separators are not spelled as escapes
// here, they are the actual bytes:
//
//   * the port list, the declarations and the analog block below are separated
//     with RUNS OF TABS where this directory's other files use spaces — every
//     keyword/identifier boundary in the module header is one, which is the
//     boundary where white space is MANDATORY and a dropped separator would
//     fuse two tokens into one identifier;
//   * a FORMFEED sits between the declarations and the `analog` keyword,
//     standing on a line of its own exactly where "ignored except when it
//     separates" is the claim (delete it and `real x;` abuts `analog`);
//   * the LAST LINE HAS NO TRAILING NEWLINE — the file ends at the `l` of
//     `endmodule`, which is A.9.4's `eof` arm. DO NOT ADD ONE; it is the
//     difference between testing the fourth alternative and testing three.
//
// WHAT IT DOES NOT PROVE. That tokens can be separated is what every file in the
// suite already demonstrates; what is asserted is a VALUE, so a lexer that
// silently swallowed a separator, or that stopped at a formfeed, would have to
// do so while still computing 120. §2.3 also requires spaces and tabs INSIDE
// a string to remain significant. The packed ASCII values below distinguish
// "A B" (0x412042) and the tab-separated literal (0x410942) from the stripped
// "AB" (0x4142).
//
// `A.9` (General) is cited as well: it is the heading over the
// subclause this file exercises and states no production of its own, so this
// file is evidence for it on the same positive side.
//
//! lrm A.9
//! lrm A.9.4
//! lrm 2.3
//! lrm 2.3:1
//! lrm 2.3:2
//! lrm 2.3:3
//! lrm A.9.4:1000
//! bias V(p) = 0.75, V(n) = 0.25
//! checks 3
`include "check.vh"
module	annex_a_white_space	(p	,	n);
	inout	p	,	n;
	electrical	p	,	n;
	integer	lhs	,	rhs;
	integer	literal_space	,	literal_tab;

	analog	begin
		lhs	=	12;
		rhs	=	10;
		literal_space	=	"A B";
		literal_tab	=	"A	B";
		`CHECKI("tab-separated and formfeed-separated tokens are the ones written",
		        lhs	*	rhs,	120);
		`CHECKI("a literal space survives inside a string", literal_space, 4268098);
		`CHECKI("a literal tab survives inside a string", literal_tab, 4262210);
		I	(p	,	n)	<+	V	(p	,	n)	;
	end
endmodule
