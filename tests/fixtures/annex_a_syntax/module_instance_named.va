// A.4.1 names every module instance:
//
//     module_instance ::= name_of_module_instance ( [ list_of_port_connections ] )
//     name_of_module_instance ::= module_instance_identifier [ range ]
//
// `named_instance_child c1(p);` connects the child's one terminal `a` to the
// parent's `p` by order (6.5.5), so inside c1 V(a) is V(p) = 0.75; the parent
// reads V(p, n) = 0.75 - 0.25 = 0.5. Both exact. Two verdicts.
// reject_A_4_1_module_instance_without_name.va is this file without `c1`.
//
//! lrm A.4.1
//! lrm A.4.1:1000
//! bias V(p) = 0.75, V(n) = 0.25
//! checks 2
`include "check.vh"
module annex_a_module_instance_named(p, n);
    inout p, n;
    electrical p, n;

    named_instance_child c1(p);

    analog begin
        `CHECKX("the parent's own terminals", V(p, n), 0.5);
        I(p, n) <+ V(p, n);
    end
endmodule

module named_instance_child(a);
    inout a;
    electrical a;

    analog begin
        `CHECKX("c1's terminal a is the parent's p", V(a), 0.75);
        I(a) <+ V(a) / 1000.0;
    end
endmodule
