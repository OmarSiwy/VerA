// A.4.1:
//
//     list_of_port_connections ::=
//             ordered_port_connection { , ordered_port_connection }
//             | named_port_connection { , named_port_connection }
//
// One instance's connections are all ordered or all named. `c1(p, .b(n))`
// starts ordered and then switches to named, which neither alternative
// derives. `c1(p, n)` and `c1(.a(p), .b(n))` are the legal forms.
//
// VerA reports E0906 "a named connection in a list of ordered connections".
//
//! lrm A.4.1
//! lrm A.4.1:1000
//! reject-only E0906
`include "disciplines.vams"
module annex_a_mix_child(a, b);
  inout a, b;
  electrical a, b;
  analog I(a, b) <+ V(a, b);
endmodule

module annex_a_mixed_connections(p, n);
  inout p, n;
  electrical p, n;
  annex_a_mix_child c1(p, .b(n));   // illegal: ordered then named
endmodule
