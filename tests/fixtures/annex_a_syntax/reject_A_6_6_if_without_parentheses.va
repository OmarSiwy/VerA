// A.6.6:
//
//     analog_conditional_statement ::=
//             if ( analog_expression ) analog_statement_or_null
//             { else if ( analog_expression ) analog_statement_or_null }
//             [ else analog_statement_or_null ]
//
// The condition is parenthesised. `if V(p, n) > 0 x = 1.0;` has none, so it is
// not derivable. `if (V(p, n) > 0) x = 1.0;` is the legal form.
//
// VerA reports E0207 "unexpected token: found V"; the E0209 at `else` is the
// parser recovering.
//
// `A.6` (Behavioral statements) is cited as well: it is the heading over the
// subclause this file exercises and states no production of its own, so this
// file is evidence for it on the same reject side.
//
//! lrm A.6
//! lrm A.6.6
//! lrm A.6.6:1000
//! reject-only E0207
//! reject E0209
//! neighbour 05_behavioral_statements.va
`include "disciplines.vams"
module annex_a_if_no_parens(p, n);
  inout p, n;
  electrical p, n;
  real x;
  analog begin
    if V(p, n) > 0 x = 1.0; else x = 0.0;   // illegal: condition not in ( )
    I(p, n) <+ x;
  end
endmodule
