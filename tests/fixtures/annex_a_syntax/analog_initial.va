// §5.2.1 analog initial: it runs once per analysis, BEFORE the analog block
// that uses what it set. `state` is a real, so §3.2 starts it at 0; if the
// analog initial block were dropped or ordered after the analog block, `state`
// would read 0.0 here instead of the 1.0 it assigns.
//
// The header used to cite "LRM 3.3.1" for the initialisation rule; there is no
// §3.3.1 (§3.3 is String data type).
//
//! lrm A.6.2
//! lrm 5.2.1
//! lrm 3.2
//! lrm A.6.2:1000
//! bias V(p) = 0.25
//! print none
`include "check.vh"
module annex_a_analog_initial(p); inout p; electrical p; real state;
analog initial state=1.0;
analog begin
    `CHECKX("analog initial ran before the analog block", state, 1.0);
    I(p)<+state*V(p);
end
endmodule
