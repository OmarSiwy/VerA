//! reject E0204
// EXPECT: error
module annex_a_child(p, n);
    inout p, n;
    electrical p, n;
endmodule

module annex_a_module_instantiation_rejected(p, n);
    inout p, n;
    electrical p, n;
    annex_a_child child_instance(p, n);
endmodule
