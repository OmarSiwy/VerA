// A.6.7:
//
//     analog_case_statement ::=
//             case ( analog_expression ) analog_case_item { analog_case_item } endcase
//
// The case expression is parenthesised. `case k` has none. `case (k)` is the
// legal form.
//
// VerA reports E0207 "unexpected token: found k".
//
//! lrm A.6.7
//! lrm A.6.7:1000
//! reject-only E0207
//! reject E0209
//! neighbour 05_behavioral_statements.va
`include "disciplines.vams"
module annex_a_case_no_parens(p, n);
  inout p, n;
  electrical p, n;
  real x;
  integer k;
  analog begin
    k = 1;
    case k                   // illegal: case expression not in ( )
      1: x = 1.0;
      default: x = 0.0;
    endcase
    I(p, n) <+ x;
  end
endmodule
