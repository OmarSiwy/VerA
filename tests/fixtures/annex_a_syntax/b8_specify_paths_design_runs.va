// A.7.1-A.7.3, the positive half, with a design around the block that RUNS
// and is observed. 63_specify_block_unsupported.va spells the block too, but
// its one check reads the testbench bias, so it passes whatever the block
// does to the module that holds it. This file reads that module's outputs.
//
//     specify_block ::= specify { specify_item } endspecify               // A.7.1
//     specify_item ::= specparam_declaration | pulsestyle_declaration
//             | showcancelled_declaration | path_declaration | system_timing_check
//     pulsestyle_declaration ::= pulsestyle_onevent list_of_path_outputs ;
//             | pulsestyle_ondetect list_of_path_outputs ;
//     showcancelled_declaration ::= showcancelled list_of_path_outputs ;
//             | noshowcancelled list_of_path_outputs ;
//     path_declaration ::= simple_path_declaration ;                       // A.7.2
//             | edge_sensitive_path_declaration ; | state_dependent_path_declaration ;
//     parallel_path_description ::= ( specify_input_terminal_descriptor
//             [ polarity_operator ] => specify_output_terminal_descriptor )
//     full_path_description ::= ( list_of_path_inputs [ polarity_operator ]
//             *> list_of_path_outputs )
//     state_dependent_path_declaration ::= if ( module_path_expression )
//             simple_path_declaration | ... | ifnone simple_path_declaration
//     specify_input_terminal_descriptor ::=                                // A.7.3
//             input_identifier [ [ constant_range_expression ] ]
//     specify_output_terminal_descriptor ::=
//             output_identifier [ [ constant_range_expression ] ]
//
// WHAT IS SPELLED. Every A.7.1 arm but `system_timing_check` (that one is
// b8_timing_checks_design_runs.va): a specparam, both pulsestyle keywords,
// both showcancelled keywords (each before any path naming its outputs, as
// IEEE 1364-2005 §14.6.4.1 and §14.6.4.2 require). A.7.2: a parallel path with
// the `-` polarity operator, a full path over a two-input list, an `if` and an
// `ifnone` state-dependent pair on one source/destination, and an
// edge-sensitive path. A.7.3: a part-select source `v[2:1]` and a bit-select
// source `v[3]`.
//
// WHAT IS NOT CLAIMED. VerA reads the block and applies none of it (W0251,
// pinned below): no path delay is scheduled. ROADMAP §1 B keeps §14 in scope
// only as parsed and visible to VPI, and CLAUSES.tsv classifies the delay
// clauses not-supported. So nothing here observes a delay. 1364-2005 §14.1:
// "the specify block is the vehicle for describing paths between a source and
// a destination and for assigning delays to these paths". A path assigns a
// delay and drives nothing; the values come from the module's functional
// description. Each sample point is 10 ns after the last input change, past
// the longest delay written here (tf = 5, the edge path's 6), so a simulator
// that applies the delays reads the same values. The claim is that the block
// is accepted, that the module around it elaborates and runs, and that no path
// alters a value: a path read as a connection (driving y from a), or a block
// that swallowed a following item, changes a value below.
//
// DERIVATION (`timescale 1ns/1ns; cell: y = ~a, z = a & b, n = a ^ en,
// w = v[2:1], m = v[3], e = er where er <= b at posedge a):
//
//   [1, 21)   a=0 b=1 en=1 v=0110: y=1 z=0 n=1 w=2'b11=3 m=0. e is still x:
//             the x->0 on a at 1 ns is no posedge, so e is not read here.
//   [21, 41)  a rises with b=1, v=1001: y=0 z=1 n=0 w=2'b00=0 m=1, e=1.
//   [41, ..)  b=0 en=0: y=0 z=0 n=1 w=0 m=1; no posedge of a, so e stays 1.
// The stimulus starts at 1 ns, not 0, so every process is waiting on its
// event control before the first change (no time-zero race). The cell's
// outputs reach the top on its wires ty, tz, tn, tw, te, tm, and a second
// initial block checks them at 11, 31 and 51 ns: 5, 6 and 6 checks, 17
// verdicts. Checking in the digital half keeps the count exact, where an
// analog-block check also prints at every point the mixed run inserts at a
// digital event.
//
//! lrm A.7
//! lrm A.7.1
//! lrm A.7.2
//! lrm A.7.3
//! lrm A.7.1:1000
//! lrm A.7.2:1000
//! lrm A.7.3:1000
//! warn W0251
//! analysis tran
//! time 0, 60n
//! checks 17
`timescale 1ns/1ns
`include "check.vh"
module b8_specify_paths_design_runs(p);
  inout p; electrical p;
  reg a, b, en;
  reg [3:0] v;
  wire ty, tz, tn, te, tm;
  wire [1:0] tw;

  b8_sp_cell u(a, b, en, v, ty, tz, tn, tw, te, tm);

  initial begin
    #1 a = 1'b0; b = 1'b1; en = 1'b1; v = 4'b0110;
    #20 a = 1'b1; v = 4'b1001;
    #20 b = 1'b0; en = 1'b0;
  end

  initial begin
    #11 `CHECKI("t=11 y = ~a through the -=> path", ty, 1);
    `CHECKI("t=11 z = a & b through the *> path", tz, 0);
    `CHECKI("t=11 n = a ^ en through the if/ifnone paths", tn, 1);
    `CHECKI("t=11 w = v[2:1] through the part-select path", tw, 3);
    `CHECKI("t=11 m = v[3] through the bit-select path", tm, 0);
    #20 `CHECKI("t=31 y", ty, 0);
    `CHECKI("t=31 z", tz, 1);
    `CHECKI("t=31 n", tn, 0);
    `CHECKI("t=31 w", tw, 0);
    `CHECKI("t=31 m", tm, 1);
    `CHECKI("t=31 e took b at posedge a through the edge path", te, 1);
    #20 `CHECKI("t=51 y", ty, 0);
    `CHECKI("t=51 z", tz, 0);
    `CHECKI("t=51 n", tn, 1);
    `CHECKI("t=51 w", tw, 0);
    `CHECKI("t=51 m", tm, 1);
    `CHECKI("t=51 e holds with no posedge", te, 1);
  end

  analog I(p) <+ V(p);
endmodule

module b8_sp_cell(a, b, en, v, y, z, n, w, e, m);
  input a, b, en;
  input [3:0] v;
  output y, z, n, m, e;
  output [1:0] w;
  reg er;

  assign y = ~a;
  assign z = a & b;
  assign n = a ^ en;
  assign w = v[2:1];
  assign m = v[3];
  always @(posedge a) er <= b;
  assign e = er;

  specify
    specparam tr = 2, tf = 5;
    pulsestyle_onevent y;
    pulsestyle_ondetect z;
    showcancelled y, n;
    noshowcancelled z;
    (a -=> y) = (tr, tf);
    (a, b *> z) = 3;
    if (en) (a => n) = 1;
    ifnone (a => n) = 2;
    (v[2:1] => w) = 1;
    (v[3] => m) = 1;
    (posedge a => (e +: b)) = (4, 6);
  endspecify
endmodule
