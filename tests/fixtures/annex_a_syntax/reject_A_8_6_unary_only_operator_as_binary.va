// A.8.6:
//
//     unary_operator ::= + | - | ! | ~ | & | ~& | | | ~| | ^ | ~^ | ^~
//     binary_operator ::= + | - | * | / | % | == | != | === | !== | && | || | **
//             | < | <= | > | >= | & | | | ^ | ^~ | ~^ | >> | << | >>> | <<<
//
// `!` is in the unary list only. `y ! 2.0` uses it between two operands,
// which requires a binary_operator, so the expression is not derivable.
// `y != 2.0` is legal.
//
// VerA reports E0207 "unexpected token: found `!`".
//
//! lrm A.8.6
//! lrm A.8.6:1000
//! reject-only E0207
//! neighbour 65_operators.va
`include "disciplines.vams"
module annex_a_unary_as_binary(p, n);
  inout p, n;
  electrical p, n;
  real x, y;
  analog begin
    y = 1.0;
    x = y ! 2.0;             // illegal: ! is not a binary_operator
    I(p, n) <+ x;
  end
endmodule
