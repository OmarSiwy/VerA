// A.5.4:
//
//     udp_instantiation ::= udp_identifier [ drive_strength ] [ delay2 ]
//             udp_instance { , udp_instance } ;
//
// and A.2.2.3's delay2 is `# delay_value | # ( mintypmax_expression [ ,
// mintypmax_expression ] )`: at most two values. `#(1, 2, 3)` has three.
// `#(1, 2)` is the legal form.
//
// VerA refuses it with E0239 "a UDP instance's delay is more than a delay2".
// (It used to report E0904 "instance names no module" for EVERY named UDP
// instance.) The legal twin, with the undelayed, `#(1)` and `#(1, 2)` forms,
// is udp_named_instance_delay2.va.
//
//! lrm A.5.4
//! lrm A.2.2.3
//! lrm A.2.2.3:1000
//! lrm A.5.4:1000
//! reject-only E0239
//! neighbour udp_named_instance_delay2.va
primitive annex_a_udp_inv(o, a);
  output o;
  input a;
  table
    0 : 1;
    1 : 0;
  endtable
endprimitive

module annex_a_udp_three_delays(o, a);
  output o;
  input a;
  wire o, a;
  annex_a_udp_inv #(1, 2, 3) u(o, a);   // illegal: delay2 has at most two values
endmodule
