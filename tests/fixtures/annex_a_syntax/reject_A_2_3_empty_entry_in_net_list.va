// A.2.3:
//
//     list_of_net_identifiers ::= ams_net_identifier { , ams_net_identifier }
//
// Every comma is followed by an identifier. `electrical p,, n;` has an empty
// entry between the two commas, which the list does not derive.
// `electrical p, n;` is the legal form.
//
// VerA reports E0208 "expected an identifier: found `,`".
//
// `A.2` (Declarations) is cited as well: it is the heading over the
// subclause this file exercises and states no production of its own, so this
// file is evidence for it on the same reject side.
//
//! lrm A.2
//! lrm A.2.3
//! lrm A.2.3:1000
//! reject-only E0208
//! neighbour 03_declarations.va
`include "disciplines.vams"
module annex_a_empty_list_entry(p, n);
  inout p, n;
  electrical p,, n;          // illegal: empty entry in the identifier list
  analog I(p, n) <+ V(p, n);
endmodule
