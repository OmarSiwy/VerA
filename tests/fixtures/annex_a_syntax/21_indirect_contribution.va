// LRM 5.6.7 indirect branch contribution, A.6.10
// `indirect_contribution_statement ::= branch_lvalue : indirect_expression == analog_expression ;`
//
// The LRM's own worked example is the ideal opamp: `V(out): V(in) == 0;` reads
// "drive V(out) so that V(in) == 0". `out` is driven with a voltage source whose
// value the solver adjusts; every branch named in the equation — here V(in) —
// is only PROBED.
//
// An equation pins no number until the probe is wired to something, so this
// module closes the textbook inverting amplifier around it: a 1 ohm resistor
// from p to in, a 1 ohm feedback resistor from in to out, and one flow
// contribution stating KCL at `in`. At the solution the constraint holds, so
// V(in) = 0 and the two resistor currents must cancel:
//
//     (0 - V(p))/1 + (0 - V(out))/1 = 0   =>   V(out) = -V(p) = -0.75
//
// 0.75 is exact in binary (3/4), but the tolerance is not exact equality: a
// conforming simulator reaches the constraint by Newton iteration and is
// entitled to stop at its own tolerance. The number is the one the standard
// itself fixes — annex D declares `nature Voltage ... abstol = `VOLTAGE_ABSTOL`
// and `VOLTAGE_ABSTOL` defaults to 1e-6 — so a tool that converges to its
// declared voltage abstol passes. This used to read 1e-9, three decades tighter
// than anything normative and not derivable from the LRM at all.
//
// WHAT THIS REPLACED, so it is not reintroduced: the previous version asserted
// `V(c) - 2.0*V(p) == 0.0` with BOTH V(p) and V(c) pinned by `//! bias`. That
// residual is 1.5 - 1.5 whatever the module body contains — deleting the
// indirect contribution statement entirely left the fixture green.
//
//! lrm 5.6.7
//! lrm A.6.10
//! lrm D.1
//! bias V(p) = 0.75
//! print none
//! xfail VerA's testbench writes `//! bias` straight into x[] and never solves (src/backend/tb.zig), so V(out) stays 0 and no 5.6.7 constraint is ever enforced
`include "check.vh"
module annex_a_indirect(p, out);
    inout p, out;
    electrical p, out;
    electrical in;

    analog begin
        // KCL at the probed input node: the source resistor and the feedback
        // resistor, both 1 ohm, are the only currents into `in`.
        I(in) <+ (V(in) - V(p)) + (V(in) - V(out));
        // Drive V(out) until the input node sits at zero.
        V(out) : V(in) == 0.0;
        `CHECK("the indirect contribution holds its equation V(in) == 0", V(in), 0.0, 1e-6);
        `CHECK("driving V(out) to satisfy it gives -V(p)", V(out), -0.75, 1e-6);
    end
endmodule
