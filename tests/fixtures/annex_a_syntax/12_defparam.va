// Annex A.1.4 parameter_override, §6.3.1.
//
//   parameter_override        ::= defparam list_of_defparam_assignments ;
//   defparam_assignment       ::= hierarchical_parameter_identifier = constant_mintypmax_expression
//
// §6.3.1: "Using the defparam statement, parameter values can be changed in any
// module instance throughout the design using the hierarchical name of the
// parameter." A parameter_override is a module_or_generate_item (A.1.4) and
// Clause 6 is in the Verilog-A subset per Annex C.8, so a conforming compiler
// accepts this file. It used to carry a bare `//! reject E0205`.
//
// The old body was `defparam child.gain = 2.0;` in a module with no instance
// named `child` at all — so even a compiler that implemented defparam had to
// reject it, for a different reason than the one the fixture claimed. The
// instance is here now, and the assertion lives inside the child where the
// override lands: the child declares `gain = 1.0`, the parent's defparam sets
// it to 2.0, and §6.3.1's "shall be a constant expression" is honoured by the
// literal.
//
// V(p,n) = 1.5 - 0.5 = 1.0 by §5.4.1, so the flow the child contributes is
// gain * 1.0 — the parent's own probe is checked too, so a defparam that
// silently rewired the instance would not pass on the gain alone.
//
// MODULE ORDER IS LOAD-BEARING. A device is elaborated from the FIRST module in
// the file (01_source_text.va documents the rule), so the parent carrying the
// defparam is written first and the child is reached only through the instance.
// Child first, the child elaborates standalone: `gain` reads its declared 1.0,
// the assertion fails at 1.0 != 2.0 however well defparam is implemented, and
// the parent's probe never runs at all — a permanent XFAIL whose marker could
// never be deleted.
//
//! lrm A.1.4
//! lrm 6.3.1
//! lrm C.8
//! bias V(p) = 1.5
//! bias V(n) = 0.5
//! print none
//! xfail VerA implements neither module instantiation (E0204, reported first) nor defparam (E0205)
`include "check.vh"
module annex_a_defparam(p, n);
    inout p, n;
    electrical p, n;

    annex_a_defparam_child child(p, n);
    defparam child.gain = 2.0;

    analog begin
        `CHECKX("the parent probes the potential across its own ports", V(p, n), 1.0);
    end
endmodule

module annex_a_defparam_child(p, n);
    inout p, n;
    electrical p, n;
    parameter real gain = 1.0;

    analog begin
        `CHECKX("the parent's defparam overrode the child's declared default", gain, 2.0);
        I(p, n) <+ gain * V(p, n);
    end
endmodule
