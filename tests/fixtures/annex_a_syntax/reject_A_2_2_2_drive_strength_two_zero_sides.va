// A.2.2.2:
//
//     drive_strength ::=
//             ( strength0 , strength1 )
//             | ( strength1 , strength0 )
//             | ( strength0 , highz1 ) | ( strength1 , highz0 )
//             | ( highz0 , strength1 ) | ( highz1 , strength0 )
//     strength0 ::= supply0 | strong0 | pull0 | weak0
//
// Every alternative pairs a 0-side strength with a 1-side one.
// `(strong0, weak0)` gives two 0-side strengths, which no alternative derives.
// `(strong0, weak1)` in the same declaration compiles (probed).
//
// VerA reports E0207 "a drive strength pairs one 0-side with one 1-side
// strength".
//
//! lrm A.2.2.2
//! lrm A.2.2.2:1000
//! reject-only E0207
//! reject pairs one 0-side with one 1-side
//! neighbour b8_drive_strength_resolves.va
module annex_a_strength_two_zero(o);
  output o;
  wire (strong0, weak0) w = 1'b1;   // illegal: two 0-side strengths
  wire o;
  buf g1(o, w);
endmodule
