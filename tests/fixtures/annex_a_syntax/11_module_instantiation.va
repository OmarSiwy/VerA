// Annex A.4.1 module_instantiation, and Annex C.8: "The hierarchical structure
// defined in Clause 6 is applicable to both Verilog-AMS HDL and Verilog-A,
// except support for real value ports is only applicable to Verilog-AMS HDL
// and IEEE Std 1364 Verilog (see 6.5.3)." Instantiating a child is INSIDE the
// Verilog-A subset — Clause 6 has exactly one carve-out and this is not it — so
// this file must run green, not reject. It used to carry a bare
// `//! reject E0204`, which asserted a VerA limitation as if it were the rule:
// a conforming compiler failed it and only VerA passed.
//
// Two things are pinned, both fixed by the LRM and neither by the host:
//   §5.4.1  the parent's two-argument probe is the potential across the pair,
//           1.5 - 0.5 = 1.0 V from the biases below;
//   §6.3.2  a named parameter value assignment on the instance overrides the
//           child's declared default, so `gain` inside the child is 2.0 and not
//           the 1.0 it declares.
//
// MODULE ORDER IS LOAD-BEARING. A device is elaborated from the FIRST module in
// the file (01_source_text.va documents the rule), so the PARENT is written
// first and `annex_a_child` is reached only through the instance. Written the
// other way round the child is elaborated standalone: `gain` is the declared
// 1.0, the assertion is 1.0 != 2.0 no matter how well instantiation is
// implemented, and the parent's own probe never executes at all — a permanent
// XFAIL whose marker could never be deleted.
//
// `A.4` (Module instantiation and generate construct) is cited as well: it is the heading over the
// subclause this file exercises and states no production of its own, so this
// file is evidence for it on the same positive side.
//
//! lrm A.4
//! bias V(p) = 1.5
//! bias V(n) = 0.5
//! lrm A.4.1
//! lrm C.8
//! lrm 6.3.2
//! lrm 6.3.3
//! lrm 6.3.3:1
//! lrm A.4.1:1000
//! print none
`include "check.vh"
module annex_a_module_instantiation(p, n);
    inout p, n;
    electrical p, n;

    annex_a_child #(.gain(2.0)) child_instance(p, n);

    analog begin
        `CHECKX("the parent probes the potential across its own ports", V(p, n), 1.0);
    end
endmodule

module annex_a_child(p, n);
    inout p, n;
    electrical p, n;
    parameter real gain = 1.0;

    analog begin
        `CHECKX("the instance's named override reaches the child", gain, 2.0);
        I(p, n) <+ gain * V(p, n);
    end
endmodule
