// A.6.5's implicit event list as an intra-assignment control:
//
//     blocking_assignment ::= variable_lvalue = [ delay_or_event_control ]
//             expression                                              // A.6.2
//     delay_or_event_control ::= delay_control | event_control
//             | repeat ( expression ) event_control                   // A.6.5
//     event_control ::= @ hierarchical_event_identifier
//             | @ ( event_expression ) | @* | @ (*)                   // A.6.5
//
// IEEE 1364-2005 §9.7.7: "An intra-assignment delay or event control shall
// delay the assignment of the new value to the left-hand side, but the
// right-hand expression shall be evaluated before the delay", and "The repeat
// event control shall specify an intra-assignment delay of a specified number
// of occurrences of an event." Syntax 9-12 lists `@*` and `@ (*)` among its
// event controls; §9.7.5 makes `@*` the nets and variables the statement reads,
// here the right-hand side's operands.
//
// DERIVATION (`timescale 1ns/1ns). a = 1, b = 2, x = y = 0 at 0.
//   t=1  `x = @(*) a + b;` samples 3 and waits on a or b
//   t=2  x = 0                                       (still waiting)
//   t=3  a = 10 ends the wait: x = 3, the sampled sum, not 12
//   t=4  x = 3
//   t=5  `y = repeat (2) @* b;` samples 2 and waits for two changes of b
//   t=6  b = 20 (the first); y = 0 at the end of the step
//   t=7  b = 30 (the second): y = 2
//   t=8  y = 2
// Four verdicts. With no wait x would be 3 at t=2; with the statement form
// `@* x = a + b` it would be 12 at t=4.
//
//! lrm A.6.5
//! lrm A.6.2
//! lrm A.6.5:1000
//! analysis tran
//! time 0, 10n
//! checks 4
`timescale 1ns/1ns
`include "check.vh"
module intra_assignment_implicit_event(p);
    inout p;
    electrical p;
    reg [7:0] a, b, x, y;

    initial begin
        a = 8'd1;
        b = 8'd2;
        x = 8'd0;
        y = 8'd0;
        #1 x = @(*) a + b;
    end

    initial #5 y = repeat (2) @* b;

    initial begin
        #3 a = 8'd10;
        #3 b = 8'd20;
        #1 b = 8'd30;
    end

    initial begin
        #2 `CHECKI("t=2: x still waits on a or b", x, 0);
        #2 `CHECKI("t=4: x took the sum sampled at t=1", x, 3);
        #2 `CHECKI("t=6: one change of b of the two", y, 0);
        #2 `CHECKI("t=8: y took b as sampled at t=5", y, 2);
    end

    analog I(p) <+ V(p);
endmodule
