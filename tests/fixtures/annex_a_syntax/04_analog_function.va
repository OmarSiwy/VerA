// Annex A.2.6 / §4.7.2.1: the return value of an analog function is whatever
// was assigned to the function's own name. `square` is x*x, so at V(p,n) = 1.5
// the call must be 2.25 — a value the function definition fixes and nothing
// else in the module can change. 1.5 and 2.25 are both exact in binary, so the
// assertion is `CHECKX` and not a tolerance.
//
// The explicit `real` return type is the point of contrast with
// 37_analog_function_default_type.va (type omitted) and
// 38_analog_function_integer_string.va (the other two types).
//
// THE FORMAL IS DECLARED IN TWO LINES, not as `input real value;`. A.2.6 gives
// `analog_function_item_declaration ::= analog_block_item_declaration
// | input_declaration ; | ...` and A.2.1.2 `input_declaration ::= input
// [ discipline_identifier ] [ net_type | wreal ] [ signed ] [ range ]
// list_of_port_identifiers` — `real` is not a net_type, so `input real x` is
// derivable only from A.2.7 `tf_input_declaration`, which is the task/digital-
// function port form and which A.2.6 does not reference. §4.7.1 says the same
// in prose: "all formal arguments shall have an associated block item
// declaration specifying the data type", and every example in that clause
// writes the two lines. 23_expression_primaries.va uses the same shape.
//
//! lrm A.2.6
//! lrm 4.7.1
//! lrm 4.7.2.1
//! lrm 4.7.1:1
//! lrm A.2.6:1000
//! bias V(p) = 1.5
//! print none
`include "check.vh"
module annex_a_analog_function(p, n);
    inout p, n;
    electrical p, n;

    analog function real square;
        input value;
        real value;
        begin
            square = value * value;
        end
    endfunction

    analog begin
        `CHECKX("analog function returns the value assigned to its own name",
                square(V(p, n)), 2.25);
        I(p, n) <+ square(V(p, n));
    end
endmodule
