// A.6.4's attributed null and attributed statements, observed through
// variables. 22_null_attributed_statements.va writes the same shapes, but its
// one check reads the bias V(p), so it cannot see what an arm did.
//
//     analog_statement ::= { attribute_instance } analog_conditional_statement
//             | { attribute_instance } analog_procedural_assignment
//             | { attribute_instance } analog_seq_block | ...          // A.6.4
//     analog_statement_or_null ::= analog_statement | { attribute_instance } ;
//     analog_conditional_statement ::= if ( analog_expression )
//             analog_statement_or_null [ else analog_statement_or_null ] // A.6.6
//     analog_case_item ::= analog_expression { , analog_expression } :
//             analog_statement_or_null | default [ : ] analog_statement_or_null
//                                                                      // A.6.7
//
// §2.9.1: an attribute "specifies properties" of the item it precedes. A
// tool that does not know the name ignores it (VerA does, for these names), so
// an attributed null does nothing and an attributed statement runs as the bare
// statement would. What a parser can get wrong is which statement the
// attribute belongs to and where the null ends: one that swallowed the
// statement after `(* ... *) ;`, or dropped an attributed assignment with its
// attribute, changes a variable below.
//
// DERIVATION. k = 2, so every condition below is decided by k and none by the
// bias. Each variable starts at 1.0.
//
//   if (k == 2) (* null_then *) ; else (* set_else *) r1 = 7.0;
//       true arm, the attributed null: r1 stays 1.0.
//   if (k != 2) (* null_then *) ; else (* set_else *) r2 = 2.5;
//       false: the attributed else assignment runs: r2 = 2.5.
//   if (k == 2) (* a1 *) (* a2 = 3 *) ; else r3 = 9.0;
//       two attribute_instances on one null; true: r3 stays 1.0.
//   (* blk *) begin r3 = r3 + 0.25; end
//       an attributed seq_block runs: r3 = 1.25.
//   case (k) 1: r4 = 5.0; 2: (* null_arm *) ; default: (* dflt *) r4 = 6.0;
//       k matches 2, the attributed null arm: r4 stays 1.0.
//
// Every value is exact in binary, so the checks are CHECKX.
//
//! lrm A.6.4
//! lrm A.6.6
//! lrm A.6.7
//! lrm 2.9.1
//! lrm A.6.4:1000
//! lrm A.6.6:1000
//! lrm A.6.7:1000
//! bias V(p) = 0.5
//! checks 4
`include "check.vh"
module b8_null_attributed_statements_effect(p);
  inout p; electrical p;
  real r1, r2, r3, r4;
  integer k;
  analog begin
    r1 = 1.0; r2 = 1.0; r3 = 1.0; r4 = 1.0;
    k = 2;
    if (k == 2) (* null_then *) ; else (* set_else *) r1 = 7.0;
    if (k != 2) (* null_then *) ; else (* set_else *) r2 = 2.5;
    if (k == 2) (* a1 *) (* a2 = 3 *) ; else r3 = 9.0;
    (* blk *) begin r3 = r3 + 0.25; end
    case (k)
      1: r4 = 5.0;
      2: (* null_arm *) ;
      default: (* dflt *) r4 = 6.0;
    endcase
    `CHECKX("a taken attributed null arm runs nothing", r1, 1.0);
    `CHECKX("an attributed else assignment runs", r2, 2.5);
    `CHECKX("two attributes on one null, then an attributed seq_block", r3, 1.25);
    `CHECKX("a matched attributed null case arm runs nothing", r4, 1.0);
    I(p) <+ V(p);
  end
endmodule
