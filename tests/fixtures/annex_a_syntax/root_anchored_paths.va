// A.9.3's `$root` anchor in the two declaration positions that take a
// hierarchical name, beside the expression position that already read one:
//
//     hierarchical_identifier ::= [ $root . ] { identifier
//             [ [ constant_expression ] ] . } identifier             // A.9.3
//     defparam_assignment ::= hierarchical_parameter_identifier =
//             constant_mintypmax_expression                           // A.2.4
//     ams_net_identifier ::= net_identifier { dimension }
//             | hierarchical_net_identifier                          // A.2.1.3
//
// §6.2.1: `$root` "can be used to unambiguously refer to a top-level instance
// or to an instance path starting from the root of the instantiation tree".
// The device is the one top-level instance, so `$root.root_anchored_paths.u`
// is the instance u written below. Annex F.2.1: a declaration of a
// hierarchical net name is an out-of-context one, which gives that net its
// discipline (§3.10 precedence order 1).
//
// DERIVATION. V(p) = 1.0, V(n) = 0 (bias); V(u.q) = 0.25 (bias).
//   `defparam $root.root_anchored_paths.u.g = 2.0;` makes the child's g 2.0
//   (declared 1.0).
//   `magnetic $root.root_anchored_paths.u.q;` gives the child's
//   discipline-less `wire q` the magnetic discipline, so MMF reads its
//   potential: 0.25. (Over a declared `electrical q` it would be §3.11.1's
//   incompatible override, E0375.)
//   The child's port a is bound to the device's p, and §6.7.1: "Potential
//   and flow access for named and unnamed branches (including port branches)
//   can be done hierarchically": V($root.root_anchored_paths.u.a) reads p, 1.0.
// Three verdicts.
//
//! lrm A.9.3
//! lrm 6.2.1
//! lrm 6.7.1
//! lrm A.2.4
//! lrm F.2.1
//! lrm A.9.3:1000
//! bias V(p) = 1.0
//! bias V(n) = 0.0
//! bias V(u.q) = 0.25
//! print none
//! checks 3
`include "check.vh"
module root_anchored_paths(p, n);
    inout p, n;
    electrical p, n;
    root_anchored_paths_child u(p, n);
    defparam $root.root_anchored_paths.u.g = 2.0;
    magnetic $root.root_anchored_paths.u.q;

    analog begin
        `CHECKX("a $root-anchored out-of-context declaration made u.q magnetic", MMF($root.root_anchored_paths.u.q), 0.25);
        `CHECKX("a $root-anchored probe of the child's port a reads p", V($root.root_anchored_paths.u.a), 1.0);
        Phi($root.root_anchored_paths.u.q) <+ MMF($root.root_anchored_paths.u.q) / 1000.0;
    end
endmodule

module root_anchored_paths_child(a, b);
    inout a, b;
    electrical a, b;
    wire q;
    parameter real g = 1.0;

    analog begin
        `CHECKX("defparam $root.root_anchored_paths.u.g reached the child", g, 2.0);
        I(a, b) <+ g * V(a, b);
    end
endmodule
