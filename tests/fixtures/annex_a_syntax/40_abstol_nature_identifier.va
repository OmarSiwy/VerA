// A.8.3 `abstol_expression ::= constant_expression | nature_identifier`, and
// §4.5.3 Table 4-17 spells the second arm out for ddt: "ddt(expr, nature) —
// same as above, except nature is specified explicitly ... The absolute
// tolerance, abstol or derived from nature, applies to the output of the ddt
// operator". `Voltage` is the annex D nature the compiler's own prelude
// declares, so the argument below is a nature_identifier and not a number.
//
// All 72 tolerance arguments elsewhere in the suite are numeric literals, so
// this production's second arm had no user.
//
// WHAT IS ASSERTED, and what is not. §4.5.3: "In DC analysis, ddt() returns
// zero (0)." That is normative and unconditional, so the two-argument form must
// give exactly the same 0.0 the one-argument form gives — a compiler that
// mis-parsed the nature argument as a second operand, or shifted the argument
// list, produces something else. What this CANNOT see is a compiler that parses
// the nature and then throws it away: abstol changes only convergence
// behaviour, which no value inside the model reflects. Both calls are here so
// that the equality of the two forms is checked as well as the value, and the
// third assertion is the `CHECKEQ` that actually states it. The header used to
// claim that equality was under test while the code held the literal 0.0 twice
// and no comparison at all.
//
// WHY THIS IS NOT WRITTEN AS `analog I(p, n) <+ ddt(V(p, n), Voltage);`. VerA
// accepts that shape — and accepts `ddt(V(p, n), Zorkmid)` in the same position
// just as happily, because in contribution position the tolerance argument is
// discarded before any name resolution runs. A fixture written that way would
// be green today and would prove nothing at all about A.8.3. Assigning the call
// to a variable is the same production and is where VerA actually tries to
// resolve the identifier, so that is the form that states the requirement.
//
//! lrm A.8.3
//! lrm 4.5.3
//! bias V(p) = 0.75
//! print none
//! xfail VerA resolves a ddt tolerance argument as an ordinary expression outside contribution position: `r = ddt(V(p,n), Voltage);` is E0314 "unknown identifier: `Voltage`" (in contribution position the argument is instead dropped unresolved)
`include "check.vh"
module annex_a_abstol_nature(p, n);
    inout p, n;
    electrical p, n;
    real bare;
    real toleranced;

    analog begin
        bare = ddt(V(p, n));
        toleranced = ddt(V(p, n), Voltage);
        `CHECKX("ddt returns zero in a dc analysis", bare, 0.0);
        `CHECKX("a nature_identifier tolerance does not change the value", toleranced, 0.0);
        `CHECKEQ("the two-argument form equals the one-argument form", toleranced, bare, 0.0);
        I(p, n) <+ toleranced + V(p, n);
    end
endmodule
