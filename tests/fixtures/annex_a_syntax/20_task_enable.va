// A.6.9 `task_enable ::= hierarchical_task_identifier ( expression { , expression } ) ;`
// is an alternative of the DIGITAL A.6.4 `statement` only. The A.6.4
// `analog_statement` list has no `task_enable` alternative — its only call form
// is `analog_system_task_enable`, a `$`-prefixed system task. So `record(V(p));`
// in analog_statement position is underivable and a conforming tool diagnoses
// this module.
//
// WHICH DIAGNOSTIC ACTUALLY FIRES, and why the fixture pins that one: the
// `task ... endtask` DECLARATION is legal. A.2.7 defines task_declaration and
// A.1.4 `module_or_generate_item` admits it, so a conforming tool parses the
// declaration and complains only at the enable. VerA refuses the declaration
// itself, E0205 "unsupported module item: found task" at column 55, before the
// call is ever reached. "This file must not compile" is right for both
// compilers; only the reason differs, so the code is the honest thing to pin.
//
// The A.6.4 claim is therefore not pinned by anything yet, and cannot be while
// E0205 stands: a fixture demanding a task-enable diagnostic today would go
// green on the declaration instead. Same dependency as 17_named_event_trigger.
// The day task declarations parse, this fixture FAILs because E0205 stops
// firing — which is the prompt to re-point it at the enable.
//
//! lrm A.6.9
//! lrm A.6.4
//! lrm A.2.7
//! reject E0205
module annex_a_task_enable(p); inout p; electrical p; task record; input real x; begin $display("%g",x); end endtask analog begin record(V(p)); I(p)<+V(p); end endmodule
