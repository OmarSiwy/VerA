// A.2.6 declares an analog function's formal in two items, its direction and
// its type:
//
//     analog_function_item_declaration ::= analog_block_item_declaration
//             | input_declaration ; | output_declaration ; | inout_declaration ;
//
// and 4.7.1 says the same in words: "all formal arguments shall have an
// associated block item declaration specifying the data type of the
// argument". So `input x; real x;` is the spelling, item after item with no
// `;` between them of its own.
//
// twice(V(p, n)) at V(p, n) = 0.75 - 0.25 = 0.5 is 1.0, exact in binary.
// reject_A_2_6_typed_analog_function_input.va writes `input real x;` instead;
// reject_A_2_6_null_item_in_analog_function.va puts a `;` between the items.
//
//! lrm A.2.6
//! lrm A.2.6:1000
//! lrm 4.7.1
//! bias V(p) = 0.75, V(n) = 0.25
//! checks 1
`include "check.vh"
module annex_a_function_formal_typed(p, n);
    inout p, n;
    electrical p, n;

    analog function real twice;
        input x;
        real x;
        twice = 2.0 * x;
    endfunction

    analog begin
        `CHECKX("twice(V(p, n)), x typed by its own item", twice(V(p, n)), 1.0);
        I(p, n) <+ V(p, n);
    end
endmodule
