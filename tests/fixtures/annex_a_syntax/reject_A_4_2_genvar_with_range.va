// A.4.2:
//
//     genvar_declaration ::= genvar list_of_genvar_identifiers ;
//     list_of_genvar_identifiers ::= genvar_identifier { , genvar_identifier }
//
// A genvar declaration takes no range. `genvar [3:0] i;` is not derivable;
// `genvar i;` in the same module compiles (probed, with an analog for loop
// over i).
//
// VerA reports E0208 "expected an identifier: found `[`".
//
//! lrm A.4.2
//! lrm A.4.2:1000
//! reject-only E0208
//! neighbour 09_generate.va
`include "disciplines.vams"
module annex_a_genvar_range(p, n);
  inout p, n;
  electrical p, n;
  genvar [3:0] i;            // illegal: a genvar has no range
  analog I(p, n) <+ V(p, n);
endmodule
