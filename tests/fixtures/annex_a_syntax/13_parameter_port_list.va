// Annex A.1.3 / §6.2 module parameter port list.
//
//   module_parameter_port_list ::= # ( parameter_declaration { , parameter_declaration } )
//   module_declaration ::= ... module_identifier [ module_parameter_port_list ] list_of_ports ; ...
//
// A parameter declared in the header is an ordinary §3.4 module parameter: it
// carries its default, it is visible to the module body, and it is overridable
// from outside. This fixture pins both halves of that with the two header
// parameters treated differently — `gain` is overridden to 3.5 by the operating
// point, `mode` is left alone and must still read its declared default 3.
//
// Only the header form is under test: the ports stay in the non-ANSI
// `(p, n)` + `inout` + `electrical` form, so nothing but `#(...)` can be the
// reason this file fails.
//
//! lrm A.1.3
//! lrm 6.2
//! bias V(p) = 0.5
//! param gain = 3.5
//! print none
//! xfail VerA has no module_parameter_port_list: the header parser expects `;` after the port list, so `#` is E0207 "unexpected token: found #" (src/frontend/parser.zig)
`include "check.vh"
module annex_a_parameter_header #(parameter real gain = 2.0, parameter integer mode = 3) (p, n);
    inout p, n;
    electrical p, n;

    analog begin
        `CHECKX("a header parameter takes its override", gain, 3.5);
        `CHECKI("a header parameter left alone keeps its declared default", mode, 3);
        I(p, n) <+ gain * V(p, n);
    end
endmodule
