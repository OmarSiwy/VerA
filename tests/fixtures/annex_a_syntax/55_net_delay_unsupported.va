// A.2.2.3 Delays:
//
//     delay3 ::=
//             # delay_value
//             | # ( mintypmax_expression [ , mintypmax_expression [ , mintypmax_expression ] ] )
//     delay2 ::=
//             # delay_value
//             | # ( mintypmax_expression [ , mintypmax_expression ] )
//     delay_value ::= unsigned_number | real_number | identifier
//
// `delay3` is the bracket A.2.1.3 puts on both `net_declaration` and the
// `trireg` arms; `delay2` is the gate instantiations' (A.3.1); `delay_value` is
// any of the three spellings, and this file takes the first, `#5`.
//
// NOT 34_delay_control_in_analog_rejected.va, which looks adjacent and is not:
// that file's `#5` is A.6.5's `delay_control`, a prefix on a STATEMENT inside an
// `analog` block, and it is correctly refused because A.6.4's `analog_statement`
// has no timing-control arm. This one is a delay on a DECLARATION, which the
// annex grants in as many words, and the two are different tokens in different
// productions that happen to share a spelling. The distinction matters for the
// same reason it does in 44_system_task_null_arguments.va: a compiler can have
// one and not the other, and the suite has to be able to say which.
//
// §1.1 makes the complete IEEE Std 1364 Verilog part of Verilog-AMS HDL;
// §8's scheduling model is where a net delay means something, and
// ch08_scheduling owns that side. So this file is an xfail and not a
// `//! reject` — the clause requires the declaration to be accepted.
//
//! lrm A.2.2.3
//! lrm A.2.1.3
//! lrm 1.1
//! xfail VerA's net declaration has no delay bracket — `wire #5 w;` reports E0208 "expected an identifier: found `#`"
//! bias V(p) = 0.75, V(n) = 0.25
`include "check.vh"
module annex_a_net_delay(p, n);
    inout p, n;
    electrical p, n;

    wire #5 w;

    analog begin
        `CHECKX("the file carrying the net delay compiles and runs",
                V(p, n), 0.5);
        I(p, n) <+ V(p, n);
    end
endmodule
