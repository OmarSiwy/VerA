// A.2.2.3 Delays:
//
//     delay3 ::=
//             # delay_value
//             | # ( mintypmax_expression [ , mintypmax_expression [ , mintypmax_expression ] ] )
//     delay2 ::=
//             # delay_value
//             | # ( mintypmax_expression [ , mintypmax_expression ] )
//     delay_value ::= unsigned_number | real_number | identifier
//
// `delay3` is the bracket A.2.1.3 puts on both `net_declaration` and the
// `trireg` arms; `delay2` is the gate instantiations' (A.3.1); `delay_value` is
// any of the three spellings, and this file takes the first, `#5`.
//
// NOT 34_delay_control_in_analog_rejected.va, which looks adjacent and is not:
// that file's `#5` is A.6.5's `delay_control`, a prefix on a STATEMENT inside an
// `analog` block, and it is correctly refused because A.6.4's `analog_statement`
// has no timing-control arm. This one is a delay on a DECLARATION, which the
// annex grants in as many words, and the two are different tokens in different
// productions that happen to share a spelling. The distinction matters for the
// same reason it does in 44_system_task_null_arguments.va: a compiler can have
// one and not the other, and the suite has to be able to say which.
//
// §1.1 makes the complete IEEE Std 1364 Verilog part of Verilog-AMS HDL;
// §8's scheduling model is where a net delay means something, and
// ch08_scheduling owns that side. So this file was an xfail and not a
// `//! reject` — the clause requires the declaration to be accepted.
//
// A CORRECTION TO THIS HEADER'S OWN DIAGNOSTIC, which is why the marker's text
// is not what the marker's deletion repaired. `delay3` was already parsed at
// this position for every net declaration; what refused the line was a rule one
// token later — E0207 "a net delay has no meaning outside a digital design
// element" — and not the E0208 the marker quoted. That rule was a verdict on
// the SEMANTICS written as a refusal of the SYNTAX, and it is the one that is
// gone: A.2.1.3 grants the bracket to all twelve of its alternatives and §1.1
// makes them VerA's to accept, so a delay with no discrete kernel to honour is
// a delay VerA carries on `Ast.NetDecl.delay` and drops, which is what every
// analog-only tool does with one.
//
// WHAT IS THEREFORE NOT CLAIMED. Nothing here observes the 5. A fixture that
// did would be a §8 scheduling fixture and would live in ch08_scheduling; this
// one states only that A.2.2.3's first `delay_value` spelling is derivable in
// this position and is read.
//
//! lrm A.2.2.3
//! lrm A.2.1.3
//! lrm 1.1
//! bias V(p) = 0.75, V(n) = 0.25
`include "check.vh"
module annex_a_net_delay(p, n);
    inout p, n;
    electrical p, n;

    wire #5 w;

    analog begin
        `CHECKX("the file carrying the net delay compiles and runs",
                V(p, n), 0.5);
        I(p, n) <+ V(p, n);
    end
endmodule
