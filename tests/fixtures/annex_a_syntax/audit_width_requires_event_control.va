// AMS A.7.5.1 / A.7.5.2 / A.7.5.3, printed pp. 375–376:
// $width requires controlled_reference_event; controlled_timing_check_event
// requires timing_check_event_control. A bare port is not that production.
// This isolates a missing grammar check; it does not test timing behavior.
//! lrm A.7.5.1
//! lrm A.7.5.3
//! lrm A.7.5.1:1000
//! lrm A.7.5.3:1000
//! reject-only timing check requires an event control
//! reject endspecify
//! neighbour b8_timing_checks_design_runs.va
module audit_width_requires_event_control(input clk);
    specify
        $width(clk, 2.0);
    endspecify
endmodule
