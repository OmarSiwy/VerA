// AMS A.7.5.1 / A.7.5.2 / A.7.5.3, printed pp. 375–376:
// $width requires controlled_reference_event; controlled_timing_check_event
// requires timing_check_event_control. A bare port is not that production.
// This isolates a missing grammar check; it does not test timing behavior.
//! lrm A.7.5.1
//! lrm A.7.5.3
//! reject timing check requires an event control
//! xfail Parser accepts a bare $width reference; the rejection phrase is the intended rule-specific diagnostic, not an observed diagnostic
module audit_width_requires_event_control(input clk);
    specify
        $width(clk, 2.0);
    endspecify
endmodule
