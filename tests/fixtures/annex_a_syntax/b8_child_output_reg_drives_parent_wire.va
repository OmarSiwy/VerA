// A child module's `output reg` port, connected to a wire of its parent.
//
//     output_declaration ::= ... | output [ discipline_identifier ] reg
//             [ signed ] [ range ] list_of_variable_port_identifiers   // A.2.1.2
//
// §6.8: "The following elements define a new scope: Modules, ..." and "An
// identifier shall be used to declare only one item within a scope." The
// parent declares one item, the wire `pq`; the child declares one, its port
// variable `q`. Nothing is declared twice in either scope. IEEE 1364-2005
// §12.3.3 (inherited through §1.1) makes the same true of the non-ANSI form
// `output q; reg q;`: "If a port declaration does not include a net or
// variable type, then the port can be again declared in a net or variable
// declaration."
//
// DERIVATION (`timescale 1ns/1ns). The child sets q = 1 at 1 ns; its port
// drives the parent's wire pq, which the parent checks at 2 ns from a digital
// initial block: 1. One verdict.
//
// The ordinary-discipline case passes: ch07_mixed_signal/m04_15's
// `output o; ddiscrete o; reg o;` connected to an electrical net compiles.
// Here the parent's net is a plain `wire`.
//
//! lrm A.2.1.2
//! lrm 6.8
//! lrm A.2.1.2:1000
//! xfail E0362 "identifier is declared twice in one scope: `pq`" when a child's output reg port (either `output reg q;` or `output q; reg q;`, both probed) is connected to a discipline-less parent wire
//! analysis tran
//! time 0, 10n
//! checks 1
`timescale 1ns/1ns
`include "check.vh"
module b8_child_output_reg_drives_parent_wire(p);
  inout p; electrical p;
  wire pq;
  b8_corw_child u(pq);
  initial #2 `CHECKI("the child's output reg drives the parent's wire", pq, 1);
  analog I(p) <+ V(p);
endmodule

module b8_corw_child(q);
  output reg q;
  initial #1 q = 1'b1;
endmodule
