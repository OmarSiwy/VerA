// A.2.6 `analog_function_type ::= integer | real | string`. The `real` arm is
// everywhere in the suite; the other two had no user at all.
//
// §4.7.1: the type "specifies the return value of the function". So:
//
//   integer  `isq` assigns x*x, and at V(p,n) = 1.5 that is 2.25 — a value
//            with a fractional part, so the declared return type is OBSERVABLE:
//            §4.2.1.1 "Real numbers are converted to integers by rounding the real
//            number to the nearest integer, rather than by truncating it", and
//            2.25 is not a tie, so the call site must see exactly 2. This used
//            to assign the integer literal 3, which a real-returning
//            implementation reproduces as 3.0 and `CHECKI` accepts — the
//            header admitted as much, which left A.2.6's `integer` arm with no
//            user in the suite after all. 37_analog_function_default_type.va
//            is the same expression with the type omitted and wants 2.25; the
//            pair is what makes the keyword the only difference under test.
//   string   `label` assigns "hi", and §4.2.7's equality on strings makes
//            `label(1.0) == "hi"` the integer 1 (§4.2.5: a comparison is an
//            integer in Verilog-A). A function that returned an empty string,
//            or a numeric 0, gives 0.
//
// Both are in one file because both are positives: a run fixture reports every
// assertion, unlike a `//! reject`, which stops at the first diagnostic.
//
//! lrm A.2.6
//! lrm 4.7.1
//! lrm 4.2.7
//! lrm 4.2.1.1
//! lrm 4.7.1:2
//! lrm 4.7.2.1
//! lrm 4.7.2.1:1
//! lrm A.2.6:1000
//! bias V(p) = 1.5
//! print none
`include "check.vh"
module annex_a_function_integer_string(p, n);
    inout p, n;
    electrical p, n;

    analog function integer isq;
        input x;
        real x;
        isq = x * x;
    endfunction

    analog function string label;
        input x;
        real x;
        label = "hi";
    endfunction

    analog begin
        `CHECKI("an integer-typed analog function rounds its real result to an integer", isq(V(p, n)), 2);
        `CHECKI("a string-typed analog function returns its assigned string", (label(1.0) == "hi"), 1);
        I(p, n) <+ isq(V(p, n)) * V(p, n);
    end
endmodule
