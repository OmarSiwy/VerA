// A.6.9 `analog_system_task_enable ::= analog_system_task_identifier
// [ ( [ analog_expression ] { , [ analog_expression ] } ) ] ;`
//
// Two optionalities, neither exercised anywhere in the suite before this:
//
//   the whole argument list is optional      `$strobe;`
//   an INDIVIDUAL argument may be empty      `$strobe("a",,"b");`
//
// Both are shapes a parser can get wrong by consuming the following statement,
// so this is written like 22_null_attributed_statements.va: the proof is that
// the file compiles AND the statement after the odd form still runs. Biased at
// V(p) = -0.5, the probe read after both tasks must still be -0.5. -0.5 is
// exact in binary, so the assertion is `CHECKX`.
//
// The assertion is a probe rather than the tasks' output because a device does
// not print: VerA drops a display task in device mode (W0850), which is
// §9.4-conforming and orthogonal to the A.6.9 syntax under test here.
//
//! lrm A.6.9
//! lrm 9.4
//! bias V(p) = -0.5
//! print none
`include "check.vh"
module annex_a_system_task_null_args(p); inout p; electrical p;
analog begin
    $strobe;
    $strobe("a",,"b");
    `CHECKX("the statement after an empty system-task argument list still runs", V(p), -0.5);
    I(p) <+ V(p);
end
endmodule
