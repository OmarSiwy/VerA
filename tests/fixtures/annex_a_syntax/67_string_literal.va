// A.8.8 is one line, and §2.7 is the paragraph that gives it a meaning:
//
//     string ::= " { Any_ASCII_character } "                        // A.8.8
//
//     "A string literal used as an operand in expressions and assignments
//      shall be treated as unsigned integer constants represented by a sequence
//      of 8-bit ASCII values, with one 8-bit ASCII value representing one
//      character."                                                §2.7
//
//     Table 2-2—Specifying special characters in string
//         Escape string   Character produced by escape string
//         \n              New line character
//         \t              Tab character
//         \\              \ character
//         \"              " character
//         \ddd            A character specified in 1–3 octal digits (0 ≤ d ≤ 7)
//                    "If less than three characters are used, the following
//                     character shall not be an octal digit."
//
// EVERY ROW OF THAT TABLE IS A NUMBER HERE. §2.7's "unsigned integer constants"
// is the whole content of the production once it leaves the lexer, so a string
// in expression position is not a parse question and must not be checked as
// one: each literal below is assigned to an `integer` and compared against the
// ASCII value the table gives it, which is what makes this file different from
// the other string users in the suite. `38_analog_function_integer_string.va`
// pins the STRING type as an analog function return, `03_declarations.va` pins
// `string label = …` as a declaration, and both compare strings with strings.
// Neither says what a literal IS, which is what A.8.8 plus §2.7 is about.
//
// THE PACK ORDER IS ASSERTED, NOT ASSUMED. `"AB"` is 0x4142 = 16706, i.e. the
// FIRST character is the most significant — the same big-endian packing §4.2.1
// gives a sized constant, and the one number here that a byte-reversing lexer
// would get wrong while every single-character check still passed.
//
// `"\101"` AND `"\1"` ARE BOTH SPELLED because the table's last row has two
// halves: three octal digits, and the fewer-than-three case whose "following
// character shall not be an octal digit". `"\101"` is 65 = 'A', so the last two
// assertions are the round trip — the escape and the bare character must reach
// the same integer, and one is spelled in octal. `"\1"` is 1, the one-digit
// end of the same row.
//
// WHAT IS NOT HERE: an escaped literal that continues past a line break, which
// §2.7 forbids by "contained on a single line"; a string containing an embedded
// space, which is A.10's sentence and 36_real_embedded_space_rejected.va's
// subject; and `\ddd` above \377, where §2.7 leaves the implementation a
// choice ("may issue an error") so there is no single verdict to pin.
//
//! lrm A.8.8
//! lrm 2.7
//! lrm 2.7:1
//! lrm 2.7:2
//! lrm A.8.8:1000
//! bias V(p) = 0.75, V(n) = 0.25
`include "check.vh"
module annex_a_string_literal(p, n);
    inout p, n;
    electrical p, n;

    integer one_char, two_chars, empty;
    integer newline, tab, backslash, quote;
    integer octal, short_octal;

    analog begin
        one_char   = "A";
        two_chars  = "AB";
        empty      = "";
        newline    = "\n";
        tab        = "\t";
        backslash  = "\\";
        quote      = "\"";
        octal      = "\101";
        short_octal = "\1";

        `CHECKI("'A' is the ASCII value 0x41", one_char, 65);
        `CHECKI("two characters pack first-most-significant: 0x4142", two_chars, 16706);
        `CHECKI("the empty literal is the integer 0", empty, 0);
        `CHECKI("Table 2-2: \\n is the newline, 10", newline, 10);
        `CHECKI("Table 2-2: \\t is the tab, 9", tab, 9);
        `CHECKI("Table 2-2: \\\\ is the backslash itself, 92", backslash, 92);
        `CHECKI("Table 2-2: \\\" is the quote itself, 34", quote, 34);
        `CHECKI("Table 2-2: \\101 is octal 101, i.e. 65, i.e. 'A'", octal, 65);
        `CHECKI("Table 2-2: \\1 is a one-digit octal escape, 1", short_octal, 1);
        `CHECKI("the same character reached two ways", ("A" == "\101"), 1);

        I(p, n) <+ V(p, n);
    end
endmodule
