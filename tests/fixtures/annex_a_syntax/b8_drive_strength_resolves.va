// A.2.2.2's drive_strength, observed through how two drivers on one net
// resolve. 54_drive_strength_unsupported.va declares
// `wire (strong1, pull0) w = 1'b1;` but its only check reads the bias, and a
// lone driver resolves to its own value at any strength, so nothing there could
// see the bracket.
//
//     drive_strength ::= ( strength0 , strength1 ) | ( strength1 , strength0 )
//             | ( strength0 , highz1 ) | ( strength1 , highz0 )
//             | ( highz0 , strength1 ) | ( highz1 , strength0 )        // A.2.2.2
//     strength0 ::= supply0 | strong0 | pull0 | weak0
//     strength1 ::= supply1 | strong1 | pull1 | weak1
//     continuous_assign ::= assign [ drive_strength ] [ delay3 ]
//             list_of_net_assignments ;                                // A.6.1
//     net_declaration ::= ... | net_type [ discipline_identifier ]
//             [ drive_strength ] [ signed ] [ delay3 ] list_of_net_decl_assignments ;
//                                                                      // A.2.1.3
//
// Every drive_strength below sits on A.6.1's continuous_assign. The other
// home, a net_declaration with an assignment (`wire (strong1, pull0) w = a;`),
// is b8_net_decl_assignment_refused.va's (an xfail).
//
// IEEE 1364-2005 (inherited through §1.1). §6.1.4: "The driving strength of a
// continuous assignment can be specified by the user"; one strength "applies
// when the value being assigned to the net is 1 and a second strength value
// that applies when the assigned value is 0 ... If drive strength is not
// specified, it shall default to (strong1, strong0)." §7.10.1: "If two or more signals of unequal strength
// combine in a wired net configuration, the stronger signal shall dominate all
// the weaker drivers and determine the result." Figure 7-2's scale: supply 7,
// strong 6, pull 5, weak 3, highz 0. §7.1.2 (stated for gates; a highz
// strength is the same on an assignment): "Specifying highz0 shall cause the
// gate to output a logic value z in place of a 0."
//
// DERIVATION. a = 1 from 1 ns, 0 from 11 ns. The initial block checks the nets
// itself at 5 ns and 15 ns (a check is a $strobe, so it reads the values at the
// end of its time step); checking in the digital half keeps the count exact,
// where an analog-block check would also print at every point the mixed run
// inserts at a digital event.
//
//   w1: assign (strong1, pull0) = a, plus assign (pull0, strong1) = ~a.
//       a=1: St1 vs Pu0 -> 1.   a=0: Pu0 vs St1 -> 1.
//       (Both at the default strong: St1 vs St0 and St0 vs St1, both x.)
//   w3: assign (weak0, strong1) = a, the ( strength0 , strength1 ) order,
//       plus assign (pull0, pull1) = ~a.
//       a=1: St1 vs Pu0 -> 1.   a=0: We0 vs Pu1 -> 1.
//       (With the first at the default, a=0 is St0 vs Pu1 -> 0.)
//   wz: assign (strong1, highz0) = a, plus assign (weak0, weak1) = 1'b1.
//       a=1: St1 vs We1, like values -> 1.   a=0: HiZ0 (z) vs We1 -> 1.
//       (With strong0 in place of highz0, a=0 is St0 vs We1 -> 0.)
//
// Every net reads 1 at both points; a bracket dropped gives 0 or x (ok=x).
// Six verdicts.
//
//! lrm A.2.2.2
//! lrm A.6.1
//! lrm A.2.2.2:1000
//! lrm A.6.1:1000
//! analysis tran
//! time 0, 30n
//! checks 6
`timescale 1ns/1ns
`include "check.vh"
module b8_drive_strength_resolves(p);
  inout p; electrical p;
  reg a;
  wire w1, w3, wz;
  assign (strong1, pull0) w1 = a;
  assign (pull0, strong1) w1 = ~a;
  assign (weak0, strong1) w3 = a;
  assign (pull0, pull1) w3 = ~a;
  assign (strong1, highz0) wz = a;
  assign (weak0, weak1) wz = 1'b1;

  initial begin
    #1 a = 1'b1;
    #4 `CHECKI("a=1, w1: strong1 beats the second assign's pull0", w1, 1);
    `CHECKI("a=1, w3: the first assign's strong1 beats pull0", w3, 1);
    `CHECKI("a=1, wz: strong1 and weak1 agree", wz, 1);
    #6 a = 1'b0;
    #4 `CHECKI("a=0, w1: the second assign's strong1 beats the first's pull0", w1, 1);
    `CHECKI("a=0, w3: pull1 beats the first assign's weak0", w3, 1);
    `CHECKI("a=0, wz: weak1 beats the first assign's highz0", wz, 1);
  end

  analog I(p) <+ V(p);
endmodule
