// Annex A.4.2 / §6.6.2 case generate.
//
//   case_generate_construct ::= case ( constant_expression ) case_generate_item
//                               { case_generate_item } endcase
//   case_generate_item      ::= constant_expression { , constant_expression } :
//                               generate_block_or_null
//                             | default [ : ] generate_block_or_null
//
// Elaboration matches the constant expression against the item labels and
// instantiates exactly one block; a multi-label item (`1, 2:`) matches either
// of its labels, and `default` is taken only when nothing else matched.
//
// `mode` is 1, so the `1, 2:` arm is the one elaborated. As in 14_if_generate,
// §6.2 concatenates a module's analog blocks in source order, so the single
// value of `sel` says which arm ran:
//
//     2.0   the `1, 2:` arm and only it                        (correct)
//     0.0   no arm was elaborated
//    -1.0   the `0:` arm ran (matched the wrong label)
//    -2.0   `default` ran (a matching label was missed)
//
//! lrm A.4.2
//! lrm 6.6.2
//! lrm 6.2
//! lrm 6.2:8
//! lrm 6.6.2:1
//! lrm 6.9.1
//! lrm 6.9.1:3
//! lrm A.4.2:1000
//! bias V(p) = 0.5
//! print none
`include "check.vh"
module annex_a_case_generate(p, n);
    inout p, n;
    electrical p, n;
    parameter integer mode = 1;
    real sel;

    analog sel = 0.0;

    generate
        case (mode)
            0: analog begin
                   sel = -1.0;
                   I(p, n) <+ 0.0;
               end
            1, 2: analog begin
                      sel = 2.0;
                      I(p, n) <+ 2.0 * V(p, n);
                  end
            default: analog begin
                         sel = -2.0;
                         I(p, n) <+ 0.0;
                     end
        endcase
    endgenerate

    analog `CHECKX("the matching case-generate item is the one elaborated", sel, 2.0);
endmodule
