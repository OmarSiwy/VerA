// A net_declaration that carries an assignment, with the drive_strength and
// the delay3 brackets A.2.1.3 grants it:
//
//     net_declaration ::= ... | net_type [ discipline_identifier ]
//             [ drive_strength ] [ signed ] [ delay3 ]
//             list_of_net_decl_assignments ;                           // A.2.1.3
//     drive_strength ::= ( strength1 , strength0 ) | ...               // A.2.2.2
//     delay3 ::= # delay_value | # ( mintypmax_expression
//             [ , mintypmax_expression [ , mintypmax_expression ] ] )  // A.2.2.3
//     net_decl_assignment ::= net_identifier = expression              // A.2.4
//
// IEEE 1364-2005 (inherited through §1.1). §4.4.2: "The drive strength
// specification allows a continuous assignment to be placed on a net in the
// same statement that declares that net." §6.1.3: "Specifying the delay in a
// continuous assignment that is part of the net declaration shall be treated
// differently from specifying a net delay and then making a continuous
// assignment to the net ... When there is a continuous assignment in a
// declaration, the delay is part of the continuous assignment and is not a net
// delay." So `wire (strong1, pull0) ws = a;` and `wire #(2, 6) wd = a;` are
// continuous assignments of a, the first with drive strength (strong1, pull0),
// the second with rise delay 2 and fall delay 6.
//
// Neither is a §3.6.3.2 nodeset. That clause is about "net discipline
// declarations" of continuous disciplines (`electrical a = 5.0;`), whose
// initializer "shall be a constant_expression"; ws and wd are `wire`s with no
// discipline, read only by digital processes.
//
// DERIVATION (`timescale 1ns/1ns). a = 0 from 1 ns, 1 from 11 ns, 0 from 31 ns.
// ws follows a at once; the assign (pull0, pull1) ws = ~a competes:
//   a=1: St1 vs Pu0 -> 1.   a=0: Pu0 vs Pu1 -> x, so ws is checked only at a=1.
// wd: 0 by 7 (x -> 0 takes the fall delay), rises at 13, falls at 37.
// A digital initial block checks at the end of these ticks:
//   12  wd 0 (a rose at 11)     13  wd 1, ws 1
//   36  wd 1 (a fell at 31)     37  wd 0
// Five verdicts.
//
// Until 2026-10-08 VerA refused both declarations here with E0365 ("net
// initializer is not a constant expression"), reading each `= a` as a
// §3.6.3.2 nodeset, when only digital processes read the net (the file was
// b8_net_decl_assignment_refused.va, an xfail). It compiled the same strength
// form when the analog block read the net.
//
//! lrm A.2.1.3
//! lrm A.2.2.2
//! lrm A.2.2.3
//! lrm A.2.4
//! lrm A.2.1.3:1000
//! lrm A.2.2.3:1000
//! inherited IEEE 1364-2005 4.4.2
//! inherited IEEE 1364-2005 6.1.3
//! analysis tran
//! time 0, 40n
//! checks 5
`timescale 1ns/1ns
`include "check.vh"
module b8_net_decl_assignment_drives_net(p);
  inout p; electrical p;
  reg a;
  wire (strong1, pull0) ws = a;
  assign (pull0, pull1) ws = ~a;
  wire #(2, 6) wd = a;

  initial begin
    #1 a = 1'b0;
    #10 a = 1'b1;
    #20 a = 1'b0;
  end

  initial begin
    #12 `CHECKI("t=12 a rose at 11; wd waits out its rise delay 2", wd, 0);
    #1  `CHECKI("t=13 wd rose", wd, 1);
    `CHECKI("t=13 ws: the declaration's strong1 beats the assign's pull0", ws, 1);
    #23 `CHECKI("t=36 a fell at 31; wd waits out its fall delay 6", wd, 1);
    #1  `CHECKI("t=37 wd fell", wd, 0);
  end

  analog I(p) <+ V(p);
endmodule
