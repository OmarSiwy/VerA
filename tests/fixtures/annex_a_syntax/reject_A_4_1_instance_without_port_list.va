// A.4.1:
//
//     module_instantiation ::=
//             module_or_paramset_identifier [ parameter_value_assignment ]
//                 module_instance { , module_instance } ;
//     module_instance ::= name_of_module_instance ( [ list_of_port_connections ] )
//
// The parentheses are part of module_instance even when there is nothing to
// connect: a portless child is instantiated as `child c1();`. `child c1;` has
// no parentheses, so it is not a module_instance, and it is not a net
// declaration either (A.2.1.3's `discipline_identifier list_of_net_identifiers`
// needs a discipline, and annex_a_noport_child is a module). `annex_a_noport_child
// c1();` compiles (probed).
//
// VerA accepts this file.
//
//! lrm A.4.1
//! reject module_instance
//! xfail VerA accepts `annex_a_noport_child c1;` with no parenthesised port list; A.4.1's module_instance ::= name_of_module_instance ( [ list_of_port_connections ] ) makes the parentheses mandatory
`include "disciplines.vams"
module annex_a_noport_child();
  electrical a;
  analog V(a) <+ 1.0;
endmodule

module annex_a_instance_no_parens(p, n);
  inout p, n;
  electrical p, n;
  annex_a_noport_child c1;   // illegal: module_instance needs ( )
  analog I(p, n) <+ V(p, n);
endmodule
