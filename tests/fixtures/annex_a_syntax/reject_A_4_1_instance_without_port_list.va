// A.4.1:
//
//     module_instantiation ::=
//             module_or_paramset_identifier [ parameter_value_assignment ]
//                 module_instance { , module_instance } ;
//     module_instance ::= name_of_module_instance ( [ list_of_port_connections ] )
//
// The parentheses are part of module_instance even when there is nothing to
// connect: a portless child is instantiated as `child c1();`. `child c1;` has
// no parentheses, so it is not a module_instance, and it is not a net
// declaration either (A.2.1.3's `discipline_identifier list_of_net_identifiers`
// needs a discipline, and annex_a_noport_child is a module). `annex_a_noport_child
// c1();` compiles (probed).
//
// VerA refuses it with E0371 "net declared with an undeclared discipline",
// naming `annex_a_noport_child` as a module and the module_instance it
// needed to be. With no parentheses the statement has A.2.1.3's SHAPE, so
// the error lands on what would be its discipline identifier.
//
// `A.4` (Module instantiation and generate construct) is cited as well: it is the heading over the
// subclause this file exercises and states no production of its own, so this
// file is evidence for it on the same reject side.
//
//! lrm A.4
//! lrm A.4.1
//! lrm A.4.1:1000
//! reject-only module_instance
`include "disciplines.vams"
module annex_a_noport_child();
  electrical a;
  analog V(a) <+ 1.0;
endmodule

module annex_a_instance_no_parens(p, n);
  inout p, n;
  electrical p, n;
  annex_a_noport_child c1;   // illegal: module_instance needs ( )
  analog I(p, n) <+ V(p, n);
endmodule
