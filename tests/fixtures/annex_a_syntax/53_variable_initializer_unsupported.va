// A.2.2.1's `variable_type`, second arm:
//
//     variable_type ::=
//             variable_identifier { dimension } [ = constant_assignment_pattern ]
//             | variable_identifier = constant_expression
//
// `list_of_variable_identifiers ::= variable_type { , variable_type }` (A.2.3),
// and `list_of_variable_identifiers` is what `reg_declaration` and
// `integer_declaration` take (A.2.1.3), so `= constant_expression` is available
// on every element of those declarations — the second element as much as the
// first, which is why the comma list below carries one initializer and one bare
// name.
//
// 52_net_and_variable_types.va spells the same production and passes, because it
// initializes only a scalar: VerA accepts `integer iv = 7;`, `time tv = 3;`,
// `realtime rtv = 2.5;` and `real dv = 1.5;` and refuses `reg [7:0] rbus =
// 8'h5a;` with E0207 "unexpected token: found `=`". So the gap is not the
// initializer as such and not the width as such — it is the combination, which
// is why this file keeps the range and drops everything else.
//
// THE WANT IS THE INITIALIZED VALUE, 0x5a = 90, read back through an ordinary
// expression: a compiler that accepted the syntax and dropped the initializer
// would read 0 (or whatever the testbench leaves in the slot) and fail here as
// well as at the parser. That is the whole claim, and it is the reason this is
// an xfail rather than a `//! reject` — legal full-AMS source, refused by VerA
// (§1.1 again: the complete IEEE Std 1364 Verilog is part of the language).
//
//! lrm A.2.2.1
//! lrm A.2.1.3
//! lrm A.2.3
//! xfail VerA refuses an initializer on a vector variable — `reg [7:0] rbus = 8'h5a;` reports E0207 "unexpected token: found `=`", while the same initializer on a scalar integer/real/time/realtime is accepted
//! bias V(p) = 0.75, V(n) = 0.25
`include "check.vh"
module annex_a_variable_initializer(p, n);
    inout p, n;
    electrical p, n;

    reg [7:0] rbus = 8'h5a, spare;

    analog begin
        `CHECKX("the file carrying the initialized vector variable compiles and runs",
                V(p, n), 0.5);
        `CHECKI("the vector variable holds the initializer it was declared with",
                rbus, 90);
        I(p, n) <+ V(p, n);
    end
endmodule
