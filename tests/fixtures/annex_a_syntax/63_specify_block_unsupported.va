// A.7.1's block, with one item from A.7.2/A.7.3/A.7.4 each inside it:
//
//     specify_block ::= specify { specify_item } endspecify      // A.7.1
//     specify_item ::=
//             specparam_declaration
//             | pulsestyle_declaration
//             | showcancelled_declaration
//             | path_declaration
//             | system_timing_check
//     path_declaration ::= simple_path_declaration ; | …          // A.7.2
//     simple_path_declaration ::= parallel_path_description = path_delay_value
//             | full_path_description = path_delay_value
//     parallel_path_description ::=
//             ( specify_input_terminal_descriptor [ polarity_operator ]
//               => specify_output_terminal_descriptor )             // A.7.3
//     path_delay_value ::= list_of_path_delay_expressions | ( list_of_path_delay_expressions )
//     list_of_path_delay_expressions ::= t_path_delay_expression
//             | trise_path_delay_expression , tfall_path_delay_expression | …   // A.7.4
//
// WHAT IS SPELLED, and what each clause gets from it. Four of A.7.1's five
// `specify_item` arms are here — `specparam` (three of them, since a path delay
// expression that names a specparam is what the whole section is for),
// `pulsestyle_onevent`, `path_declaration` twice, and (in
// 64_timing_checks_unsupported.va) `system_timing_check`. `showcancelled` is the
// fifth and is omitted: it takes the same `list_of_path_outputs` as
// `pulsestyle_onevent` and would be a second spelling of one production.
// A.7.3 gets `p`, `n` and `y` as terminal descriptors; A.7.4 gets both of its
// `path_delay_value` arms — a parenthesised rise/fall list of two specparams
// naming the `trise`/`tfall` pair, and a bare `1` for the full path.
//
// THE WHOLE FAMILY USED TO BE ONE REFUSAL IN VERA, which is why one file covers
// four clauses: the parser declined `specify` at the module-item dispatch and
// never looked inside, so every inner production reported the same E0205
// "unsupported module item: found specify" whether it were spelled right,
// wrong, or not at all. The claim this file makes is therefore about the BLOCK:
// this text is derivable from A.7.1–A.7.4 and a full-AMS compiler must accept
// it.
//
// WHAT CHANGED, AND WHAT DID NOT. The block is now READ — every `specify_item`
// arm against its own production, which is why the four clauses above are
// separable claims again rather than four names on one refusal. `=>`, `*>` and
// `&&&` reach the parser as single `.invalid` tokens the lexer already spells
// out as specify-only, so the three operators A.7 has and the rest of the
// language does not mean nothing anywhere else. Nothing is RECORDED: the block
// leaves a W0251 ("specify block read, and part or all of it is not modelled") and no
// AST. Its entire content is §8 scheduling — a compiled analog device has no
// event queue for a path delay to schedule on — so there is nothing to stamp,
// and inventing one would pin a convention of VerA's as if the standard had
// asked for it. W0250 is the same call on A.4.1's pass switches and its
// `--explain` states the reasoning in full.
//
// SO THIS FILE'S VERDICT IS ABOUT THE GRAMMAR AND NOT THE TIMING, and nothing
// below observes a delay. A fixture that did would be a §8 fixture and would
// live in ch08_scheduling. What this one is now able to catch that it could not
// before is a typo: `(p = y) = 1;` and `$setup(d, posedge clk);` are errors
// inside a block that used to accept any text at all between its keywords.
//
// §1.1 makes the complete IEEE Std 1364 Verilog part of Verilog-AMS HDL. A
// specify block is the digital half of what a mixed-signal netlist needs to be
// simulatable at all — it is where a cell's timing lives — so the gap was a real
// one for the full-AMS target and not an analog-subset question. Annex C.16 does
// not exempt it either: `specify` is not among the nine keywords C.16 lists.
//
// `A.7` (Specify section) is cited as well: it is the heading over the
// subclauses this file exercises and states no production of its own. What
// this file proves for it is the GRAMMAR — the specify block parses and the file runs its
// analog assertion — not a behaviour: the specify block reaches no device (W0251). No fixture runs its
// timing behaviour; this is grammar coverage only.
//
// Corrected 2026-10-08 (construct only, the want is unchanged): the file wrote
// `pulsestyle_onevent (y);`, which A.7.1 does not derive: the declaration takes
// list_of_path_outputs, and IEEE 1364-2005 14.6.4.2's examples write
// `pulsestyle_ondetect out, out_b;` with no parentheses (E0207;
// reject_A_7_1_pulsestyle_parenthesized.va keeps the old line).
//
//! lrm A.7
//! lrm A.7.1
//! lrm A.7.2
//! lrm A.7.3
//! lrm A.7.4
//! lrm 1.1
//! bias V(p) = 0.75, V(n) = 0.25
`include "check.vh"
module annex_a_specify(p, n, y);
    inout p, n;
    electrical p, n;
    output y;

    specify
        specparam tplh = 1.5, tphl = 2.5;
        (p => y) = (tplh, tphl);
        (n *> y) = 1;
        pulsestyle_onevent y;
    endspecify

    analog begin
        `CHECKX("the file carrying the A.7.1 specify block compiles and runs",
                V(p, n), 0.5);
        I(p, n) <+ V(p, n);
    end
endmodule
