// A.2.1.3:
//
//     branch_declaration ::=
//             branch ( branch_terminal [ , branch_terminal ] ) list_of_branch_identifiers ;
//             | port_branch_declaration
//
// A branch has one or two terminals. `branch (p, n, c) br;` names three, which
// is not derivable. `branch (p, n) br;` compiles (probed).
//
// VerA reports E0207 "unexpected token: found `,`" at the second comma.
//
//! lrm A.2.1.3
//! lrm A.2.1.3:1000
//! reject-only E0207
`include "disciplines.vams"
module annex_a_branch_three_terminals(p, n);
  inout p, n;
  electrical p, n;
  electrical c;
  branch (p, n, c) br;       // illegal: a branch has at most two terminals
  analog I(br) <+ V(br);
endmodule
