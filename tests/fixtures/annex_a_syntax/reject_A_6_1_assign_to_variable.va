// A.6.1 spells the continuous assignment:
//
//     continuous_assign ::= assign [ drive_strength ] [ delay3 ]
//                           list_of_net_assignments ;
//     net_assignment    ::= net_lvalue = expression
//
// The target is a net_lvalue. `r` is a reg, so `assign r = d;` has no
// net_assignment and A.6.1 derives nothing for it. IEEE 1364-2005 §6.1
// (part of Verilog-AMS by §1.1) gives the reason: a continuous assignment
// is a driver, and only a net has drivers to resolve; a variable holds the
// last value a procedural statement stored (§8.5.3.1).
//
// The legal counterpart is b8_net_delay_observed.va, whose continuous
// assignments all drive wires. ch08_scheduling/
// continuous_assignment_to_a_variable_rejected.va pins the same refusal
// with the §8.5.3.1 derivation.
//! lrm 8.5.3.1
//! lrm A.6.1
//! lrm A.6.1:1000
//! reject-only E0438
//! neighbour b8_net_delay_observed.va
`timescale 1ns/1ns
`include "disciplines.vams"
module annex_a_assign_reg(p);
  inout p;
  electrical p;
  reg r;
  reg d;

  initial begin
    d = 1'b0;
    #5 d = 1'b1;
  end

  assign r = d;              // illegal: r is a variable, not a net

  analog I(p) <+ V(p) / 1k;
endmodule
