// A.7.5.2:
//
//     notifier ::= variable_identifier
//
// and A.7.5.1 gives $setup its optional fourth argument as that notifier:
// `$setup ( data_event , reference_event , timing_check_limit [ , [ notifier ] ] )`.
// A notifier is a reg the timing check toggles on a violation, so it must name
// a variable; the constant `5` does not. `$setup(a, posedge clk, 1, ntfr)` with
// `reg ntfr;` is accepted (probed).
//
// VerA refuses the argument with E0207 "the notifier argument of `$setup`
// names a variable".
//
// `A.7.5` (System timing checks) is cited as well: it is the heading over the
// subclause this file exercises and states no production of its own, so this
// file is evidence for it on the same reject side.
//
//! lrm A.7.5
//! lrm A.7.5.2
//! lrm A.7.5.2:1000
//! reject-only notifier
//! reject endspecify
//! neighbour b8_timing_checks_design_runs.va
module annex_a_numeric_notifier(o, a, clk);
  output o;
  input a, clk;
  wire o, a, clk;
  buf g1(o, a);
  specify
    $setup(a, posedge clk, 1, 5);   // illegal: the notifier is not a variable
  endspecify
endmodule
