// A.5.3 splits the two UDP bodies at the top and never lets them mix:
//
//     udp_body ::= combinational_body | sequential_body
//     combinational_body ::= table combinational_entry { combinational_entry }
//             endtable
//     combinational_entry ::= level_input_list : output_symbol ;
//     level_input_list ::= level_symbol { level_symbol }
//     level_symbol ::= 0 | 1 | x | X | ? | b | B
//
// An edge indicator is reachable only through a sequential_entry's
// edge_input_list, so `(01)` in a combinational table derives from no
// production of combinational_body. The table's first entry decides the
// alternative, and every later entry must agree.
//
// The legal counterpart is b8_udp_declared_and_instantiated.va: its
// b8_udp_mux is a level-only combinational table and its b8_udp_dff is a
// sequential one with (01) edges. ieee1364/08_udp/d08_reject_udp_comb_edge.v
// pins the same refusal on the 1364 side.
//
//! lrm A.5.3
//! lrm A.5.3:1000
//! reject-only combinational
//! reject edge
//! neighbour b8_udp_declared_and_instantiated.va
`timescale 1ns/1ns

primitive annex_a_udp_comb_edge (o, a, b);
  output o;
  input  a, b;
  table
  //  a     b  :  o
     (01)   0  :  1  ;      // illegal: an edge in a combinational_body
      1     1  :  0  ;
  endtable
endprimitive

module annex_a_udp_comb_edge_top;
  reg  a, b;
  wire o;

  annex_a_udp_comb_edge u1 (o, a, b);

  initial begin
    a = 1'b0;
    b = 1'b0;
  end
endmodule
