// A.4.1 names every module instance:
//
//     module_instance ::= name_of_module_instance ( [ list_of_port_connections ] )
//     name_of_module_instance ::= module_instance_identifier [ range ]
//
// The only instance Annex A lets go unnamed is a UDP's (A.5.4), and that one
// connects an output and at least one input terminal:
//
//     udp_instance ::= [ name_of_udp_instance ]
//             ( output_terminal , input_terminal { , input_terminal } )
//
// So `named_instance_child(p);`, one terminal and no name, derives from
// neither: it is a module instance with its name left out. The legal
// neighbour writes `named_instance_child c1(p);`.
//
// VerA refuses it with E0293 at the parse (it used to read it as a UDP
// instance and drop it with only a warning); the code is pinned.
//
//! lrm A.4.1
//! lrm A.4.1:1000
//! lrm A.5.4
//! reject-only E0293
//! neighbour module_instance_named.va
`include "check.vh"
module annex_a_module_instance_named(p, n);
    inout p, n;
    electrical p, n;

    named_instance_child(p);      // illegal: no instance name

    analog begin
        `CHECKX("the parent's own terminals", V(p, n), 0.5);
        I(p, n) <+ V(p, n);
    end
endmodule

module named_instance_child(a);
    inout a;
    electrical a;

    analog begin
        `CHECKX("c1's terminal a is the parent's p", V(a), 0.75);
        I(a) <+ V(a) / 1000.0;
    end
endmodule
