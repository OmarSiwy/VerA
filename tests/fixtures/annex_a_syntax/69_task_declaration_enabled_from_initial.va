// A.2.7 task_declaration ::=
//     task [ automatic ] task_identifier ;
//         { task_item_declaration } statement_or_null endtask
//   | task [ automatic ] task_identifier ( [ task_port_list ] ) ;
//         { block_item_declaration } statement_or_null endtask
// task_item_declaration ::= block_item_declaration
//   | { attribute_instance } tf_input_declaration ; | ...
// tf_input_declaration ::= ... | input task_port_type list_of_port_identifiers
// task_port_type ::= integer | real | realtime | time
//
// The positive half. 20_task_enable.va is A.2.7's only other cite and it is a
// rejection — of the ENABLE in analog position (A.6.4), not of the declaration,
// which its own header calls legal. This file declares one task in each of
// A.2.7's two forms and enables both where A.6.9's `task_enable` IS derivable:
// a digital `initial` block (A.6.2, A.6.4 `statement`).
//
// DERIVATION. `set_twice` (the first form, ports as task_item_declarations)
// runs `level = 2 * 3` = 6. `add_to` (the second, ANSI form) runs
// `level = level + 4` after it, = 10. The two enables are sequential statements
// of one `initial` block, so the order is fixed (IEEE 1364 §9.8.1). The analog
// block reads the digital integer through §7.3.1 Table 7-1: 10, an integer, so
// the check is exact.
//
//! lrm A.2.7
//! lrm A.6.9
//! bias V(p) = 0.5
//! xfail VerA refuses every task declaration (E0205 "unsupported module item: found task"); A.2.7 makes both forms legal module items and A.6.9 lets a digital initial block enable them
`include "check.vh"
module annex_a_task_declaration_enabled_from_initial(p);
  inout p;
  electrical p;
  integer level;

  task set_twice;
    input integer k;
    begin
      level = 2 * k;
    end
  endtask

  task add_to(input integer k);
    level = level + k;
  endtask

  initial begin
    set_twice(3);
    add_to(4);
  end

  analog begin
    `CHECKI("A.2.7 two declared tasks ran from a digital initial block", level, 10);
    I(p) <+ V(p);
  end
endmodule
