// A.7.1-A.7.3, the positive half, with a design around the block that RUNS
// and is observed. specify_block_unsupported.va spells the block too, but
// its one check reads the testbench bias, so it passes whatever the block
// does to the module that holds it. This file reads that module's outputs.
//
//     specify_block ::= specify { specify_item } endspecify               // A.7.1
//     specify_item ::= specparam_declaration | pulsestyle_declaration
//             | showcancelled_declaration | path_declaration | system_timing_check
//     pulsestyle_declaration ::= pulsestyle_onevent list_of_path_outputs ;
//             | pulsestyle_ondetect list_of_path_outputs ;
//     showcancelled_declaration ::= showcancelled list_of_path_outputs ;
//             | noshowcancelled list_of_path_outputs ;
//     path_declaration ::= simple_path_declaration ;                       // A.7.2
//             | edge_sensitive_path_declaration ; | state_dependent_path_declaration ;
//     parallel_path_description ::= ( specify_input_terminal_descriptor
//             [ polarity_operator ] => specify_output_terminal_descriptor )
//     full_path_description ::= ( list_of_path_inputs [ polarity_operator ]
//             *> list_of_path_outputs )
//     state_dependent_path_declaration ::= if ( module_path_expression )
//             simple_path_declaration | ... | ifnone simple_path_declaration
//     specify_input_terminal_descriptor ::=                                // A.7.3
//             input_identifier [ [ constant_range_expression ] ]
//     specify_output_terminal_descriptor ::=
//             output_identifier [ [ constant_range_expression ] ]
//
// WHAT IS SPELLED. Every A.7.1 arm but `system_timing_check` (that one is
// timing_checks_design_runs.va): a specparam, both pulsestyle keywords,
// both showcancelled keywords (each before any path naming its outputs, as
// IEEE 1364-2005 §14.6.4.1 and §14.6.4.2 require). A.7.2: a parallel path with
// the `-` polarity operator, a full path over a two-input list, an `if` and an
// `ifnone` state-dependent pair on one source/destination, and an
// edge-sensitive path. A.7.3: a part-select source `v[2:1]` and a bit-select
// source `v[3]`.
//
// Delays are observed before and after their deadlines. At t=21 a rises:
// y falls at 26 (tf=5), z rises at 24 (full path=3), n falls at 22 (en=1),
// w and m update at 22, and e rises at 25 (edge path rise=4). At t=23,
// y and z must still hold their old values while n, w and m have changed.
// At t=41 en is cleared before a and b fall: n rises at 43 (ifnone=2)
// and z falls at 44.
// Sampling at t=42 and t=45 distinguishes both path choices and delays.
// Dropping the specify block no longer passes on settled logic alone.
//
// DERIVATION (`timescale 1ns/1ns; cell: y = ~a, z = a & b, n = ~a,
// w = v[2:1], m = v[3], e = er where er <= b at posedge a):
//
//   [1, 21)   a=0 b=1 en=1 v=0110: y=1 z=0 n=1 w=2'b11=3 m=0. e is still x:
//             the x->0 on a at 1 ns is no posedge, so e is not read here.
//   [21, 41)  a rises with b=1, v=1001: y=0 z=1 n=0 w=2'b00=0 m=1, e=1.
//   [41, ..)  a=0 b=0 en=0: y=1 z=0 n=1 w=0 m=1; no posedge of a, so e stays 1.
// The stimulus starts at 1 ns, not 0, so every process is waiting on its
// event control before the first change (no time-zero race). The cell's
// outputs reach the top on its wires ty, tz, tn, tw, te, tm, and a second
// initial block checks both settled values and the delay windows: 27
// verdicts. Checking in the digital half keeps the count exact, where an
// analog-block check also prints at every point the mixed run inserts at a
// digital event.
//
//! lrm A.7
//! lrm A.7.1
//! lrm A.7.2
//! lrm A.7.3
//! lrm A.7.1:1000
//! lrm A.7.2:1000
//! lrm A.7.3:1000
//! analysis tran
//! time 0, 60n
//! checks 27
`timescale 1ns/1ns
`include "check.vh"
module b8_specify_paths_design_runs(p);
  inout p; electrical p;
  reg a, b, en;
  reg [3:0] v;
  wire ty, tz, tn, te, tm;
  wire [1:0] tw;

  b8_sp_cell u(a, b, en, v, ty, tz, tn, tw, te, tm);

  initial begin
    #1 a = 1'b0; b = 1'b1; en = 1'b1; v = 4'b0110;
    #20 a = 1'b1; v = 4'b1001;
    #20 b = 1'b0; en = 1'b0; a = 1'b0;
  end

  initial begin
    #11 `CHECKI("t=11 y = ~a through the -=> path", ty, 1);
    `CHECKI("t=11 z = a & b through the *> path", tz, 0);
    `CHECKI("t=11 n = ~a through the if/ifnone paths", tn, 1);
    `CHECKI("t=11 w = v[2:1] through the part-select path", tw, 3);
    `CHECKI("t=11 m = v[3] through the bit-select path", tm, 0);
    #12 `CHECKI("t=23 parallel fall path still holds y", ty, 1);
    `CHECKI("t=23 full path still holds z", tz, 0);
    `CHECKI("t=23 enabled state path already changed n", tn, 0);
    `CHECKI("t=23 selected vector path already changed w", tw, 0);
    `CHECKI("t=23 selected bit path already changed m", tm, 1);
    `CHECKI("t=23 edge-sensitive output has not reached its delay", te === 1'bx, 1);
    #8 `CHECKI("t=31 y", ty, 0);
    `CHECKI("t=31 z", tz, 1);
    `CHECKI("t=31 n", tn, 0);
    `CHECKI("t=31 w", tw, 0);
    `CHECKI("t=31 m", tm, 1);
    `CHECKI("t=31 e took b at posedge a through the edge path", te, 1);
    #11 `CHECKI("t=42 full path has not propagated b", tz, 1);
    `CHECKI("t=42 ifnone path has not propagated en", tn, 0);
    #3 `CHECKI("t=45 full path propagated b", tz, 0);
    `CHECKI("t=45 ifnone path propagated en", tn, 1);
    #6 `CHECKI("t=51 y", ty, 1);
    `CHECKI("t=51 z", tz, 0);
    `CHECKI("t=51 n", tn, 1);
    `CHECKI("t=51 w", tw, 0);
    `CHECKI("t=51 m", tm, 1);
    `CHECKI("t=51 e holds with no posedge", te, 1);
  end

  analog I(p) <+ V(p);
endmodule

module b8_sp_cell(a, b, en, v, y, z, n, w, e, m);
  input a, b, en;
  input [3:0] v;
  output y, z, n, m, e;
  output [1:0] w;
  reg er;

  assign y = ~a;
  assign z = a & b;
  assign n = ~a;
  assign w = v[2:1];
  assign m = v[3];
  always @(posedge a) er <= b;
  assign e = er;

  specify
    specparam tr = 2, tf = 5;
    pulsestyle_onevent y;
    pulsestyle_ondetect z;
    showcancelled y, n;
    noshowcancelled z;
    (a -=> y) = (tr, tf);
    (a, b *> z) = 3;
    if (en) (a => n) = 1;
    ifnone (a => n) = 2;
    (v[2:1] => w) = 1;
    (v[3] => m) = 1;
    (posedge a => (e +: b)) = (4, 6);
  endspecify
endmodule
