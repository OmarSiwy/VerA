// A.8.4 `primary` — every shape an expression leaf can take, in one module:
// an array word select `array[0]`, a branch probe `V(path)` on a named branch
// (A.8.9 `branch_reference`), a port probe `I(<p>)` (A.8.2
// `port_probe_function_call`), an analog function call, and a system function
// call `$pow` (§4.3.1 Table 4-14, C `pow`).
//
// The values are pinned by the bias: `branch (p,n) path` names the (p,n) pair,
// so §5.5.1 makes V(path) the potential difference V(p) - V(n) = 0.5.
// A word select of a real array yields that element (§3.9), and `identity`
// returns its input unchanged (§4.7.1 the function's own name is its return
// storage), so both must read back 0.5. $pow(0.5, 3.0) = 1/8 = 0.125.
//
// The tolerance is 1e-15 rather than exact: 0.7 and 0.2 are not representable
// in binary, so the subtraction lands on 0.49999999999999994 (5.6e-17 low) and
// the cube on 0.12499999999999996 (4.2e-17 low). Both are one or two ulp, far
// inside 1e-15 and far outside any tolerance that would hide a real error.
//
//! bias V(p) = 0.7
//! bias V(n) = 0.2
`include "check.vh"
module annex_a_primaries(p, n);
  inout p, n;
  electrical p, n;
  branch (p, n) path;
  real array[0:1];
  real result;

  analog function real identity;
    input x;
    real x;
    identity = x;
  endfunction

  analog begin
    array[0] = V(path);
    array[1] = I(path);
    `CHECK("named branch probe", V(path), 0.5, 1e-15);
    `CHECK("word select through an analog function call", identity(array[0]), 0.5, 1e-15);
    `CHECK("system function call on a word select", $pow(array[0], 3.0), 0.125, 1e-15);
    result = identity(array[0]) + $pow(array[1], 2.0) + I(<p>);
    I(p, n) <+ result;
  end
endmodule
