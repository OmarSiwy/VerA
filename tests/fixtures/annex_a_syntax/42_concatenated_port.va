// A.1.3 `port_expression ::= port_reference | { port_reference { , port_reference } }`
//
// One port of the module may be a CONCATENATION of several internal nets —
// §6.5.1's fourth bullet, "a vector net formed as a result of the concatenation
// operator". Externally `{a, b}` is one two-bit port; internally `a` and `b`
// stay separate nets that behavioral code addresses by name.
//
// No module header in the suite uses the form. Same production and same
// diagnostic as 41_named_port.va, which is why they were written together.
//
// What the fixture demands once it parses: concatenating the nets into one port
// does not merge them, so the two probes differ. 0.6 - 0.1 lands on exactly 0.5
// but 0.3 - 0.1 lands on 0.19999999999999998, one ulp low, so both use the
// 1e-15 tolerance for symmetry rather than one `CHECKX` and one `CHECK`.
//
// A run fixture, not a `//! reject`: A.1.3 makes this legal.
//
//! lrm A.1.3
//! lrm 6.5.1
//! bias V(a) = 0.6
//! bias V(b) = 0.3
//! bias V(n) = 0.1
//! print none
//! xfail VerA's header parser has no concatenated-port form: `{a, b}` in a list of ports is E0208 "expected an identifier: found `{`"
`include "check.vh"
module annex_a_concatenated_port({a, b}, n);
    inout a, b, n;
    electrical a, b, n;

    analog begin
        `CHECK("the first net of a concatenated port keeps its own identity", V(a, n), 0.5, 1e-15);
        `CHECK("the second net of a concatenated port keeps its own identity", V(b, n), 0.2, 1e-15);
        I(a, n) <+ V(a, n);
        I(b, n) <+ V(b, n);
    end
endmodule
