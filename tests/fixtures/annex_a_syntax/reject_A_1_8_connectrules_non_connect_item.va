// A.1.8:
//
//     connectrules_declaration ::=
//             connectrules connectrules_identifier ;
//                 { connectrules_item }
//             endconnectrules
//     connectrules_item ::= connect_insertion | connect_resolution
//
// Both alternatives begin with the keyword `connect`. `module x;` is neither,
// so it cannot appear between `connectrules` and `endconnectrules`. The same
// block holding `connect electrical, electrical resolveto electrical;` is
// accepted (probed).
//
// VerA reports E0207 "unexpected token: found `module`"; the E0205 that
// follows is the parser recovering from it.
//
//! lrm A.1.8
//! lrm A.1.8:1000
//! reject-only E0207
//! reject endconnectrules
//! neighbour 60_connectrules_declaration.va
`include "disciplines.vams"
module annex_a_cr_top(p, n);
  inout p, n;
  electrical p, n;
  analog I(p, n) <+ V(p, n);
endmodule

connectrules annex_a_cr;
  module x;                  // illegal: not a connect_insertion or connect_resolution
endconnectrules
