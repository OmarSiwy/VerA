// A.3.3 makes a switch's and a pull gate's net terminals `net_lvalue`s, and
// A.8.5's net_lvalue includes a concatenation:
//
//     inout_terminal ::= net_lvalue
//     output_terminal ::= net_lvalue                                  // A.3.3
//     net_lvalue ::= hierarchical_net_identifier [ ... ]
//             | { net_lvalue { , net_lvalue } }                       // A.8.5
//
// A one-element concatenation is the element's own bits (IEEE 1364-2005
// §5.1.14), so `tran ({a}, b)` connects a and b as `tran (a, b)` does.
//
// DERIVATION (`timescale 1ns/1ns; IEEE 1364-2005 §7.6-§7.8). At 1 ns
// d = 0 and en = 1.
//   b: `tran ({a}, b)` with a driven 1 by a continuous assign       -> 1
//   u: `pullup ({u})`, nothing else drives u                        -> 1
//   q: `nmos ({q}, d, en)`, conducting, passes d                    -> 0
// {b, u, q} = 3'b110 = 6, checked at 2 ns. One verdict.
//
//! lrm A.3.3
//! lrm A.8.5
//! lrm A.3.3:1000
//! analysis tran
//! time 0, 5n
//! checks 1
`timescale 1ns/1ns
`include "check.vh"
module concatenation_as_switch_terminal(p);
    inout p;
    electrical p;
    reg d, en;
    wire a, b, u, q;
    assign a = 1'b1;
    tran ({a}, b);
    pullup ({u});
    nmos ({q}, d, en);

    initial begin
        #1 d = 1'b0;
        en = 1'b1;
        #1 `CHECKI("{b, u, q} through concatenated terminals", ({b, u, q}), 6);
    end

    analog I(p) <+ V(p);
endmodule
