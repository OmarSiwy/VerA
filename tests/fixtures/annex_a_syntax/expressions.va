// Annex A.8 expression forms, all folded into one number by hand:
//
//   coefficients[0] + coefficients[1]   array parameter indexing (§3.4.4)
//                                       = 1.0 + 2.0 = 3.0
//   2.0 ** 3.0                          power binds tighter than `*` (§4.2.2
//                                       Operator precedence, Table 4-3) = 8.0
//   3.0 * 8.0                           = 24.0
//   24.0 > 0.0 ? sin(24.0) : cos(24.0)  conditional operator (§4.2.12)
//                                       = sin(24) = -0.9055783620066239
//
// Written with `*` applied before `**` the first line would be 6**3 = 216, and
// with the false arm taken it would be cos(24) = +0.424179007336997, so both
// operators are pinned by the one digit string.
//
// The header used to cite "LRM 4.1.5" and "LRM 4.1.13"; neither section exists
// (§4.1 is Overview and has no subclauses).
//
//! lrm A.8
//! lrm 3.4.4
//! lrm 4.2.2
//! lrm 4.2.12
//! lrm 4.2.2:1000
//! lrm A.8.1
//! lrm A.8.1:1000
//! lrm A.8.3
//! lrm A.8.3:1000
//! print none
`include "check.vh"
module annex_a_expressions(p, n);
    inout p, n;
    electrical p, n;
    parameter real coefficients[0:1] = '{1.0, 2.0};
    real value;

    analog begin
        value = (coefficients[0] + coefficients[1]) * 2.0 ** 3.0;
        `CHECKX("** binds tighter than *: (1+2) * 2**3", value, 24.0);
        value = value > 0.0 ? sin(value) : cos(value);
        `CHECK("?: takes the true arm, sin(24)", value, -0.9055783620066239, 1e-15);
        I(p, n) <+ value;
    end
endmodule
