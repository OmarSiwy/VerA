// A.1.8 Connectrules Declaration, both arms of its item production:
//
//     connectrules_declaration ::=
//             connectrules connectrules_identifier ;
//                 { connectrules_item }
//             endconnectrules
//     connectrules_item ::= connect_insertion | connect_resolution
//     connect_insertion ::= connect connectmodule_identifier [ connect_mode ]
//             [ parameter_value_assignment ] [ connect_port_overrides ] ;
//     connect_mode ::= merged | split
//     connect_resolution ::= connect discipline_identifier { , discipline_identifier }
//             resolveto discipline_identifier_or_exclude ;
//
// The two items share the `connect` keyword and diverge after it, so a parser
// that has one can easily lack the other; this file spells both, in grammar
// order, in one block.
//
// WHAT THE TWO STATEMENTS SAY. `connect p_a2d merged;` names a §7.6 connect
// module and the `merged` mode — the mode the m03 group in ch07_mixed_signal
// tests semantically, and which §7.7.3's two-instance/one-instance distinction
// is about. `connect p_ra, p_rb resolveto p_rc;` is the resolution form of
// §7.7.2: three natureless discrete disciplines, so §3.11.1 makes them
// compatible and the statement is decided on compatibility alone. Like
// connectrules_accepted.va in ch07, neither statement has anything to insert or
// resolve here: there is no mixed net in this file, so the block is parsed,
// validated and consumed as configuration. That is the whole claim — ACCEPTANCE —
// and it is a real one: ch07's header records that VerA once refused the block
// with E0201 on the argument that C.9/C.16 exempt it, until the fixture moved to
// the LRM's side of that question.
//
// WHAT IS NOT CLAIMED. No connect module is inserted and no discipline is
// resolved by this file — no net here is mixed, and the anchor that makes
// acceptance observable is the ordinary module's bias readback below
// (`V(p)`, 0.75, exact in binary). The resolution semantics live in
// annex_f_resolution/resolveto_resolution.va, which is the fixture that would
// notice if `resolveto` were parsed and dropped: it reads the resolved
// discipline back through an access function only that discipline defines.
//
//! lrm A.1.8
//! lrm 7.7.2
//! lrm 3.11.1
//! bias V(p) = 0.75
`include "check.vh"
discipline annex_a_ra;
    domain discrete;
enddiscipline

discipline annex_a_rb;
    domain discrete;
enddiscipline

discipline annex_a_rc;
    domain discrete;
enddiscipline

connectmodule annex_a_a2d(a, d);
    input a;
    output d;
    electrical a;
endmodule

module annex_a_connectrules_host(p);
    inout p;
    electrical p;

    analog begin
        `CHECKX("the A.1.8 connectrules block is accepted and the ordinary module runs",
                V(p), 0.75);
        I(p) <+ V(p);
    end
endmodule

connectrules annex_a_rules;
    connect annex_a_a2d merged;
    connect annex_a_ra, annex_a_rb resolveto annex_a_rc;
endconnectrules
