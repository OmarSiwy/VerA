// Annex A.1.9 paramset_declaration, §6.4.
//
//   paramset_declaration ::= paramset paramset_identifier module_or_paramset_identifier ;
//                                paramset_item_declaration { ... }
//                                paramset_statement { ... }
//                            endparamset
//   paramset_statement   ::= .module_parameter_identifier = paramset_constant_expression ;
//
// §6.4: "The paramset itself contains no behavioral code; all of the behavior is
// determined by the associated module" — a paramset is a named bundle of
// parameter values for that module, the Verilog-AMS spelling of a SPICE model
// card, and A.4.1 instantiates it exactly like one (`module_instantiation ::=
// module_or_paramset_identifier ...`). Clause 6 is in the Verilog-A subset per
// Annex C.8 and C.16 does not name paramset, so a conforming compiler accepts
// this file. It used to carry a bare `//! reject E0201`, which pinned VerA's own
// "construct is not in the supported subset" as though it were a rule of the
// language.
//
// The value is fixed by the paramset and by nothing else: the target declares
// `gain = 1.0`, the paramset overrides it with `2.0 * scale`, and the
// paramset's own `scale` defaults to 1.5 — so the gain the target sees is 3.0.
// A paramset that was parsed but never applied leaves 1.0; one that dropped its
// own parameter default leaves 2.0.
//
// MODULE ORDER IS LOAD-BEARING. The device is elaborated from the module nothing
// instantiates (01_source_text.va documents the rule), and an instance naming a
// PARAMSET counts as an incoming edge on the module that paramset specializes —
// so `annex_a_target` is reached THROUGH the paramset instance. Were it
// elaborated standalone its `gain` would read the declared 1.0, and this file
// would be red at 1.0 != 3.0 however well paramsets worked.
//
//! lrm A.1.9
//! lrm 6.4
//! lrm C.8
//! lrm A.1.9:1000
//! lrm A.4.1
//! lrm A.4.1:1000
//! bias V(p) = 0.5
//! print none
`include "check.vh"
module annex_a_paramset(p, n);
    inout p, n;
    electrical p, n;

    annex_a_parameters instance_of_paramset(p, n);
endmodule

paramset annex_a_parameters annex_a_target;
    parameter real scale = 1.5 from (0:inf);
    .gain = 2.0 * scale;
endparamset

module annex_a_target(p, n);
    inout p, n;
    electrical p, n;
    parameter real gain = 1.0;

    analog begin
        `CHECKX("the paramset's value reaches the module parameter", gain, 3.0);
        I(p, n) <+ gain * V(p, n);
    end
endmodule
