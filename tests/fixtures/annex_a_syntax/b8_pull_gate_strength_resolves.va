// A.3.2's pullup/pulldown strengths, observed through how each pull source
// resolves against a competing driver. 57_primitive_strengths_unsupported.va
// writes `pulldown (strong0) pd (o);` but its only check reads the bias, and a
// lone pulldown gives 0 at any strength.
//
//     pulldown_strength ::= ( strength0 , strength1 ) | ( strength1 , strength0 )
//             | ( strength0 )                                         // A.3.2
//     pullup_strength ::= ( strength0 , strength1 ) | ( strength1 , strength0 )
//             | ( strength1 )
//     gate_instantiation ::= ... | pulldown [ pulldown_strength ]
//             pull_gate_instance { , pull_gate_instance } ;
//             | pullup [ pullup_strength ] pull_gate_instance { , pull_gate_instance } ;
//                                                                     // A.3.1
//
// IEEE 1364-2005 §7.8 (inherited through §1.1): "A pullup source shall place a
// logic value 1 on the nets connected in its terminal list. A pulldown source
// shall place a logic value 0 ... The signals that these sources place on nets
// shall have pull strength in the absence of a strength specification. If there
// is a strength1 specification on a pullup source or a strength0 specification
// on a pulldown source, the signals shall have the strength specified. A
// strength0 specification on a pullup source and a strength1 specification on a
// pulldown source shall be ignored." §7.10.1: "the stronger signal shall
// dominate all the weaker drivers"; Figure 7-2: supply 7, strong 6, pull 5,
// weak 3.
//
// DERIVATION. Each competitor is a continuous assignment from a reg the initial
// block sets at 1 ns; at 3 ns the same block checks every net. W0252 says the
// analog device computes no gate; the digital half of the mixed run does, and
// that is where the checks run.
//
//   o1  pullup (strong1) p1 (o1), p2 (o1b): St1 vs assign (pull0, pull1) o1 = 0
//       -> 1. (At the default pull strength: Pu1 vs Pu0 -> x.)
//   o1b the list's second instance, alone on its net -> 1.
//   o2  pulldown (strong0): St0 vs assign (pull0, pull1) o2 = 1 -> 0.
//       (Default: Pu0 vs Pu1 -> x.)
//   o3  pullup (weak1): We1 vs assign (pull0, pull1) o3 = 0 -> 0.
//       (Default: Pu1 vs Pu0 -> x.)
//   o4  pullup (strong0, weak1), the pair form: strength0 is ignored, so it is
//       o3 again: We1 vs Pu0 -> 0.
//   o5  pulldown (weak1, supply0), the pair form: Su0 vs
//       assign (strong0, strong1) o5 = 1 -> 0. (Default: Pu0 vs St1 -> 1.)
//   o6  pullup with no strength: Pu1 vs assign (weak0, weak1) o6 = 0 -> 1.
//
// Seven verdicts; a strength dropped gives x (ok=x) or the wrong value.
//
//! lrm A.3.2
//! lrm A.3.1
//! lrm A.3.2:1000
//! lrm A.3.1:1000
//! analysis tran
//! time 0, 10n
//! checks 7
`timescale 1ns/1ns
`include "check.vh"
module b8_pull_gate_strength_resolves(p);
  inout p; electrical p;
  reg zero, one;
  wire o1, o1b, o2, o3, o4, o5, o6;

  pullup (strong1) p1 (o1), p2 (o1b);
  assign (pull0, pull1) o1 = zero;
  pulldown (strong0) pd2 (o2);
  assign (pull0, pull1) o2 = one;
  pullup (weak1) pu3 (o3);
  assign (pull0, pull1) o3 = zero;
  pullup (strong0, weak1) pu4 (o4);
  assign (pull0, pull1) o4 = zero;
  pulldown (weak1, supply0) pd5 (o5);
  assign (strong0, strong1) o5 = one;
  pullup pu6 (o6);
  assign (weak0, weak1) o6 = zero;

  initial begin
    #1 zero = 1'b0;
    one = 1'b1;
    #2 `CHECKI("o1: pullup (strong1) beats a pull0 driver", o1, 1);
    `CHECKI("o1b: the list's second pullup alone", o1b, 1);
    `CHECKI("o2: pulldown (strong0) beats a pull1 driver", o2, 0);
    `CHECKI("o3: a pull0 driver beats pullup (weak1)", o3, 0);
    `CHECKI("o4: pullup (strong0, weak1) is weak; its strength0 is ignored", o4, 0);
    `CHECKI("o5: pulldown (weak1, supply0) beats a strong1 driver", o5, 0);
    `CHECKI("o6: a strength-less pullup is pull and beats weak0", o6, 1);
  end

  analog I(p) <+ V(p);
endmodule
