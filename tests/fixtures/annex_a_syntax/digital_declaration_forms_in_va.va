// The digital declaration forms Annex A gives every Verilog-AMS module, in a
// .va whose discrete half runs them:
//
//     reg_declaration ::= reg [ discipline_identifier ] [ signed ] [ range ]
//             list_of_variable_identifiers ;                         // A.2.1.3
//     function_declaration ::= function [ automatic ]
//             [ function_range_or_type ] function_identifier ... ;   // A.2.6
//     function_range_or_type ::= [ signed ] [ range ] | integer | real
//             | realtime | time                                      // A.2.6
//     tf_input_declaration ::= input [ discipline_identifier ] [ reg ]
//             [ signed ] [ range ] list_of_port_identifiers
//             | input task_port_type list_of_port_identifiers        // A.2.7
//
// §4.7: "Each function can be an analog user-defined function or a digital
// function (as defined in IEEE Std 1364 Verilog)", so a function written
// without `analog` takes IEEE 1364-2005 §10.4's forms, not §4.7.1's; in
// particular §4.7.1's "all formal arguments shall have an associated block item
// declaration specifying the data type" (E0225) is an analog-function rule.
// A.2.7 makes every keyword of `input [ reg ] [ signed ] [ range ]` optional,
// so `input a;` is `input reg a;`, a 1-bit reg.
//
// DERIVATION (IEEE 1364-2005 §5.5 signed expressions, §10.4.1 automatic):
//   rs  `reg signed [3:0]` = -3        -3 truncates to 4'b1101, read signed -3;
//                                      unsigned it would read 13
//   rl  `reg logic [3:0]` = 4'b1010    10 (annex D.1's discrete `logic`)
//   negate(8'd5), `function signed [7:0]` over `input reg [7:0] x`:
//       -x is 8'b11111011, which the signed result reads as -5 (unsigned: 251)
//   fact(5), `function automatic integer`, `fact = ... fact(n - 1) * n`:
//       each call has its own n (§10.4.1 "reentrant"), so 1*2*3*4*5 = 120. A
//       static n is 1 when every multiplication reads it, giving 1.
//   half, `function realtime`, is declared and not called: the mixed run's
//   digital half holds no real-valued function (a real function of a mixed
//   module is the analog side's, src/sim/digital/elab.zig `usesReal`), so the
//   form is parsed here and its value is ieee1364/A_formal_syntax's
//   b_A_2_6_real_functions.v.
//   later(10), `function time` over `input time t`: 10 + 5 = 15
//   pass(3), `input a;` with no type: a 1-bit reg holds 3's low bit, 1
// Each result is assigned at 0 ns (an integer takes the signed 8-bit -5
// sign-extended) and checked at 1 ns: six verdicts.
//
//! lrm A.2.1.3
//! lrm A.2.6
//! lrm A.2.7
//! lrm 4.7
//! lrm A.2.6:1000
//! analysis tran
//! time 0, 5n
//! checks 6
`timescale 1ns/1ns
`include "check.vh"
module digital_declaration_forms_in_va(p);
    inout p;
    electrical p;
    reg signed [3:0] rs;
    reg logic [3:0] rl;

    function signed [7:0] negate(input reg [7:0] x);
        negate = -x;
    endfunction

    function automatic integer fact;
        input integer n;
        fact = (n <= 1) ? 1 : fact(n - 1) * n;
    endfunction

    function realtime half;
        input realtime t;
        half = t / 2.0;
    endfunction

    function time later;
        input time t;
        later = t + 5;
    endfunction

    function integer pass;
        input a;
        pass = a;
    endfunction

    integer v_neg, v_fact, v_later, v_pass;

    initial begin
        rs = -3;
        rl = 4'b1010;
        v_neg = negate(8'd5);
        v_fact = fact(5);
        v_later = later(10);
        v_pass = pass(3);
        #1;
        `CHECKI("reg signed [3:0] rs = -3", rs, -3);
        `CHECKI("reg logic [3:0] rl = 4'b1010", rl, 10);
        `CHECKI("function signed [7:0] negate(8'd5)", v_neg, -5);
        `CHECKI("function automatic fact(5)", v_fact, 120);
        `CHECKI("function time later(10)", v_later, 15);
        `CHECKI("an untyped input is a 1-bit reg: pass(3)", v_pass, 1);
    end

    analog I(p) <+ V(p);
endmodule
