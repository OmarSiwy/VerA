// A.7.3:
//
//     specify_input_terminal_descriptor ::=
//             input_identifier [ [ constant_range_expression ] ]
//
// A path source is a terminal identifier, optionally bit- or part-selected;
// it is not an expression. `(a + b => o)` is not derivable. It is worth being
// precise about how it fails: `+` IS legal immediately before `=>` as the
// polarity_operator (`(a + => o)`), so after `a +` the grammar requires `=>`,
// and `b` is the first token that cannot be derived.
//
// VerA reports exactly that: E0207 "found b: a path description connects its
// terminals with `=>` or `*>`".
//
//! lrm A.7.3
//! lrm A.7.3:1000
//! reject-only E0207
//! reject connects its terminals with
//! reject endspecify
//! neighbour b8_specify_paths_design_runs.va
module annex_a_expression_path_terminal(o, a, b);
  output o;
  input a, b;
  wire o, a, b;
  and g1(o, a, b);
  specify
    (a + b => o) = 1;        // illegal: a terminal descriptor is not an expression
  endspecify
endmodule
