// A.2.1.2 and A.2.2.1:
//
//     output_declaration ::= ...
//             | output output_variable_type list_of_variable_port_identifiers
//     output_variable_type ::= integer | time
//
// A variable output port may be integer or time; `real` is not an
// output_variable_type, so `output real r` is not derivable. `output integer r`
// is accepted in the same position (probed), which is what makes the type the
// defect.
//
// VerA reports E0208 "expected an identifier: found `real`". (It gives the same
// E0208 for the legal net form `output wreal r` — probed — which is a gap in
// the positive half, not in this rule.)
//
//! lrm A.2.2.1
//! lrm A.2.1.2
//! lrm A.2.1.2:1000
//! lrm A.2.2.1:1000
//! reject-only E0208
//! neighbour 52_net_and_variable_types.va
`include "disciplines.vams"
module annex_a_output_real(p, n, r);
  inout p, n;
  electrical p, n;
  output real r;             // illegal: real is not an output_variable_type
  analog I(p, n) <+ V(p, n);
endmodule
