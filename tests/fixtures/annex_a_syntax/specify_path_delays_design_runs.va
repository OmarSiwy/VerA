// A.7.4, the positive half: every legal length of a path delay list, in both
// `path_delay_value` arms, with specparam and expression values, on a module
// whose outputs are then read. specify_block_unsupported.va spells two of
// these, but its only check reads the testbench bias.
//
//     path_delay_value ::= list_of_path_delay_expressions
//             | ( list_of_path_delay_expressions )
//     list_of_path_delay_expressions ::= t_path_delay_expression
//             | trise_path_delay_expression , tfall_path_delay_expression
//             | trise_... , tfall_... , tz_path_delay_expression
//             | t01_... , t10_... , t0z_... , tz1_... , t1z_... , tz0_...
//             | (the twelve-value list, t01 ... tzx)
//     path_delay_expression ::= constant_mintypmax_expression
//
// WHAT IS SPELLED. One output per form: 1 value bare (q1), 2 specparams in
// parentheses (q2), 2 values bare (q2b, the first `path_delay_value` arm),
// 3 values (q3), 6 (q6), 12 (q12), and one constant expression over a
// specparam (qe). reject_A_7_4_four_path_delays.va is the refusal: a
// four-value list derives from no arm. The constant_mintypmax_expression arm of
// path_delay_expression (`1:2:3`) is specify_path_delay_mintypmax_list.va's
// (an xfail).
//
// Every delay-list form now has a sampled transition window. With c rising
// at 21 ns, output changes occur at 22 (q6), 23 (q2,q3,q12), 24 (q2b,qe),
// and 25 (q1). On the falling edge at 41 ns they occur at 42 (q2,q3,q12),
// 43 (q6), 44 (qe), 45 (q1), and 46 (q2b). Samples at half-nanoseconds
// avoid races with the path update itself. The bit order is
// {q1,q2,q2b,q3,q6,q12,qe}; deleting the delays changes the intermediate words.
//
//! lrm A.7.4
//! lrm A.7.4:1000
//! analysis tran
//! time 0, 60n
//! checks 12
`timescale 1ns/1ps
`include "check.vh"
module b8_specify_path_delays_design_runs(p);
  inout p; electrical p;
  reg c;
  wire t1, t2, t2b, t3, t6, t12, te;

  b8_pd_cell u(c, t1, t2, t2b, t3, t6, t12, te);

  initial begin
    #1 c = 1'b0;
    #20 c = 1'b1;
    #20 c = 1'b0;
  end

  initial begin
    #16 `CHECKI("t=16 c=0: {q1,q2,q2b,q3,q6,q12,qe}", ({t1, t2, t2b, t3, t6, t12, te}), 42);
    #6.5 `CHECKI("t=22.5 only q6 has propagated the rising input", ({t1, t2, t2b, t3, t6, t12, te}), 46);
    #1 `CHECKI("t=23.5 the inverted outputs have fallen", ({t1, t2, t2b, t3, t6, t12, te}), 4);
    #1 `CHECKI("t=24.5 the bare two-value and expression paths arrive", ({t1, t2, t2b, t3, t6, t12, te}), 21);
    #1 `CHECKI("t=25.5 the one-value path arrives last", ({t1, t2, t2b, t3, t6, t12, te}), 85);
    #16 `CHECKI("t=41.5 no path has propagated the falling input", ({t1, t2, t2b, t3, t6, t12, te}), 85);
    #1 `CHECKI("t=42.5 the inverted outputs have risen", ({t1, t2, t2b, t3, t6, t12, te}), 127);
    #1 `CHECKI("t=43.5 the six-value fall delay expires", ({t1, t2, t2b, t3, t6, t12, te}), 123);
    #1 `CHECKI("t=44.5 the expression delay expires", ({t1, t2, t2b, t3, t6, t12, te}), 122);
    #1 `CHECKI("t=45.5 the single delay expires", ({t1, t2, t2b, t3, t6, t12, te}), 58);
    #1 `CHECKI("t=46.5 the distinct two-value fall delay expires", ({t1, t2, t2b, t3, t6, t12, te}), 42);
    #9.5 `CHECKI("t=56 c=0 remains settled", ({t1, t2, t2b, t3, t6, t12, te}), 42);
  end

  analog I(p) <+ V(p);
endmodule

module b8_pd_cell(c, q1, q2, q2b, q3, q6, q12, qe);
  input c;
  output q1, q2, q2b, q3, q6, q12, qe;

  assign q1 = c;
  assign q2 = ~c;
  assign q2b = c;
  assign q3 = ~c;
  assign q6 = c;
  assign q12 = ~c;
  assign qe = c;

  specify
    specparam tplh = 1, tphl = 2;
    (c => q1) = 4;
    (c => q2) = (tplh, tphl);
    (c => q2b) = 3, 5;
    (c => q3) = (1, 2, 3);
    (c => q6) = (1, 2, 3, 4, 5, 6);
    (c => q12) = (1, 2, 3, 4, 5, 6, 7, 8, 9, 10, 11, 12);
    (c => qe) = (2 * tplh + 1);
  endspecify
endmodule
