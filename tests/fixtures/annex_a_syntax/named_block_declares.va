// A.6.3 puts a block's declarations inside the bracket that opens with its
// name:
//
//     analog_seq_block ::= begin [ : analog_block_identifier
//             { analog_block_item_declaration } ] { analog_statement } end
//
// so `begin : body real x; ...` declares x in the block. x = 2 * V(p, n) with
// V(p, n) = 0.75 - 0.25 = 0.5 is 1.0, exact in binary.
// reject_A_6_3_declaration_in_unnamed_block.va is this file without the name.
//
//! lrm A.6.3
//! lrm A.6.3:1000
//! bias V(p) = 0.75, V(n) = 0.25
//! checks 1
`include "check.vh"
module annex_a_named_block_declares(p, n);
    inout p, n;
    electrical p, n;

    analog begin : body
        real x;
        x = 2.0 * V(p, n);
        `CHECKX("x, declared in the named block, holds 2 * V(p, n)", x, 1.0);
        I(p, n) <+ x / 1000.0;
    end
endmodule
