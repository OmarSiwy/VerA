// A.1.5 Configuration source text — the third arm of A.1.1's
// `library_description`, printed in full because this file is the only fixture
// that reaches it:
//
//     config_declaration ::=
//             config config_identifier ;
//                 design_statement
//                 {config_rule_statement}
//             endconfig
//     design_statement ::= design { [library_identifier.]cell_identifier } ;
//     config_rule_statement ::=
//             default_clause liblist_clause ;
//             | inst_clause liblist_clause ;
//             | inst_clause use_clause ;
//             | cell_clause liblist_clause ;
//             | cell_clause use_clause ;
//     liblist_clause ::= liblist { library_identifier }
//     use_clause ::= use [library_identifier.]cell_identifier[:config]
//
// WHAT IS SPELLED. The declaration, its one mandatory statement (`design`), and
// three of the five `config_rule_statement` arms: `default … liblist …`,
// `cell … liblist …`, and `instance … use …`. `inst_clause ::= instance
// inst_name` with `inst_name ::= topmodule_identifier{.instance_identifier}` is
// the arm the `instance` line takes, and `use` names a cell in a library.
//
// WHY IT IS A FIXTURE AT ALL, when the annex intro says a library map file
// derives from `library_text` and not from `source_text`. Because a
// CONFIGURATION is not library-map-only, and this is where it parts company
// with 46_library_source_text.va, which stays red. A.1.2 settles it by listing
// the alternatives of the starting symbol a `.va` IS derived from:
//
//     source_text ::= { description }
//     description ::=
//             module_declaration
//             | udp_declaration
//             | config_declaration
//             | paramset_declaration
//             | nature_declaration
//             | discipline_declaration
//             | connectrules_declaration
//
// `config_declaration` is in that list and `library_description` is not, so a
// configuration in a source file is derivable from `source_text` and a library
// declaration in one is not. §1.1 makes the complete IEEE Std 1364 Verilog part
// of Verilog-AMS HDL, so the arm is VerA's to take, and it does.
//
// WHAT IT DOES WITH IT: nothing, out loud (W0253, "configuration read, and
// nothing binds through it"). A configuration selects which CELL of which
// LIBRARY an instance resolves to. VerA reads no library map, so every instance
// resolves to a module declared in the source it was given, by name — the
// `design` statement selects nothing, the four `config_rule_statement`s below
// apply to nothing, and the elaborated design is exactly what it would be with
// the configuration deleted. `--deny=W0253` turns that into a refusal for a
// design whose answer depends on the configuration selecting.
//
// The file was an xfail against E0201 "construct is not in the supported
// subset: `config`" — a SUBSET diagnostic, which was the wrong rule twice over:
// the production is in A.1.2's list, and what is missing is a library map
// reader rather than a piece of the analog subset.
//
// So the file carries both: the configuration, and a module with an assertion in
// it. The assertion is a verdict that EXISTS — the day VerA took configurations
// this file XPASSed instead of quietly reporting `unasserted`, which is what an
// xfail with no assertion can do and the reason ch09_system_tasks/38 spells the
// rule out at length. It is now the row's positive evidence.
//
// NOTE THE DESIGN NAME. `annex_a_cfg_top` is a cell this file does not define,
// which a configuration is allowed to be: §13 of 1364 binds a *library* cell at
// elaboration. VerA has instances (11/12/10 are green) but no library mapping
// behind them, and the warning is what records that missing half rather than a
// marker: a gap that is announced on every compile is not a silent one.
//
//! lrm A.1.5
//! lrm A.1.2
//! lrm A.1.1
//! lrm 1.1
//! warn W0253
//! bias V(p) = 0.75, V(n) = 0.25
`include "check.vh"
config annex_a_cfg;
    design work.annex_a_cfg_top;
    default liblist annex_a_lib;
    instance annex_a_cfg_top.u1 use work.annex_a_cfg_top;
    cell annex_a_cfg_top liblist annex_a_lib;
endconfig

module annex_a_config_host(p, n);
    inout p, n;
    electrical p, n;

    analog begin
        `CHECKX("the file carrying the A.1.5 configuration compiles and runs",
                V(p, n), 0.5);
        I(p, n) <+ V(p, n);
    end
endmodule
