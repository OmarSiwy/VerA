// A.1.5 Configuration source text — the third arm of A.1.1's
// `library_description`, printed in full because this file is the only fixture
// that reaches it:
//
//     config_declaration ::=
//             config config_identifier ;
//                 design_statement
//                 {config_rule_statement}
//             endconfig
//     design_statement ::= design { [library_identifier.]cell_identifier } ;
//     config_rule_statement ::=
//             default_clause liblist_clause ;
//             | inst_clause liblist_clause ;
//             | inst_clause use_clause ;
//             | cell_clause liblist_clause ;
//             | cell_clause use_clause ;
//     liblist_clause ::= liblist { library_identifier }
//     use_clause ::= use [library_identifier.]cell_identifier[:config]
//
// WHAT IS SPELLED. The declaration, its one mandatory statement (`design`), and
// three of the five `config_rule_statement` arms: `default … liblist …`,
// `cell … liblist …`, and `instance … use …`. `inst_clause ::= instance
// inst_name` with `inst_name ::= topmodule_identifier{.instance_identifier}` is
// the arm the `instance` line takes, and `use` names a cell in a library.
//
// WHY IT IS A FIXTURE AT ALL, when the annex intro says a library map file
// derives from `library_text` and not from `source_text` (see
// 46_library_source_text.va for the same argument). §1.1 makes the complete
// IEEE Std 1364 Verilog part of Verilog-AMS HDL, and configurations are part of
// 1364. VerA's own parser agrees that this is source-level syntax: a `.va` file
// holding a configuration is refused with E0201 "construct is not in the
// supported subset: `config`", which is a *subset* diagnostic reported after the
// keyword was recognised — not E1001 "source contains no module declaration",
// which is what a file of pure nonsense gets (probe: `connectrules` alone, and
// any file with no module, both report E1001 for this same compiler).
//
// So the file carries both: the configuration, and a module with an assertion in
// it. The assertion is a verdict that EXISTS — the day VerA takes configurations
// this file XPASSes instead of quietly reporting `unasserted`, which is what an
// xfail with no assertion can do and the reason ch09_system_tasks/38 spells the
// rule out at length.
//
// NOTE THE DESIGN NAME. `annex_a_cfg_top` is a cell this file does not define,
// which a configuration is allowed to be: §13 of 1364 binds a *library* cell at
// elaboration, and there is no elaboration here. VerA has instances (11/12/10
// are green) but no library mapping behind them, which is exactly the missing
// half this row records.
//
//! lrm A.1.5
//! lrm A.1.1
//! lrm 1.1
//! xfail VerA recognises `config` at the top of a source file and refuses it with E0201 "construct is not in the supported subset"; there is no library mapping to bind the design statement to
//! bias V(p) = 0.75, V(n) = 0.25
`include "check.vh"
config annex_a_cfg;
    design work.annex_a_cfg_top;
    default liblist annex_a_lib;
    instance annex_a_cfg_top.u1 use work.annex_a_cfg_top;
    cell annex_a_cfg_top liblist annex_a_lib;
endconfig

module annex_a_config_host(p, n);
    inout p, n;
    electrical p, n;

    analog begin
        `CHECKX("the file carrying the A.1.5 configuration compiles and runs",
                V(p, n), 0.5);
        I(p, n) <+ V(p, n);
    end
endmodule
