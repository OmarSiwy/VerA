// Annex A.4.2 / §6.6.2 conditional generate.
//
//   if_generate_construct ::= if ( constant_expression ) generate_block_or_null
//                             [ else generate_block_or_null ]
//
// Elaboration evaluates the constant expression and instantiates ONE arm; the
// other produces no instances at all. A.1.4 admits a contribution into an arm
// only through `analog_construct ::= analog analog_statement`, so the `analog`
// keyword is part of the conforming form (see 09_generate.va).
//
// The verdict is a variable rather than the branch current, because §6.2
// concatenates a module's analog blocks in the order they appear: `sel` starts
// at 0.0, the elaborated arm overwrites it, and the last block reads it. That
// one number separates all three ways this can go wrong —
//
//     2.0   the true arm was elaborated and only it            (correct)
//     0.0   neither arm was elaborated
//    -1.0   the false arm ran, or both did (it appears second)
//
//! lrm A.4.2
//! lrm 6.6.2
//! bias V(p) = 0.5
//! print none
//! xfail VerA rejects the `analog` keyword inside a generate block with E0209 "expected an expression: found analog"; the bare `if (e) I(p,n) <+ ...;` form it does accept is not derivable from A.4.2
`include "check.vh"
module annex_a_if_generate(p, n);
    inout p, n;
    electrical p, n;
    parameter integer enabled = 1;
    real sel;

    analog sel = 0.0;

    generate
        if (enabled) begin : on
            analog begin
                sel = 2.0;
                I(p, n) <+ 2.0 * V(p, n);
            end
        end else begin : off
            analog begin
                sel = -1.0;
                I(p, n) <+ 0.0;
            end
        end
    endgenerate

    analog `CHECKX("the true arm of an if-generate is the one elaborated", sel, 2.0);
endmodule
