// IEEE 1364-2005 A.2.6, which VAMS A.2.6 keeps for a function written without
// `analog`:
//
//     function_item_declaration ::= block_item_declaration
//             | { attribute_instance } tf_input_declaration ;
//
// A digital function has inputs only (IEEE 1364-2005 10.4.1). This module
// declares one, `passive`, with its single input typed by a block item, and
// is legal. 4.7 lets a module carry a digital function; 7.3.7 forbids only
// calling it from analog, so nothing here calls it, and what runs is the
// analog block: V(p, n) = 0.75 - 0.25 = 0.5, exact.
// reject_A_2_6_function_output_formal.va adds an `output` formal.
//
//! lrm A.2.6
//! lrm A.2.6:1000
//! lrm 4.7
//! bias V(p) = 0.75, V(n) = 0.25
//! checks 1
`include "check.vh"
module annex_a_function_inputs(p, n);
    inout p, n;
    electrical p, n;

    function real passive;
        input seed;
        real seed;
        passive = seed;
    endfunction

    analog begin
        `CHECKX("the file declaring a digital function of inputs compiles and runs", V(p, n), 0.5);
        I(p, n) <+ V(p, n);
    end
endmodule
