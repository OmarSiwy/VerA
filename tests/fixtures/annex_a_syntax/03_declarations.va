// Annex A.2 module item declarations. Three of them carry a value that can be
// checked from inside the model:
//
//   `branch (p, n) path;`      §3.12 — a named branch between p and n, so
//                              V(path) is the potential across that node pair.
//                              Biased at 0.8 and 0.3, that is 0.5 V — neither
//                              operand is representable in binary but their
//                              difference is exactly 0.5 (verified), so this
//                              is `CHECKX` and not a tolerance.
//   `aliasparam amplification = gain;`
//                              §3.4.7 — an alternate name for the SAME
//                              parameter. Overriding `gain` to 3.5 must be
//                              visible through the alias; a second, separate
//                              storage would still read the 2.0 default.
//   `parameter real bipolar = -0.5 from (-inf:0];`
//                              A.2.5 `value_range_expression ::= constant_expression
//                              | -inf | inf` and §3.4.2. The LOWER half of that
//                              production has no other user in the suite: 44
//                              files bound a parameter above with `inf)` and
//                              none below with `-inf`. -0.5 is exact in binary
//                              and lies inside (-inf:0], so the declared default
//                              stands; a compiler that read `-inf` as `inf`, or
//                              dropped the sign, rejects the default instead.
//
// The header used to cite "LRM 3.7" for branches (§3.7 is Real net declarations)
// and "LRM 3.4.5" for aliasparam (§3.4.5 is Local parameters).
//
//! lrm A.2
//! lrm A.2.5
//! lrm 3.12
//! lrm 3.4.7
//! lrm 3.4.2
//! bias V(p) = 0.8
//! bias V(n) = 0.3
//! param gain = 3.5
//! print none
`include "check.vh"
module annex_a_declarations(p, n);
    inout p, n;
    electrical p, n, internal;
    branch (p, n) path;
    parameter real gain = 2.0 from (0:inf);
    parameter real bipolar = -0.5 from (-inf:0];
    localparam real offset = 1.0;
    aliasparam amplification = gain;
    integer index;
    real value;
    string label = "declarations";

    analog begin
        `CHECKX("named branch probes the declared node pair", V(path), 0.5);
        `CHECKX("aliasparam reads the overridden parameter", amplification, 3.5);
        `CHECKX("a parameter bounded below by -inf keeps its negative default", bipolar, -0.5);
        I(path) <+ gain * V(path) + offset + bipolar;
    end
endmodule
