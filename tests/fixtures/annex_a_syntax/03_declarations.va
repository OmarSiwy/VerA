// Annex A.2 module item declarations. Two of them carry a value that can be
// checked from inside the model:
//
//   `branch (p, n) path;`      LRM 3.7 — a named branch between p and n, so
//                              V(path) is the potential across that node pair.
//                              Biased at 0.8 and 0.3, that is 0.5 V.
//   `aliasparam amplification = gain;`
//                              LRM 3.4.5 — an alternate name for the SAME
//                              parameter. Overriding `gain` to 3.5 must be
//                              visible through the alias; a second, separate
//                              storage would still read the 2.0 default.
//
//! bias V(p) = 0.8
//! bias V(n) = 0.3
//! param gain = 3.5
//! print none
`include "check.vh"
module annex_a_declarations(p, n);
    inout p, n;
    electrical p, n, internal;
    branch (p, n) path;
    parameter real gain = 2.0 from (0:inf);
    localparam real offset = 1.0;
    aliasparam amplification = gain;
    integer index;
    real value;
    string label = "declarations";

    analog begin
        `CHECK("named branch probes the declared node pair", V(path), 0.5, 1e-15);
        `CHECKX("aliasparam reads the overridden parameter", amplification, 3.5);
        I(path) <+ gain * V(path) + offset;
    end
endmodule
