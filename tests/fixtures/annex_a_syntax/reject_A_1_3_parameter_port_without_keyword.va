// A.1.3:
//
//     module_parameter_port_list ::= # ( parameter_declaration { , parameter_declaration } )
//
// and A.2.1.1 starts every parameter_declaration with the keyword `parameter`.
// `#(real k = 1.0)` omits it, so the list is not derivable. (SystemVerilog
// lets the keyword be dropped; Verilog-AMS's grammar does not.) The same header
// written `#(parameter real k = 1.0)` compiles (probed).
//
// VerA reports E0207 "unexpected token: found `real`".
//
//! lrm A.1.3
//! lrm A.1.3:1000
//! reject-only E0207
`include "disciplines.vams"
module annex_a_param_port_no_keyword #(real k = 1.0) (p, n);
  inout p, n;
  electrical p, n;
  analog I(p, n) <+ k * V(p, n);
endmodule
