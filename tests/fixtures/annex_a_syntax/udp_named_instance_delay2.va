// A.5.4:
//
//     udp_instantiation ::= udp_identifier [ drive_strength ] [ delay2 ]
//             udp_instance { , udp_instance } ;
//     udp_instance ::= [ name_of_udp_instance ]
//             ( output_terminal , input_terminal { , input_terminal } )
//
// and A.2.2.3's `delay2 ::= # delay_value | # ( mintypmax_expression [ ,
// mintypmax_expression ] )`. This file writes the NAMED udp_instance, with no
// delay, with a one-value delay2 and with the two-value one — the half of A.5.4
// 59_udp_instantiation_unsupported.va leaves out, because a named UDP instance
// is spelled like a module instance and only elaboration can tell them apart.
// It is the legal twin of reject_A_5_4_udp_three_delays.va (`#(1, 2, 3)`).
//
// Each instance is accepted and computes nothing in an analog device (W0252,
// the same as the unnamed form). The wires it drives are connected to nothing
// else, so the check below is about the file compiling and running, not about
// a dropped driver.
//
//! lrm A.5.4
//! lrm A.2.2.3
//! bias V(p) = 0.75, V(n) = 0.25
`include "check.vh"
module annex_a_udp_named(p, n);
    inout p, n;
    electrical p, n;

    wire a, b, c, d;
    annex_a_udp_named_inv u0 (b, a);
    annex_a_udp_named_inv #(1) u1 (c, a);
    annex_a_udp_named_inv #(1, 2) u2 (d, a);

    analog begin
        `CHECKX("a file with named, delayed UDP instances compiles and runs",
                V(p, n), 0.5);
        I(p, n) <+ V(p, n);
    end
endmodule

primitive annex_a_udp_named_inv (o, a);
    output o;
    input a;
    table
        0 : 1;
        1 : 0;
    endtable
endprimitive
