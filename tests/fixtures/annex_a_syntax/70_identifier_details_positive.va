// A.10 Details: "A simple_identifier shall start with an alpha or underscore
// ( _ ) character, shall have at least one character, and shall not have any
// spaces. The $ character in a system_function_identifier,
// system_task_identifier, or system_parameter_identifier shall not be followed
// by white_space. A system_function_identifier or system_task_identifier shall
// not be escaped."
//
// The positive half. 35_escaped_system_identifier_rejected.va and
// 36_real_embedded_space_rejected.va pin the two refusals; this file writes the
// shapes the note PERMITS and uses each as the identifier it is:
//
//   _lead     starts with an underscore
//   g         one character is enough ("at least one character")
//   mid$9_    alpha start, then `$`, a digit and an underscore (A.9.3's
//             `[ a-zA-Z_ ] { [ a-zA-Z0-9_$ ] }`)
//   $sqrt     a system function identifier with no white space after `$`
//
// DERIVATION. _lead = 0.25, g = 2.0, mid$9_ = _lead * g = 0.5, and
// $sqrt(mid$9_ * 0.5) = $sqrt(0.25) = 0.5. All exact in binary64 ($sqrt is
// correctly rounded, and 0.25 is a perfect square).
//
//! lrm A.10
//! lrm A.9.3
//! lrm A.9.3:1000
//! bias V(p) = 0.5
`include "check.vh"
module annex_a_identifier_details_positive(p);
  inout p;
  electrical p;
  real _lead, g, mid$9_;
  analog begin
    _lead = 0.25;
    g = 2.0;
    mid$9_ = _lead * g;
    `CHECKX("A.10 underscore-led, one-letter and $-bearing identifiers name their own storage", mid$9_, 0.5);
    `CHECKX("A.10 a system function name with no space after $", $sqrt(mid$9_ * 0.5), 0.5);
    I(p) <+ V(p) * g;
  end
endmodule
