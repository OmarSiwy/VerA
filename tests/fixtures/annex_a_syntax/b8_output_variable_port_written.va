// A.2.1.2's variable-typed output ports, observed: each port is written by a
// digital initial block and read back with its type. 51_output_variable_type_
// unsupported.va declares `output integer o` but its only check reads the bias,
// so whether `o` became a variable at all is never seen.
//
//     output_declaration ::=
//             output [ discipline_identifier ] [ net_type | wreal ] [ signed ]
//                 [ range ] list_of_port_identifiers
//             | output [ discipline_identifier ] reg [ signed ] [ range ]
//                 list_of_variable_port_identifiers
//             | output output_variable_type list_of_variable_port_identifiers
//                                                                      // A.2.1.2
//     output_variable_type ::= integer | time                         // A.2.2.1
//
// The last two arms declare the port as a VARIABLE (A.2.3's
// list_of_variable_port_identifiers), so a procedural assignment may write it:
// IEEE 1364-2005 §9.2 makes the left-hand side of a procedural assignment a
// variable, and an `initial` block is a digital procedural context (§7.2.2).
//
// DERIVATION. The initial block writes each port once; the dc solution reads
// two of them through §7.3.1 Table 7-1, as 69_task_declaration_enabled_from_
// initial.va reads its integer:
//
//   output integer o      o = -7        "Discrete integers are accessed in
//                                       continuous context as integer numbers": -7
//   output reg [3:0] r    r = 4'b1001   a bit grouping, lowest bit to bit 0: 9
//
// `output time t` is written (t = 12) and not read: Table 7-1 has no `time`
// row, and a time is 64 bits where a bit grouping wider than 31 bits "is
// illegal" there. So the `time` arm of A.2.2.1 is shown accepted and assigned,
// and only the `integer` arm is shown holding its value.
//
// A tool that recorded only the direction (a net) refuses the procedural
// assignments; one that dropped the port's variable reads 0 or x.
//
//! lrm A.2.1.2
//! lrm A.2.2.1
//! lrm A.2.1.2:1000
//! lrm A.2.2.1:1000
//! bias V(p) = 0.5
//! checks 2
`include "check.vh"
module b8_output_variable_port_written(p, o, t, r);
  inout p; electrical p;
  output integer o;
  output time t;
  output reg [3:0] r;
  initial begin
    o = -7;
    t = 12;
    r = 4'b1001;
  end
  analog begin
    `CHECKI("output integer port written from initial", o, -7);
    `CHECKI("output reg [3:0] port written from initial", r, 9);
    I(p) <+ V(p);
  end
endmodule
