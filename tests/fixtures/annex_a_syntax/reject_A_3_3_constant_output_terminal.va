// A.3.3:
//
//     output_terminal ::= net_lvalue
//     input_terminal ::= expression
//
// A gate's output terminal is something the gate can drive: a net lvalue. A
// constant is an expression but not a net_lvalue, so `and g1(1'b0, a, b)` puts
// an underivable first terminal on the gate. `and g1(o, a, b)` compiles
// (probed).
//
// VerA accepts this file (with W0252, "gate primitive accepted, and it
// computes nothing", which it gives every gate primitive).
//
//! lrm A.3.3
//! reject net_lvalue
//! xfail VerA accepts `and g1(1'b0, a, b)` with a constant as the output terminal; A.3.3 says "output_terminal ::= net_lvalue", and a constant is not one
module annex_a_constant_output_terminal(o, a, b);
  output o;
  input a, b;
  wire o, a, b;
  and g1(1'b0, a, b);        // illegal: the output terminal is not a net_lvalue
endmodule
