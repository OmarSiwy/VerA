// A.3.1, A.3.3 and A.3.4, observed. 56_gate_instantiation_unsupported.va and
// gate_instantiation_one_input.va spell gate instances, but their only check
// reads the testbench bias, so they pass whatever the gates compute. Here each
// gate's output is read against its truth table.
//
//     n_input_gate_instance ::= [ name_of_gate_instance ]                 // A.3.1
//             ( output_terminal , input_terminal { , input_terminal } )
//     n_output_gate_instance ::= [ name_of_gate_instance ]
//             ( output_terminal { , output_terminal } , input_terminal )
//     enable_gate_instance ::= [ name_of_gate_instance ]
//             ( output_terminal , input_terminal , enable_terminal )
//     output_terminal ::= net_lvalue    input_terminal ::= expression     // A.3.3
//     n_input_gatetype ::= and | nand | or | nor | xor | xnor            // A.3.4
//     n_output_gatetype ::= buf | not
//     enable_gatetype ::= bufif0 | bufif1 | notif0 | notif1
//
// WHAT IS SPELLED. Every n_input gatetype, one of them (`and g1`) with ONE
// input (the `{ , input_terminal }` repetition taken zero times), and one with
// three; both n_output gatetypes, `buf` with two outputs; and `bufif1`. One
// instance has no name (the bracket of A.3.1 omitted), and one input terminal
// is an expression, `a & b` (A.3.3).
//
// DERIVATION. IEEE 1364-2005 §7.2 Tables 7-3 and 7-4 (and/nand/or/nor/xor/
// xnor), §7.3 Table 7-5 (buf, not), §7.4 Table 7-6 (bufif1). The inputs step
// through (a, b) = (0, 0), (0, 1), (1, 0), (1, 1) at 1, 11, 21 and 31 ns (from
// 1 ns, so every process waits on its event control before the first change);
// with no gate delay each output settles in its own time step. The initial
// block checks the outputs, packed MSB first, at 6, 16, 26 and 36 ns (a check
// is a $strobe: it reads the end of its time step; checking in the digital half
// keeps the count exact, where an analog-block check also prints at every point
// the mixed run inserts at a digital event). The packing is
// {g1, and, nand, or, nor, xor, xnor, and3, b1, b2, nt, bif}:
//
//   g1 = and(a)          = a
//   and3 = and(a, b, a&b) = a & b
//   b1 = b2 = buf(a), nt = not(a), bif = bufif1(data a, enable 1) = a
//
//   (a,b) | g1 and nand or nor xor xnor and3 b1 b2 nt bif | value
//   (0,0) |  0   0   1   0   1   0   1    0   0  0  1   0  | 0b001010100010 =  674
//   (0,1) |  0   0   1   1   0   1   0    0   0  0  1   0  | 0b001101000010 =  834
//   (1,0) |  1   0   1   1   0   1   0    0   1  1  0   1  | 0b101101001101 = 2893
//   (1,1) |  1   1   0   1   0   0   1    1   1  1  0   1  | 0b110100111101 = 3389
//
// A gate dropped leaves its output undriven (z), and a z bit makes the
// comparison x (ok=x fails). Four verdicts. W0252 says the analog device
// computes no gate; the digital half of the mixed run does, and that is what
// is read.
//
//! lrm A.3
//! lrm A.3.1
//! lrm A.3.3
//! lrm A.3.4
//! lrm A.3.1:1000
//! lrm A.3.3:1000
//! lrm A.3.4:1000
//! analysis tran
//! time 0, 40n
//! checks 4
`timescale 1ns/1ns
`include "check.vh"
module b8_gate_instantiation_truth_table(p);
  inout p; electrical p;
  reg a, b, one;
  wire g1, w_and, w_nand, w_or, w_nor, w_xor, w_xnor, w_and3, b1, b2, nt, bif;

  and    g1i (g1, a);
  and    ga  (w_and, a, b);
  nand   gn  (w_nand, a, b);
  or     go  (w_or, a, b);
  nor    gnr (w_nor, a, b);
  xor        (w_xor, a, b);
  xnor   gxn (w_xnor, a, b);
  and    g3  (w_and3, a, b, a & b);
  buf    gb  (b1, b2, a);
  not    gnt (nt, a);
  bufif1 gbf (bif, a, one);

  initial begin
    #1 one = 1'b1;
    a = 1'b0; b = 1'b0;
    #5 `CHECKI("(a,b)=(0,0): {g1,and,nand,or,nor,xor,xnor,and3,b1,b2,not,bufif1}",
               ({g1, w_and, w_nand, w_or, w_nor, w_xor, w_xnor, w_and3, b1, b2, nt, bif}), 674);
    #5 b = 1'b1;
    #5 `CHECKI("(a,b)=(0,1)",
               ({g1, w_and, w_nand, w_or, w_nor, w_xor, w_xnor, w_and3, b1, b2, nt, bif}), 834);
    #5 a = 1'b1; b = 1'b0;
    #5 `CHECKI("(a,b)=(1,0)",
               ({g1, w_and, w_nand, w_or, w_nor, w_xor, w_xnor, w_and3, b1, b2, nt, bif}), 2893);
    #5 b = 1'b1;
    #5 `CHECKI("(a,b)=(1,1)",
               ({g1, w_and, w_nand, w_or, w_nor, w_xor, w_xnor, w_and3, b1, b2, nt, bif}), 3389);
  end

  analog I(p) <+ V(p);
endmodule
