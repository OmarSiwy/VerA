// A.6.8's THIRD production is the digital one, and `forever` appears in it and
// nowhere else in the annex:
//
//     loop_statement ::=
//             forever statement
//             | repeat ( expression ) statement
//             | while ( expression ) statement
//             | for ( variable_assignment ; expression ; variable_assignment ) statement
//
// Two things follow, and this file pins the second. `analog_loop_statement` is
// the closed list `repeat | while | for`, and A.6.4's `analog_statement` reaches
// `analog_loop_statement` and never `loop_statement` — `loop_statement` is
// reachable only from `statement`, which is the digital arm's body. So a
// `forever` inside an `analog` block is not derivable from the grammar at all,
// and a conforming compiler MUST refuse it. That is the mirror of
// 61_looping_statements.va, which takes the analog-function arm of the same
// clause: the file pair is what separates "the analog grammar has three loop
// forms" from "the digital grammar has four".
//
// E0256 names that rule (A.6.8, with annex G.2.1's retirement in its
// explanation). Until 2026-10 the refusal came from the parser's generic E0209
// "expected an expression: found `forever`", the right verdict for no stated
// reason.
//
// A `forever` in DIGITAL context, inside an `initial` block, is the legal use of
// the same keyword: 63_digital_statements_in_initial.va runs one.
//
//! lrm A.6.8
//! lrm A.6.4
//! lrm A.6.4:1000
//! lrm A.6.8:1000
//! reject-only E0256
//! neighbour 61_looping_statements.va
`include "check.vh"
module annex_a_forever_rejected(p, n);
    inout p, n;
    electrical p, n;

    analog begin
        forever I(p, n) <+ V(p, n);
    end
endmodule
