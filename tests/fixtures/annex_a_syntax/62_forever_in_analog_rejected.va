// A.6.8's THIRD production is the digital one, and `forever` appears in it and
// nowhere else in the annex:
//
//     loop_statement ::=
//             forever statement
//             | repeat ( expression ) statement
//             | while ( expression ) statement
//             | for ( variable_assignment ; expression ; variable_assignment ) statement
//
// Two things follow, and this file pins the second. `analog_loop_statement` is
// the closed list `repeat | while | for`, and A.6.4's `analog_statement` reaches
// `analog_loop_statement` and never `loop_statement` — `loop_statement` is
// reachable only from `statement`, which is the digital arm's body. So a
// `forever` inside an `analog` block is not derivable from the grammar at all,
// and a conforming compiler MUST refuse it. That is the mirror of
// 61_looping_statements.va, which takes the analog-function arm of the same
// clause: the file pair is what separates "the analog grammar has three loop
// forms" from "the digital grammar has four".
//
// The refusal is CORRECT and the diagnostic is not: VerA reports E0209 "expected
// an expression: found `forever`", which is the parser's generic complaint and
// not a considered statement that a digital loop has no analog form (the same
// E0209 that tests/fixtures/annex_a_syntax/COVERAGE.md at 8b1514d4's rejection section calls out for `force`, `fork`,
// `wait` and `#5`). The fixture pins the code that fires today; a better
// diagnostic should name the rule.
//
// A `forever` in DIGITAL context — inside an `initial` or `always` — is the
// legal use of the same keyword and has no fixture here: VerA refuses `always`
// and `initial` at the module-item dispatch (probe: E0205 "unsupported module
// item: found always"), which is the A.6.2 row's gap and not this clause's.
//
//! lrm A.6.8
//! lrm A.6.4
//! reject E0209
`include "check.vh"
module annex_a_forever_rejected(p, n);
    inout p, n;
    electrical p, n;

    analog begin
        forever I(p, n) <+ V(p, n);
    end
endmodule
