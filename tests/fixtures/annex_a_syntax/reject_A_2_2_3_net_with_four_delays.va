// A.2.2.3:
//
//     delay3 ::=
//             # delay_value
//             | # ( mintypmax_expression [ , mintypmax_expression [ , mintypmax_expression ] ] )
//
// A net's delay3 has at most three values (rise, fall, turn-off).
// `#(1, 2, 3, 4)` has four. `wire #(1, 2, 3) w;` compiles (probed).
//
// VerA reports E0210 "expected ')': found `,`" at the fourth value.
//
//! lrm A.2.2.3
//! reject E0210
module annex_a_net_four_delays(o, a);
  output o;
  input a;
  wire #(1, 2, 3, 4) w;      // illegal: delay3 has at most three values
  wire o, a;
  buf g1(w, a);
  buf g2(o, w);
endmodule
