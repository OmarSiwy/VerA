// A.8.1 expression composites: a concatenation and the four operator forms
// built on top of it. Every digit below is fixed by Clause 4 and none of them
// depends on the operating point except the last.
//
// §4.2.13: "concatenations ... shall be expressed using the brace characters
// { }, with commas separating the expressions within" and the operands are
// packed left to right, so
//
//     {4'b1010, 4'b0101}  =  8'b1010_0101  =  165
//
// From that one value:
//   §4.2.9  ~165  = -166   — an integer is a 32-bit signed quantity (§3.4), so
//                            the bitwise complement is -(165 + 1)
//   §4.2.11 165<<1 = 330   — a left shift fills with zeros
//   §4.2.9  165 & 8'h0f = 5 — 1010_0101 & 0000_1111 = 0000_0101
//   §4.2.12 the conditional operator picks its first arm when the condition is
//           nonzero; V(p,n) = 0.5 by the bias, so the sign is +1.0
// Both arms are observed below, including fractional and negative real
// conditions. Always choosing the first arm or truncating a real condition
// to an integer must not satisfy the conditional-expression checks.
//
// The replication form `{2{4'b0011}}` used to live in this file and made the
// whole thing a `//! reject`, which lost the coverage of everything above.
// It is now replication.va, where it can carry its own gap marker.
//
//! lrm A.8.1
//! lrm 4.2.13
//! lrm 4.2.9
//! lrm 4.2.11
//! lrm 4.2.12
//! lrm 4.2.13:1
//! lrm 4.2.12:1
//! lrm A.8.1:1000
//! lrm A.8.6
//! lrm A.8.6:1000
//! bias V(p) = 0.5
//! print none
//! checks 8
`include "check.vh"
module annex_a_composites(p, n);
    inout p, n;
    electrical p, n;
    integer bits;
    real sign;

    analog begin
        bits = {4'b1010, 4'b0101};
        sign = (V(p, n) > 0.0) ? 1.0 : -1.0;
        `CHECKI("a concatenation packs its operands left to right", bits, 165);
        `CHECKI("bitwise complement of a 32-bit signed integer", ~bits, -166);
        `CHECKI("left shift fills with zeros", bits << 1, 330);
        `CHECKI("bitwise and with a sized literal", bits & 8'h0f, 5);
        `CHECKX("the conditional operator takes its first arm", sign, 1.0);
        `CHECKX("a zero real condition takes the second arm", (V(p, n) - 0.5) ? 1.0 : -1.0, -1.0);
        `CHECKX("a fractional real condition is true without truncation", V(p, n) ? 2.0 : -2.0, 2.0);
        `CHECKX("a negative fractional real condition is also true", -V(p, n) ? 3.0 : -3.0, 3.0);
        I(p, n) <+ sign * V(p, n);
    end
endmodule
