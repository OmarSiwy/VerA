// A.7.1:
//
//     specify_block ::= specify { specify_item } endspecify
//     specify_item ::=
//             specparam_declaration | pulsestyle_declaration
//             | showcancelled_declaration | path_declaration | system_timing_check
//
// A gate instance is a module item, not a specify_item. `buf g2(o, a);` inside
// `specify ... endspecify` is not derivable; the same gate outside the block
// is legal, and a specify block holding path declarations is accepted
// (probed).
//
// VerA reports E0207 "found `buf`, which begins no A.7.1 specify_item".
//
// `A.7` (Specify section) is cited as well: it is the heading over the
// subclause this file exercises and states no production of its own, so this
// file is evidence for it on the same reject side.
//
//! lrm A.7
//! lrm A.7.1
//! lrm A.7.1:1000
//! reject E0207
//! reject begins no A.7.1 specify_item
module annex_a_gate_in_specify(o, a);
  output o;
  input a;
  wire o, a;
  buf g1(o, a);
  specify
    buf g2(o, a);            // illegal: not a specify_item
  endspecify
endmodule
