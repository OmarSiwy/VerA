// A.7.4:
//
//     list_of_path_delay_expressions ::=
//             t_path_delay_expression
//             | trise_path_delay_expression , tfall_path_delay_expression
//             | trise_... , tfall_... , tz_path_delay_expression
//             | (six values: t01, t10, t0z, tz1, t1z, tz0)
//             | (twelve values)
//
// A path delay has 1, 2, 3, 6 or 12 values. `(1, 2, 3, 4)` has four, which no
// alternative derives. The six-value form in the same position is accepted
// (probed).
//
// VerA accepts this file (W0251: the specify block is read and nothing in it
// is modelled).
//
//! lrm A.7.4
//! reject path delay
//! xfail VerA accepts the four-value path delay `(a => o) = (1, 2, 3, 4);`; A.7.4's list_of_path_delay_expressions allows 1, 2, 3, 6 or 12 values
module annex_a_four_path_delays(o, a, b);
  output o;
  input a, b;
  wire o, a, b;
  and g1(o, a, b);
  specify
    (a => o) = (1, 2, 3, 4);  // illegal: four delay values
  endspecify
endmodule
