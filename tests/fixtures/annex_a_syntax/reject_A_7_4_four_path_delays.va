// A.7.4:
//
//     list_of_path_delay_expressions ::=
//             t_path_delay_expression
//             | trise_path_delay_expression , tfall_path_delay_expression
//             | trise_... , tfall_... , tz_path_delay_expression
//             | (six values: t01, t10, t0z, tz1, t1z, tz0)
//             | (twelve values)
//
// A path delay has 1, 2, 3, 6 or 12 values. `(1, 2, 3, 4)` has four, which no
// alternative derives. The six-value form in the same position is accepted
// (probed).
//
// VerA refuses the delay list with E0207 "a path delay lists 1, 2, 3, 6 or
// 12 values".
//
//! lrm A.7.4
//! lrm A.7.4:1000
//! reject-only path delay
//! reject endspecify
//! neighbour b8_specify_path_delay_mintypmax_list.va
module annex_a_four_path_delays(o, a, b);
  output o;
  input a, b;
  wire o, a, b;
  and g1(o, a, b);
  specify
    (a => o) = (1, 2, 3, 4);  // illegal: four delay values
  endspecify
endmodule
