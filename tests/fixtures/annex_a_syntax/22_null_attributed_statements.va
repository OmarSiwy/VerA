// Attribute instances may precede a null statement and a statement (LRM 2.9.1,
// Annex A.9.x); they are parsed and skipped, so this must COMPILE — and the
// statement AFTER an attributed null statement must still be the statement the
// author wrote.
//
// The attributed null is written in the one place A.6.4 derives it: an
// `analog_statement_or_null` arm of a conditional. A free-standing
// `(* explicit_null *) ;` at the head of an `analog_seq_block` is exactly as
// underivable as a bare `;`, and G.2.2 made that form obsolete — it is pinned
// by annex_g_change_history/09_null_statement_unconditional_rejected.va.
//
// Biased at V(p) = -0.5 the condition is false, so the else arm runs and the
// probe read after the conditional must still be -0.5: an attribute swallowed
// together with the following statement, or a null arm that consumed the next
// statement, changes what runs here. -0.5 is exact in binary, so the assertion
// is `CHECKX`.
//
//! lrm 2.9.1
//! lrm A.6.4
//! lrm G.2.2
//! bias V(p) = -0.5
//! print none
`include "check.vh"
module annex_a_null_attr(p); inout p; electrical p;
analog begin
    if(V(p)>0.0) (* conditional_null *) ; else (* contribution_attr *) I(p)<+V(p);
    `CHECKX("the statement after an attributed null arm still runs", V(p), -0.5);
end
endmodule
