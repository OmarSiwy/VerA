// A.5.1:
//
//     udp_declaration ::=
//             { attribute_instance } primitive udp_identifier ( udp_port_list ) ;
//                 udp_port_declaration { udp_port_declaration }
//                 udp_body
//             endprimitive
//
// udp_body (a combinational or sequential `table ... endtable`) is mandatory.
// This primitive declares its ports and ends. The same primitive with a
// two-row table parses (the table form is accepted up to instantiation; see
// reject_A_5_4_udp_three_delays.va).
//
// VerA reports E0207 "found endprimitive: a udp_body is a `table … endtable`".
//
// `A.5` (UDP declaration and instantiation) is cited as well: it is the heading over the
// subclause this file exercises and states no production of its own, so this
// file is evidence for it on the same reject side.
//
//! lrm A.5
//! lrm A.5.1
//! lrm A.5.1:1000
//! reject-only E0207
//! reject a udp_body is a
//! neighbour b8_udp_declared_and_instantiated.va
primitive annex_a_udp_no_table(o, a);
  output o;
  input a;
endprimitive                 // illegal: no udp_body

// A module, so the file is a complete design without instantiating the UDP.
module annex_a_udp_no_table_host(o, a);
  output o;
  input a;
  wire o, a;
  buf g1(o, a);
endmodule
