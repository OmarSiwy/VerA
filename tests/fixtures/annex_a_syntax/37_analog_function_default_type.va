// A.2.6 `analog_function_declaration ::= analog function [ analog_function_type ]
// analog_function_identifier ; ...` — the type is OPTIONAL, and §4.7.1 fixes
// what its absence means: "The analog_function_type specifies the return value
// of the function; its use is optional. type can be real, integer, or string;
// if unspecified, the default is real."
//
// Every analog function in the rest of the suite writes `real` explicitly, so a
// compiler that defaulted to `integer` passed all 859 fixtures. Here `sq` has
// no type at all and must still return a real: at V(p,n) = 1.5 the answer is
// 2.25, and an integer default truncates it to 2, failing by 0.25 — far outside
// any plausible tolerance. 1.5 and 2.25 are both exact in binary, so the
// assertion is `CHECKX` and not a tolerance.
//
// 04_analog_function.va is the same shape with the type written out; the pair
// is what makes the omission the only difference under test — including the
// two-line formal declaration, which is the only form A.2.6 derives (its
// `input_declaration` admits a net_type, not `real`; see 04's header).
//
//! lrm A.2.6
//! lrm 4.7.1
//! lrm 4.7.1:2
//! lrm A.2.6:1000
//! bias V(p) = 1.5
//! print none
`include "check.vh"
module annex_a_function_default_type(p, n);
    inout p, n;
    electrical p, n;

    analog function sq;
        input x;
        real x;
        sq = x * x;
    endfunction

    analog begin
        `CHECKX("an analog function with no declared type returns real", sq(V(p, n)), 2.25);
        I(p, n) <+ sq(V(p, n));
    end
endmodule
