// A.8.6 Operators, spelled out and evaluated:
//
//     unary_operator ::=
//             + | - | ! | ~ | & | ~& | | | ~| | ^ | ~^ | ^~
//     binary_operator ::=
//             + | - | * | / | % | == | != | === | !== | && | || | **
//             | < | <= | > | >= | & | | | ^ | ^~ | ~^ | >> | << | >>> | <<<
//     unary_module_path_operator ::=
//             ! | ~ | & | ~& | | | ~| | ^ | ~^ | ^~
//     binary_module_path_operator ::=
//             == | != | && | || | & | | | ^ | ^~ | ~^
//
// THIS IS A CENSUS WITH VALUES, not a parse. Every binary spelling above that is
// legal in an analog block is written below and checked against a number a human
// derived from §4 — Clause 4 is what defines what they MEAN, this clause is only
// the list. The spellings of the same list that are NOT below, and why:
//
//   * `&`, `~&`, `|`, `~|`, `^`, `~^`, `^~` in the UNARY list are the reduction
//     operators, and §4.2.10 says in as many words that they "can not be used
//     inside the analog block and only have meaning when used in the digital
//     context". A conforming compiler must refuse them here, so a fixture for
//     them is a `//! reject` and belongs to §4.2.10's row, not this one. The
//     unary spellings that ARE legal — `+ - ! ~` — are below.
//   * `<<<` and `>>>` are §4.2.11's arithmetic shifts, which "can not be used in
//     an analog block" either. `<<` and `>>` are the logical pair and are the
//     two shift operators this file uses.
//   * `===` and `!==` are legal in the analog context when the operands are
//     4-state (§7.3.2's list, which §4.2.6 points at) and VerA refuses them
//     anyway; that gap is real, it is about this same clause, and it has its own
//     file: 66_case_equality_in_analog.va.
//   * the module-path operator lists are digital-only by construction — they
//     belong to `module_path_expression`, which no analog production reaches —
//     so nothing in an analog block can spell them. `*>` and `=>` (A.7.2) are
//     where they would appear, and 63/64 are the files that record that section.
//
// THE THREE NEGATING OPERATORS READ NEGATIVE, AND THAT IS THE IEEE ANSWER, NOT A
// TYPO. `~4'b0101` is -6 below and not 10. The destination of an assignment
// fixes the width its right-hand side is evaluated at, and §4.2 leaves that rule
// to IEEE Std 1364 rather than restating it: an `integer` is 32 bits, so the
// 4-bit operand is zero-extended to 0x00000005 BEFORE the complement, and
// 0xFFFFFFFA is -6 read back as two's complement. The 4-bit answer, 1010, is
// what the same operator gives in a 4-bit context — a different expression.
// `&`, `|`, `^`, `<<`, `>>`, `%` and `**` do not care, because their results
// happen to fit under bit 4 either way; `~`, `^~` and `~^` do, and they are the
// three worth writing down for exactly that reason. (Width determination is
// ch04_expressions' subject; what is claimed HERE is that the spelling exists
// and that these are the values it produces.)
//
// `^~` AND `~^` ARE ONE OPERATOR WITH TWO SPELLINGS — the clause lists both, at
// two different positions in the same alternative — and the two assertions that
// read -7 in the same breath are what proves it: a lexer that read `a ~^ b` as
// the unary `~` applied to `a ^ b` would get a different number, and one that
// read `^~` as `^` followed by `~` would not compile the line at all. `~^`
// appears in `binary_operator` and in `binary_module_path_operator`, `^~` in all
// four lists.
//
//! lrm A.8.6
//! lrm 4.2.10
//! lrm 4.2.11
//! lrm 4.2
//! lrm 4.2:1000
//! lrm A.8.6:1000
//! bias V(p) = 0.75, V(n) = 0.25
`include "check.vh"
module annex_a_operators(p, n);
    inout p, n;
    electrical p, n;

    integer lhs, rhs;
    integer un;

    analog begin
        lhs = 12;
        rhs = 10;
        un = 5;

        `CHECKI("binary +", lhs + rhs, 22);
        `CHECKI("binary -", lhs - rhs, 2);
        `CHECKI("binary *", lhs * rhs, 120);
        `CHECKX("binary / on reals", 6.0 / 4.0, 1.5);
        `CHECKI("binary %", 7 % 3, 1);
        `CHECKI("binary **", 2 ** 3, 8);
        `CHECKI("binary >", (3 > 2), 1);
        `CHECKI("binary >=", (2 >= 3), 0);
        `CHECKI("binary <", (3 < 4), 1);
        `CHECKI("binary <=", (3 <= 3), 1);
        `CHECKI("binary ==", (3 == 3), 1);
        `CHECKI("binary !=", (3 != 4), 1);
        `CHECKI("binary &&", (1 && 0), 0);
        `CHECKI("binary ||", (1 || 0), 1);
        `CHECKI("binary &", 4'b1100 & 4'b1010, 8);
        `CHECKI("binary |", 4'b1100 | 4'b1010, 14);
        `CHECKI("binary ^", 4'b1100 ^ 4'b1010, 6);
        `CHECKI("binary ^~", 4'b1100 ^~ 4'b1010, -7);
        `CHECKI("binary ~^ is the same operator as ^~", 4'b1100 ~^ 4'b1010, -7);
        `CHECKI("binary <<", un << 2, 20);
        `CHECKI("binary >>", un >> 1, 2);
        `CHECKI("unary +", +un, 5);
        `CHECKI("unary -", -un, -5);
        `CHECKI("unary !", !0, 1);
        `CHECKI("unary ~", ~4'b0101, -6);

        I(p, n) <+ V(p, n);
    end
endmodule
