// A.3.2:
//
//     pullup_strength ::=
//             ( strength0 , strength1 )
//             | ( strength1 , strength0 )
//             | ( strength1 )
//
// A pullup's single-strength form names a 1-side strength (it drives a 1).
// `pullup (strong0)` names a 0-side strength alone, which only pulldown_strength
// derives. `pullup (strong1) p1(o);` compiles (probed).
//
// VerA reports E0207 "a single-strength bracket on this gate is A.3.2's
// `( strength1 )`".
//
//! lrm A.3.2
//! lrm A.3.2:1000
//! reject-only E0207
//! reject single-strength bracket
//! neighbour b8_pull_gate_strength_resolves.va
module annex_a_pullup_zero_strength(o);
  output o;
  wire o;
  pullup (strong0) p1(o);    // illegal: a pullup's lone strength is a 1-side one
endmodule
