// A.5.1-A.5.4, observed: a combinational and a sequential UDP, each instanced
// and read. 58_udp_declaration_unsupported.va declares a UDP it never uses,
// 59_udp_instantiation_unsupported.va and udp_named_instance_delay2.va instance
// one, and all three check only the testbench bias.
//
//     udp_declaration ::= { attribute_instance } primitive udp_identifier
//             ( udp_port_list ) ; udp_port_declaration { udp_port_declaration }
//             udp_body endprimitive | ...                              // A.5.1
//     udp_output_declaration ::= { attribute_instance } output port_identifier
//             | ... output reg port_identifier [ = constant_expression ]
//     udp_reg_declaration ::= { attribute_instance } reg variable_identifier
//                                                                      // A.5.2
//     udp_body ::= combinational_body | sequential_body                // A.5.3
//     sequential_body ::= [ udp_initial_statement ] table sequential_entry
//             { sequential_entry } endtable
//     udp_instantiation ::= udp_identifier [ drive_strength ] [ delay2 ]
//             udp_instance { , udp_instance } ;                        // A.5.4
//     udp_instance ::= [ name_of_udp_instance ] ( output_terminal ,
//             input_terminal { , input_terminal } )
//
// IEEE 1364-2005 (inherited through §1.1). §8.2: a combinational UDP's output
// is the table row its inputs match. §8.4's `d_edge_ff`, used here verbatim
// with §8.5's initial statement added: (01) on clock loads data, (?0) and data
// changes on a steady clock keep the state. §8.5: "a delay specification on an
// instantiated UDP does not delay the simulation time of the assignment of this
// initial value to the output." §8.6: "Only two delays may be specified because
// z is not supported for UDPs"; §7.14's delay2 is (rise, fall).
//
// WHAT IS SPELLED. A.5.4: a named instance (m0), an unnamed one, a
// `delay2 ::= # delay_value` instance (m3, #3) and a `# ( rise , fall )` one
// (f1, #(1, 2)). A.5.2: `output q; reg q;` in a sequential UDP. A.5.3: a level
// table with `?`, an edge table with (01), (0?), (?0) and (??), and an initial
// statement.
//
// DERIVATION (`timescale 1ns/1ns). mux: o = s ? b : a.
//   t = 0:  q = 0 from the initial statement; every other output is x.
//   t = 1:  s=0 a=1 b=0 clk=0 d=0. om = om2 = a = 1; om3 = 1 at 4 (#3);
//           clk x->0 and d x->0 match the (?0) and (??) rows: q holds 0.
//   t = 11: s=1: om = om2 = b = 0; om3 = 0 at 14.
//   t = 16: d 0->1 on a steady clock: (??), q holds 0. (d moves a step
//           before clk so no clock edge shares a time step with its data.)
//   t = 21: clk 0->1 with d=1: q = 1 at 22 (rise 1).
//   t = 31: d=0, b=1: om = om2 = 1, om3 = 1 at 34; q holds (steady clock).
//   t = 41: clk 1->0: (?0), q holds.
//   t = 51: clk 0->1 with d=0: q = 0 at 53 (fall 2).
// A second initial block checks {om, om2, om3, q} (MSB first) at these ticks.
// A check is a $strobe, which displays when "all the simulation events have
// occurred for that simulation time" (IEEE 1364 §17.1.2), so a tick shows the
// updates scheduled for it:
//   6 1110=14  12 0010=2  14 0000=0  21 0000=0  22 0001=1
//   36 1111=15  46 1111=15  52 1111=15  53 1110=14
// Nine verdicts; ticks 12, 21 and 52 see the instance delays. W0252 says the
// analog device computes no primitive; the digital half of the mixed run does,
// and checking there also keeps the count exact (an analog-block check prints
// at every point the mixed run inserts at a digital event).
//
//! lrm A.5
//! lrm A.5.1
//! lrm A.5.2
//! lrm A.5.3
//! lrm A.5.4
//! lrm A.2.2.3
//! lrm A.5.1:1000
//! lrm A.5.2:1000
//! lrm A.5.3:1000
//! lrm A.5.4:1000
//! analysis tran
//! time 0, 60n
//! checks 9
`timescale 1ns/1ns
`include "check.vh"
module b8_udp_declared_and_instantiated(p);
  inout p; electrical p;
  reg s, a, b, clk, d;
  wire om, om2, om3, q;

  b8_udp_mux m0 (om, s, a, b);
  b8_udp_mux (om2, s, a, b);
  b8_udp_mux #3 m3 (om3, s, a, b);
  b8_udp_dff #(1, 2) f1 (q, clk, d);

  initial begin
    #1 s = 1'b0; a = 1'b1; b = 1'b0; clk = 1'b0; d = 1'b0;
    #10 s = 1'b1;
    #5 d = 1'b1;
    #5 clk = 1'b1;
    #10 d = 1'b0; b = 1'b1;
    #10 clk = 1'b0;
    #10 clk = 1'b1;
  end

  initial begin
    #6  `CHECKI("t=6 {om,om2,om3,q}: a passes, q from the initial statement", ({om, om2, om3, q}), 14);
    #6  `CHECKI("t=12 s=1 passes b; om3 still waits out #3", ({om, om2, om3, q}), 2);
    #2  `CHECKI("t=14 om3 follows", ({om, om2, om3, q}), 0);
    #7  `CHECKI("t=21 clock rose; q waits out its rise delay 1", ({om, om2, om3, q}), 0);
    #1  `CHECKI("t=22 q loaded d = 1", ({om, om2, om3, q}), 1);
    #14 `CHECKI("t=36 b=1 passed; q held on a steady clock", ({om, om2, om3, q}), 15);
    #10 `CHECKI("t=46 q held through the falling clock", ({om, om2, om3, q}), 15);
    #6  `CHECKI("t=52 clock rose with d = 0; q waits out its fall delay 2", ({om, om2, om3, q}), 15);
    #1  `CHECKI("t=53 q loaded d = 0", ({om, om2, om3, q}), 14);
  end

  analog I(p) <+ V(p);
endmodule

primitive b8_udp_mux (o, s, a, b);
  output o;
  input s, a, b;
  table
  // s a b : o
     0 0 ? : 0 ;
     0 1 ? : 1 ;
     1 ? 0 : 0 ;
     1 ? 1 : 1 ;
  endtable
endprimitive

primitive b8_udp_dff (q, clock, data);
  output q; reg q;
  input clock, data;
  initial q = 1'b0;
  table
  // clock data : q : q+
     (01)    0  : ? : 0 ;
     (01)    1  : ? : 1 ;
     (0?)    1  : 1 : 1 ;
     (0?)    0  : 0 : 0 ;
     (?0)    ?  : ? : - ;
      ?    (??) : ? : - ;
  endtable
endprimitive
