// A.1.3 `port ::= [ port_expression ] | . port_identifier ( [ port_expression ] )`
//
// The second alternative gives a port an EXTERNAL name that differs from the
// internal net it connects to: `.ext(inner)` is a port called `ext` to whoever
// instantiates the module, wired to the net `inner` inside it. §6.5.1 lists the
// four things a port expression may be, the first being "a simple net
// identifier", and §6.5.2 declares the internal net's type and direction in the
// body as usual.
//
// Every `.name(x)` in the suite today is an INSTANTIATION-side named connection
// (§6.5.5, annex_e_spice); the module-header form has no user.
//
// What the fixture demands once it parses: the internal name is what behavioral
// code sees, so V(inner, n) is the biased 0.6 - 0.1. Neither operand is
// representable in binary but their difference is exactly 0.5 (verified), so
// this is `CHECKX`.
//
// A run fixture, not a `//! reject`: A.1.3 makes this legal.
//
//! lrm A.1.3
//! lrm 6.5.1
//! lrm 6.5.2
//! bias V(inner) = 0.6
//! bias V(n) = 0.1
//! print none
//! xfail VerA's header parser has no named-port form: `.ext(inner)` in a list of ports is E0208 "expected an identifier: found `.`"
`include "check.vh"
module annex_a_named_port(.ext(inner), n);
    inout inner, n;
    electrical inner, n;

    analog begin
        `CHECKX("a named port's INTERNAL name is what the body probes", V(inner, n), 0.5);
        I(inner, n) <+ V(inner, n);
    end
endmodule
