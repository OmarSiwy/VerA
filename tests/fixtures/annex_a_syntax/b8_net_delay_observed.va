// A.2.2.3's delay3, observed: each net below lags its driver by the delay its
// declaration or assignment writes. 55_net_delay_unsupported.va declares
// `wire #5 w;` but its only check reads the bias, and nothing drives w there.
//
//     delay3 ::= # delay_value | # ( mintypmax_expression
//             [ , mintypmax_expression [ , mintypmax_expression ] ] )  // A.2.2.3
//     delay_value ::= unsigned_number | real_number | identifier
//     net_declaration ::= ... | net_type [ discipline_identifier ]
//             [ drive_strength ] [ signed ] [ delay3 ] list_of_net_identifiers ;
//                                                                      // A.2.1.3
//     continuous_assign ::= assign [ drive_strength ] [ delay3 ]
//             list_of_net_assignments ;                                // A.6.1
//
// IEEE 1364-2005 §6.1.3 (inherited through §1.1): "A delay given to a
// continuous assignment shall specify the time duration between a right-hand
// operand value change and the assignment made to the left-hand side. If the
// left-hand references a scalar net, then the delay shall be treated in the
// same way as for gate delays", i.e. (rise, fall). And: "wire #10 wireA; This
// syntax, called a net delay, means that any value change that is to be
// applied to wireA by some other statement shall be delayed for ten time units
// before it takes effect."
//
// WHAT IS SPELLED, one form per net:
//   w    `wire #5 w;` plus `assign w = a;`   a net delay, unsigned_number
//   wr   `assign #(2, 6) wr = a;`            the parenthesised two-value form:
//                                            rise 2, fall 6
//   wc   `assign #3 wc = a;`                 `# delay_value` on an assign
//   wp   `assign #d wp = a;`, d = 4          delay_value as an identifier
// The same delay on a net_decl_assignment, `wire #(2, 6) wd = a;`, is
// b8_net_decl_assignment_refused.va's (an xfail).
//
// DERIVATION (`timescale 1ns/1ns). a = 0 from 1 ns, 1 from 11 ns, 0 from 31 ns.
// The x -> 0 at 1 ns settles every net by 7 ns. Rising edges land at wr 13,
// wc 14, wp 15, w 16; falling edges at wc 34, wp 35, w 36, wr 37. A second
// initial block checks {w, wr, wc, wp} (MSB first) at the ticks below. A check
// is a $strobe, which displays at "the end of the current simulation time, when
// all the simulation events have occurred for that simulation time" (IEEE 1364
// §17.1.2), so after the update a delay scheduled for that tick; checking in the
// digital half keeps the count exact, where an analog-block check also prints
// at every point the mixed run inserts at a digital event.
//
//   10  0000 =  0      12  0000 =  0 (a is 1, nothing has arrived)
//   13  0100 =  4      14  0110 =  6     15  0111 =  7    16  1111 = 15
//   32  1111 = 15 (a is 0, nothing has arrived)
//   34  1101 = 13      35  1100 = 12     36  0100 =  4    37  0000 =  0
//
// A delay dropped makes that net follow a at once: tick 12 reads 15, not 0.
// Eleven verdicts.
//
//! lrm A.2.2.3
//! lrm A.2.1.3
//! lrm A.6.1
//! lrm A.2.2.3:1000
//! lrm A.2.1.3:1000
//! lrm A.6.1:1000
//! analysis tran
//! time 0, 40n
//! checks 11
`timescale 1ns/1ns
`include "check.vh"
module b8_net_delay_observed(p);
  inout p; electrical p;
  parameter integer d = 4;
  reg a;
  wire #5 w;
  wire wr, wc, wp;
  assign w = a;
  assign #(2, 6) wr = a;
  assign #3 wc = a;
  assign #d wp = a;

  initial begin
    #1 a = 1'b0;
    #10 a = 1'b1;
    #20 a = 1'b0;
  end

  initial begin
    #10 `CHECKI("t=10 {w,wr,wc,wp}", ({w, wr, wc, wp}), 0);
    #2  `CHECKI("t=12 a rose at 11, nothing has arrived", ({w, wr, wc, wp}), 0);
    #1  `CHECKI("t=13 wr rose (rise 2)", ({w, wr, wc, wp}), 4);
    #1  `CHECKI("t=14 wc rose (#3)", ({w, wr, wc, wp}), 6);
    #1  `CHECKI("t=15 wp rose (#d, d = 4)", ({w, wr, wc, wp}), 7);
    #1  `CHECKI("t=16 w rose (net delay 5)", ({w, wr, wc, wp}), 15);
    #16 `CHECKI("t=32 a fell at 31, nothing has arrived", ({w, wr, wc, wp}), 15);
    #2  `CHECKI("t=34 wc fell", ({w, wr, wc, wp}), 13);
    #1  `CHECKI("t=35 wp fell", ({w, wr, wc, wp}), 12);
    #1  `CHECKI("t=36 w fell", ({w, wr, wc, wp}), 4);
    #1  `CHECKI("t=37 wr fell (fall 6)", ({w, wr, wc, wp}), 0);
  end

  analog I(p) <+ V(p);
endmodule
