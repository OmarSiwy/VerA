// A.8.2 writes a user function call with every argument present:
//
//     analog_function_call ::= analog_function_identifier { attribute_instance }
//             ( analog_expression { , analog_expression } )
//
// There is no `_or_null` slot, so `add2(, 1.0)` derives from nothing. Only a
// system function call (`$f(a, , c)`) and the slots A.6.5 and A.8.2 write
// `_or_null` take an empty argument. The grammar diff found the same shape in
// a misspelled probe: `Vp(, n)` names no access function, so it is a call of
// `Vp` with an empty first argument, and VerA's parser used to take it and
// fail later on an unknown function.
//
// VerA refuses the empty slot with E0289 at the parse; the code is pinned. The
// legal neighbour writes `add2(2.0, 1.0)`.
//
//! lrm A.8.2
//! lrm A.8.2:1000
//! reject-only E0289
//! neighbour function_call_takes_every_argument.va
`include "check.vh"
module annex_a_function_call_arguments(p, n);
    inout p, n;
    electrical p, n;

    analog function real add2;
        input a, b;
        real a, b;
        add2 = a + b;
    endfunction

    analog begin
        `CHECKX("add2(, 1.0)", add2(, 1.0), 3.0);    // illegal: an empty argument
        `CHECKX("add2(V(p, n), 1.0) at V(p, n) = 0.5", add2(V(p, n), 1.0), 1.5);
        I(p, n) <+ V(p, n);
    end
endmodule
