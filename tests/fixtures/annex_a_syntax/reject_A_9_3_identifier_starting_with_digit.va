// A.9.3:
//
//     simple_identifier ::= [ a-zA-Z_ ] { [ a-zA-Z0-9_$ ] }
//
// The first character of a simple identifier is a letter or an underscore.
// `1x` starts with a digit, so `real 1x;` declares nothing derivable (the
// lexer sees the number 1 followed by the identifier x). `real x1;` is legal.
//
// VerA reports E0208 "expected an identifier: found 1".
//
//! lrm A.9.3
//! lrm A.9.3:1000
//! lrm A.10
//! lrm A.10:2
//! reject-only E0208
//! neighbour 70_identifier_details_positive.va
`include "disciplines.vams"
module annex_a_identifier_digit_first(p, n);
  inout p, n;
  electrical p, n;
  real 1x;                   // illegal: an identifier cannot start with a digit
  analog I(p, n) <+ V(p, n);
endmodule
