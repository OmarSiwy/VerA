// A.8.4 `primary` — the expression leaves this file ASSERTS a value for:
// an array word select `array[0]`, a branch probe `V(path)` on a named branch
// (A.8.9 `branch_reference`), an analog function call, and a system function
// call `$pow` (§4.3.1 Table 4-14, C `pow`).
//
// The values are pinned by the bias: `branch (p,n) path` names the (p,n) pair,
// so §5.5.1 makes V(path) the potential difference V(p) - V(n) = 0.5.
// A word select of a real array yields that element (§3.2 declares the array),
// and `identity` returns its input unchanged (§4.7.2.1 the function's own name
// is its return storage), so both must read back 0.5. $pow(0.5, 3.0) = 1/8 =
// 0.125.
//
// The tolerance is 1e-15 rather than exact: 0.7 and 0.2 are not representable
// in binary, so the subtraction lands on 0.49999999999999994 (5.6e-17 low) and
// the cube on 0.12499999999999996 (4.2e-17 low). Both are one or two ulp, far
// inside 1e-15 and far outside any tolerance that would hide a real error.
//
// `I(path)` IS GONE, and must not come back. §5.4.2.1: "If no value is
// specified for either the potential or the flow, the branch is a probe. If the
// flow of the branch appears in an expression anywhere in the module, the branch
// is a flow probe... Using both the potential and the flow of a probe branch is
// illegal." The named branch `path` is never contributed to — the contribution
// below is `I(p, n)`, the UNNAMED branch over the same pair, which §5.4.1 makes
// a different branch ("There can only be one unnamed branch between any two
// nets ... in addition to any number of named branches"). So `path` is a probe,
// and reading both V(path) and I(path) made the module illegal. Worse, under
// the conforming reading the I(path) read turned `path` into a flow probe,
// whose "branch potential ... is zero (0)" — which falsifies the 0.5 asserted
// below and the two values derived from it.
//
// THE PORT PROBE `I(<p>)` IS PRESENT AND UNASSERTED, deliberately. A.8.2
// `port_probe_function_call` is exercised — it lexes, lowers, and feeds the
// contribution — but §5.4.3 defines the flow through a port as the current the
// EXTERNAL circuit pushes into it, and a standalone operating point with
// nothing attached to `p` does not fix that number. Asserting the 0.0 this
// harness happens to leave in the unknown would pin the harness, not the LRM.
// The header used to list the port probe among the primaries this file covers,
// with no assertion behind the claim; it needs a fixture with a driven port.
//
// The header used to cite "§3.9" for a real array word select; §3.9 is
// Disciplines of primitives.
//
//! lrm A.8.2
//! lrm A.8.4
//! lrm A.8.9
//! lrm 5.5.1
//! lrm 5.4.2.1
//! lrm 4.7.2.1
//! lrm 3.2
//! lrm A.8.2:1000
//! lrm A.8.4:1000
//! lrm A.8.9:1000
//! bias V(p) = 0.7
//! bias V(n) = 0.2
`include "check.vh"
module annex_a_primaries(p, n);
  inout p, n;
  electrical p, n;
  branch (p, n) path;
  real array[0:1];
  real result;

  analog function real identity;
    input x;
    real x;
    identity = x;
  endfunction

  analog begin
    array[0] = V(path);
    array[1] = I(<p>);
    `CHECK("named branch probe", V(path), 0.5, 1e-15);
    `CHECK("word select through an analog function call", identity(array[0]), 0.5, 1e-15);
    `CHECK("system function call on a word select", $pow(array[0], 3.0), 0.125, 1e-15);
    result = identity(array[0]) + $pow(array[1], 2.0);
    I(p, n) <+ result;
  end
endmodule
