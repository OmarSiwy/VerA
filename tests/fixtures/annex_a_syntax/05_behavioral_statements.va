// Annex A.6.4-A.6.7 behavioral statements, traced by hand at V(p,n) = 1:
//
//   result = 0.0
//   index  = 0
//   if (1 > 0)                       result = 1.0
//   case (index)                     index is 0 -> the `0:` arm runs, result = 2.0
//   for (index = 0; index < 2; ...)  result += 0 then += 1  -> 3.0, index = 2
//   while (index < 3)                index = 3
//   repeat (2)                       result += 1.0 twice    -> 5.0
//
// `index` is checked separately because its final value depends only on the
// loop bounds, not on any initializer: the `for` must leave 2 and the `while`
// must then run exactly once.
//
// WHY `index = 0;` IS WRITTEN OUT. The case selector used to read `index`
// before anything assigned it, and the header justified want=5.0 by the
// zero-initialisation rule. That is right for the FIRST execution only. §3.2
// initialises a variable "at the start of a simulation"; §5.6.1.3 contrasts a
// branch value, "only valid for the current iteration", with variables, which
// retain; and §5.2 says the analog block "shall be executed at every point in a
// simulation". So on the second evaluation `index` still holds the 3 the
// `while` left, the case falls to `default` (+3 instead of +1) and a conforming
// iterating simulator computes 7.0. It passed only because this harness
// evaluates the block once from a fresh state. Assigning the selector makes the
// number true on every evaluation; the §3.2 rule itself belongs in a fixture
// that asserts it directly, not in the middle of a six-statement trace.
//
// A.6.7 `analog_case_item ::= ... | default [ : ]` makes the colon after
// `default` OPTIONAL, and it is written without one here — the only place in
// the suite that exercises that half of the production.
//
// The header used to cite "LRM 3.3.1" for the initialisation rule; there is no
// §3.3.1 (§3.3 is String data type) and the rule is §3.2.
//
// `A.6` (Behavioral statements) is cited as well: it is the heading over the
// subclause this file exercises and states no production of its own, so this
// file is evidence for it on the same positive side.
//
//! lrm A.6
//! lrm 5.1
//! lrm A.6.4
//! lrm A.6.6
//! lrm A.6.7
//! lrm 5.8.3
//! lrm 5.9
//! lrm A.6.4:1000
//! lrm A.6.6:1000
//! lrm A.6.7:1000
//! lrm A.6.8
//! lrm A.6.8:1000
//! bias V(p) = 1.0
//! print none
`include "check.vh"
module annex_a_behavioral_statements(p, n);
    inout p, n;
    electrical p, n;
    integer index;
    real result;

    analog begin : behavior
        result = 0.0;
        index = 0;
        if (V(p, n) > 0.0)
            result = 1.0;
        else
            result = -1.0;
        case (index)
            0: result = result + 1.0;
            1, 2: result = result + 2.0;
            default result = result + 3.0;
        endcase
        for (index = 0; index < 2; index = index + 1)
            result = result + index;
        while (index < 3)
            index = index + 1;
        repeat (2)
            result = result + 1.0;
        `CHECKX("if + case + for + repeat accumulate to 5", result, 5.0);
        `CHECKI("for leaves index at its bound, while raises it to 3", index, 3);
        I(p, n) <+ result;
    end
endmodule
