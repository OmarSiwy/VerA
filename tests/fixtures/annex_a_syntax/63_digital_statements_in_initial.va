// The legal neighbour of 30, 32, 33, 34 and 62. Those files put a digital
// statement in an `analog` block, where A.6.4's `analog_statement` does not
// derive it (E0258, E0249, E0255, E0254, E0256). The same statements inside an
// `initial` block are A.6.4's digital `statement` and must run, so the five
// refusals are refusals of a position, not of the constructs.
//
//   A.6.5 wait_statement:  `wait (a) f = 1;` blocks until a goes 1 at t = 10,
//                          so f = 1 from t = 10 on (IEEE 1364-2005 9.7.6).
//   A.6.8 forever:         `forever #4 n = n + 1;` increments at t = 4, 8, 12,
//                          16, 20, ... (9.6), so n = 4 on 16 < t < 20.
//   A.6.3 par_block:       `fork #3 k = 1; #5 k = k + 10; join` starts both
//                          statements at t = 0 (9.8.2): k = 1 at t = 3, k = 11
//                          at t = 5, and the join completes at t = 5, so
//                          tj = $time = 5. Run as a begin/end the delays add:
//                          k = 11 at t = 8 and tj = 8.
//   A.6.5 delay_control:   every `#` above.
//   A.6.2 force:           ch08_scheduling/procedural_continuous_semantics.va.
//
// Delays are in the default time unit, 1 s (no `timescale). The values are
// pinned at t = 18, clear of every digital event (16 and 20 bracket it),
// behind a `$abstime > 17` guard; every earlier point, including the ones the
// mixed runner inserts at digital events, asserts the wanted literal against
// itself, so no point depends on the order §8.4.1 leaves open between an
// analog solve and a digital event at the same time. No `//! checks`: the
// point count is the runner's choice of inserted points, not this clause's.
//
//! lrm A.6.4
//! lrm A.6.3
//! lrm A.6.5
//! lrm A.6.8
//! analysis tran
//! time 0, 18
`include "check.vh"
module annex_a_digital_statements_in_initial(p);
  inout p; electrical p;
  reg a, f; integer n, k, tj;
  initial begin a = 1'b0; #10 a = 1'b1; end
  initial begin f = 1'b0; wait (a) f = 1'b1; end
  initial begin n = 0; forever #4 n = n + 1; end
  initial begin k = 0; tj = 0; fork #3 k = 1; #5 k = k + 10; join tj = $time; end
  analog begin
    `CHECKI("wait released at a's rise", ($abstime > 17.0) ? f : 1'b1, 1);
    `CHECKI("forever ran four periods", ($abstime > 17.0) ? n : 4, 4);
    `CHECKI("fork ran both arms", ($abstime > 17.0) ? k : 11, 11);
    `CHECKI("join waited for the longer arm only", ($abstime > 17.0) ? tj : 5, 5);
    I(p) <+ V(p);
  end
endmodule
