// Annex A preamble and A.1.1/A.1.2, printed p. 355:
// Design source derives from source_text; its description alternatives do not
// contain library_declaration. Library-map declarations require library_text.
// This negative does not test the missing library-map reader interface.
//! lrm A.1.1
//! lrm A.1.2
//! lrm A
//! lrm A:1000
//! lrm A.1.2:1000
//! reject-only E0232
library audit_library ".";
module audit_library_declaration_in_design_rejected;
endmodule
