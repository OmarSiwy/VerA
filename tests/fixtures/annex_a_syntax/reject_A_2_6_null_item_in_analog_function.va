// A.2.6:
//
//     analog_function_declaration ::= analog function [ analog_function_type ]
//             analog_function_identifier ;
//             analog_function_item_declaration { analog_function_item_declaration }
//             analog_function_statement
//         endfunction
//
// Every item ends in its own `;`, and A.6.4's analog_function_statement has no
// null alternative, so a `;` standing alone between `input x;` and `real x;`
// derives from nothing. The legal neighbour has no such `;`.
//
// VerA refuses it with E0219, the null-statement code (an A.6.4
// analog_function_statement is where the parser reads it); the code is pinned.
//
//! lrm A.2.6
//! lrm A.2.6:1000
//! lrm A.6.4
//! reject-only E0219
//! neighbour analog_function_formal_typed_by_item.va
`include "check.vh"
module annex_a_function_formal_typed(p, n);
    inout p, n;
    electrical p, n;

    analog function real twice;
        input x;
        ;                         // illegal: no null item
        real x;
        twice = 2.0 * x;
    endfunction

    analog begin
        `CHECKX("twice(V(p, n)), x typed by its own item", twice(V(p, n)), 1.0);
        I(p, n) <+ V(p, n);
    end
endmodule
