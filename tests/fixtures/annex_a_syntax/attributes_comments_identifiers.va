// §2.8.1 escaped identifiers: `\punctuated+identifier ` is the single
// identifier `punctuated+identifier` — the backslash and the terminating
// whitespace are not part of the name, and the `+` is not an operator. Both
// mentions below must therefore resolve to ONE variable; a lexer that stopped
// the identifier at the `+` would read back 0.0 (or fail to compile).
//
// `+ 0.0` is not decoration: VerA's preprocessor trims each macro argument
// (lib/frontend/preprocessor.zig:741), which eats the whitespace that TERMINATES
// an escaped identifier, so a bare `\punctuated+identifier ` as the last token
// of an argument goes on to swallow the `)` that follows it. Anything after the
// identifier restores the terminator.
//
// The header used to cite "LRM 2.7", which is String literals.
//
//! lrm A.9.1
//! lrm A.9.2
//! lrm A.9.3
//! lrm 2.8.1
//! lrm A.9.3:1000
//! print none
`include "check.vh"
(* annex = "A.9" *)
module annex_a_general(p, n);
    // line comment
    /* block comment */
    inout p, n;
    electrical p, n;
    real \punctuated+identifier ;

    analog begin
        \punctuated+identifier  = 1.0;
        `CHECKX("escaped identifier names one variable", \punctuated+identifier + 0.0, 1.0);
        I(p, n) <+ \punctuated+identifier ;
    end
endmodule
