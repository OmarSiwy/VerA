// A.1.2 `module_keyword ::= module | macromodule`, observed through what the
// macromodule bodies contribute. 43_macromodule.va has one analog macromodule,
// but its only check reads the bias across its own ports, which no body
// statement can change.
//
//     module_declaration ::= { attribute_instance } module_keyword module_identifier
//             [ module_parameter_port_list ] list_of_ports ; { module_item }
//             endmodule | ...                                          // A.1.3
//     module_keyword ::= module | macromodule                          // A.1.2
//
// IEEE 1364-2005 §12.1: "The keyword macromodule can be used interchangeably
// with the keyword module to define a module. An implementation may choose to
// treat module definitions beginning with the macromodule keyword
// differently." The second sentence licenses a different implementation (such
// as inlining), not a different design: the keywords are interchangeable. So
// three macromodules here must elaborate, take parameter overrides and
// contribute exactly as modules would.
//
// DERIVATION. The top is a macromodule with no ports and one internal node a,
// solved by the testbench (`//! solve`). Instance s is a Thevenin source,
// I(x) <+ (V(x) - v0)/rs with v0 = 1 and rs overridden to 1 kOhm; instance l is
// a load, I(x) <+ V(x)/rl with rl overridden to 3 kOhm. KCL at a:
//
//     (V - 1)/1000 + V/3000 = 0  ->  3(V - 1) + V = 0  ->  V(a) = 3/4 = 0.75
//
// A macromodule that elaborated with its default rs = rl = 1 MOhm gives 0.5, one
// whose contribution was dropped gives 1.0 or 0.0. 0.75 is exact in binary; the
// 1e-12 bound only absorbs the Newton solve.
//
//! lrm A.1.2
//! lrm A.1.2:1000
//! solve
//! checks 1
`include "check.vh"
macromodule b8_macromodule_contributes;
  electrical a;
  b8_mm_source #(.rs(1k)) s(a);
  b8_mm_load #(.rl(3k)) l(a);
  analog
    `CHECK("two macromodule instances divide 1 V into 3/4", V(a), 0.75, 1e-12);
endmodule

macromodule b8_mm_source(x);
  inout x; electrical x;
  parameter real v0 = 1.0;
  parameter real rs = 1M;
  analog I(x) <+ (V(x) - v0) / rs;
endmodule

macromodule b8_mm_load(x);
  inout x; electrical x;
  parameter real rl = 1M;
  analog I(x) <+ V(x) / rl;
endmodule
