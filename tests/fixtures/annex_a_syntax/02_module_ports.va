// Annex A.1.3 / §6.5.2 `list_of_port_declarations`: an ANSI-style module port
// list declares direction (§6.5.2.2) and discipline (§6.5.2.1) in the header
// itself. The assertion pins that each header-declared port binds to the node
// the testbench biases: V(sense) = 0.7 and V(common) = 0.2 make the input
// branch probe 0.5 V. Swap two port bindings and the number moves.
//
// Not exactly 0.5: neither 0.7 nor 0.2 is representable in binary and the
// difference lands on 0.49999999999999994, one ulp low — hence the 1e-15
// tolerance rather than `CHECKX`. (23_expression_primaries.va does the same
// arithmetic and says the same thing.)
//
// The header used to cite "LRM 3.5" for ANSI ports; §3.5 is Genvars.
//
//! lrm A.1.3
//! lrm 6.5.2
//! lrm A.1.3:1000
//! lrm A.2.1.2
//! lrm A.2.1.2:1000
//! bias V(sense) = 0.7
//! bias V(common) = 0.2
//! print none
`include "check.vh"
module annex_a_module_ports(input electrical sense, output electrical drive, inout electrical common);
    analog begin
        `CHECK("ANSI-declared input port probes its own node", V(sense, common), 0.5, 1e-15);
        V(drive, common) <+ V(sense, common);
    end
endmodule
