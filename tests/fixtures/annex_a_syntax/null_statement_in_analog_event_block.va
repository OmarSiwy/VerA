// A.6.4's analog_event_statement has a null alternative, and the block form of
// an event body takes analog_event_statements, so a `;` is legal inside it:
//
//     analog_event_control_statement ::= analog_event_control
//             analog_event_statement                                  // A.6.4
//     analog_event_statement ::= ... | { attribute_instance }
//             analog_event_seq_block | ... | { attribute_instance } ;  // A.6.4
//     analog_event_seq_block ::= begin [ : analog_block_identifier
//             { analog_block_item_declaration } ]
//             { analog_event_statement } end                          // A.6.3
//
// Annex G.2.2: "Certain functions such as case, conditionals and the event
// statement do allow null statements as defined by the syntax." A plain
// `analog_seq_block` takes `{ analog_statement }`, which has no null:
// 09_null_statement_unconditional_rejected.va (E0219) is that refusal, and it
// still holds outside the event block below.
//
// DERIVATION. steps = 0, then the initial_step body (which fires on the first
// point of any analysis, 06_event_control.va) runs its two increments around
// three null statements, one of them in a nested event block: steps = 2.
//
//! lrm A.6.4
//! lrm A.6.3
//! lrm G.2.2
//! lrm A.6.4:1000
//! bias V(p) = 1.0
//! print none
//! checks 1
`include "check.vh"
module null_statement_in_analog_event_block(p, n);
    inout p, n;
    electrical p, n;
    integer steps;

    analog begin
        steps = 0;
        @(initial_step) begin
            ;
            steps = steps + 1;
            begin
                ;
                steps = steps + 1;
            end
            ;
        end
        `CHECKI("both increments ran past the event block's null statements", steps, 2);
        I(p, n) <+ steps * V(p, n);
    end
endmodule
