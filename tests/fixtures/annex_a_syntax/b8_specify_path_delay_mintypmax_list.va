// A.7.4's constant_mintypmax_expression arm, in the three places a specify
// block takes it: a specparam's value, a bare path delay, and the entries of a
// parenthesised path delay list.
//
//     path_delay_value ::= list_of_path_delay_expressions
//             | ( list_of_path_delay_expressions )
//     path_delay_expression ::= constant_mintypmax_expression          // A.7.4
//     specparam_assignment ::= specparam_identifier =
//             constant_mintypmax_expression | ...                      // A.2.4
//     constant_mintypmax_expression ::= constant_expression
//             | constant_expression : constant_expression : constant_expression
//                                                                      // A.8.3
//
// So each of these derives:
//     specparam tr = 1:2:3;                 (A.2.4, in a specify block, A.7.1)
//     (c => q1) = 1:2:3;                    (the bare arm, one value)
//     (c => q2) = (1:2:3, 2:3:4);           (the parenthesised arm, rise/fall)
//     (c => q3) = (tr, tr);                 (specparams holding min:typ:max)
// IEEE 1364-2005 §14.3.1's own example writes the first and the last
// (`specparam tRise_clk_q = 45:150:270, ...` then
// `(clk => q) = (tRise_clk_q, tFall_clk_q);`).
//
// WHAT IS NOT CLAIMED. No delay is observed: VerA applies none (W0251), and
// every check is 15 ns after the last change of c, past the largest max (4),
// so a simulator that applies them reads the same values. §14.1: the specify
// block assigns delays to paths; each q is the assign's value, q = c.
//
// DERIVATION. c = 0 from 1 ns, 1 from 21 ns. {q1, q2, q3} = 0 at 16 ns and
// 3'b111 = 7 at 36 ns, checked from a digital initial block. Two verdicts.
//
//! lrm A.7.4
//! lrm A.2.4
//! lrm A.7.4:1000
//! warn W0251
//! xfail E0207 at the first `:`: a constant_mintypmax_expression is refused everywhere in a .va specify block, as a specparam value, a bare path delay and a parenthesised list entry (each probed alone), though A.7.4 and A.2.4 derive each and the .v path takes them (ieee1364/14_specify_blocks/b_14_3_1_mintypmax_path_delays.v)
//! analysis tran
//! time 0, 40n
//! checks 2
`timescale 1ns/1ns
`include "check.vh"
module b8_specify_path_delay_mintypmax_list(p);
  inout p; electrical p;
  reg c;
  wire t1, t2, t3;

  b8_pdm_cell u(c, t1, t2, t3);

  initial begin
    #1 c = 1'b0;
    #20 c = 1'b1;
  end

  initial begin
    #16 `CHECKI("t=16 c=0: {q1,q2,q3}", ({t1, t2, t3}), 0);
    #20 `CHECKI("t=36 c=1: {q1,q2,q3}", ({t1, t2, t3}), 7);
  end

  analog I(p) <+ V(p);
endmodule

module b8_pdm_cell(c, q1, q2, q3);
  input c;
  output q1, q2, q3;
  assign q1 = c;
  assign q2 = c;
  assign q3 = c;
  specify
    specparam tr = 1:2:3;
    (c => q1) = 1:2:3;
    (c => q2) = (1:2:3, 2:3:4);
    (c => q3) = (tr, tr);
  endspecify
endmodule
