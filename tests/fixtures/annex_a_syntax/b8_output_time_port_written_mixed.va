// A.2.1.2's `output output_variable_type` arm with A.2.2.1's `time`, written by
// a delayed initial block, so the digital half of a mixed run executes it.
//
//     output_declaration ::= ... | output output_variable_type
//             list_of_variable_port_identifiers                        // A.2.1.2
//     output_variable_type ::= integer | time                         // A.2.2.1
//
// The arm declares the port as a VARIABLE (A.2.3's
// list_of_variable_port_identifiers), so a procedural assignment may write it:
// IEEE 1364-2005 §9.2 (inherited through §1.1) makes the left-hand side of a
// procedural assignment a variable, and an `initial` block is a digital
// procedural context (§7.2.2). `output integer o` takes the same arm and the
// same run executes it (probed); b8_output_variable_port_written.va shows both
// arms on the dc path, where the initial block runs before the analysis.
//
// DERIVATION (`timescale 1ns/1ns). t = 12 at 1 ns; checked at 2 ns as the flag
// (t == 12), so the check needs no 64-bit print: 1. One verdict.
//
//! lrm A.2.1.2
//! lrm A.2.2.1
//! lrm A.2.1.2:1000
//! lrm A.2.2.1:1000
//! xfail E1100 "a net is driven by a continuous assignment; there is no procedural assignment to a net" at `t = 12`: the digital half of the mixed run treats a top-level `output time t` port as a net (`output integer o` runs)
//! analysis tran
//! time 0, 10n
//! checks 1
`timescale 1ns/1ns
`include "check.vh"
module b8_output_time_port_written_mixed(p, t);
  inout p; electrical p;
  output time t;
  initial begin
    #1 t = 12;
    #1 `CHECKI("an output time port holds the 12 written to it", (t == 12), 1);
  end
  analog I(p) <+ V(p);
endmodule
