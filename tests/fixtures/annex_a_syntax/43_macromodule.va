// A.1.2 `module_keyword ::= module | macromodule`. The two keywords are
// interchangeable at the head of a module_declaration, and nothing in Annex C
// removes the second from Verilog-A — C.16's keyword exclusions are the
// connect/wreal family, not this.
//
// The only macromodule in the suite is annex_b_keywords/11_macromodule_keyword.va,
// which is a DIGITAL body (`assign b = a;`) pinned to a VerA refusal, so it
// says nothing about the analog case and reads as though macromodule itself
// were out of the subset. This file is a plain analog macromodule: if the
// keyword is interchangeable, a body that works under `module` works here too.
//
// V(p) - V(n) = 0.75 - 0.25 = 0.5, all three exact in binary, so the gain-2
// contribution and the probe are both exactly representable and `CHECKX` is
// justified.
//
// A run fixture, not a `//! reject`: A.1.2 makes this legal.
//
//! lrm A.1.2
//! bias V(p) = 0.75
//! bias V(n) = 0.25
//! print none
//! xfail VerA refuses the keyword outright: E0201 "construct is not in the supported subset: `macromodule`"
`include "check.vh"
macromodule annex_a_macromodule(p, n);
    inout p, n;
    electrical p, n;

    analog begin
        `CHECKX("a macromodule body behaves exactly as a module body", V(p, n), 0.5);
        I(p, n) <+ 2.0 * V(p, n);
    end
endmodule
