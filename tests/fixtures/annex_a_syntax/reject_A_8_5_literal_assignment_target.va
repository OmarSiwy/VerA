// A.8.5's lvalues all open with a name or a `{`:
//
//     analog_variable_lvalue ::= variable_identifier
//             | variable_identifier [ analog_expression ] { [ analog_expression ] }
//     variable_lvalue ::= hierarchical_variable_identifier [ ... ]
//             | { variable_lvalue { , variable_lvalue } }
//
// so `2.0 = 2.0 * V(p, n);` assigns to nothing. The grammar diff found the
// digital twin, `#d 20 = 1'bx;`, which VerA's parser took with no diagnostic.
// The legal neighbour, named_block_declares.va, assigns the same value to x.
//
// VerA refuses the literal target with E0207 and a message naming A.8.5; both
// are pinned.
//
//! lrm A.8.5
//! lrm A.8.5:1000
//! reject-only E0207
//! reject-only assignment target is a variable
//! neighbour named_block_declares.va
`include "check.vh"
module annex_a_named_block_declares(p, n);
    inout p, n;
    electrical p, n;

    analog begin : body
        real x;
        2.0 = 2.0 * V(p, n);      // illegal: a literal is no lvalue
        `CHECKX("x, declared in the named block, holds 2 * V(p, n)", x, 1.0);
        I(p, n) <+ x / 1000.0;
    end
endmodule
