// A.5.1, A.5.2 and A.5.3 in one declaration:
//
//     udp_declaration ::=                                                  // A.5.1
//             { attribute_instance } primitive udp_identifier ( udp_port_list ) ;
//                 udp_port_declaration { udp_port_declaration }
//                 udp_body
//             endprimitive
//     udp_port_declaration ::=                                             // A.5.2
//             udp_output_declaration ; | udp_input_declaration ; | udp_reg_declaration ;
//     udp_output_declaration ::= { attribute_instance } output port_identifier
//     udp_input_declaration ::= { attribute_instance } input list_of_port_identifiers
//     udp_body ::= combinational_body | sequential_body                    // A.5.3
//     combinational_body ::= table combinational_entry { combinational_entry } endtable
//     combinational_entry ::= level_input_list : output_symbol ;
//
// This is the FIRST arm of `udp_declaration` — a bare `udp_port_list` in the
// header, with the ports declared separately inside the body — and it is the
// only place in the annex where a `table` appears. The `0 : 1;` entries are
// `combinational_entry`s: a `level_input_list` of one symbol, an output symbol,
// and the `;` the production ends with.
//
// AN INVERTER, deliberately the smallest table that is still a table. A
// zero-entry `table endtable` would parse the same way and say less; two entries
// make the `{ combinational_entry }` repetition do work. The sequential form
// (`udp_initial_statement`, `edge_indicator`, `current_state : next_state`) is
// the other arm of `udp_body` and is NOT spelled here — a UDP stops at its first
// bad row and the header records the arm rather than pretending the one file
// covers both.
//
// §1.1 makes the complete IEEE Std 1364 Verilog part of Verilog-AMS HDL, and a
// user-defined primitive is 1364's primitive-composition mechanism — the thing a
// digital cell is written in when a gate is not enough. VerA used to refuse the
// keyword at the top-level dispatch: E0201 "construct is not in the supported
// subset: `primitive`", which was a subset refusal rather than a parse error and
// so an xfail and not a `//! reject`. A.1.2 is the sharper argument and the one
// that settles it — `description ::= module_declaration | udp_declaration |
// config_declaration | …` puts `udp_declaration` in the list of things a
// `source_text` IS, so the refusal was of text derivable from the starting
// symbol a `.va` is compiled against.
//
// THE TABLE IS VALIDATED, WHICH IS THE PART WORTH SAYING. A.5.3's symbols are
// CHARACTERS and not tokens — `(01)` is four symbols and three tokens, `0 0` is
// two of each, `b` is a symbol and an identifier — so the entries are judged
// over the characters of their tokens, column by column, against the three
// alphabets the clause enumerates. What that buys, measured on the two `.v`
// fixtures that asked for it in writing:
//
//     ieee1364/08_udp/d08_reject_udp_z_output.v    E0233 "`z` is not a UDP output symbol"
//     ieee1364/08_udp/d08_reject_udp_comb_edge.v   E0234 "an edge indicator `(` in a
//                                          combinational UDP table entry"
//
// Both files say, at length, that a bare `DiagnosticsReported` would have been
// satisfied by a parser that merely tripped over the port list, and ask for a
// refusal that names the rule. These two codes are the ones they asked to be
// allocated.
//
// AND NOTHING IS RECORDED. The declaration parses, the table is checked and
// dropped: there is no discrete engine here to evaluate it. The instantiation
// site is where that is announced (W0252, 59_udp_instantiation_unsupported.va),
// because a primitive nobody instantiates contributes nothing either way — an
// uninstantiated module is silent for the same reason.
//
// `A.5` (UDP declaration and instantiation) is cited as well: it is the heading over the
// subclauses this file exercises and states no production of its own. What
// this file proves for it is the GRAMMAR — the UDP parses and the file runs its
// analog assertion — not a behaviour: an instance of the UDP reaches no device (W0252). The behaviour is
// run under the discrete engine by tests/fixtures/ieee1364/08_udp/d08_udp_comb.v.
//
//! lrm A.5
//! lrm A.5.1
//! lrm A.5.2
//! lrm A.5.3
//! lrm A.1.2
//! lrm 1.1
//! bias V(p) = 0.75, V(n) = 0.25
`include "check.vh"
primitive annex_a_udp_pulse (o, a);
    output o;
    input a;
    table
        0 : 1;
        1 : 0;
    endtable
endprimitive

module annex_a_udp_host(p, n);
    inout p, n;
    electrical p, n;

    analog begin
        `CHECKX("the file carrying the A.5.1 UDP declaration compiles and runs",
                V(p, n), 0.5);
        I(p, n) <+ V(p, n);
    end
endmodule
