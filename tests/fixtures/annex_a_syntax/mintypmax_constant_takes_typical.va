// A.8.3's min:typ:max expression in the constant places Annex A writes one,
// observed by reading the values.
//
//     constant_mintypmax_expression ::= constant_expression
//             | constant_expression : constant_expression : constant_expression
//                                                                      // A.8.3
//     param_assignment ::= parameter_identifier =
//             constant_mintypmax_expression { value_range }           // A.2.4
//     defparam_assignment ::= hierarchical_parameter_identifier =
//             constant_mintypmax_expression                           // A.2.4
//     specparam_assignment ::= specparam_identifier =
//             constant_mintypmax_expression | ...                     // A.2.4
//     named_parameter_assignment ::=
//             . parameter_identifier ( [ mintypmax_expression ] )     // A.4.1
//     constant_primary ::= ... | ( constant_mintypmax_expression )   // A.8.4
//
// IEEE 1364-2005 §5.3 (inherited through §1.1): the three values "represent
// minimum, typical, and maximum values—in that order", and "The min:typ:max
// format can be used wherever expressions can appear". Its Example 1,
// `(a:b:c) + (d:e:f)`, has "the typical value is b+e". §5.3 leaves the choice
// of member to the tool; VerA takes the typical one everywhere
// (specification/Vague_Decisions.md VD-099), so this file tests that choice, and a tool
// that picks another member also conforms.
//
// DERIVATION, every value exact in binary:
//   a  = 1.0 : 2.0 : 3.0                         -> 2.0
//   b  = (1.0 : 2.0 : 3.0) + (4.0 : 5.0 : 6.0)   -> 2.0 + 5.0 = 7.0 (Example 1)
//   c  = 10 : 20 : 30 from [0:inf)               -> 20, inside its range
//   sp = 3 : 6 : 9 (a module-scope specparam)    -> 6
//   scaled(2.0), whose local `k = 1.0 : 3.0 : 5.0` -> 3.0 * 2.0 = 6.0
//     (A.2.8 puts parameter_declaration among an analog function's items)
//   u1: `#(.g(1.0 : 4.0 : 9.0))`                 -> g = 4.0
//   u2: `defparam u2.g = 0.5 : 0.25 : 1.0;`      -> g = 0.25
// Five checks in the top, one in each child: seven verdicts. A tool that read
// the minimum would print 1.0, 5.0, 10, 3, 2.0, 1.0, 0.5; the maximum 3.0,
// 9.0, 30, 9, 10.0, 9.0, 1.0.
//
// MODULE ORDER IS LOAD-BEARING: the first module is the device (see
// 12_defparam.va).
//
//! lrm A.8.3
//! lrm A.2.4
//! lrm A.4.1
//! lrm A.8.4
//! lrm A.8.3:1000
//! lrm A.2.4:1000
//! lrm A.4.1:1000
//! lrm A.8.4:1000
//! bias V(p) = 1.5
//! bias V(n) = 0.5
//! checks 7
`include "check.vh"
module annex_a_mintypmax_constant(p, n);
    inout p, n;
    electrical p, n;
    parameter real a = 1.0 : 2.0 : 3.0;
    localparam real b = (1.0 : 2.0 : 3.0) + (4.0 : 5.0 : 6.0);
    parameter integer c = 10 : 20 : 30 from [0:inf);
    specparam sp = 3 : 6 : 9;

    analog function real scaled;
        input x;
        real x;
        parameter real k = 1.0 : 3.0 : 5.0;
        scaled = k * x;
    endfunction

    annex_a_mintypmax_constant_named #(.g(1.0 : 4.0 : 9.0)) u1(p, n);
    annex_a_mintypmax_constant_defparam u2(p, n);
    defparam u2.g = 0.5 : 0.25 : 1.0;

    analog begin
        `CHECKX("parameter a = 1.0 : 2.0 : 3.0 reads the typical value", a, 2.0);
        `CHECKX("(1:2:3) + (4:5:6) reads typical + typical (IEEE 1364 5.3 Example 1)", b, 7.0);
        `CHECKI("integer c = 10 : 20 : 30 from [0:inf)", c, 20);
        `CHECKI("specparam sp = 3 : 6 : 9", sp, 6);
        `CHECKX("an analog function's local parameter k = 1.0 : 3.0 : 5.0", scaled(2.0), 6.0);
    end
endmodule

module annex_a_mintypmax_constant_named(p, n);
    inout p, n;
    electrical p, n;
    parameter real g = 1.0;

    analog begin
        `CHECKX("#(.g(1.0 : 4.0 : 9.0)) gives g the typical 4.0", g, 4.0);
        I(p, n) <+ g * V(p, n);
    end
endmodule

module annex_a_mintypmax_constant_defparam(p, n);
    inout p, n;
    electrical p, n;
    parameter real g = 1.0;

    analog begin
        `CHECKX("defparam u2.g = 0.5 : 0.25 : 1.0 gives g the typical 0.25", g, 0.25);
        I(p, n) <+ g * V(p, n);
    end
endmodule
