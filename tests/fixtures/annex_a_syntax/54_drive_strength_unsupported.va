// A.2.2.2 Strengths:
//
//     drive_strength ::=
//             ( strength0 , strength1 )
//             | ( strength1 , strength0 )
//             | ( strength0 , highz1 )
//             | ( strength1 , highz0 )
//             | ( highz0 , strength1 )
//             | ( highz1 , strength0 )
//     strength0 ::= supply0 | strong0 | pull0 | weak0
//     strength1 ::= supply1 | strong1 | pull1 | weak1
//     charge_strength ::= ( small ) | ( medium ) | ( large )
//
// A strength is what `net_declaration` puts between the net type and the
// identifier (`net_type [ discipline_identifier ] [ drive_strength ] [ signed ]
// [ delay3 ] list_of_net_decl_assignments`, A.2.1.3's second arm) and what the
// gate instantiations of A.3.1 take; `charge_strength` is the `trireg` arm's.
// The file spells the first `drive_strength` arm, `( strength1 , strength0 )` in
// the grammar's second position — `(strong1, pull0)` — on a net that is assigned
// as it is declared, so the declaration and A.2.4's `net_decl_assignment` are
// reached in one line.
//
// NEITHER OTHER PRODUCTION IS SPELLED: `charge_strength` is `trireg`'s alone
// and a `pulldown (strong0)` is A.3.2's, which is
// 57_primitive_strengths_unsupported.va.
//
// A CORRECTION TO THIS HEADER'S OWN PROBE, which claimed that `trireg (small)
// tr;` reported the same E0208 as the line below. It did not, and it does not:
// `charge_strength` has been read at exactly this position for as long as the
// net types have had tags. Only `drive_strength` was missing, so the two
// brackets were never one gap, and the sentence that said they were had the
// clause right and the measurement wrong.
//
// HOW THE TWO ARE TOLD APART, now that both are read at the same `(`: every one
// of A.2.2.2's six `drive_strength` alternatives is a PAIR and A.2.2.1's
// `charge_strength ::= ( small ) | ( medium ) | ( large )` is always one word,
// so the comma after the first strength keyword decides it in one token with no
// backtrack. A `(small, large)` is derivable from neither and keeps
// `parseChargeStrength`'s "a charge strength is only legal on a trireg".
//
// §1.1 makes the complete IEEE Std 1364 Verilog part of Verilog-AMS HDL. A
// strength is a 1364 construct (a real netlist's resolution function needs it,
// which §7.7's connect-rule work in ch07_mixed_signal is the AMS-side echo of),
// so this file was an xfail and not a `//! reject`: it states what the annex
// requires, and the marker recorded that VerA did not do it.
//
// WHAT IS PARSED AND WHAT IS NOT MODELLED. The pair reaches
// `Ast.NetDecl.strength0`/`strength1`, whose defaults are IEEE 1364-2005
// §7.10's `(strong1, strong0)` — so a net with no bracket and a net with that
// bracket are the same object, which is what the clause says they are. What
// VerA does not have is a driver-resolution function for the levels to feed;
// `src/sim/digital.zig`'s `wired()` is where one lives, and this row makes no
// claim about it.
//
//! lrm A.2.2.2
//! lrm A.2.1.3
//! lrm 1.1
//! bias V(p) = 0.75, V(n) = 0.25
`include "check.vh"
module annex_a_drive_strength(p, n);
    inout p, n;
    electrical p, n;

    wire (strong1, pull0) w = 1'b1;

    analog begin
        `CHECKX("the file carrying the strength bracket compiles and runs",
                V(p, n), 0.5);
        I(p, n) <+ V(p, n);
    end
endmodule
