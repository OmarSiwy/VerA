// A.2.1.2's THIRD arm, and the A.2.2.1 production it names:
//
//     output_declaration ::=
//             output [ discipline_identifier ] [ net_type | wreal ] [ signed ] [ range ]
//                 list_of_port_identifiers
//             | output [ discipline_identifier ] reg [ signed ] [ range ]
//                 list_of_variable_port_identifiers
//             | output output_variable_type list_of_variable_port_identifiers      // A.2.1.2
//     output_variable_type ::= integer | time                                       // A.2.2.1
//
// The first arm — a port that is a NET — is what 52_net_and_variable_types.va and
// 02_module_ports.va spell (`output wire c`, `output electrical drive`). This file
// takes the third: a port that is a VARIABLE of one of the two integral types
// 1364 gives an output port, which is what a `$strobe`-style monitor port or a
// digital driver is declared as.
//
// ONE OF THE TWO VARIABLE ARMS IS SPELLED. The middle arm (`output … reg`) used
// to be refused by the same token in the same place — probe: `output reg o;`
// reported E0208 "expected an identifier: found `reg`", `output integer o;` the
// same code naming `integer` — so a second module here would add a line, not a
// claim. The header records it instead, the way this directory's A.6.4 row
// records the eleven statements that share one production. Both arms are now
// read by one branch, which is the shape the production asks for: `[ signed ]`
// and `[ range ]` are shared by all three alternatives and the first arm's
// `[ net_type | wreal ]` is already consumed by the time the cursor gets there,
// so the keyword in this position is the only thing that tells the arms apart.
//
// A VARIABLE, NOT A NET — the half of the clause a parser can get wrong by
// accepting the syntax and recording only the direction. The name list lands in
// the module's VARIABLES as well as on the port, with the storage the arm
// names, because §6.5.2 calls this the port type declaration and A.2.3's
// `list_of_variable_port_identifiers` — the only list in A.2.1.2 carrying an
// `[ = constant_expression ]` slot — is a list of variables:
//
//     list_of_variable_port_identifiers ::= port_identifier [ = constant_expression ]
//             { , port_identifier [ = constant_expression ] }              // A.2.3
//
// WHY IT WAS AN XFAIL AND NOT A `//! reject`. §1.1: "Verilog-AMS HDL consists of
// the complete IEEE Std 1364 Verilog specification". An output port declared with
// a variable type is legal 1364 and the AMS annex admits it explicitly, so a
// conforming full-AMS compiler must ACCEPT this file; VerA's refusal was the gap
// the marker recorded. §1.2's feature list is the same claim from the other side —
// "digital signal values can be set (write operations) from any context outside
// of an analog procedural block" — which needs a digital-lvalue port to write to.
// That WRITE is not claimed here: the port is declared and the file runs, and no
// analog statement may assign it (§4.7.2/§7.2.2 own that), so this row is the
// declaration and not the digital-lvalue half of §1.2's sentence.
//
// `o` is in the port list, which is not decoration: in the non-ANSI style this
// file uses, a port declaration must name a port the header listed. Without it
// the first diagnostic is E0206 ("identifier is not a port of this module"),
// which would pin a different rule and hide this one.
//
//! lrm A.2.1.2
//! lrm A.2.2.1
//! lrm 1.1
//! bias V(p) = 0.75, V(n) = 0.25
`include "check.vh"
module annex_a_output_variable(p, n, o);
    inout p, n;
    electrical p, n;
    output integer o;

    analog begin
        `CHECKX("the file carrying the variable-typed output port compiles and runs",
                V(p, n), 0.5);
        I(p, n) <+ V(p, n);
    end
endmodule
