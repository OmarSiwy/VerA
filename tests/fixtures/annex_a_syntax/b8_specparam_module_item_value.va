// A.2.1.1's specparam_declaration as a module item, observed by reading the
// values. 49_specparam_declaration_unsupported.va declares `specparam tdr = 1.5`
// but its only check reads the bias, so the value it declares is never seen.
//
//     specparam_declaration ::= specparam [ range ] list_of_specparam_assignments ;
//                                                                      // A.2.1.1
//     list_of_specparam_assignments ::= specparam_assignment
//             { , specparam_assignment }                               // A.2.3
//     specparam_assignment ::= specparam_identifier =
//             constant_mintypmax_expression | pulse_control_specparam  // A.2.4
//
// IEEE 1364-2005 §4.10.3 (inherited through §1.1): a specparam "can appear in
// any expression that is not assigned to a parameter and is not part of the
// range specification of a declaration. Specify parameters ... are permitted
// both within the specify block ... and in the main module body." And: "A
// specify parameter declared outside a specify block shall be declared before
// it is referenced. The value assigned to a specify parameter can be any
// constant expression. A specify parameter can be used as part of a constant
// expression for a subsequent specify parameter declaration."
//
// So module-scope specparams are readable in the analog block, and one may be
// built from another.
//
// DERIVATION. All values are exact in binary.
//
//   tdr = 1.5
//   tdf = tdr * 2 + 0.25 = 3.25          (a subsequent specparam over tdr)
//   trf = 0.5, tsum = tdr + trf = 2.0    (two in one list, A.2.3)
//   the analog block reads tdr + tdf     = 4.75
//
//! lrm A.2.1.1
//! lrm A.2.3
//! lrm A.2.4
//! lrm A.2.1.1:1000
//! lrm A.2.3:1000
//! lrm A.2.4:1000
//! bias V(p) = 0.5
//! checks 4
`include "check.vh"
module b8_specparam_module_item_value(p);
  inout p; electrical p;
  specparam tdr = 1.5;
  specparam tdf = tdr * 2 + 0.25;
  specparam trf = 0.5, tsum = tdr + trf;
  analog begin
    `CHECKX("a module-scope specparam holds its value", tdr, 1.5);
    `CHECKX("a specparam built from an earlier one", tdf, 3.25);
    `CHECKX("tsum = tdr + trf, the second assignment of a two-item list", tsum, 2.0);
    `CHECKX("specparams in an analog expression", tdr + tdf, 4.75);
    I(p) <+ V(p);
  end
endmodule
