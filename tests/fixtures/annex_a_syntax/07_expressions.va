// Annex A.8 expression forms, all folded into one number by hand:
//
//   coefficients[0] + coefficients[1]   array parameter indexing (LRM 3.4.4)
//                                       = 1.0 + 2.0 = 3.0
//   2.0 ** 3.0                          power binds tighter than `*` (LRM 4.1.5
//                                       precedence table) = 8.0
//   3.0 * 8.0                           = 24.0
//   24.0 > 0.0 ? sin(24.0) : cos(24.0)  conditional operator (LRM 4.1.13)
//                                       = sin(24) = -0.9055783620066239
//
// Written with `*` applied before `**` the first line would be 6**3 = 216, and
// with the false arm taken it would be cos(24) = +0.424, so both operators are
// pinned by the one digit string.
//
//! print none
`include "check.vh"
module annex_a_expressions(p, n);
    inout p, n;
    electrical p, n;
    parameter real coefficients[0:1] = '{1.0, 2.0};
    real value;

    analog begin
        value = (coefficients[0] + coefficients[1]) * 2.0 ** 3.0;
        `CHECKX("** binds tighter than *: (1+2) * 2**3", value, 24.0);
        value = value > 0.0 ? sin(value) : cos(value);
        `CHECK("?: takes the true arm, sin(24)", value, -0.9055783620066239, 1e-15);
        I(p, n) <+ value;
    end
endmodule
