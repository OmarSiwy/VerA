// A.7.5.1-A.7.5.3, the positive half: all twelve system timing checks, each
// with a notifier, in a flop whose output and notifier are then read.
// timing_checks_unsupported.va spells four of them, but its only check
// reads the testbench bias.
//
//     system_timing_check ::= $setup_timing_check | $hold_timing_check     // A.7.5.1
//             | $setuphold_timing_check | $recovery_timing_check
//             | $removal_timing_check | $recrem_timing_check | $skew_timing_check
//             | $timeskew_timing_check | $fullskew_timing_check
//             | $period_timing_check | $width_timing_check | $nochange_timing_check
//     notifier ::= variable_identifier                                     // A.7.5.2
//     timing_check_limit ::= expression
//     threshold ::= constant_expression
//     timing_check_event ::= [ timing_check_event_control ]                // A.7.5.3
//             specify_terminal_descriptor [ &&& timing_check_condition ]
//     controlled_timing_check_event ::= timing_check_event_control
//             specify_terminal_descriptor [ &&& timing_check_condition ]
//     timing_check_event_control ::= posedge | negedge | edge_control_specifier
//     edge_control_specifier ::= edge [ edge_descriptor { , edge_descriptor } ]
//
// WHAT IS SPELLED. The twelve commands with their mandatory arguments and a
// notifier (A.7.5.1). A.7.5.2: limits as numbers and as specparams, $width's
// threshold, and the notifier `ntfr`, a variable (a reg). A.7.5.3: a
// bare data event (`d`), posedge/negedge controls, a mandatory control on a
// controlled_reference_event ($period, $width), a `&&& en` condition, and
// three edge_control_specifiers, one with z transitions.
//
// The twelve-form cell is a no-violation control. Its stimulus is
// ieee1364/15_timing_checks/
// timing_check_forms.v's, whose header derives event by event that the
// stimulus meets every one of these checks. §15.5: "Whenever a timing violation occurs,
// the timing check updates the value of the notifier", and Table 15-13 takes a
// 0 notifier to 1. With no violation the notifier keeps the 0 the cell gives it
// at 1 ns, under VerA and under a conforming simulator alike. The claim is
// that the checks are accepted, the notifier argument names a variable the
// design can read, and the flop around them runs.
//
// An independent observed_setup cell also provokes a violation. Its edge[01]
// event and &&& enable gate first suppress a one-nanosecond setup interval,
// then permit the same interval to toggle a notifier from0 to1. A later
// ten-nanosecond interval leaves it1. Thus ignoring the checks, ignoring the
// condition, or treating the expression-valued five-nanosecond limit as zero
// changes at least one assertion. The original control and new observer
// together give eight verdicts.
//
// DERIVATION (`timescale 1ns/1ns; cell: q <= d at posedge clk):
//   t = 1:   d = 1, clr = 1, en = 1, clk x -> 0, clkb x -> 1.
//   t = 100: clk rises and takes d = 1: q = 1.
//   t = 102, 200, 202: clkb falls, clk falls, clkb rises: no posedge of clk.
//   t = 250: d falls; there is no later posedge, so q stays 1.
// The cell drives its ports q and nout from the regs qr and ntfr; the top
// checks them on its wires tq and tntfr from a digital initial block at 50
// (ntfr = 0; q is still x and is not read), 150 and 300 (q = 1, ntfr = 0):
// 5 verdicts. Checking in the digital half keeps the count exact, where an
// analog-block check also prints at every point the mixed run inserts at a
// digital event.
//
//! lrm A.7.5
//! lrm A.7.5.1
//! lrm A.7.5.2
//! lrm A.7.5.3
//! lrm A.7.5.1:1000
//! lrm A.7.5.2:1000
//! lrm A.7.5.3:1000
//! analysis tran
//! time 0, 320n
//! checks 8
`timescale 1ns/1ns
`include "check.vh"
module b8_timing_checks_design_runs(p);
  inout p; electrical p;
  reg clk, clkb, d, clr, en;
  wire tq, tntfr;
  reg check_clk, check_d, check_en;
  wire check_notifier;

  b8_tc_ff u(clk, clkb, d, clr, en, tq, tntfr);
  annex_a_observed_setup checked(check_clk, check_d, check_en, check_notifier);

  initial begin
    #1 check_clk = 0; check_d = 0; check_en = 0;
    #9 check_d = 1;
    #1 check_clk = 1;
    #9 check_clk = 0; check_d = 0; check_en = 1;
    #10 check_d = 1;
    #1 check_clk = 1;
    #9 check_clk = 0; check_d = 0;
    #10 check_d = 1;
    #10 check_clk = 1;
  end

  initial begin
    #12 `CHECKI("disabled timing-check event leaves its notifier at zero", check_notifier, 0);
    #20 `CHECKI("enabled one-nanosecond setup interval toggles the notifier", check_notifier, 1);
    #29 `CHECKI("a legal ten-nanosecond interval does not toggle it again", check_notifier, 1);
  end

  initial begin
    #1 d = 1; clr = 1; en = 1; clk = 0; clkb = 1;
    #99 clk = 1;
    #2 clkb = 0;
    #98 clk = 0;
    #2 clkb = 1;
    #48 d = 0;
  end

  initial begin
    #50  `CHECKI("t=50: no check has toggled the notifier", tntfr, 0);
    #100 `CHECKI("t=150: the flop took d = 1 at the one posedge of clk", tq, 1);
    `CHECKI("t=150: notifier still 0", tntfr, 0);
    #150 `CHECKI("t=300: q holds 1 (no later posedge)", tq, 1);
    `CHECKI("t=300: the stimulus met every check, notifier still 0", tntfr, 0);
  end

  analog I(p) <+ V(p);
endmodule

module annex_a_observed_setup(clk, d, en, notification);
  input clk, d, en;
  output notification;
  reg ntfr;
  initial ntfr = 0;
  assign notification = ntfr;
  specify
    specparam setup_limit = 2 + 3;
    $setup(edge[01] d, edge[01] clk &&& en, setup_limit, ntfr);
  endspecify
endmodule

module b8_tc_ff(clk, clkb, d, clr, en, q, nout);
  input clk, clkb, d, clr, en;
  output q, nout;
  reg qr, ntfr;
  assign q = qr;
  assign nout = ntfr;
  initial #1 ntfr = 1'b0;
  always @(posedge clk) qr <= d;
  specify
    specparam tSU = 10, tH = 10;
    $setup(d, posedge clk, tSU, ntfr);
    $hold(posedge clk, d, tH, ntfr);
    $setuphold(posedge clk, d, tSU, tH, ntfr);
    $recovery(posedge clr, posedge clk, 10, ntfr);
    $removal(posedge clr, posedge clk, 10, ntfr);
    $recrem(posedge clr, posedge clk, 10, 10, ntfr);
    $skew(posedge clk, negedge clkb, 50, ntfr);
    $timeskew(posedge clk, negedge clkb, 50, ntfr);
    $fullskew(posedge clk, negedge clkb, 50, 50, ntfr);
    $period(posedge clk, 20, ntfr);
    $width(posedge clk, 5, 1, ntfr);
    $nochange(posedge clk, d, 0, 0, ntfr);
    $setup(d, edge[01, 0x, x1] clk &&& en, tSU);
    $width(edge[10, x0, 1x] clkb, 5);
    $hold(posedge clk, edge[01, 10, 0z, z1] d, tH);
  endspecify
endmodule
