// A.5.4 UDP instantiation:
//
//     udp_instantiation ::= udp_identifier [ drive_strength ] [ delay2 ]
//             udp_instance { , udp_instance } ;
//     udp_instance ::= [ name_of_udp_instance ]
//             ( output_terminal , input_terminal { , input_terminal } )
//     name_of_udp_instance ::= udp_instance_identifier [ range ]
//
// The instantiation site, which is a different production from A.5.1's
// declaration and can be missing from a compiler that has the other one: 58
// records VerA's refusal of the declaration, this file records the USE.
//
// WHY THE MODULE COMES FIRST AND THE PRIMITIVE SECOND. VerA stops at the first
// diagnostic, so the order of the file decided which claim the fixture made.
// With `annex_a_udp_pulse (b, a);` in the module at the top, the refusal was
// E0205 "unsupported module item: found annex_a_udp_pulse" — the module-item
// dispatch declining an identifier followed by a port list — where a file with
// the `primitive` first would have stopped at E0201 and said nothing about the
// instantiation at all. Both features have landed, and the file is now the
// complete design the paragraph anticipated: the module instantiates the
// primitive declared below it, and the declaration is a legal one (58 spells
// the same four lines).
//
// HOW IT IS TOLD FROM A MODULE INSTANTIATION, which is the whole of why this row
// is separable from 11_module_instantiation.va. By one token, with no lookup of
// the name: A.4.1's `module_instance ::= name_of_module_instance
// ( [ list_of_port_connections ] )` makes the instance name MANDATORY, and
// A.5.4's `udp_instance ::= [ name_of_udp_instance ] ( output_terminal , … )`
// makes it optional, so an identifier followed DIRECTLY by `(` derives from
// A.5.4 and from nothing else at module scope. Which is exactly the shape this
// file writes, and is why it writes it.
//
// THE OTHER HALF OF A.5.4 IS NOT CLAIMED HERE. A udp_instance WITH a name is
// spelled identically to a module instance, and this parser leaves it a module
// instantiation — elaboration resolves the name, which is the only stage that
// can tell the two apart. So `annex_a_udp_pulse u1 (b, a);` is E0904 today, and
// a fixture for that form would be a fixture about elaboration.
//
// `b` and `a` are the output and input terminals of A.3.3's `output_terminal`/
// `input_terminal`, reused by A.5.4 by reference. The `[ drive_strength ]` and
// `[ delay2 ]` brackets are omitted, which the grammar allows.
//
// AND IT COMPUTES NOTHING (W0252), for the reason 56's header gives at length:
// a UDP's function is a table rather than a keyword, and a table is a logic
// function for an event queue a compiled analog device does not have. `b` is
// connected to nothing else in this module, so the want below is about the
// instantiation and not about a dropped driver.
//
// §1.1 again: the complete IEEE Std 1364 Verilog is part of Verilog-AMS HDL, so
// refusing this was the gap the marker recorded, not a conformance choice. A UDP
// is also the only way a user-defined *digital* cell enters a mixed design, so
// the row is not decorative for the AMS side either.
//
//! lrm A.5.4
//! lrm A.3.3
//! lrm A.4.1
//! lrm 1.1
//! bias V(p) = 0.75, V(n) = 0.25
`include "check.vh"
module annex_a_udp_use(p, n);
    inout p, n;
    electrical p, n;

    wire a, b;
    annex_a_udp_pulse (b, a);

    analog begin
        `CHECKX("the file carrying the UDP instantiation compiles and runs",
                V(p, n), 0.5);
        I(p, n) <+ V(p, n);
    end
endmodule

primitive annex_a_udp_pulse (o, a);
    output o;
    input a;
    table
        0 : 1;
        1 : 0;
    endtable
endprimitive
