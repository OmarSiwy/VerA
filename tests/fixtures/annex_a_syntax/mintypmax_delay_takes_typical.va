// A.8.3's min:typ:max expression as a delay in a .va, observed: the two
// digital delay productions a Verilog-AMS module's discrete half writes.
//
//     delay3 ::= # delay_value | # ( mintypmax_expression
//             [ , mintypmax_expression [ , mintypmax_expression ] ] )  // A.2.2.3
//     continuous_assign ::= assign [ drive_strength ] [ delay3 ]
//             list_of_net_assignments ;                                // A.6.1
//     delay_control ::= # delay_value | # ( mintypmax_expression )     // A.6.5
//     mintypmax_expression ::= expression
//             | expression : expression : expression                  // A.8.3
//
// IEEE 1364-2005 §5.3: "Verilog HDL models typically specify three values for
// delay expressions. The three values allow a design to be tested with
// minimum, typical, or maximum delay values." Which one a run uses is the
// tool's; VerA takes the typical, the middle (specification/Vague_Decisions.md VD-099),
// so this file tests that choice, not the clause.
//
// DERIVATION (`timescale 1ns/1ns):
//   y = 0 at 0, then `#(2:4:6) y = 1;`             y rises at 4 (typ)
//   a = 0 at 0, a = 1 at 10; `assign #(2:4:6) w = a;` w follows at 4, 14
// Checks, from a second initial block, as $strobe (end of the time step):
//   t=3   y = 0                  (min 2 would give 1; w is still x here)
//   t=5   {y, w} = 2'b10 = 2     (max 6 would give y = 0, w = x)
//   t=13  {y, w} = 2'b10 = 2     (a rose at 10; min 12 would give 3)
//   t=15  {y, w} = 2'b11 = 3     (max 16 would give 2)
// Four verdicts.
//
//! lrm A.8.3
//! lrm A.2.2.3
//! lrm A.6.5
//! lrm A.8.3:1000
//! analysis tran
//! time 0, 20n
//! checks 4
`timescale 1ns/1ns
`include "check.vh"
module annex_a_mintypmax_delay(p);
    inout p;
    electrical p;
    reg y, a;
    wire w;
    assign #(2:4:6) w = a;

    initial begin
        y = 1'b0;
        a = 1'b0;
        #(2:4:6) y = 1'b1;
    end

    initial #10 a = 1'b1;

    initial begin
        #3  `CHECKI("t=3: the typical delay (4) has not elapsed", y, 0);
        #2  `CHECKI("t=5: both typical delays (4) have", ({y, w}), 2);
        #8  `CHECKI("t=13: a rose at 10, w has not followed", ({y, w}), 2);
        #2  `CHECKI("t=15: w followed at 14", ({y, w}), 3);
    end

    analog I(p) <+ V(p);
endmodule
