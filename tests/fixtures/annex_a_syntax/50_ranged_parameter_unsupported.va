// A.2.1.1's `[ range ]` slot, in the production's first arm:
//
//     parameter_declaration ::=
//             parameter [ signed ] [ range ] list_of_param_assignments
//             | parameter parameter_type list_of_param_assignments
//
// 48_parameter_declarations.va takes the `[ signed ]` half of that bracket (its
// `parameter signed signed_value`) and takes BOTH arms of the second
// alternative. What is left is the range, so this file is the pair-completing
// fixture: a parameter sized by the bracket rather than by `parameter_type`.
//
// The bracket is A.2.5's `range ::= [ msb_constant_expression :
// lsb_constant_expression ]` — the same production `net_declaration` and
// `reg_declaration` use for a vector, which is why `parameter [3:0] nib` is the
// declaration-side spelling of "four bits" and `nib` reads back 0101 = 5.
// §3.4.1 is the clause the two spellings share: "The parameter declaration can
// contain an optional type specification … A default value for the parameter
// shall be specified", with the type "derived from the type of the final value
// assigned to the parameter" when it is not written down. A range is the third
// way of writing that shape, and §3.4.2's `from`/`exclude` is a different thing
// entirely — a restriction on the VALUES, not a width — so the two brackets are
// not interchangeable and this file deliberately spells only the width.
//
// WHAT A WRONG IMPLEMENTATION DOES. It reads `parameter` and then expects a
// `parameter_type` keyword or an identifier, so the `[` is a syntax error
// instead of a range: VerA reports E0208 "expected an identifier: found `[`" on
// this line. The SHAPE of the diagnostic is the evidence that the gap is real
// and not a semantic refusal — a compiler that had the arm and disliked the
// value would name the range, and this one cannot name what it never parsed.
//
// §1.1 makes the complete IEEE Std 1364 Verilog part of Verilog-AMS HDL, and a
// sized parameter is 1364's. So the file is an xfail and not a `//! reject`: the
// fixture states the clause's requirement, and the marker records that VerA
// does not meet it.
//
//! lrm A.2.1.1
//! lrm A.2.5
//! lrm 3.4.1
//! xfail VerA has no `[ range ]` slot after `parameter` — the bracket is a syntax error (E0208 "expected an identifier: found `[`")
//! bias V(p) = 0.75, V(n) = 0.25
`include "check.vh"
module annex_a_ranged_parameter(p, n);
    inout p, n;
    electrical p, n;

    parameter [3:0] nib = 4'h5;

    analog begin
        `CHECKX("the file carrying the sized parameter compiles and runs",
                V(p, n), 0.5);
        `CHECKI("the 4-bit parameter reads back 0101", nib, 5);
        I(p, n) <+ V(p, n);
    end
endmodule
