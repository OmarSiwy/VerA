// A.1.3's two port forms with the port_expression left out, a null port:
//
//     list_of_ports ::= ( port { , port } )
//     port ::= [ port_expression ] | . port_identifier ( [ port_expression ] )
//
// §6.5.1: "The port expression is optional because ports can be defined which
// do not connect to anything internal to the module." A null port still holds
// its POSITION in the list of ports, so an ordered connection (§6.5.5, A.4.1
// `ordered_port_connection`) counts it, and the net connected to it reaches
// nothing inside the module.
//
// WHAT IS SPELLED:
//   the device   null_port_connects_nothing(p, , n)   three terminals, the
//                                                      middle one bound to
//                                                      nothing
//   c1           null_port_child(a, , b)              a null port between two
//   c2           null_port_named_child(.x(), a, b)    a named null port first
//
// DERIVATION. V(p) = 1.0, V(n) = 0.25 (bias), so V(p, n) = 0.75 exactly.
//   c1 is connected (p, p, n) by order: a = p, the null port takes the second
//   p and drops it, b = n, so V(a, b) = 0.75. A parser that dropped the null
//   port would bind b to p (V(a, b) = 0) and leave a third actual over.
//   c2 is connected (n, p, n): `.x()` takes n and drops it, a = p, b = n, so
//   V(a, b) = 0.75 again; reading x as a port of the body would bind a to n.
//   c3 is connected by name, `.x(n), .a(p), .b(n)`: §6.5.5 "The port name
//   shall be the name specified in the module definition", which for `.x()`
//   is x; a = p and b = n, V(a, b) = 0.75.
//   The device checks V(p, n) = 0.75 across its two connected terminals.
// Four verdicts.
//
//! lrm A.1.3
//! lrm 6.5.1
//! lrm 6.5.5
//! lrm A.1.3:1000
//! lrm 6.5.1:1
//! bias V(p) = 1.0
//! bias V(n) = 0.25
//! print none
//! checks 4
`include "check.vh"
module null_port_connects_nothing(p, , n);
    inout p, n;
    electrical p, n;

    null_port_child c1(p, p, n);
    null_port_named_child c2(n, p, n);
    null_port_named_child c3(.x(n), .a(p), .b(n));

    analog begin
        `CHECKX("the device's two connected terminals", V(p, n), 0.75);
    end
endmodule

module null_port_child(a, , b);
    inout a, b;
    electrical a, b;

    analog begin
        `CHECKX("(a, , b) by order: the null port took the second actual", V(a, b), 0.75);
        I(a, b) <+ V(a, b);
    end
endmodule

module null_port_named_child(.x(), a, b);
    inout a, b;
    electrical a, b;

    analog begin
        `CHECKX("(.x(), a, b): .x() took the first actual or the one named x", V(a, b), 0.75);
        I(a, b) <+ V(a, b);
    end
endmodule
