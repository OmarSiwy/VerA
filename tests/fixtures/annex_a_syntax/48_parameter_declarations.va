// A.2.1.1 Module parameter declarations:
//
//     local_parameter_declaration ::=
//         localparam [ signed ] [ range ] list_of_param_assignments
//         | localparam parameter_type list_of_param_assignments
//     parameter_declaration ::=
//         parameter [ signed ] [ range ] list_of_param_assignments
//         | parameter parameter_type list_of_param_assignments
//     parameter_type ::= integer | real | realtime | time | string
//     aliasparam_declaration ::= aliasparam parameter_identifier = parameter_identifier ;
//
// Three of the four productions are reached here — `parameter_declaration` and
// `local_parameter_declaration` on BOTH arms, and `aliasparam_declaration`. The
// fourth, `specparam_declaration`, is the subject of
// 49_specparam_declaration_unsupported.va: it is legal full-AMS source that
// VerA refuses, and putting it in this file would take the seven assertions
// below down with it.
//
// THE TYPE LIST IS THE POINT. `parameter integer` is common in this suite
// (09/14/15 use it) but `real`, `realtime`, `time` and `string` are declared
// nowhere else, and each names a different slot in the parameter table: an
// integer is a 32-bit signed value (§3.4.2 puts an unspecified parameter inside
// the range of an integer), a real is a double, `realtime` is a real that
// §3.3 keeps distinguishable, and `time` is the 64-bit unsigned type of §3.3.
// `string` is §3.4.6, which is also where the value range of a string parameter
// comes from: "The set of allowed values for the string can be specified as a
// comma-separated list of strings inside curly braces", which is
// `from '{ "NPN", "PNP" }` below. The LRM's own ebersmoll example (3.4.6) is
// where that form is printed, and Table 3-3's string operators are what the
// assertion on `mode` uses.
//
// `signed` on `signed_value` is the other bracket of the same alternative, which
// VerA reads; the `[ range ]` half of `[ signed ] [ range ]` it does not, and
// that gap is recorded on 51_ranged_parameter_unsupported.va rather than by
// widening this file. A `parameter_type` where `signed` stands would be the
// first arm again.
//
// Values other than gain are the declared defaults. The host binds its
// alias amplification=5, so equations read the ORIGINAL gain as 5 and
// gain*scale is 5*4=20. §3.4.7 forbids the former alias equation read; that
// withdrawn acceptance claim moves to
// ch03_data_types/aliasparam_equation_rejected.va. The string comparison
// mode == "NPN" is 1 by Table 3-3 and §4.2.6.
//
// `A.2.1` (Declaration types) is cited as well: it is the heading over the
// subclause this file exercises and states no production of its own, so this
// file is evidence for it on the same positive side.
//
//! lrm A.2.1
//! lrm A.2.1.1
//! lrm 3.4.6
//! lrm 3.4.7
//! lrm A.2.1.1:1000
//! param amplification = 5
//! print none
`include "check.vh"
module annex_a_parameters(p, n);
    inout p, n;
    electrical p, n;

    parameter integer gain = 3;
    parameter real factor = 2.5;
    parameter realtime tstep = 1.25;
    parameter time delay = 5;
    parameter string mode = "NPN" from '{ "NPN", "PNP" };
    parameter signed signed_value = 5;
    localparam integer scale = 4;
    localparam real offset = 1.5;
    aliasparam amplification = gain;

    analog begin
        `CHECKI("parameter integer after alias override", gain, 5);
        `CHECKX("parameter real", factor, 2.5);
        `CHECKX("parameter realtime", tstep, 1.25);
        `CHECKI("parameter time", delay, 5);
        `CHECKI("parameter string equal to the first allowed value", (mode == "NPN"), 1);
        `CHECKI("parameter [signed]", signed_value, 5);
        `CHECKI("localparam integer", scale, 4);
        `CHECKX("localparam real", offset, 1.5);
        `CHECKI("alias override participates in integer arithmetic", gain * scale, 20);
        I(p, n) <+ V(p, n);
    end
endmodule
