// The legal neighbour of pattern_empty_element_rejected.va: every element of
// the §3.4.4 array parameter's assignment pattern is written (A.8.1), so
// a[1] is the second element, 2.0, exactly.
//
//! lrm A.8.1
//! lrm 3.4.4
//! bias V(p) = 1, V(n) = 0
//! checks 1
`include "check.vh"
module pattern_every_element_written(p, n);
  inout p, n; electrical p, n;
  parameter real a[0:2] = '{1.0, 2.0, 3.0};
  analog begin
    I(p, n) <+ a[1] * V(p, n);
    `CHECKX("the pattern's second element", a[1], 2.0);
  end
endmodule
