// A.2.3 `list_of_branch_identifiers ::= branch_identifier [ range ]
//                                       { , branch_identifier [ range ] }`
// and A.8.9 `branch_reference ::= hierarchical_branch_identifier
//                               | hierarchical_branch_identifier [ constant_expression ] | ...`
//
// A branch declaration may carry a RANGE, and a branch reference may carry an
// index. Both halves of that pair are legal Verilog-AMS and neither has a user
// anywhere in the suite: every branch declared in all 859 fixtures is scalar.
//
// The declaration `branch (p, n) pair[0:1];` gives two branches over the same
// node pair, so §5.5.1 makes V(pair[0]) and V(pair[1]) both the potential
// difference V(p) - V(n) = 0.8 - 0.3 = 0.5, and their sum 1.0.
//
// Both branch elements span the same pair, so their equal potentials alone
// cannot distinguish an implementation that collapses the range to one branch.
// Give each element a different conductance and read its actual flow:
// I(pair[0]) = 2*0.5 = 1, I(pair[1]) = 3*0.5 = 1.5. Swapping the elements or
// merging their identities changes at least one of those two observations.
// The harness solves the branch-flow rows with the terminal potentials held.
//
// The numbers are the ones to demand the day it parses; nothing about them is
// VerA-specific. Neither 0.8 nor 0.3 is representable in binary but their
// difference is exactly 0.5 (verified), and 0.5 + 0.5 is exactly 1.0, so all
// potential checks are `CHECKX`; the solved flows allow a small tolerance.
//
// This is written as a run fixture, not a `//! reject`: A.2.3 makes the source
// legal, so demanding a diagnostic would invert it and only VerA would pass.
//
// Side note for whoever closes this: lib/diag_code.zig carries E0305 "branch
// arrays are not supported", which no fixture references and which this syntax
// never reaches, because the parser errors on the `[` first.
//
//! lrm A.2.3
//! lrm A.8.9
//! lrm 5.5.1
//! lrm A.2.3:1000
//! lrm A.8.9:1000
//! bias V(p) = 0.8
//! bias V(n) = 0.3
//! print none
//! solve
//! checks 5
`include "check.vh"
module annex_a_branch_array(p, n);
    inout p, n;
    electrical p, n;
    branch (p, n) pair[0:1];

    analog begin
        `CHECKX("the first element of a branch array probes the declared pair", V(pair[0]), 0.5);
        `CHECKX("the second element probes the same pair", V(pair[1]), 0.5);
        `CHECKX("both indexed potentials participate in the expression",
                V(pair[0]) + V(pair[1]), 1.0);
        I(pair[0]) <+ 2.0 * V(pair[0]);
        I(pair[1]) <+ 3.0 * V(pair[1]);
        `CHECK("the first array branch carries its own flow", I(pair[0]), 1.0, 1e-12);
        `CHECK("the second array branch carries a different flow", I(pair[1]), 1.5, 1e-12);
    end
endmodule
