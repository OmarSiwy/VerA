// A.6.3 puts a block's declarations inside the bracket that opens with its
// name:
//
//     analog_seq_block ::= begin [ : analog_block_identifier
//             { analog_block_item_declaration } ] { analog_statement } end
//
// IEEE 1364-2005's seq_block and par_block are written the same way. An
// unnamed `analog begin` therefore declares nothing: `real x;` right after it
// derives from no alternative. The legal neighbour names the block
// (`begin : body`), which is all that differs.
//
// VerA refuses the declaration with E0290; the code is pinned. The digital
// parse reports the same code (ieee1364 b_A_6_3, b_9_8_1, b_9_8_2).
//
//! lrm A.6.3
//! lrm A.6.3:1000
//! reject-only E0290
//! neighbour named_block_declares.va
`include "check.vh"
module annex_a_named_block_declares(p, n);
    inout p, n;
    electrical p, n;

    analog begin
        real x;                   // illegal: the block has no name
        x = 2.0 * V(p, n);
        `CHECKX("x, declared in the named block, holds 2 * V(p, n)", x, 1.0);
        I(p, n) <+ x / 1000.0;
    end
endmodule
