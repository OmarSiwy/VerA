// A.3.1 Primitive instantiation, A.3.3 terminals and A.3.4 types, in one line:
//
//     gate_instantiation ::=                                              // A.3.1
//             …
//             | n_input_gatetype [drive_strength] [delay2]
//                 n_input_gate_instance { , n_input_gate_instance } ;
//     n_input_gate_instance ::= [ name_of_gate_instance ]
//             ( output_terminal , input_terminal { , input_terminal } )
//     name_of_gate_instance ::= gate_instance_identifier [ range ]
//     output_terminal ::= net_lvalue                                      // A.3.3
//     input_terminal ::= expression
//     n_input_gatetype ::= and | nand | or | nor | xor | xnor             // A.3.4
//
// `and nand_g1 (c, a, b);` reaches all three clauses at once: the gate
// instantiation arm with its instance name (`nand_g1`, the optional
// `name_of_gate_instance`), an output terminal `c` (a `net_lvalue`) followed by
// two input terminals, and the `and` spelling of A.3.4's seven `n_input_gatetype`
// names. The `[drive_strength] [delay2]` brackets are A.2.2.2/A.2.2.3 and are
// omitted here, which the grammar allows — 54/55 are their fixtures.
//
// THE OTHER ARMS ARE NOT SPELLED, and the header says so rather than letting a
// reader assume the row covers them: the switch types (`cmos`, `nmos`, `tran`,
// `rtran`), the enable gates (`bufif0` … `notif1`), the `buf`/`not` output
// gates, and the two pull gates (`pullup`/`pulldown`, A.3.1's last two arms) are
// separate arms of the same production, each reached by a different keyword. The
// pull gates are 57_primitive_strengths_unsupported.va, whose A.3.2 bracket is
// what makes them interesting.
//
// §1.1: "Verilog-AMS HDL consists of the complete IEEE Std 1364 Verilog
// specification". A gate primitive is 1364's, and §1.2's feature list assumes
// the digital side of the language is there ("signals of both analog and digital
// types can be declared in the same module"). So this file is an xfail and not a
// `//! reject`: it states what the annex requires and records that VerA declines
// the whole `gate_instantiation` production with E0205 "unsupported module item:
// found and" — the module-item dispatch refusing the keyword after recognising
// it.
//
//! lrm A.3.1
//! lrm A.3.3
//! lrm A.3.4
//! lrm 1.1
//! xfail VerA refuses gate primitives at the module-item dispatch — `and nand_g1 (c, a, b);` reports E0205 "unsupported module item: found and"
//! bias V(p) = 0.75, V(n) = 0.25
`include "check.vh"
module annex_a_gate(p, n);
    inout p, n;
    electrical p, n;

    wire a, b, c;
    and nand_g1 (c, a, b);

    analog begin
        `CHECKX("the file carrying the gate instantiation compiles and runs",
                V(p, n), 0.5);
        I(p, n) <+ V(p, n);
    end
endmodule
