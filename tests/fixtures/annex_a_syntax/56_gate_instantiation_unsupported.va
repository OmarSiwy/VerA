// A.3.1 Primitive instantiation, A.3.3 terminals and A.3.4 types, in one line:
//
//     gate_instantiation ::=                                              // A.3.1
//             …
//             | n_input_gatetype [drive_strength] [delay2]
//                 n_input_gate_instance { , n_input_gate_instance } ;
//     n_input_gate_instance ::= [ name_of_gate_instance ]
//             ( output_terminal , input_terminal { , input_terminal } )
//     name_of_gate_instance ::= gate_instance_identifier [ range ]
//     output_terminal ::= net_lvalue                                      // A.3.3
//     input_terminal ::= expression
//     n_input_gatetype ::= and | nand | or | nor | xor | xnor             // A.3.4
//
// `and nand_g1 (c, a, b);` reaches all three clauses at once: the gate
// instantiation arm with its instance name (`nand_g1`, the optional
// `name_of_gate_instance`), an output terminal `c` (a `net_lvalue`) followed by
// two input terminals, and the `and` spelling of A.3.4's seven `n_input_gatetype`
// names. The `[drive_strength] [delay2]` brackets are A.2.2.2/A.2.2.3 and are
// omitted here, which the grammar allows — 54/55 are their fixtures.
//
// THE OTHER ARMS ARE NOT SPELLED, and the header says so rather than letting a
// reader assume the row covers them: the switch types (`cmos`, `nmos`, `tran`,
// `rtran`), the enable gates (`bufif0` … `notif1`), the `buf`/`not` output
// gates, and the two pull gates (`pullup`/`pulldown`, A.3.1's last two arms) are
// separate arms of the same production, each reached by a different keyword. The
// pull gates are 57_primitive_strengths_unsupported.va, whose A.3.2 bracket is
// what makes them interesting.
//
// §1.1: "Verilog-AMS HDL consists of the complete IEEE Std 1364 Verilog
// specification". A gate primitive is 1364's, and §1.2's feature list assumes
// the digital side of the language is there ("signals of both analog and digital
// types can be declared in the same module"). So this file was an xfail and not
// a `//! reject`: it states what the annex requires and recorded that VerA
// declined the whole `gate_instantiation` production with E0205 "unsupported
// module item: found and" — the module-item dispatch refusing the keyword after
// recognising it.
//
// IT IS READ NOW, AND IT COMPUTES NOTHING, and the second half is said out loud
// (W0252). The production was already implemented for `vera --run` over a `.v`
// source, where the discrete engine executes the gate for real; what refused
// this line was a gate on the ARTIFACT being built, not on the grammar. §8.5.3.5
// is why that distinction is a real one: "The event-driven simulation algorithm
// described in 11 of IEEE Std 1364 Verilog depends on unidirectional signal
// flow and can process each event independently. The inputs are read, the result
// is computed, and the update is scheduled. The IEEE Std 1364 Verilog provides
// switch-level modeling in addition to behavioral and gate-level modeling." A
// gate's output is that scheduled UPDATE, and a compiled analog device has no
// queue to put one on, so `c` below keeps whatever the continuous solver leaves
// it.
//
// WHICH IS WHY THE THREE NETS ARE UNCONNECTED HERE. `a`, `b` and `c` touch
// nothing the analog block reads, so the module's answer is the same with the
// gate and without it, and this file's want is not silently a want about a
// dropped driver. The warning is what carries that claim; `--deny=W0252` turns
// it back into a refusal for a model that cannot afford the omission, which is
// W0250's arrangement for A.4.1's pass switches and the reason this one is
// shaped like it.
//
// `A.3` (Primitive instances) is cited as well: it is the heading over the
// subclauses this file exercises and states no production of its own. What
// this file proves for it is the GRAMMAR — the gate parses and the file runs its
// analog assertion — not a behaviour: the gate reaches no device (W0252). The behaviour is
// run under the discrete engine by tests/fixtures/ieee1364/07_gate_switch_level/d08_gates_ninput.v.
//
//! lrm A.3
//! lrm A.3.1
//! lrm A.3.3
//! lrm A.3.4
//! lrm 1.1
//! bias V(p) = 0.75, V(n) = 0.25
`include "check.vh"
module annex_a_gate(p, n);
    inout p, n;
    electrical p, n;

    wire a, b, c;
    and nand_g1 (c, a, b);

    analog begin
        `CHECKX("the file carrying the gate instantiation compiles and runs",
                V(p, n), 0.5);
        I(p, n) <+ V(p, n);
    end
endmodule
