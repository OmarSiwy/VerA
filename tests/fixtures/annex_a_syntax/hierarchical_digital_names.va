// A.9.3 hierarchical names in the statement positions A.6 gives them, in a
// .va's discrete half:
//
//     task_enable ::= hierarchical_task_identifier
//             [ ( expression { , expression } ) ] ;                  // A.6.9
//     event_control ::= @ hierarchical_event_identifier | ...         // A.6.5
//     event_trigger ::= -> hierarchical_event_identifier
//             { [ expression ] } ;                                    // A.6.5
//     hierarchical_identifier ::= [ $root . ] { identifier
//             [ [ constant_expression ] ] . } identifier              // A.9.3
//
// IEEE 1364-2005 §12.5: "Every identifier in a Verilog HDL description shall
// have a unique hierarchical path name", reachable from anywhere in the
// design. `c.bump;` enables the child's task with no argument list, and
// `@ c.go` waits on the child's named event.
//
// DERIVATION (`timescale 1ns/1ns). c.n = 0 from 0.
//   t=1  `c.bump;` makes c.n = 1
//   t=2  `-> c.go;` wakes `@ c.go seen = 1;`
//   t=3  c.n = 1 and seen = 1, as {c.n, seen} = 2'b11 = 3 (both 32-bit
//        integers, so (c.n << 1) | seen)
// One verdict. A task enable that ran nothing leaves c.n = 0 (1); an event
// wait that never woke leaves seen = 0 (2).
//
//! lrm A.9.3
//! lrm A.6.5
//! lrm A.9.3:1000
//! analysis tran
//! time 0, 5n
//! checks 1
`timescale 1ns/1ns
`include "check.vh"
module hierarchical_digital_names(p);
    inout p;
    electrical p;
    integer seen;
    hierarchical_digital_names_child c();

    initial begin
        seen = 0;
        #1 c.bump;
        #1 -> c.go;
    end

    initial @ c.go seen = 1;

    initial #3 `CHECKI("c.bump ran and @ c.go woke", (c.n << 1) | seen, 3);

    analog I(p) <+ V(p);
endmodule

module hierarchical_digital_names_child;
    integer n;
    event go;
    initial n = 0;
    task bump;
        n = n + 1;
    endtask
endmodule
