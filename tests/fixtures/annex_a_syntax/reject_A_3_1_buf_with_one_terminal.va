// A.3.1:
//
//     n_output_gate_instance ::= [ name_of_gate_instance ]
//             ( output_terminal { , output_terminal } , input_terminal )
//
// A buf (an n_output_gatetype) has at least one output and exactly one input
// terminal. `buf g1(o);` has a single terminal. `buf g1(o, a);` is the legal
// form.
//
// VerA reports E0209 "a buf/not gate needs at least one output and one input".
//
//! lrm A.3.1
//! lrm A.3.1:1000
//! reject-only E0209
//! reject needs at least one output and one input
module annex_a_buf_one_terminal(o, a);
  output o;
  input a;
  wire o, a;
  buf g1(o);                 // illegal: no input terminal
endmodule
