// A.9.2 gives `block_comment ::= /* comment_text */`, and §2.4 states the
// rule the grammar alone does not: "Block comments shall not be nested."
//
// So in `/* outer /* inner */ */` the comment ends at the FIRST `*/`; the
// inner `/*` is just comment text, and the trailing ` */` is left over as the
// tokens `*` and `/` in statement position. A conforming compiler must reject
// that; one that nested comments would accept it. Without the trailing `*/`
// the line is one legal comment.
//
// VerA reports E0209 "expected an expression: found `*`" at the leftover.
//
//! lrm A.9.2
//! lrm 2.4
//! lrm 2.4:3
//! lrm A.9.2:1000
//! reject-only E0209
//! neighbour 08_attributes_comments_identifiers.va
`include "disciplines.vams"
module annex_a_nested_comment(p, n);
  inout p, n;
  electrical p, n;
  real x;
  analog begin
    x = 1.0;
    /* outer /* inner */ */
    I(p, n) <+ x;
  end
endmodule
