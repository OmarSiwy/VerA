// A.6.8's SECOND production, the one no other fixture reaches:
//
//     analog_loop_statement ::=                                            // A.6.8
//             repeat ( analog_expression ) analog_statement
//             | while ( analog_expression ) analog_statement
//             | for ( analog_variable_assignment ; analog_expression ;
//                     analog_variable_assignment ) analog_statement
//     analog_function_loop_statement ::=
//             repeat ( analog_expression ) analog_function_statement
//             | while ( analog_expression ) analog_function_statement
//             | for ( analog_variable_assignment ; analog_expression ;
//                     analog_variable_assignment ) analog_function_statement
//     loop_statement ::= forever statement | repeat ( expression ) statement | …
//
// `analog_function_loop_statement` is the analog arm with the BODY SWAPPED:
// A.6.4 gives an analog block `analog_statement` and an analog function
// `analog_function_statement`, and A.6.8's two loop productions differ only in
// which of the two the body is. A compiler can therefore have loops in an
// `analog` block and not in an analog function, which is exactly the split
// 05_behavioral_statements.va (the analog arm, green) and this file (the
// function arm) are written to expose.
//
// ALL THREE LOOPS ARE IN ONE FUNCTION, in grammar order, so the three bodies are
// proved to be `analog_function_statement`s and not statements: each body is a
// plain `analog_procedural_assignment` to the function's own local `acc`, which
// is legal in an analog function and would be a contribution or a digital
// assignment anywhere else.
//
// THE ARITHMETIC IS EXACT AND EVERY STEP IS VISIBLE. `limit` = 5:
//
//     for   k = 1,2,3,4,5   acc = 0+1+2+3+4+5 = 15   (k = 6 fails k <= limit)
//     while acc < 20        acc = 16, 17, 18, 19, 20 (20 < 20 is false, so it stops)
//     repeat (2)            acc = 20.5, 21.0
//
// 21.0 is exact in binary, so `CHECKX` is the honest macro and a compiler that
// ran the `while` one turn too long reads 22.0, one too few 21.0 from the
// `for` alone if the `repeat` were dropped. The `for`'s post-test is the other
// half: a compiler that tested before incrementing would sum 1..4 and land on
// 20.0.
//
// NOT THE DIGITAL ARM. `loop_statement`'s `forever` has no analog counterpart —
// A.6.8's analog arms are a closed list of three, and A.6.4's `analog_statement`
// reaches `loop_statement` nowhere — which is why `forever` inside an `analog`
// block is a REJECTION and has its own file:
// 62_forever_in_analog_rejected.va.
//
// Corrected 2026-10-08 (construct only, the wants are unchanged): the formal
// was declared `input integer limit;`. A.2.6's analog_function_item_declaration
// takes A.2.1.2's input_declaration, which carries no data type, and 4.7.1
// types a formal by a separate block item declaration (E0291), so the file now
// writes `input limit; integer limit;`.
//
//! lrm A.6.8
//! lrm A.6.4
//! lrm A.6.8:1000
//! bias V(p) = 0.75, V(n) = 0.25
`include "check.vh"
module annex_a_loops(p, n);
    inout p, n;
    electrical p, n;

    analog function real annex_a_accumulate;
        input limit;
        integer limit;
        integer k;
        real acc;
        begin
            acc = 0.0;
            for (k = 1; k <= limit; k = k + 1) acc = acc + k;
            while (acc < 20.0) acc = acc + 1.0;
            repeat (2) acc = acc + 0.5;
            annex_a_accumulate = acc;
        end
    endfunction

    analog begin
        `CHECKX("A.6.8's three analog-function loop forms: 15 + 5 + 2*0.5",
                annex_a_accumulate(5), 21.0);
        `CHECKX("a `for` past the `while` guard skips it: 1+..+25 = 325, then 2*0.5",
                annex_a_accumulate(25), 326.0);
        I(p, n) <+ V(p, n);
    end
endmodule
