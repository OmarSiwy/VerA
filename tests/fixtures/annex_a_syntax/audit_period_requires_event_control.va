// AMS A.7.5.1 / A.7.5.2 / A.7.5.3, printed pp. 375–376:
// $period requires controlled_reference_event, not the optional-event-control
// timing_check_event used by $setup. Bare clk therefore requires rejection.
//! lrm A.7.5.1
//! lrm A.7.5.3
//! lrm A.7.5.1:1000
//! lrm A.7.5.3:1000
//! reject-only timing check requires an event control
//! reject endspecify
//! neighbour b8_timing_checks_design_runs.va
module audit_period_requires_event_control(input clk);
    specify
        $period(clk, 2.0);
    endspecify
endmodule
