// AMS A.7.5.1 / A.7.5.2 / A.7.5.3, printed pp. 375–376:
// $period requires controlled_reference_event, not the optional-event-control
// timing_check_event used by $setup. Bare clk therefore requires rejection.
//! lrm A.7.5.1
//! lrm A.7.5.3
//! reject timing check requires an event control
//! xfail Parser accepts a bare $period reference; the rejection phrase is the intended rule-specific diagnostic, not an observed diagnostic
module audit_period_requires_event_control(input clk);
    specify
        $period(clk, 2.0);
    endspecify
endmodule
