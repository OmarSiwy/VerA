// A.2.1.1:
//
//     parameter_declaration ::=
//             parameter [ signed ] [ range ] list_of_param_assignments
//             | parameter parameter_type list_of_param_assignments
//     parameter_type ::= integer | real | realtime | time | string
//
// `reg` is not a parameter_type, and cannot start a list_of_param_assignments
// (that begins with the parameter's identifier). `parameter integer k = 1;`
// is the legal spelling and compiles (probed).
//
// VerA reports E0208 "expected an identifier: found `reg`".
//
//! lrm A.2.1.1
//! reject E0208
`include "disciplines.vams"
module annex_a_param_reg(p, n);
  inout p, n;
  electrical p, n;
  parameter reg k = 1;       // illegal: reg is not a parameter_type
  analog I(p, n) <+ k * V(p, n);
endmodule
