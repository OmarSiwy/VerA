// A.2.1.1's `[ range ]` bracket on a specparam_declaration, and a bit- and
// part-select of the result, observed. Neither 49_specparam_declaration_
// unsupported.va nor b8_specparam_module_item_value.va takes the bracket.
//
//     specparam_declaration ::= specparam [ range ] list_of_specparam_assignments ;
//                                                                      // A.2.1.1
//     range ::= [ msb_constant_expression : lsb_constant_expression ]  // A.2.5
//
// IEEE 1364-2005 §4.10.3 (inherited through §1.1): "A specparam with a range
// specification shall be the range of the parameter declaration. The range
// shall not be affected by value overrides." And: "Bit-selects and
// part-selects of specify parameters that are not of type real shall be
// allowed (see 5.2)."
//
// DERIVATION.
//
//   specparam [3:0] code = 4'b1010:  code[1] = 1, code[0] = 0,
//                                    code[3:2] = 2'b10 = 2.
//   specparam [3:0] wrap = 21:       the declaration's range is 4 bits wide,
//                                    so the value is 21 kept to its low 4
//                                    bits: 21 = 5'b10101 -> 4'b0101 = 5.
//
// The selects are taken at 1 ns in a digital initial block, the context 1364
// states the rule for, into integers the analog block reads at 5 ns (§7.3.1
// Table 7-1).
// A tool that ignored the range would read wrap = 21.
//
//! lrm A.2.1.1
//! lrm A.2.5
//! lrm A.2.1.1:1000
//! lrm A.2.5:1000
//! analysis tran
//! time 5n
//! checks 4
`timescale 1ns/1ns
`include "check.vh"
module b8_specparam_range_and_select(p);
  inout p; electrical p;
  specparam [3:0] code = 4'b1010;
  specparam [3:0] wrap = 21;
  integer b1, b0, hi, w;
  initial begin
    #1 b1 = code[1];
    b0 = code[0];
    hi = code[3:2];
    w = wrap;
  end
  analog begin
    `CHECKI("bit-select code[1] of 4'b1010", b1, 1);
    `CHECKI("bit-select code[0] of 4'b1010", b0, 0);
    `CHECKI("part-select code[3:2] of 4'b1010", hi, 2);
    `CHECKI("a [3:0] specparam assigned 21 holds its low 4 bits", w, 5);
    I(p) <+ V(p);
  end
endmodule
