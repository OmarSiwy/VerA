// A.7.1:
//
//     pulsestyle_declaration ::= pulsestyle_onevent list_of_path_outputs ;
//             | pulsestyle_ondetect list_of_path_outputs ;
//     list_of_path_outputs ::= specify_output_terminal_descriptor
//             { , specify_output_terminal_descriptor }                // A.7.2
//
// The list has no parentheses, and IEEE 1364-2005 14.6.4.2's examples write
// none (`pulsestyle_ondetect out, out_b;`). `pulsestyle_onevent (y);` derives
// from nothing. The legal neighbour, 63_specify_block_unsupported.va, is this
// specify block with `pulsestyle_onevent y;`.
//
// VerA refuses the `(` with E0207 and a message naming A.7.1's rule; both are
// pinned.
//
//! lrm A.7.1
//! lrm A.7.1:1000
//! reject-only E0207
//! reject-only written without parentheses
//! neighbour 63_specify_block_unsupported.va
`include "check.vh"
module annex_a_specify(p, n, y);
    inout p, n;
    electrical p, n;
    output y;

    specify
        specparam tplh = 1.5, tphl = 2.5;
        (p => y) = (tplh, tphl);
        (n *> y) = 1;
        pulsestyle_onevent (y);   // illegal: list_of_path_outputs has no parentheses
    endspecify

    analog begin
        `CHECKX("the file carrying the A.7.1 specify block compiles and runs",
                V(p, n), 0.5);
        I(p, n) <+ V(p, n);
    end
endmodule
