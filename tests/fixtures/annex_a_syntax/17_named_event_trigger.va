// A.2.1.3 `event_declaration ::= event list_of_event_identifiers ;` and
// A.6.5 `event_trigger ::= -> hierarchical_event_identifier { [ expression ] } ;`
//
// §5.10.4: "Named events can be triggered from always and initial blocks, or
// from an analog event statement", and the clause prints the analog shape this
// fixture follows —
//
//     analog begin
//        @(timer(1n)) -> ana_event;
//        @(ana_event) $display("Event: ana_event detected in analog");
//     end
//
// with `timer` swapped for `initial_step`, which is the event a dc operating
// point does carry (§5.10.2, Table 5-1). So `tick` is triggered and the
// statement waiting on it runs: `fired` ends at 1, not the 0 it was set to.
//
// WHERE THE TRIGGER MAY *NOT* GO, and why no fixture pins it yet: A.6.4's
// `analog_statement` has no `event_trigger` alternative — a bare `-> tick;` is
// only derivable in `analog_event_statement` position, i.e. under an `@(...)`,
// which is why the trigger above is written under `@(initial_step)`. The same
// A.6.4 list has no `contribution_statement` either, so `@(tick) I(p) <+ V(p);`
// is illegal too. Both are unreachable as reject fixtures while VerA refuses
// the legal declaration on line one (E0203) — a fixture pinning them today
// would go green on the wrong diagnostic, which is exactly what this file used
// to do with a bare `//! reject DiagnosticsReported`. They become testable the
// day E0203 goes away.
//
//! lrm A.2.1.3
//! lrm A.6.5
//! lrm 5.10.4
//! bias V(p) = 0.5
//! print none
//! xfail VerA does not implement named events: `event tick;` is E0203 "named event declaration is not implemented", so nothing after it is ever reached
`include "check.vh"
module annex_a_named_event(p, n);
    inout p, n;
    electrical p, n;
    event tick;
    integer fired;

    analog begin
        fired = 0;
        @(initial_step) -> tick;
        @(tick) fired = 1;
        `CHECKI("the statement waiting on a triggered named event ran", fired, 1);
        I(p, n) <+ V(p, n);
    end
endmodule
