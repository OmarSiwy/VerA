// A.8.2 writes a user function call with every argument present:
//
//     analog_function_call ::= analog_function_identifier { attribute_instance }
//             ( analog_expression { , analog_expression } )
//
// 4.7.3 binds the actuals to the formals in the order the function declares
// them, so add2(2.0, 1.0) runs a = 2.0, b = 1.0 and returns a + b = 3.0, and
// add2(V(p, n), 1.0) at V(p, n) = 0.75 - 0.25 = 0.5 returns 1.5. Both sums are
// exact in binary, so CHECKX. reject_A_8_2_empty_function_argument.va is this
// file with the first argument of the first call left empty.
//
//! lrm A.8.2
//! lrm A.8.2:1000
//! bias V(p) = 0.75, V(n) = 0.25
//! checks 2
`include "check.vh"
module annex_a_function_call_arguments(p, n);
    inout p, n;
    electrical p, n;

    analog function real add2;
        input a, b;
        real a, b;
        add2 = a + b;
    endfunction

    analog begin
        `CHECKX("add2(2.0, 1.0): a = 2.0, b = 1.0", add2(2.0, 1.0), 3.0);
        `CHECKX("add2(V(p, n), 1.0) at V(p, n) = 0.5", add2(V(p, n), 1.0), 1.5);
        I(p, n) <+ V(p, n);
    end
endmodule
