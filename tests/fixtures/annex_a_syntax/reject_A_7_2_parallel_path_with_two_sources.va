// A.7.2:
//
//     parallel_path_description ::=
//             ( specify_input_terminal_descriptor [ polarity_operator ]
//               => specify_output_terminal_descriptor )
//     full_path_description ::=
//             ( list_of_path_inputs [ polarity_operator ] *> list_of_path_outputs )
//
// A parallel (`=>`) path connects ONE source to ONE destination; lists belong
// to the full (`*>`) form. `(a, b => o)` puts a list before `=>`, which neither
// alternative derives. `(a, b *> o) = 1;` is the legal form and is accepted
// (probed).
//
// VerA refuses the path with E0207 "a parallel path (`=>`) connects one
// source to one destination".
//
//! lrm A.7.2
//! lrm A.7.2:1000
//! reject-only parallel
//! reject endspecify
//! neighbour b8_specify_paths_design_runs.va
module annex_a_parallel_two_sources(o, a, b);
  output o;
  input a, b;
  wire o, a, b;
  and g1(o, a, b);
  specify
    (a, b => o) = 1;         // illegal: a parallel path has one source
  endspecify
endmodule
