// A.3.1, the n-input gate with ONE input:
//
//     n_input_gate_instance ::= [ name_of_gate_instance ]
//             ( output_terminal , input_terminal { , input_terminal } )
//
// The braces are zero or more, so `and g1 (c, a);` is derivable, and IEEE
// 1364-2005 §7.2 (VAMS §1.1 inherits it) agrees: "These six logic gates shall
// have one output and one or more inputs." VerA refused it with E0209 ("at
// least two inputs").
//
// In an analog compile it is 56_gate_instantiation_unsupported.va's case: the
// gate is accepted and modelled by nothing (W0252), so the nets touch nothing
// the analog block reads and the answer is the same with the gate or without.
// What the gate COMPUTES — a buffer for and/or/xor, an inverter for
// nand/nor/xnor — is checked under `vera --run` by
// ieee1364/07_gate_switch_level/d08_gates_one_input.v.
//
//! lrm A.3.1
//! lrm 1.1
//! bias V(p) = 0.75, V(n) = 0.25
`include "check.vh"
module annex_a_gate_one_input(p, n);
    inout p, n;
    electrical p, n;

    wire a, c, d;
    and g1 (c, a);
    xnor g2 (d, a);

    analog begin
        `CHECKX("the file carrying one-input gates compiles and runs",
                V(p, n), 0.5);
        I(p, n) <+ V(p, n);
    end
endmodule
