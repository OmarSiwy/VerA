// §6.3.6's `badres`, the only source line in Clause 6 the LRM prints with a
// literal `// ERROR`, transcribed verbatim. The clause's own words: "The first
// example, badres, misuses the $mfactor such that the contributed current would be
// multiplied by $mfactor twice, once by the explicit multiplication and once by the
// automatic scaling rule. The simulator will generate an error for this module."
//
// The automatic rule is the first bullet of §6.3.6 — "All contributions to a branch
// flow quantity in the analog block shall be multiplied by $mfactor" — and the
// clause adds that "Verilog-AMS does not provide a method to disable" it. So the
// explicit `* $mfactor` below cannot be a deliberate opt-out; it can only be the
// double-scaling the paragraph before names: "The simulator shall issue a warning
// if it detects a misuse of the $mfactor in a manner that would result in
// double-scaling."
//
// That general sentence says WARNING while the sentence about this specific module
// says ERROR. This fixture pins the specific one, because it is the statement the
// LRM makes about this exact source; a compiler that only warns compiles the module
// and fails here, and that disagreement is worth surfacing rather than hiding
// behind a directive weak enough to pass either way.
//
// `parares` in the same clause is the legal companion — $mfactor read in a guard
// and not multiplied into the output — and is mfactor_conditional_only.va. It is
// the negative control: a check added for this file must not reject that one.
//
// No `//! reject <code>`: VerA has no diagnostic for this at all, so there is no
// code to name yet. `DiagnosticsReported` is the weakest form that still demands a
// rejection; tighten it to the E-code the day one exists.
//
//! lrm 6.3.6
//! reject DiagnosticsReported
//! xfail VerA does not detect $mfactor double-scaling: badres compiles with no diagnostic at all
module badres(a, b);
  inout a, b;
  electrical a, b;
  parameter real r = 1.0 from (0:inf);
  analog begin
    I(a,b) <+ V(a,b) / r * $mfactor; // ERROR
  end
endmodule
