// LRM 6.6: "Generate regions do not nest, and they may only occur directly
// within a module."  A `generate` inside a `generate` is therefore illegal, and
// the LRM assigns the construct no semantics -- there is no value a CHECK could
// pin, the expected behavior IS the diagnostic.
//
// KNOWN GAP: VerA has no non-nesting check.  It accepts this silently and emits
// a device, so this fixture fails until the frontend grows the rule.  Tighten
// the directive to the E-code once one exists.
//! reject DiagnosticsReported
module ch6_generate_nested_region(p);
  inout p; electrical p;
  generate
    generate
      if (1) I(p) <+ V(p);
    endgenerate
  endgenerate
endmodule
