// LRM 6.6: "Generate regions do not nest, and they may only occur directly
// within a module."  A `generate` inside a `generate` is therefore illegal, and
// the LRM assigns the construct no semantics -- there is no value a CHECK could
// pin, the expected behavior IS the diagnostic.
//
// KNOWN GAP: see the `//! xfail` below.  Tighten the reject directive to the
// E-code once one exists.
//! lrm 6.6
//! reject DiagnosticsReported
//! xfail VerA has no generate-region non-nesting check; a `generate` inside a `generate` parses and elaborates silently
module ch6_generate_nested_region(p);
  inout p; electrical p;
  generate
    generate
      if (1) I(p) <+ V(p);
    endgenerate
  endgenerate
endmodule
