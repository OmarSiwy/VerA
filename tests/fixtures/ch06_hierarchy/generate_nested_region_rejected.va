// LRM 6.6: "Generate regions do not nest, and they may only occur directly
// within a module."  A `generate` inside a `generate` is therefore illegal -- and
// not only by that sentence: `generate_region` is a `module_item` (A.4.2) and is
// absent from `module_or_generate_item`, so Syntax 6-8 gives an inner region no
// production either. The LRM assigns the construct no semantics -- there is no
// value a CHECK could pin, the expected behavior IS the diagnostic.
//
// The inner region holds an if-generate with the NULL block (`generate_block_or_null
// ::= generate_block | ;`) so that the nesting is the only thing wrong with this
// file. It used to hold a bare `I(p) <+ V(p);`, which has no production in
// Syntax 6-8 at all -- a contribution is reachable only through `analog_construct
// ::= analog analog_statement` -- so a conforming compiler would have rejected the
// body and never reported the nesting.
//
// KNOWN GAP: see the `//! xfail` below.  Tighten the reject directive to the
// E-code once one exists.
//! lrm 6.6
//! reject DiagnosticsReported
//! xfail VerA has no generate-region non-nesting check; a `generate` inside a `generate` parses and elaborates silently
module ch6_generate_nested_region(p);
  inout p; electrical p;
  generate
    generate
      if (1) ;
    endgenerate
  endgenerate
  analog I(p) <+ V(p);
endmodule
