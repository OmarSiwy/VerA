// §6.4.3 Paramset output variables, the hiding rule, observed at run time:
//
//   "If a paramset variable without a description has the same name as a
//    module output variable, the module output variable shall not be available
//    for instances using the paramset."
//
// §9.16 gives the observable: "If either the inst_name or param_name cannot be
// resolved, and the optional expression is not supplied, then an error shall
// be generated. If the optional expression is supplied, its value will be
// returned in lieu of raising an error."
//
// Two instances of the SAME module, `ch6_psfb_dev`, whose `(* desc *) real id`
// is an output variable:
//
//   u_plain  instantiates the module directly        -> `id` available
//   u_ps     instantiates it through `ch6_psfb_ps`,  -> `id` NOT available
//            which declares an undescribed `real id`
//
// BY HAND, with V(a,b) = 0.75 - 0.25 = 0.5:
//   u_plain.id = scale * 0.5 = 1.0 * 0.5 = 0.5   (probe returns the value)
//   u_ps.id    unavailable                       (probe returns the fallback, -1.0)
//   u_ps.scale = 4.0, set by the paramset        (a PARAMETER: the rule hides
//                                                 output variables only)
//
// The first line is the control: the same probe spelling on the same module
// does resolve when no paramset intervenes, so the -1.0 is the rule and not a
// probe that cannot read variables at all.
//
// `paramset_variable_hides_module_output_variable_rejected.va` is the no-
// fallback form, which is the §9.16 error.
//
//! lrm 6.4.3
//! lrm 9.16
//! bias V(p) = 0.75, V(n) = 0.25
`include "check.vh"
module ch6_psfb_top(p, n);
  inout p, n;
  electrical p, n;
  ch6_psfb_dev u_plain(p, n);
  ch6_psfb_ps u_ps(p, n);
  ch6_psfb_mon u_mon(p, n);
endmodule

paramset ch6_psfb_ps ch6_psfb_dev;
  real id;
  .scale = 4.0;
endparamset

module ch6_psfb_dev(a, b);
  inout a, b;
  electrical a, b;
  parameter real scale = 1.0;
  (* desc = "branch current" *) real id;
  analog begin
    id = scale * V(a, b);
    I(a, b) <+ id;
  end
endmodule

module ch6_psfb_mon(a, b);
  inout a, b;
  electrical a, b;
  real plain_id, ps_id, ps_scale;
  analog begin
    plain_id = $simprobe("u_plain", "id", -1.0);
    ps_id = $simprobe("u_ps", "id", -1.0);
    ps_scale = $simprobe("u_ps", "scale", -1.0);
    `CHECKX("without a paramset the module's output variable is available", plain_id, 0.5);
    `CHECKX("an undescribed paramset variable of the same name hides it: the fallback", ps_id, -1.0);
    `CHECKX("the paramset's parameter is still reachable", ps_scale, 4.0);
    I(a, b) <+ 0.0 * V(a, b);
  end
endmodule
