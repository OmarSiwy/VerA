// What an instance is worth when nobody says anything: the un-overridden final
// default, at both levels of a paramset — and, beside it, the one thing §9.19
// states in so many words about $param_given.
//
// §6.4: "A paramset provides a convenient way to collect parameter values for a
// particular module, such that an instance need only provide overrides for a
// smaller number of parameters." §3.4.1: "A default value for the parameter shall
// be specified", and §3.4's list of override mechanisms is exhaustive — a
// parameter nothing overrides keeps its declaration assignment.
//
// THE NUMBERS, each a different path through the same instance:
//
//   k         = 3.0 * w = 3.0 * 2.0 = 6.0   the paramset's own default w,
//                                           un-overridden, feeding a module
//                                           parameter the paramset DOES set
//   untouched = 7.5                         the module's own default, for a
//                                           parameter no paramset statement and
//                                           no instance override mentions
//   $param_given(untouched) = 0             nothing overrode it, by any mechanism
//   tdevice   = 27.0, $param_given = 1      a MODULE INSTANCE PARAMETER VALUE
//                                           ASSIGNMENT of exactly the declared
//                                           default
//
// The first is the one that can go wrong quietly: a paramset parameter left at its
// default is still an INPUT to the module's value, so an implementation that only
// propagates overridden paramset parameters leaves k at the module default 0.0 and
// the device becomes an open circuit rather than a 6 S conductance. The second is
// the "unused model default" the plan warns must not be rejected: `untouched` is
// never mentioned by the paramset, and that is legal, not an error. The
// contribution is k*V = 6.0 * 0.5 = 3.0 A.
//
// §9.19 AND WHY THE 1 IS ASSERTED ON A SECOND INSTANCE. "The return value shall
// be one (1) if the parameter was overridden, EITHER BY A DEFPARAM STATEMENT OR BY
// A MODULE INSTANCE PARAMETER VALUE ASSIGNMENT, and zero (0) otherwise." Both
// halves are pinned here, but only on bindings that sentence actually names:
//
//   * zero: `untouched` is at its declaration default and no mechanism of any
//     kind touched it, so every reading of §9.19 answers 0.
//   * one: `h01_given_probe #(.tdevice(27.0))` is literally a module instance
//     parameter value assignment, and 27.0 is literally the declared default —
//     §9.19's own worked example is this case ("It is important to be able to
//     distinguish the case where tdevice has its default value (say, 27) from the
//     declaration statement from the case where the value 27 was in fact
//     specified as an override, if the simulation is performed at a different
//     temperature").
//
// The pair is what gives the check teeth. An implementation returning a constant
// 0 fails the probe; one returning a constant 1 fails `untouched`; and one that
// computes $param_given by comparing the final value against the declaration
// default — the obvious cheap implementation — passes `untouched` and fails the
// probe, because there the two values are the same number.
//
// WITHDRAWN, AND WHERE IT WENT. This fixture used to assert
// `$param_given(k) == 1` for a value supplied by a PARAMSET STATEMENT. §9.19's
// normative sentence enumerates two mechanisms and a paramset statement is
// neither of them; the preceding descriptive sentence ("whether a parameter value
// was obtained from the default value in its declaration statement or if that
// value was overridden") reads the other way, since k is plainly not its
// declaration default here. The clause does not settle it, so the row does not
// assert it: the claim is withdrawn and is made nowhere else in the suite — no
// row owns it, and tests/fixtures/ch06_hierarchy/h01_SPEC.md at 8b1514d4 records it as withdrawn rather than covered. It comes
// back if §9.19's list grows a third item, or if §6.4 says a paramset statement
// is a module instance parameter value assignment made on the instance's behalf.
// VerA answers 1 today, which is the reading this row would have taken; tests/fixtures/ch06_hierarchy/h01_SPEC.md at 8b1514d4
// keeps that as an observation, not a claim.
//
// GROUND TRUTH TODAY: green, all five, and previously unasserted — ch06_hierarchy's
// paramset fixtures all override something. Kept as the evidence for a row the
// audit found claimed but untested.
//
//! lrm 6.4
//! lrm 3.4.1
//! lrm 9.19
//! bias V(p) = 0.5
`include "check.vh"
module h01_defaults(p, n);
  inout p, n; electrical p, n;
  h01_defaults_ps u(p, n);
  h01_given_probe #(.tdevice(27.0)) g(p, n);
endmodule

paramset h01_defaults_ps h01_defaults_base;
  parameter real w = 2.0 from (0:inf);
  .k = 3.0 * w;
endparamset

module h01_defaults_base(a, b);
  inout a, b; electrical a, b;
  parameter real k = 0.0;
  parameter real untouched = 7.5;
  analog begin
    `CHECKX("the paramset's own un-overridden default feeds the module value", k, 6.0);
    `CHECKX("a module parameter no paramset statement names keeps its default", untouched, 7.5);
    `CHECKI("$param_given is 0 for the parameter no mechanism overrode", $param_given(untouched), 0);
    `CHECKX("so the current is 6.0 * 0.5 V", k * V(a, b), 3.0);
    I(a, b) <+ k * V(a, b);
  end
endmodule

// §9.19's own tdevice example: the override and the declared default are the
// same number, so only a $param_given that tracks the BINDING can answer 1.
module h01_given_probe(a, b);
  inout a, b; electrical a, b;
  parameter real tdevice = 27.0;
  analog begin
    `CHECKX("the instance override carries the declared default value itself", tdevice, 27.0);
    `CHECKI("$param_given is 1 for a module instance parameter value assignment", $param_given(tdevice), 1);
    I(a, b) <+ 0.0;
  end
endmodule
