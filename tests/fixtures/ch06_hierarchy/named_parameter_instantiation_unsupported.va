// §6.3, module instance parameter value assignment BY NAME: "which allows values
// to be assigned in-line during module instantiation by explicitly associating
// parameter names with the overriding values." The LRM's §6.2.2 example writes
// `d2a #(.width(1)) D1(...)`, so this is legal source; it used to be a
// `//! reject`, which inverted the test.
//
// The instance overrides ONLY the second declared parameter, `.offset(3.0)`, and
// that is what separates this fixture from its ordered sibling
// parameterized_instantiation_unsupported.va. A compiler that quietly treated the
// list as positional would put 3.0 into `gain` and leave `offset` at 0.0 — so
// gain = 1.0 and offset = 3.0 is the discriminating pair, and $param_given is 0
// for gain and 1 for offset (§9.19), which no positional reading can produce.
//
// With V(p,n) = 0.5 the contribution is 1.0 * 0.5 + 3.0 = 3.5 exactly; a
// positional misread would give 3.0 * 0.5 + 0.0 = 1.5.
//
//! lrm 6.3
//! lrm 6.2.2
//! bias V(p) = 0.75, V(n) = 0.25
//! xfail VerA compiles one flat module, so a module instantiation is refused outright at E0204 "module instantiation is not supported"
`include "check.vh"
module ch6_parent_named(p, n);
  inout p, n; electrical p, n;
  ch6_pn_child #(.offset(3.0)) u(p, n);
endmodule

module ch6_pn_child(a, b);
  inout a, b; electrical a, b;
  parameter real gain = 1.0;
  parameter real offset = 0.0;
  analog begin
    `CHECKX("the named override reaches the parameter it names", offset, 3.0);
    `CHECKI("and counts as an override", $param_given(offset), 1);
    `CHECKX("the unnamed parameter keeps its declared default", gain, 1.0);
    `CHECKI("and is NOT reported as overridden", $param_given(gain), 0);
    `CHECKX("so the child stamps gain*V + offset", gain * V(a, b) + offset, 3.5);
    I(a, b) <+ gain * V(a, b) + offset;
  end
endmodule
