// LRM §6.2, the non-ANSI module form: the header carries a bare ORDERED list of
// port identifiers, and "the identifiers in the port list shall be declared in
// input, output, or inout declaration statements within the body". Direction
// and discipline arrive on separate lines, and the binding is by POSITION.
//
// The testbench holds the two nodes apart — V(p) = 0.75, V(n) = 0.25, both
// binary-exact — so the branch potential is exactly 0.5. Bind the list the
// other way round and it is -0.5; collapse the two names onto one node and it
// is 0.
//
//! lrm 6.2
//! lrm 6.5.2
//! lrm 6.5.2:1000
//! bias V(p) = 0.75, V(n) = 0.25
`include "check.vh"
module ch6_nonansi(p, n);
  inout p;
  output n;
  electrical p, n;
  analog begin
    `CHECKX("the body declarations bind to the header's ordered port list", V(p, n), 0.5);
    V(n) <+ V(p);
  end
endmodule
