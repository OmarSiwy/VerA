// §6.2.2: "A connection can be a simple reference to a variable or a net
// identifier, an expression or a blank. A blank port connection shall represent
// the situation where the port is not to be connected." The blank is legal
// source — `ordered_port_connection ::= { attribute_instance } [ expression ]`
// makes the expression OPTIONAL in Syntax 6-2 — so a conforming compiler accepts
// `u(p, , n)` and this is a run fixture, not the `//! reject` it used to be.
//
// This is the one place in the chapter where $port_connected has a 0 that is the
// LRM's and not a harness convention: §9.19 gives one "if the port was connected
// to a net (by order or by name) when the module was instantiated, and zero (0)
// otherwise", and the middle position is explicitly not to be connected. So the
// three answers are 1, 0, 1 — a compiler that dropped the blank and shifted the
// list left would connect `mid` to n and leave `b` blank, reporting 1, 1, 0.
//
// The bias makes the survivors checkable too: p = 0.75 V, n = 0.25 V, so
// V(a,b) = 0.5 exactly, which also proves the blank did not shift the binding.
//
//! lrm 6.2.2
//! lrm 6.5.6
//! bias V(p) = 0.75, V(n) = 0.25
//! xfail VerA compiles one flat module, so a module instantiation is refused outright at E0204 "module instantiation is not supported"
`include "check.vh"
module ch6_blank_ordered_parent(p, n);
  inout p, n; electrical p, n;
  ch6_blank_child u(p, , n);
endmodule

module ch6_blank_child(a, mid, b);
  inout a, mid, b; electrical a, mid, b;
  analog begin
    `CHECKI("the first ordered connection is a net, so connected", $port_connected(a), 1);
    `CHECKI("a BLANK ordered connection leaves the port unconnected", $port_connected(mid), 0);
    `CHECKI("the third is a net again, so the blank did not shift the list", $port_connected(b), 1);
    `CHECKX("and a and b still straddle the biased pair", V(a, b), 0.5);
    I(a, b) <+ V(a, b);
  end
endmodule
