// §6.3.6 Geometrical system parameters: "The five geometrical system parameters
// ($xposition, $yposition, $angle, $hflip, $vflip) do not have any automatic
// effect on the simulation. The paramset or module may use these values to
// compute geometric layout-dependent effects", followed by the clause's
// `polyres` example, whose resistivity is a linear gradient over position:
//
//     rho = rho_nominal + $xposition * drho_dx + $yposition * drho_dy;
//     reff = rho * length / width;
//
// This is that resistor with the process constants as its own parameters
// rather than an out-of-module `processinfo` (the example assumes a second
// top-level module, which is not the rule under test), placed by the parent
// with `.$xposition(2.0), .$yposition(4.0)` (§6.3.6: system parameters are
// overridden "by name ... prefixed by a period").
//
// BY HAND. The parent is the top, so Table 9-29 gives the instance
//   $xposition = 2.0 + 0.0 = 2.0 m,   $yposition = 4.0 + 0.0 = 4.0 m
// and with rho_nominal = 1.0, drho_dx = 0.25, drho_dy = 0.5:
//   rho  = 1.0 + 2.0 * 0.25 + 4.0 * 0.5 = 3.5
//   reff = 3.5 * 1.0 / 0.5            = 7.0
// At the instance's origin (no override) rho would be 1.0 and reff 2.0. Every
// value is exact in binary.
//
//! lrm 6.3.6
//! lrm 6.3.6:9
//! lrm 9.18
//! bias V(p) = 0.75, V(n) = 0.25
//! checks 4
`include "check.vh"
module b4_geo_top(p, n);
  inout p, n; electrical p, n;
  b4_geo_polyres #(.$xposition(2.0), .$yposition(4.0)) r1(p, n);
endmodule

module b4_geo_polyres(a, b);
  inout a, b; electrical a, b;
  parameter real length = 1.0 from (0:inf);
  parameter real width = 0.5 from (0:inf);
  parameter real rho_nominal = 1.0, drho_dx = 0.25, drho_dy = 0.5;
  real rho, reff;
  analog begin
    rho = rho_nominal + $xposition * drho_dx + $yposition * drho_dy;
    reff = rho * length / width;
    `CHECKX("the instance sits at the x offset its parent gave it", $xposition, 2.0);
    `CHECKX("and at the y offset", $yposition, 4.0);
    `CHECKX("so the gradient gives rho = 1 + 2*0.25 + 4*0.5", rho, 3.5);
    `CHECKX("and the layout-dependent resistance 3.5 * 1 / 0.5", reff, 7.0);
    I(a, b) <+ V(a, b) / reff;
  end
endmodule
