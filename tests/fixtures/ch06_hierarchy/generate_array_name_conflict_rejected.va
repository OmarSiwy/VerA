// §6.6.1, verbatim: "If the generate block is named, IT IS A DECLARATION OF AN
// ARRAY OF GENERATE BLOCK INSTANCES ... IT SHALL BE AN ERROR IF THE NAME OF A
// GENERATE BLOCK INSTANCE ARRAY CONFLICTS WITH ANY OTHER DECLARATION, including any
// other generate block instance array."
//
// `begin : g` inside a loop generate construct is therefore not a label — it
// declares `g` in the enclosing module scope, as an array indexed by the values the
// genvar takes. `real g;` declares `g` in that same scope. Two items, one
// identifier, one scope: the clause makes it an error, and §6.8 says the same in
// general terms ("An identifier shall be used to declare only one item within a
// scope ... For generate blocks, this rule applies regardless of whether the
// generate block is instantiated").
//
// The pairing with a plain variable is deliberate. A compiler that kept generate
// block names in a table of their own — which is the natural way to build one —
// passes any test that collides two generate blocks with each other and still
// fails this, because the rule is that the array name lands in the ORDINARY
// declaration space of the module.
//
// No `//! reject <code>`: VerA has no diagnostic here, so there is no code to name.
// `DiagnosticsReported` is the weakest form that still demands a rejection;
// tighten it to the E-code the day one exists.
//
//! lrm 6.6.1
//! lrm 6.8
//! reject DiagnosticsReported
//! xfail VerA does not declare a named generate block's instance array in the module scope, so `begin : g` and `real g;` coexist silently
module ch6_generate_array_name_conflict(p);
  inout p; electrical p;
  real g;
  genvar i;
  generate
    for (i = 0; i < 2; i = i + 1) begin : g
      localparam integer k = i;
    end
  endgenerate
  analog begin
    g = 1.0;
    I(p) <+ g * V(p);
  end
endmodule
