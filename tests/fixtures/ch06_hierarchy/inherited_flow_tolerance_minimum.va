// The source branch spans a node shared by a loose-flow parent and a
// tight-flow child. Its current unknown must use min(1n, 1p) = 1p.
// Reading p.flow.abstol alone would only check the segment's local attribute.
//! lrm 6.5.8:1001
//! solve
//! abstol I(p) = 1e-12
//! checks 2
`include "check.vh"
nature loose_current;
  units="A"; access=I; abstol=1n;
endnature
nature tight_current : loose_current;
  abstol=1p;
endnature
discipline loose_flow;
  potential Voltage; flow loose_current;
enddiscipline
discipline tight_flow;
  potential Voltage; flow tight_current;
enddiscipline
module flow_tolerance_child(p);
  inout p; tight_flow p;
  analog I(p) <+ V(p)/1000;
endmodule
module inherited_flow_tolerance_minimum;
  loose_flow p;
  branch (p) source;
  flow_tolerance_child u(p);
  analog begin
    V(source) <+ 1.0;
    `CHECKX("source holds the shared node", V(p), 1.0);
  end
endmodule
