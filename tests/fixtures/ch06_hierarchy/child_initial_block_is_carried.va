// §6.2.2 instantiation carries the WHOLE module: IEEE 1364 Clause 12, which
// §6.2 builds on, gives every instance its own copy of the definition's items,
// and §7.2.2 puts an `initial` block in the discrete context wherever it is
// written — "assignment statements within an initial or always block" — with no
// exception for a module that happens to be instantiated. So the child's
// `initial` below runs for instance `u` exactly as it would if `ch6_ib_child`
// were the top.
//
// DERIVATION. §7.2.2: "The domain of a variable is that of the context from
// which its value is assigned", so `k` is the discrete context's, written once
// before the analysis: k = 3 for the whole run. The child's analog block reads
// it (§7.3.1 Table 7-1, an integer read as an integer). With V(p,n) = 0.5 the
// child stamps I = k * V = 3 * 0.5 = 1.5, exact in binary.
//
// THE DEFECT THIS PINS. Elaboration flattens `u` into the top, and it used to
// copy the child's analog blocks and nothing of its discrete half — so this file
// compiled silently and read §3.2's analog default, k = 0. A compiler that drops
// the block reads 0 and 0.0 below.
//
// digital_initial_accepted.va (ch07) is the same block with no hierarchy.
//
//! lrm 6.2.2
//! lrm 7.2.2
//! bias V(p) = 0.75, V(n) = 0.25
`include "check.vh"
module ch6_child_initial(p, n);
  inout p, n; electrical p, n;
  ch6_ib_child u(p, n);
endmodule

module ch6_ib_child(a, b);
  inout a, b; electrical a, b;
  integer k;
  initial k = 3;
  analog begin
    `CHECKI("an instantiated child's initial block runs", k, 3);
    `CHECKX("so the child stamps k * V", k * V(a, b), 1.5);
    I(a, b) <+ k * V(a, b);
  end
endmodule
