// §6.3.1 permits a hierarchical target and evaluates the RHS in the declaring
// module. The top's base=3 sets middle.u[0].w=2*3+1=7. The middle's base=5
// sets u[1].w=5+3=8. They must not accidentally read each other's base.
// Selection is per ARRAY ELEMENT, so both replace the inline low-bin w=2
// independently. High computes gain=3*w: 21 and 24 siemens. A 45 A source
// feeding the two parallel instances gives V(p)=45/(21+24)=1 V. Each leaf
// also checks its gain is one of those two hand-derived values; the sum
// distinguishes 21+21 and 24+24. A pre-array choice of low gives 14+16 and
// 1.5 V. Reading either RHS in the other module's scope gives the wrong sum
// (or an out-of-range value), so neither a constant bin nor a shared scope
// can satisfy these checks. Indexed hierarchy expression reads are not used.
//! lrm 6.3.1
//! lrm 6.4.2
//! lrm 6.4.2:4
//! solve
//! checks 3
`include "check.vh"
module ps_outer_hierarchy;
  electrical p;
  localparam real base=3.0;
  ps_outer_middle #(.base(5.0)) middle(p);
  defparam middle.u[0].w=2.0*base+1.0;
  analog begin
    `CHECK("both scoped overrides select and execute their high bins", V(p), 1.0, 1e-12);
    I(p) <+ -45.0;
  end
endmodule
module ps_outer_middle(p);
  inout p; electrical p;
  parameter real base=1.0;
  ps_hier_bin #(.w(2.0)) u[1:0](p);
  defparam u[1].w=base+3.0;
endmodule
paramset ps_hier_bin ps_hier_leaf;
  parameter real w=1.0 from [0:4);
  .gain=2.0*w;
endparamset
paramset ps_hier_bin ps_hier_leaf;
  parameter real w=0.0 from [4:10];
  .gain=3.0*w;
endparamset
module ps_hier_leaf(p);
  inout p; electrical p;
  parameter real gain=1.0;
  branch (p) br;
  analog begin
    `CHECKI("each selected leaf has a derived high-bin gain", gain==21.0 || gain==24.0, 1);
    I(br) <+ gain*V(br);
  end
endmodule
