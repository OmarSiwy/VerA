// §6.3.6's `parares`, transcribed verbatim and given assertions. The clause: "In
// this second example, parares, $mfactor is used only in the conditional
// expression and does not scale the output. NO ERROR WILL BE GENERATED FOR THIS
// MODULE. In cases where the effective resistance r/$mfactor would be too small,
// the resistance is simply shorted out."
//
// It is the negative control for mfactor_double_scaling_rejected.va (`badres`).
// The two modules differ by where $mfactor appears, not by whether it appears, so
// a double-scaling check that keys on the mere presence of $mfactor in an analog
// block rejects this one too — and this file is what stops that check from
// shipping. Reading $mfactor is always legal; multiplying a flow contribution by
// it is the misuse.
//
// Nothing overrides $mfactor, so Table 9-29 fixes it at the top-level 1.0 and the
// guard is `1.0 / 1.0 < 1.0e-3`, which is false. The else branch is the one taken,
// and it stamps V(a,b)/r with no $mfactor in it at all. The guard's verdict is
// asserted as a number rather than tested with an `if`: a comparison is an integer
// in Verilog-A (§4.2.5), which keeps the assertion unconditional.
//
// Held at V(a) = 0.75 and V(b) = 0.25, V(a,b) is 0.5 and r is its declared 1.0, so
// the branch stamps 0.5 — every value binary-exact, hence CHECKX. A compiler that
// applied the §6.3.6 flow rule to this contribution would still stamp 0.5 here,
// because $mfactor is 1.0; what this file pins is that the module is ACCEPTED and
// that the guard resolves the way the clause describes.
//
//! lrm 6.3.6
//! lrm 6.3.6:8
//! lrm 6.3.6:1
//! bias V(a) = 0.75, V(b) = 0.25
`include "check.vh"
module parares(a, b);
  inout a, b;
  electrical a, b;
  parameter real r = 1.0 from (0:inf);
  analog begin
    `CHECKI("r/$mfactor is not below the short-out threshold", (r / $mfactor < 1.0e-3), 0);
    `CHECKX("so the else branch is taken and stamps V(a,b)/r, unscaled", V(a,b) / r, 0.5);
    if (r / $mfactor < 1.0e-3)
      V(a,b) <+ 0.0;
    else
      I(a,b) <+ V(a,b) / r;
  end
endmodule
