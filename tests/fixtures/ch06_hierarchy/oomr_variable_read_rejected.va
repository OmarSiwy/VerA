// §6.7.1, fifth bullet: "It shall be an error to access analog variables
// hierarchically." Unlike its neighbours in the same list — branch potentials and
// flows, parameters, analog user defined functions, all of which the clause
// expressly PERMITS through a hierarchical name — an analog variable is off
// limits, so this rejection is correct conformance and carries no `//! xfail`.
//
// `device` is a real instance and `local_value` a real variable of it, so the
// path resolves and the ONLY defect is the one the bullet names: renaming
// `local_value` to a parameter of the child makes the read legal
// (oomr_parameter_unsupported.va). VerA refuses it with E0910, the §6.7.1 code.
//
//! lrm 6.7.1
//! lrm 6.7.1:3
//! reject-only E0910
//! neighbour oomr_parameter_unsupported.va
`include "disciplines.vams"
module ch6_oomr_variable_read(p);
  inout p; electrical p;
  ch6_oomr_variable_read_child device(p);
  analog I(p) <+ device.local_value;
endmodule

module ch6_oomr_variable_read_child(a);
  inout a; electrical a;
  real local_value;
  analog begin
    local_value = 1.0;
    I(a) <+ V(a);
  end
endmodule
