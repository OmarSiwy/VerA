// §6.7.1, first bullet: "Potential and flow access for named and unnamed
// branches (including port branches) can be done hierarchically." §6.7's own
// example paths are more than one instance deep (`top.block1.opamp1.outstage`),
// so this pins the DEPTH of the resolution where the sibling fixture
// (`ch05_analog_behavior/child_named_branch_potential_and_flow_access.va`) pins one level: `V(u.v.b)` names a
// branch declared two instances down, through a middle module that adds a level
// of renaming and nothing else.
//
// The leaf's `branch (a, b) b` is flattened to `u.v.b` over the nodes its
// terminals were BOUND to — the middle's ports, themselves bound to the top's
// (p, n) — so the probe reads the parent's own pair through the two-deep name.
// The leaf retains 0.625 on it (§5.6.1.2), a potential source; with
// V(n) = 0 the source holds V(p) at 0.625, and the probe reads the source's
// own value exactly (0.625 is dyadic, exact in IEEE 754). The top's own
// `I(p, n) <+ V(u.v.b)` pushes 0.625 A from p to n, so KCL at p fixes the
// same branch's flow at -0.625 A; both quantities are read through the
// two-deep name.
//
//! lrm 6.7.1
//! lrm 5.5.5
//! lrm 6.7.1:1
//! lrm 6.7:1004
//! bias V(n) = 0.0
//! solve
//! checks 2
`include "check.vh"
module ch6_obp2_top(p, n);
  inout p, n; electrical p, n;
  ch6_obp2_mid u(p, n);
  analog begin
    `CHECKX("a branch probe resolves through two instance levels", V(u.v.b), 0.625);
    `CHECKX("and the source supplies the parent's nonzero flow contribution", I(u.v.b), -0.625);
    I(p, n) <+ V(u.v.b);
  end
endmodule

module ch6_obp2_mid(a, b);
  inout a, b; electrical a, b;
  ch6_obp2_leaf v(a, b);
endmodule

module ch6_obp2_leaf(x, y);
  inout x, y; electrical x, y;
  branch (x, y) b;
  analog V(b) <+ 0.625;
endmodule
