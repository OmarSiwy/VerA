// §6.2.2: "When connecting ports by name, an unconnected port can be indicated
// either by omitting it in the port list or by providing no expression in the
// parentheses [i.e., .port_name ()]". This file pins the SECOND of the two
// spellings; its sibling omitted_named_connection_unsupported.va pins the first,
// and the point of having both is that the LRM says they mean the same thing.
// Legal source, so a run fixture and not the `//! reject` it used to be.
//
// `.mid()` is written explicitly, so a compiler cannot reach the right answer by
// treating the empty parentheses as a syntax error, nor by treating a mentioned
// port as connected: §9.19's "connected to a net" is false for `mid`, giving 0,
// while `a` and `b` give 1. With p = 0.75 V and n = 0.25 V, V(a,b) = 0.5 exactly,
// which pins that the named binding survived the empty entry in the middle.
//
//! lrm 6.2.2
//! lrm 6.5.6
//! bias V(p) = 0.75, V(n) = 0.25
//! xfail VerA compiles one flat module, so a module instantiation is refused outright at E0204 "module instantiation is not supported"
`include "check.vh"
module ch6_empty_named_parent(p, n);
  inout p, n; electrical p, n;
  ch6_empty_child u(.a(p), .mid(), .b(n));
endmodule

module ch6_empty_child(a, mid, b);
  inout a, mid, b; electrical a, mid, b;
  analog begin
    `CHECKI("a named connection to a net is connected", $port_connected(a), 1);
    `CHECKI(".mid() with no expression is UNconnected, though it is named", $port_connected(mid), 0);
    `CHECKI("the last named connection is unaffected", $port_connected(b), 1);
    `CHECKX("and the named bindings still straddle the biased pair", V(a, b), 0.5);
    I(a, b) <+ V(a, b);
  end
endmodule
