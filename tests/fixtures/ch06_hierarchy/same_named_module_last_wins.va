// IEEE 1364-2005 §13.2.1.1: "If multiple cells with the same name map to the
// same library, then the LAST cell encountered shall be written to the
// library. ... In the case where multiple modules with the same name are
// mapped to the same library in a single invocation of the compiler, then a
// warning message shall be issued."
//
// §4.11 ("the name shall not be used again to declare another module")
// predates libraries; §13.2.1.1 names this exact case and is the specific
// rule (Vague_Decisions VD-009). The digital path already binds the later
// cell (`ieee1364/13_configuration/b_13_2_1_1_same_name_cell_last_wins.v`);
// this is the analog elaborator agreeing with it.
//
// Two `vd9_leaf` modules load the node with different conductances. The top
// drives 1 mA into `a` through its own 1 kohm shunt:
//   first  vd9_leaf (1 kohm):  V/1000 + V/1000 = 1e-3  ->  V(a) = 0.5
//   second vd9_leaf (3 kohm):  V/1000 + V/3000 = 1e-3  ->  V(a) = 0.75
// The later definition is the cell, so 0.75; a first-wins elaborator reads 0.5.
//
// The warning is W1152, at the second definition. The rule has no invalid
// form: a redefinition is legal with a warning, so there is no rejection
// fixture to pair this with.
//
//! inherited IEEE 1364-2005 13.2.1.1
//! lrm 6.2.2
//! warn W1152
//! solve
//! checks 1
`include "check.vh"
module vd9_leaf(p);
  inout p; electrical p;
  analog I(p) <+ V(p) / 1000.0;
endmodule
module vd9_leaf(p);
  inout p; electrical p;
  analog I(p) <+ V(p) / 3000.0;
endmodule
module vd9_top;
  electrical a;
  vd9_leaf u(a);
  analog begin
    I(a) <+ V(a) / 1000.0 - 1e-3;
    `CHECK("the later same-named module is the one instantiated", V(a), 0.75, 1e-9);
  end
endmodule
