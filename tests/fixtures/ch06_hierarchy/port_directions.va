// LRM 6.5 / 3.5: a non-ANSI header lists the port names, and the separate
// `input`/`output`/`inout` declarations give each one its direction. Direction
// constrains USE, not binding: every port names its own node, in the order the
// header lists them. So biasing i and io separately must be visible as two
// distinct probes, and their difference is the branch potential of 4.4.1.
//
// i at 0.4 V, io at 0.3 V: V(i) = 0.4, V(io) = 0.3, V(i,io) = 0.1. Swap the
// binding of any two ports and all three numbers move.
//
//! lrm 6.5.2.2
//! lrm 6.5.2
//! lrm 6.5.2:1000
//! bias V(i) = 0.4
//! bias V(io) = 0.3
`include "check.vh"
module ch6_directions(i, o, io);
  input i; output o; inout io;
  electrical i, o, io;
  analog begin
    `CHECK("the input port probes its own node", V(i), 0.4, 1e-15);
    `CHECK("the inout port probes its own node", V(io), 0.3, 1e-15);
    `CHECK("branch potential is the difference of the two nodes", V(i, io), 0.1, 1e-15);
    V(o) <+ V(i);
    I(io) <+ V(io);
  end
endmodule
