// §6.2.2, ordered port connection: "When a list of port connections is given
// using the ordered port connection method, the first element in the list shall
// connect to the first port declared in the module, the second to the second
// port, and so on." The LRM's own §6.2.2 example instantiates comparator C2 this
// way, so a conforming compiler must accept this file — which is why it is no
// longer a `//! reject`. Written that way it demanded a diagnostic the LRM never
// asked for, and only VerA could have passed it.
//
// The digits come from the bias and the order. p = 0.75 V and n = 0.25 V, so
// V(p,n) = 0.5 exactly (both are dyadic rationals). ch6_mi_child is instantiated
// `u(p, n)`, so its first declared port `a` binds to p and its second, `b`, binds
// to n, and the child sees V(a,b) = +0.5. A compiler that bound the list in
// reverse sees -0.5, so the sign alone catches it; one that bound both to the
// same net sees 0.0. gain is 3.0 by declaration and nothing overrides it here, so
// the child's contribution is 3.0 * 0.5 = 1.5 A.
//
// $param_given is 0 because an instantiation with no `#(...)` overrides nothing
// (§9.19), and $port_connected is 1 for both ports because both appear in the
// list (§6.5.6) — those are the two facts the mere existence of the instance
// fixes, independent of the numbers.
//
//! lrm 6.2.2
//! bias V(p) = 0.75, V(n) = 0.25
//! xfail VerA compiles one flat module, so a module instantiation is refused outright at E0204 "module instantiation is not supported"
`include "check.vh"
module ch6_parent(p, n);
  inout p, n; electrical p, n;
  ch6_mi_child u(p, n);
endmodule

module ch6_mi_child(a, b);
  inout a, b; electrical a, b;
  parameter real gain = 3.0;
  analog begin
    `CHECKX("the first connection binds to the first declared port", V(a, b), 0.5);
    `CHECKI("a port named in the connection list is connected", $port_connected(a), 1);
    `CHECKI("and so is the second", $port_connected(b), 1);
    `CHECKI("an instantiation with no #() overrides nothing", $param_given(gain), 0);
    `CHECKX("so the child stamps gain * V(a,b)", gain * V(a, b), 1.5);
    I(a, b) <+ gain * V(a, b);
  end
endmodule
