//! reject module instantiation is not supported
// EXPECT: error -- FastVAF deliberately compiles one flattened device.
module ch6_parent(p);
  inout p; electrical p;
  child u(p);
endmodule
