// LRM 6.6: "all expressions in generate schemes shall be constant expressions,
// deterministic at elaboration time."  `runtime_value` is an integer VARIABLE,
// so the if-generate condition is not elaboration-time constant.  The LRM gives
// the construct no semantics -- the expected behavior IS the diagnostic.
//
// KNOWN GAP: see the `//! xfail` below.  Tighten the reject directive to the
// E-code once one exists.
//! lrm 6.6
//! reject DiagnosticsReported
//! xfail VerA has no constant-expression check on a generate scheme; the if-generate condition may name a runtime `integer` and it elaborates silently
module ch6_generate_nonconstant(p);
  inout p; electrical p; integer runtime_value;
  generate
    if (runtime_value) I(p) <+ V(p);
  endgenerate
endmodule
