//! reject expected `)`
// EXPECT: error -- genblk<n> external names exist only after generate elaboration.
module ch6_external_genblk_reference(p);
  inout p; electrical p;
  parameter integer enabled = 1;
  generate
    if (enabled) begin
      electrical internal;
    end
  endgenerate
  analog I(p) <+ V(genblk1.internal);
endmodule
