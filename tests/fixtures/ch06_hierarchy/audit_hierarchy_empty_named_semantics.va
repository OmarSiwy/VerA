// AMS6.3.3 empty associations retain defaults;9.19 only a value override
// makes param_given true. g defaults to a+1, so overriding a4 yields g5;
// empty alias ag supplies no replacement expression. Offset7 is explicitly
// given even though it equals its default. A child empty mfactor retains
// its parent's specified factor4 (AMS9.18), rather than multiplying by zero.
//! lrm 6.3.3
//! lrm 6.3.4
//! lrm 9.18
//! lrm 9.19
//! lrm 6.3.3:2
//! lrm 6.3.4:1000
//! lrm 6.3.5
//! lrm 6.3.5:1000
//! lrm 6.3.6
//! lrm 6.3.6:2
//! lrm 9.18:1000
//! lrm 9.19:4
//! checks 6
`include "check.vh"
module audit_hierarchy_empty_named_semantics(p);
  inout p; electrical p;
  audit_empty_mid #(.$mfactor(4.0)) u(p);
endmodule
module audit_empty_mid(p);
  inout p; electrical p;
  audit_empty_leaf #(.a(4.0),.ag(),.offset(7.0),.$mfactor()) v(p);
endmodule
module audit_empty_leaf(p);
  inout p; electrical p;
  parameter real a=2.0,g=a+1.0,offset=7.0;
  aliasparam ag=g;
  analog begin
    `CHECKX("empty alias retains updated dependency",g,5.0);
    `CHECKI("empty alias does not give target",$param_given(g),0);
    `CHECKI("explicit a was given",$param_given(a),1);
    `CHECKI("explicit equal-default value was given",$param_given(offset),1);
    `CHECKX("empty mfactor propagates parent",$mfactor,4.0);
    `CHECKX("explicit equal-default value retained",offset,7.0);
    I(p)<+g*V(p);
  end
endmodule
