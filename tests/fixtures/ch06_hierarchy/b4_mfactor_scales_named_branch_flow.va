// §6.3.6 $mfactor automatic scaling, the first two rules, on §3.12 named
// branches: "All contributions to a branch flow quantity in the analog block
// shall be multiplied by $mfactor. The value returned by any branch flow probe
// in the analog block, including those used in indirect assignments, shall be
// divided by $mfactor." §3.12: "A branch is a path between two nets ...
// Explicitly declared branches are referred to as named branches." A named
// branch's flow is a branch flow quantity like an unnamed one's, so both rules
// reach it. b4_mfactor_multiplies_a_flow_contribution.va and
// b4_mfactor_divides_a_flow_probe.va are the same two circuits on unnamed
// branches.
//
// THE CIRCUITS, side by side under one top, V(p) = 1 V and V(n) = 0 V held:
//  1. u1, `.$mfactor(3.0)`, a 1 ohm resistor written `I(br) <+ V(br) / 1.0`
//     on `branch (a, b) br`, from the top's internal node x to n. The top
//     joins p to x with a 0 V source, `V(p, x) <+ 0.0`, whose branch flow is
//     an ammeter (Kirchhoff's flow law at x).
//  2. u2, `.$mfactor(2.0)`, a short `V(sb) <+ 0.0` on `branch (a, b) sb`, from
//     the top's internal node y to n. The top pushes 2 A from n into y,
//     `I(n, y) <+ 2.0` (§5.6.1.1: flow enters a branch at its first net and
//     leaves at its second), and the only way back from y is u2's branch.
//
// BY HAND:
//   V(x) = V(p) - 0 = 1.0 V; one copy of u1 draws 1.0/1.0 = 1.0 A; three
//   copies 3.0 A (rule 1), so I(p, x) = 3.0 A (the top's own $mfactor is 1.0).
//   u2's branch carries all 2.0 A from y to n; two copies in parallel carry
//   1.0 A each, so I(sb) in u2 = 2.0 / 2 = 1.0 A (rule 2).
// Until 2026-10-08 neither rule reached a named branch: I(p, x) read 1.0 and
// I(sb) read 2.0. Absolute tolerance 1e-12.
//
// THE COUNT: one CHECK in the top, one CHECKX in u1, a CHECKX and a CHECK in
// u2. Four.
//
//! lrm 6.3.6
//! lrm 6.3.6:3
//! lrm 6.3.6:4
//! lrm 3.12
//! bias V(p) = 1.0, V(n) = 0.0
//! solve
//! checks 4
`include "check.vh"
module b4_mfb_top(p, n);
  inout p, n; electrical p, n, x, y;
  b4_mfb_res #(.$mfactor(3.0)) u1(x, n);
  b4_mfb_short #(.$mfactor(2.0)) u2(y, n);
  analog begin
    V(p, x) <+ 0.0;
    I(n, y) <+ 2.0;
    `CHECK("the ammeter carries three copies of the 1 A one copy of u1 draws", I(p, x), 3.0, 1e-12);
  end
endmodule

module b4_mfb_res(a, b);
  inout a, b; electrical a, b;
  branch (a, b) br;
  analog begin
    `CHECKX("Table 9-29: u1's $mfactor is 1.0 * 3.0", $mfactor, 3.0);
    I(br) <+ V(br) / 1.0;
  end
endmodule

module b4_mfb_short(a, b);
  inout a, b; electrical a, b;
  branch (a, b) sb;
  analog begin
    V(sb) <+ 0.0;
    `CHECKX("Table 9-29: u2's $mfactor is 1.0 * 2.0", $mfactor, 2.0);
    `CHECK("each of u2's two copies carries half of the 2 A", I(sb), 1.0, 1e-12);
  end
endmodule
