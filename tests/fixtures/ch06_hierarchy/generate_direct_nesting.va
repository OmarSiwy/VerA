// §6.6.2 "Direct nesting": a generate block that consists of a single
// conditional generate construct with no begin/end around it is not a scope of
// its own — the inner construct's blocks belong to the outer one. That is what
// licenses the three blocks below to share the name `selected`: "it is
// permissible for more than one block within a single conditional generate
// construct to have the same name (since at most one is instantiated)".
//
// The whole point is AT MOST ONE. first = 0 and second = 1, so the else-if
// alternative is the one elaborated: `arm` must come out 2. It comes out 1 or 3
// if the chain is walked wrong, and 0 if no alternative is elaborated at all —
// `arm` is seeded before the generate region so that last case is a failure and
// not an undefined read. §6.9.1 concatenates the analog blocks in source order,
// which is what makes the seed, the generate, and the check run in that order.
//
//! bias V(p) = 0.5
`include "check.vh"
module ch6_generate_direct_nesting(p);
  inout p; electrical p;
  parameter integer first = 0, second = 1;
  integer arm;
  analog arm = 0;
  generate
    if (first) begin : selected
      arm = 1;
      I(p) <+ V(p);
    end else if (second) begin : selected
      arm = 2;
      I(p) <+ 2.0 * V(p);
    end else begin : selected
      arm = 3;
      I(p) <+ 0.0;
    end
  endgenerate
  analog `CHECKI("only the else-if alternative is elaborated", arm, 2);
endmodule
