// §6.3/§6.4.2 uses the final elaboration value of base for paramset selection.
// The testbench's compile-time override base=7 replaces default 2 and makes
// defparam u.w=base select high. High gain=3*w=21 gives 10.5 A at 1/2 V.
// This distinguishes selection from the declared default (low gain=4), and
// verifies that the emitted model agrees with the compile-time choice.
//! lrm 6.3
//! lrm 6.4.2
//! lrm 6.4.2:4
//! param base = 7
//! bias V(p) = 0.5
//! checks 2
`include "check.vh"
module ps_outer_selection_parameter(p);
  inout p; electrical p;
  parameter real base=2.0;
  ps_parameter_bin #(.w(1.0)) u(p);
  defparam u.w=base;
  analog begin
    `CHECKX("the final base selected the high member", u.gain, 21.0);
    `CHECKX("the selected member's behavior executes", I(u.br), 10.5);
    I(p) <+ 0.0;
  end
endmodule
paramset ps_parameter_bin ps_parameter_leaf;
  parameter real w=1.0 from [0:4);
  .gain=2.0*w;
endparamset
paramset ps_parameter_bin ps_parameter_leaf;
  parameter real w=0.0 from [4:10];
  .gain=3.0*w;
endparamset
module ps_parameter_leaf(p);
  inout p; electrical p;
  parameter real gain=1.0;
  branch (p) br;
  analog I(br) <+ gain*V(br);
endmodule
