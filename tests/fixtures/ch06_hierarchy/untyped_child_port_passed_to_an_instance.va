// §6.5.2.1: an undeclared port type "can only be used in a structural
// description. (It can be passed to instances of modules, but cannot be
// accessed in a behavioral description.)" §3.6.2.4: a net "bound only to ports
// in module instantiations ... may have no declaration at all", and its
// discipline "is determined by discipline resolution" (§7.4).
//
// `pass_mid`'s port `c` has a direction and no discipline, and the module only
// passes it to `pass_leaf`, whose port is `electrical`. That is the structural
// use the clause allows, so this compiles and runs: the top's `p`, mid's `c`
// and the leaf's `a` are one node. With V(p) biased to 0.5 V the leaf reads
// V(a) = 0.5 exactly (the same node, no arithmetic). One check.
//
// The refusal beside it is untyped_child_port_behavioral_use_rejected.va: the
// same undeclared port, accessed in the child's analog block, is E0337.
//
//! lrm 6.5.2.1
//! lrm 3.6.2.4
//! bias V(p) = 0.5
//! checks 1
`include "check.vh"
module untyped_child_port_passed_to_an_instance(p);
  inout p; electrical p;
  pass_mid u(p);
endmodule
module pass_mid(c);
  inout c;
  pass_leaf l(c);
endmodule
module pass_leaf(a);
  inout a; electrical a;
  analog begin
    `CHECK("the leaf reads the top's node through the untyped port", V(a), 0.5, 1e-15);
    I(a) <+ V(a) / 2.0;
  end
endmodule
