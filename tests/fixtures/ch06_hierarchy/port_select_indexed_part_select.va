// §6.5.5's "sub-range" of a net, written as IEEE 1364-2005 §5.2.1's indexed
// part-select: A.2.1.3's constant_range_expression includes `base +: width`
// and `base -: width`, and both bounds are constants here. §5.2.1: "+:"
// selects the width bits from the base upward, "-:" downward, and the part
// reads in the declared direction (msb first):
//   d is [7:0]:  d[4 +: 4] is d[7:4],   d[3 -: 4] is d[3:0]
//   a is [0:7]:  a[0 +: 4] is a[0:3]    (a[0] the most significant)
//
// Each connects a [3:0] cell port `o`, which drives every bit against the
// top's p (held at 0) with its own value:
//   V(o[3]) = 0.5, V(o[2]) = 0.25, V(o[1]) = 0.125, V(o[0]) = 0.0625
// and IEEE 1364-2005 12.3.9.2 pairs o[3] with the part's msb. By hand:
//   d[7], d[6], d[5], d[4] = 0.5, 0.25, 0.125, 0.0625   (u1)
//   d[3], d[2], d[1], d[0] = 0.5, 0.25, 0.125, 0.0625   (u2)
//   a[0], a[1], a[2], a[3] = 0.5, 0.25, 0.125, 0.0625   (u3)
// `+:` read downward lands u1 on d[4:1]; a part read against the declared
// direction reverses each row. Dyadic, so exact.
//
//! lrm 6.5.5
//! lrm 6.5.5:2
//! bias V(p) = 0.0
//! solve
//! checks 12
`include "check.vh"
module ch6_psel_idx_top(p);
  inout p; electrical p;
  electrical [7:0] d;
  electrical [0:7] a;
  ch6_psel_idx_cell u1(.o(d[4 +: 4]), .c(p));
  ch6_psel_idx_cell u2(.o(d[3 -: 4]), .c(p));
  ch6_psel_idx_cell u3(.o(a[0 +: 4]), .c(p));
  analog begin
    `CHECKX("d[4 +: 4]: o[3] on d[7]", V(d[7]), 0.5);
    `CHECKX("d[4 +: 4]: o[2] on d[6]", V(d[6]), 0.25);
    `CHECKX("d[4 +: 4]: o[1] on d[5]", V(d[5]), 0.125);
    `CHECKX("d[4 +: 4]: o[0] on d[4]", V(d[4]), 0.0625);
    `CHECKX("d[3 -: 4]: o[3] on d[3]", V(d[3]), 0.5);
    `CHECKX("d[3 -: 4]: o[2] on d[2]", V(d[2]), 0.25);
    `CHECKX("d[3 -: 4]: o[1] on d[1]", V(d[1]), 0.125);
    `CHECKX("d[3 -: 4]: o[0] on d[0]", V(d[0]), 0.0625);
    `CHECKX("a[0 +: 4] of [0:7]: o[3] on a[0]", V(a[0]), 0.5);
    `CHECKX("a[0 +: 4] of [0:7]: o[2] on a[1]", V(a[1]), 0.25);
    `CHECKX("a[0 +: 4] of [0:7]: o[1] on a[2]", V(a[2]), 0.125);
    `CHECKX("a[0 +: 4] of [0:7]: o[0] on a[3]", V(a[3]), 0.0625);
  end
endmodule

module ch6_psel_idx_cell(o, c);
  inout [3:0] o; inout c;
  electrical [3:0] o; electrical c;
  analog begin
    V(o[3], c) <+ 0.5;
    V(o[2], c) <+ 0.25;
    V(o[1], c) <+ 0.125;
    V(o[0], c) <+ 0.0625;
  end
endmodule
