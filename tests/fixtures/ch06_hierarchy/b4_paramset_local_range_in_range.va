// The legal neighbour of b4_paramset_local_range_rejected.va: one paramset
// whose local parameter `twice = 2.0 * l from [0:2]` (§6.4.2: "The local
// parameters of the paramset, computed from parameters, shall be within the
// allowed ranges specified in the paramset"). The instance overrides l = 0.75,
// so twice = 1.5, inside [0:2]: the paramset is applicable and selected.
//
// BY HAND: k = 10.0 from the paramset (the module default is 9.0), and with
// V(p,n) = 0.5 the module stamps 10.0 * 0.5 = 5.0.
//
//! lrm 6.4.2
//! lrm 6.4.2:5
//! bias V(p) = 0.75, V(n) = 0.25
//! checks 2
`include "check.vh"
module b4_pli_top(p, n);
  inout p, n; electrical p, n;
  b4_pli_ps #(.l(0.75)) u(p, n);
endmodule

paramset b4_pli_ps b4_pli_dev;
  parameter real l = 1.0 from (0:inf);
  localparam real twice = 2.0 * l from [0:2];
  .k = 10.0;
endparamset

module b4_pli_dev(a, b);
  inout a, b; electrical a, b;
  parameter real k = 9.0;
  analog begin
    `CHECKX("the paramset is applicable and assigned k", k, 10.0);
    `CHECKX("so the module stamps 10.0 * 0.5", k * V(a, b), 5.0);
    I(a, b) <+ k * V(a, b);
  end
endmodule
