// §6.9, verbatim: "Elaboration is the process that occurs between parsing and
// simulation. It binds modules to module instances, builds the model hierarchy,
// computes parameter values, selects paramsets, resolves hierarchical names,
// establishes net connectivity, resolves disciplines, inserts connect modules,
// and prepares all of this for simulation."
//
// THE CLAUSE IS A LIST OF TASKS, SO THE FIXTURE MAKES EACH TASK THE ONLY WAY TO
// GET THE NUMBER. ONE module is instantiated TWICE with a different parameter
// override, a different input pair, and its own node on which it publishes the
// product it computed. Both published values are read by the top, which is the
// only place two different literals can live: an assertion inside the cell has
// one literal for both instances and therefore cannot see a per-instance
// difference at all.
//
//     u1:  g = 2.0,  V(n1, com) = 0.25  ->  2.0 * 0.25 = 0.5
//     u2:  g = 0.5,  V(n2, com) = 0.5   ->  0.5 * 0.5  = 0.25
//
// The two products must differ for the assertions to be able to see a per
// instance difference at all; a pair of biases that made them equal would let a
// shared result pass both. Each of §6.9's tasks this shape can reach is
// individually necessary:
//
//   * "computes parameter values" — the override is per INSTANCE. A compiler
//     that elaborated one parameter object and let the second `#(.g(0.5))`
//     overwrite it gives u1: 0.5 * 0.25 = 0.125 and u2: 0.5 * 0.5 = 0.25 —
//     the first literal caught it, the second did not.
//   * "establishes net connectivity" — the `p`/`q` pair is per INSTANCE. A
//     compiler that shared one bound net pair (both instances reading n1) gives
//     u2: 0.5 * 0.25 = 0.125 — again the first literal only.
//   * "binds modules to module instances" — a compiler that elaborated the
//     analog block ONCE and reused the result prints the same number on both
//     sens nodes, which no pair of distinct literals accepts.
//
// THE VALUES ARE EXACT. 2.0 * 0.25 and 0.5 * 0.5 are powers of two, and the
// cell's only equation is linear in the one unknown it publishes, so one Newton
// step from the harness's seed lands on the value with no rounding to absorb.
// CHECKX is therefore the right comparison and no tolerance is passed.
//
// `//! solve` is required and not decoration: without it the harness ties every
// unknown no line names to zero, so the two `sense` nodes would be pinned at 0
// and the cells' contributions would be answering nothing. It frees exactly the
// unknowns that have no other answer — the two sense nodes — and leaves the
// biased ones forced.
//
//! lrm 6.9
//! lrm 6.9:1000
//! bias V(n1) = 0.25, V(n2) = 0.5, V(com) = 0.0
//! solve
//! print none
`include "check.vh"
module ch6_elaboration_top;
  electrical n1, n2, com, s1, s2;

  ch6_elaboration_gain #(.g(2.0)) u1(n1, com, s1);
  ch6_elaboration_gain #(.g(0.5)) u2(n2, com, s2);

  analog begin
    `CHECKX("u1's own gain against u1's own nets", V(s1), 0.5);
    `CHECKX("u2's own gain against u2's own nets", V(s2), 0.25);
    I(com) <+ 0.0;
  end
endmodule

module ch6_elaboration_gain(p, q, sense);
  inout p, q, sense;
  electrical p, q, sense;

  parameter real g = 1.0;

  analog begin
    V(sense) <+ g * V(p, q);
    I(p) <+ 0.0;
    I(q) <+ 0.0;
  end
endmodule
