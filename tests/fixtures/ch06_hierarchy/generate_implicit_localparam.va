// §6.6.1, the implicit localparam: "within the generate block, there is an
// implicit localparam declaration with the same name and type as the loop index
// variable, whose value is the genvar value at the time the instance was
// elaborated". The genvar itself "does not exist at simulation time", so every
// unrolled copy of the block sees its OWN frozen 0, 1, 2 — not one shared
// counter left at its terminal value.
//
// `code` accumulates base-10 digits, so it pins the values AND the order the
// loop was unrolled in (§6.9.1: "the order in which the loop is unrolled during
// elaboration determines the concatenation order"):
//
//   i = 0 -> code = 0*10 + 1 =   1
//   i = 1 -> code = 1*10 + 2 =  12
//   i = 2 -> code = 12*10 + 3 = 123
//
// One shared counter stuck at 3 would give 444; descending unrolling gives 321;
// a body that ran once gives 1. Only 0,1,2 in that order gives 123.
//
//! bias V(p) = 0.5
`include "check.vh"
module ch6_generate_implicit_localparam(p);
  inout p; electrical p; genvar i;
  integer code;
  analog code = 0;
  generate
    for (i = 0; i < 3; i = i + 1) begin : stage
      code = code * 10 + (i + 1);
      I(p) <+ i * V(p);
    end
  endgenerate
  analog `CHECKI("each unrolled block froze its own genvar value", code, 123);
endmodule
