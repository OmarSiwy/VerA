// §6.6.1, the implicit localparam: "within the generate block, there is an
// implicit localparam declaration with the same name and type as the loop index
// variable, whose value is the genvar value at the time the instance was
// elaborated". The genvar itself "does not exist at simulation time", so every
// unrolled copy of the block sees its OWN frozen 0, 1, 2 — not one shared
// counter left at its terminal value.
//
// `code` accumulates base-10 digits, so it pins the values AND the order the
// loop was unrolled in (§6.9.1: "the order in which the loop is unrolled during
// elaboration determines the concatenation order"):
//
//   i = 0 -> code = 0*10 + 1 =   1
//   i = 1 -> code = 1*10 + 2 =  12
//   i = 2 -> code = 12*10 + 3 = 123
//
// One shared counter stuck at 3 would give 444; descending unrolling gives 321;
// a body that ran once gives 1. Only 0,1,2 in that order gives 123.
//
// The loop body is `analog begin ... end`. §6.6 makes a generate block "a
// collection of one or more module items"; Syntax 6-8 lists analog_construct as
// one and no procedural statement at all, so the bare assignment this file used
// to carry pinned a VerA extension rather than the LRM. Note the LRM also spells
// a genvar for-loop over a plain analog_statement — `analog_loop_generate_statement`
// in Syntax 6-8 — but that form lives INSIDE an analog block, not in a generate
// region, and would not give each unrolled copy its own localparam scope.
//
//! lrm 6.6
//! lrm 6.6.1
//! bias V(p) = 0.5
//! xfail VerA's parser reads a generate block body as an analog statement, so the `analog` keyword inside `generate` dies at E0209 "expected an expression: found `analog`"
`include "check.vh"
module ch6_generate_implicit_localparam(p);
  inout p; electrical p; genvar i;
  integer code;
  analog code = 0;
  generate
    for (i = 0; i < 3; i = i + 1) begin : stage
      analog begin
        code = code * 10 + (i + 1);
        I(p) <+ i * V(p);
      end
    end
  endgenerate
  analog `CHECKI("each unrolled block froze its own genvar value", code, 123);
endmodule
