// IEEE 1364-2005 12.6 resolves a hierarchical name's first identifier
// through the current module's scopes, then each module above it, by
// instance or module name (Syntax 12-7). `no_such_scope` is none of them, so
// the defparam names no parameter of the design: E0907 (AMS 6.3.1, 6.3).
// defparam_upward_module_name_path.va is the legal neighbour: the same
// defparam with the top module's name in front is applied.
//! lrm 6.3.1
//! inherited IEEE 1364-2005 12.2.1 12.6
//! reject-only E0907
//! reject `m.no_such_scope.u1.g` names no parameter of the elaborated design
//! neighbour defparam_upward_module_name_path.va
`include "check.vh"
module dpn_leaf(a, b);
  inout a, b; electrical a, b;
  parameter real g = 1.0;
  analog I(a, b) <+ g * V(a, b);
endmodule
module dpn_mid(a, b);
  inout a, b; electrical a, b;
  defparam no_such_scope.u1.g = 4.0;
  dpn_leaf u1(a, b);
endmodule
module defparam_path_names_nothing_rejected(p, n);
  inout p, n; electrical p, n;
  dpn_mid m(p, n);
  dpn_leaf u1(p, n);
endmodule
