// LRM §6.3.4 parameter dependence: a parameter defined by an expression over
// another parameter TRACKS it — "an update of gate_width, whether by a defparam
// statement or in an instantiation statement, automatically updates gate_cap".
// §3.4.5 makes `doubled` local (not overridable itself), which is exactly why
// its only source of value is the expression `2.0*base`.
//
// The testbench overrides base to 3.0, so doubled = 2.0*3.0 = 6.0 (exact in
// binary). Freezing `doubled` at the 4.0 it folds to under base's DEFAULT is
// the failure this pins, and it is invisible without an override.
//
//! lrm 6.3.4
//! lrm 3.4.5
//! lrm 6.3.4:1000
//! param base = 3.0
`include "check.vh"
module ch6_localparam(p);
  inout p; electrical p;
  parameter real base = 2.0;
  localparam real doubled = 2.0 * base;
  analog begin
    `CHECKX("localparam tracks the overridden parameter", doubled, 6.0);
    I(p) <+ doubled * V(p);
  end
endmodule
