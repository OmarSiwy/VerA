// §6.3.6's third automatic rule — "Contributions to a branch flow quantity using
// the noise functions shall have the noise power MULTIPLIED by $mfactor" — IS NOT
// PINNED BY THIS FILE, and the `//! lrm 6.3.6` cite it used to carry has been
// removed rather than left to launder the gap in `--coverage`.
//
// Why it cannot be: the rule is only observable when $mfactor differs from 1.0 and
// when the noise power is observable at all. Neither holds here.
//
//   - $mfactor is 1.0. Table 9-29 fixes the top-level value at 1.0 and there is no
//     way to move it: it is set by a `parameter_value_assignment` on an instance,
//     VerA compiles one flat module (E0204), and `tb.zig` has no directive for it —
//     `inst.mfactor` is a generated field with a 1.0 default (codegen.zig:991). At
//     1.0, multiply, divide and "ignore $mfactor entirely" are the same function.
//   - The power is zero. §4.6.4: "The noise functions are only active in
//     small-signal noise analyses and return zero (0) otherwise", and this
//     testbench runs the default DC analysis. 0 == 0*m == 0/m for every m.
//
// So this file and its sibling mfactor_potential_noise.va, which cites the OPPOSITE
// sense of the same pair of rules, would assert identical numbers. Closing the gap
// needs an instantiation carrying a non-unity $mfactor plus `//! analysis noise`
// and a way to read the noise summary; until then the rule is uncovered and this
// header is where that is written down.
//
// What IS pinned here is genuine and is what the two assertions say: Table 9-29's
// top-level $mfactor is 1.0, and §4.6.4 makes `white_noise` contribute exactly zero
// to the DC residual — a device that folded the declared 1e-18 A^2/Hz into the DC
// current prints 1e-18 instead of 0.
//
//! lrm 9.18
//! lrm 4.6.4
//! lrm 4.6.4:1000
//! lrm 9.18:1000
`include "check.vh"
module ch6_mfactor_flow_noise(p, n);
  inout p, n; electrical p, n;
  analog begin
    `CHECKX("Table 9-29 fixes the top-level $mfactor at 1.0", $mfactor, 1.0);
    `CHECKX("white_noise returns 0 outside a noise analysis", white_noise(1e-18, "flow_noise"), 0.0);
    I(p, n) <+ white_noise(1e-18, "flow_noise");
  end
endmodule
