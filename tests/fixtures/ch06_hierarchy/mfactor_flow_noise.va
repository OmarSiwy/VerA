// LRM §6.3.6, third automatic rule: "Contributions to a branch flow quantity
// using the noise functions shall have the noise power MULTIPLIED by
// $mfactor." Table 9-29 fixes $mfactor at its top-level 1.0 here (nothing
// overrides it), so the scaling is the identity and the declared power 1e-18
// A^2/Hz reaches the noise summary unchanged.
//
// The other half is §4.6.4: "The noise functions are only active in
// small-signal noise analyses and return zero (0) otherwise." This testbench
// runs the default DC analysis, so the value the source contributes to the
// residual is exactly zero — a device that folded the noise power into the DC
// current would print 1e-18 instead.
//
//! lrm 6.3.6
//! lrm 4.6.4
`include "check.vh"
module ch6_mfactor_flow_noise(p, n);
  inout p, n; electrical p, n;
  analog begin
    `CHECKX("$mfactor is 1.0, so the noise power is unscaled", $mfactor, 1.0);
    `CHECKX("white_noise returns 0 outside a noise analysis", white_noise(1e-18, "flow_noise"), 0.0);
    I(p, n) <+ white_noise(1e-18, "flow_noise");
  end
endmodule
