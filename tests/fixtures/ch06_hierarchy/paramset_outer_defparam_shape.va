// §6.3/§6.4.2: base=2 selects numeric gain=2*base=4; mode="low" selects
// string gain=5. The single-member paramset computes gain=2*drive=6.
// At 1/2 V the branch currents are 2, 2.5 and 3 A. Integer choice=1 selects
// a zero-current member, so the extra selection leaves that total unchanged.
//
// The accompanying tests/fixtures/ch06_hierarchy/paramset_host.zig executes the emitted device after
// actual host card writes: drive may change without changing any selection,
// while base/mode changes require re-elaboration through checkShape. The host
// refusal is an implementation limit, not an invalid-source LRM rule.
//! lrm 6.3
//! lrm 6.4.2
//! lrm 6.4.2:4
//! bias V(p) = 0.5
//! checks 4
`include "check.vh"
module ps_outer_shape(p);
  inout p; electrical p;
  parameter real base=2.0, drive=3.0;
  parameter string mode="low";
  parameter integer choice=1;
  ps_shape_numeric numeric(p);
  ps_shape_string text_bin(p);
  ps_shape_single single(p);
  ps_shape_choice chosen(p);
  defparam numeric.w=base, text_bin.kind=mode, single.w=drive;
  defparam chosen.w=choice;
  analog begin
    `CHECKX("numeric member executes", I(numeric.br), 2.0);
    `CHECKX("string member executes", I(text_bin.br), 2.5);
    `CHECKX("single-member assignment executes", I(single.br), 3.0);
    `CHECKX("integer-selected member executes", I(chosen.br), 0.0);
    I(p) <+ 0.0;
  end
endmodule
paramset ps_shape_numeric ps_shape_leaf;
  parameter real w=1.0 from [0:4);
  .gain=2.0*w;
endparamset
paramset ps_shape_numeric ps_shape_leaf;
  parameter real w=0.0 from [4:10];
  .gain=3.0*w;
endparamset
paramset ps_shape_string ps_shape_leaf;
  parameter string kind="low" from '{"low"};
  .gain=5.0;
endparamset
paramset ps_shape_string ps_shape_leaf;
  parameter string kind="low" from '{"high"};
  .gain=9.0;
endparamset
paramset ps_shape_single ps_shape_leaf;
  parameter real w=1.0;
  .gain=2.0*w;
endparamset
paramset ps_shape_choice ps_shape_leaf;
  parameter integer w=1 from [0:2);
  .gain=0.0;
endparamset
paramset ps_shape_choice ps_shape_leaf;
  parameter integer w=0 from [2:inf);
  .gain=10.0;
endparamset
module ps_shape_leaf(p);
  inout p; electrical p;
  parameter real gain=1.0;
  branch (p) br;
  analog I(br) <+ gain*V(br);
endmodule
