// LRM §6.2 / §3.5, the ANSI module form: `output electrical p` declares the
// port, its direction and its discipline in the header, and (§6.2) such a port
// "shall not be redeclared within the body". The node it names is a solver
// unknown like any other, so the potential access function V(p) reads whatever
// the solver holds it at — 0.375 here, exact in binary — and NOT the 1.0 the
// module drives onto it. Probe and source are separate (§5.4.2); an `output`
// direction does not turn the probe into a read-back of the contribution.
//
//! lrm 6.2
//! lrm 6.5.2.2
//! bias V(p) = 0.375
`include "check.vh"
module ch6_output(output electrical p);
  analog begin
    `CHECKX("V() of a header-declared output port reads its node", V(p), 0.375);
    V(p) <+ 1.0;
  end
endmodule
