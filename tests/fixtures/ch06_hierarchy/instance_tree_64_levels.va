// §6.2.2 builds a finite instance tree and bounds nothing about its depth.
// VerA elaborates at most 64 nested instances below the top module (E1018 is
// the 65th; instance_tree_deeper_than_64_rejected.va). e0 instantiates e1 and
// so on to e64, which holds the only analog block: 64 nested instances, the
// deepest tree VerA accepts.
//
// HAND DERIVATION. The bias pins V(p) = 0.5 and V(n) = 0 at the top, and e64
// reads them through 64 levels of port connections: V(p, n) = 0.5.
//
//! lrm 6.2.2
//! bias V(p) = 0.5, V(n) = 0
`include "check.vh"
module e0(p, n);
  inout p, n; electrical p, n;
  e1 u(p, n);
endmodule
module e1(p, n);
  inout p, n; electrical p, n;
  e2 u(p, n);
endmodule
module e2(p, n);
  inout p, n; electrical p, n;
  e3 u(p, n);
endmodule
module e3(p, n);
  inout p, n; electrical p, n;
  e4 u(p, n);
endmodule
module e4(p, n);
  inout p, n; electrical p, n;
  e5 u(p, n);
endmodule
module e5(p, n);
  inout p, n; electrical p, n;
  e6 u(p, n);
endmodule
module e6(p, n);
  inout p, n; electrical p, n;
  e7 u(p, n);
endmodule
module e7(p, n);
  inout p, n; electrical p, n;
  e8 u(p, n);
endmodule
module e8(p, n);
  inout p, n; electrical p, n;
  e9 u(p, n);
endmodule
module e9(p, n);
  inout p, n; electrical p, n;
  e10 u(p, n);
endmodule
module e10(p, n);
  inout p, n; electrical p, n;
  e11 u(p, n);
endmodule
module e11(p, n);
  inout p, n; electrical p, n;
  e12 u(p, n);
endmodule
module e12(p, n);
  inout p, n; electrical p, n;
  e13 u(p, n);
endmodule
module e13(p, n);
  inout p, n; electrical p, n;
  e14 u(p, n);
endmodule
module e14(p, n);
  inout p, n; electrical p, n;
  e15 u(p, n);
endmodule
module e15(p, n);
  inout p, n; electrical p, n;
  e16 u(p, n);
endmodule
module e16(p, n);
  inout p, n; electrical p, n;
  e17 u(p, n);
endmodule
module e17(p, n);
  inout p, n; electrical p, n;
  e18 u(p, n);
endmodule
module e18(p, n);
  inout p, n; electrical p, n;
  e19 u(p, n);
endmodule
module e19(p, n);
  inout p, n; electrical p, n;
  e20 u(p, n);
endmodule
module e20(p, n);
  inout p, n; electrical p, n;
  e21 u(p, n);
endmodule
module e21(p, n);
  inout p, n; electrical p, n;
  e22 u(p, n);
endmodule
module e22(p, n);
  inout p, n; electrical p, n;
  e23 u(p, n);
endmodule
module e23(p, n);
  inout p, n; electrical p, n;
  e24 u(p, n);
endmodule
module e24(p, n);
  inout p, n; electrical p, n;
  e25 u(p, n);
endmodule
module e25(p, n);
  inout p, n; electrical p, n;
  e26 u(p, n);
endmodule
module e26(p, n);
  inout p, n; electrical p, n;
  e27 u(p, n);
endmodule
module e27(p, n);
  inout p, n; electrical p, n;
  e28 u(p, n);
endmodule
module e28(p, n);
  inout p, n; electrical p, n;
  e29 u(p, n);
endmodule
module e29(p, n);
  inout p, n; electrical p, n;
  e30 u(p, n);
endmodule
module e30(p, n);
  inout p, n; electrical p, n;
  e31 u(p, n);
endmodule
module e31(p, n);
  inout p, n; electrical p, n;
  e32 u(p, n);
endmodule
module e32(p, n);
  inout p, n; electrical p, n;
  e33 u(p, n);
endmodule
module e33(p, n);
  inout p, n; electrical p, n;
  e34 u(p, n);
endmodule
module e34(p, n);
  inout p, n; electrical p, n;
  e35 u(p, n);
endmodule
module e35(p, n);
  inout p, n; electrical p, n;
  e36 u(p, n);
endmodule
module e36(p, n);
  inout p, n; electrical p, n;
  e37 u(p, n);
endmodule
module e37(p, n);
  inout p, n; electrical p, n;
  e38 u(p, n);
endmodule
module e38(p, n);
  inout p, n; electrical p, n;
  e39 u(p, n);
endmodule
module e39(p, n);
  inout p, n; electrical p, n;
  e40 u(p, n);
endmodule
module e40(p, n);
  inout p, n; electrical p, n;
  e41 u(p, n);
endmodule
module e41(p, n);
  inout p, n; electrical p, n;
  e42 u(p, n);
endmodule
module e42(p, n);
  inout p, n; electrical p, n;
  e43 u(p, n);
endmodule
module e43(p, n);
  inout p, n; electrical p, n;
  e44 u(p, n);
endmodule
module e44(p, n);
  inout p, n; electrical p, n;
  e45 u(p, n);
endmodule
module e45(p, n);
  inout p, n; electrical p, n;
  e46 u(p, n);
endmodule
module e46(p, n);
  inout p, n; electrical p, n;
  e47 u(p, n);
endmodule
module e47(p, n);
  inout p, n; electrical p, n;
  e48 u(p, n);
endmodule
module e48(p, n);
  inout p, n; electrical p, n;
  e49 u(p, n);
endmodule
module e49(p, n);
  inout p, n; electrical p, n;
  e50 u(p, n);
endmodule
module e50(p, n);
  inout p, n; electrical p, n;
  e51 u(p, n);
endmodule
module e51(p, n);
  inout p, n; electrical p, n;
  e52 u(p, n);
endmodule
module e52(p, n);
  inout p, n; electrical p, n;
  e53 u(p, n);
endmodule
module e53(p, n);
  inout p, n; electrical p, n;
  e54 u(p, n);
endmodule
module e54(p, n);
  inout p, n; electrical p, n;
  e55 u(p, n);
endmodule
module e55(p, n);
  inout p, n; electrical p, n;
  e56 u(p, n);
endmodule
module e56(p, n);
  inout p, n; electrical p, n;
  e57 u(p, n);
endmodule
module e57(p, n);
  inout p, n; electrical p, n;
  e58 u(p, n);
endmodule
module e58(p, n);
  inout p, n; electrical p, n;
  e59 u(p, n);
endmodule
module e59(p, n);
  inout p, n; electrical p, n;
  e60 u(p, n);
endmodule
module e60(p, n);
  inout p, n; electrical p, n;
  e61 u(p, n);
endmodule
module e61(p, n);
  inout p, n; electrical p, n;
  e62 u(p, n);
endmodule
module e62(p, n);
  inout p, n; electrical p, n;
  e63 u(p, n);
endmodule
module e63(p, n);
  inout p, n; electrical p, n;
  e64 u(p, n);
endmodule
module e64(p, n);
  inout p, n; electrical p, n;
  analog begin
    `CHECK("a 64-level instance tree elaborates and runs", V(p, n), 0.5, 1e-15);
    I(p,n) <+ V(p,n);
  end
endmodule
