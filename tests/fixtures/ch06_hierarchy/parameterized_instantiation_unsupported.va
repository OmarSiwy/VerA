// §6.3, module instance parameter value assignment BY ORDER: "which allows values
// to be assigned in-line during module instantiation in the order of their
// declaration." The LRM's §6.2.2 example does exactly this — `integrator #(1.0)
// I1(...)` — so the construct is legal and this file must run, not reject.
//
// The child declares `gain` first and `offset` second, and the instance supplies
// `#(2.0, 3.0)`. Order is the whole content of the rule: gain must be 2.0 and
// offset 3.0, and a compiler that matched by declaration order backwards would
// report the numbers swapped. Both are overrides, so §9.19 makes $param_given 1
// for each — which distinguishes "overridden with 2.0" from "happened to default
// to 2.0" and is the reason `gain`'s default below is 1.0 and not 2.0.
//
// With V(p,n) = 0.5 the contribution is 2.0 * 0.5 + 3.0 = 4.0 exactly.
//
//! lrm 6.3
//! lrm 6.2.2
//! bias V(p) = 0.75, V(n) = 0.25
//! xfail VerA compiles one flat module, so a module instantiation is refused outright at E0204 "module instantiation is not supported"
`include "check.vh"
module ch6_parent_ordered(p, n);
  inout p, n; electrical p, n;
  ch6_po_child #(2.0, 3.0) u(p, n);
endmodule

module ch6_po_child(a, b);
  inout a, b; electrical a, b;
  parameter real gain = 1.0;
  parameter real offset = 0.0;
  analog begin
    `CHECKX("the first ordered value lands on the first declared parameter", gain, 2.0);
    `CHECKX("the second lands on the second", offset, 3.0);
    `CHECKI("an ordered assignment is an override", $param_given(gain), 1);
    `CHECKI("for both of them", $param_given(offset), 1);
    `CHECKX("so the child stamps gain*V + offset", gain * V(a, b) + offset, 4.0);
    I(a, b) <+ gain * V(a, b) + offset;
  end
endmodule
