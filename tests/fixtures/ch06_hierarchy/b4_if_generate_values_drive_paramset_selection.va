// §6.9.2 Elaboration and paramsets: "If a generate construct contains an
// instantiation of an overloaded paramset, paramset selection is performed
// after the generate construct has been evaluated. The evaluation of the
// generate construct may influence the values and connections of the paramset
// instance, and hence the selection of matching paramset and module."
//
// The conditional-generate form of b4_generate_values_drive_paramset_selection.va
// (whose loop generate VerA refuses). Two if-generate constructs, each with an
// instance of the overloaded paramset b4_pgi_sel in both arms; which arm is
// instantiated, and so which override value w the instance carries, is decided
// by the top's parameter `wide` when the scheme is evaluated (§6.6.2). The two
// paramsets split on w's range and lead to different modules:
//   w in [5:inf)   -> b4_pgi_wide
//   w in (-inf:5)  -> b4_pgi_narrow
//
// BY HAND, wide = 1:
//   g1: `if (wide)` is true, the then-arm: u1 with w = 9.0 -> wide    (2 lines)
//   g2: `if (!wide)` is false, the else-arm: u4 with w = 1.0 -> narrow (1 line)
// `//! checks 3` counts them. Selecting before the schemes are evaluated
// (every arm's instance) would print 6 lines; a swapped arm prints ok=0.
// Every arm's instance has its own name (u1..u4) so that this file does not
// depend on generate-block scoping, which is not what it tests.
//
//! lrm 6.9.2
//! lrm 6.9.2:1
//! lrm 6.4.2
//! bias V(p) = 0.75, V(n) = 0.25
//! checks 3
`include "check.vh"
module b4_pgi_top(p, n);
  inout p, n; electrical p, n;
  parameter integer wide = 1;
  if (wide) begin : g1
    b4_pgi_sel #(.w(9.0)) u1(p, n);
  end else begin : g1
    b4_pgi_sel #(.w(1.0)) u2(p, n);
  end
  if (!wide) begin : g2
    b4_pgi_sel #(.w(9.0)) u3(p, n);
  end else begin : g2
    b4_pgi_sel #(.w(1.0)) u4(p, n);
  end
endmodule

paramset b4_pgi_sel b4_pgi_wide;
  parameter real w = 10.0 from [5.0:inf);
  .w = w;
endparamset

paramset b4_pgi_sel b4_pgi_narrow;
  parameter real w = 1.0 from (-inf:5.0);
  .w = w;
endparamset

module b4_pgi_wide(a, b);
  inout a, b; electrical a, b;
  parameter real w = 0.0;
  analog begin
    `CHECKX("g1's then-arm instance u1 carries w = 9 and selects the wide paramset", w, 9.0);
    `CHECKX("and stamps its conductance 9 * 0.5", w * V(a, b), 4.5);
    I(a, b) <+ w * V(a, b);
  end
endmodule

module b4_pgi_narrow(a, b);
  inout a, b; electrical a, b;
  parameter real w = 0.0;
  analog begin
    `CHECKX("g2's else-arm instance u4 carries w = 1 and selects the narrow paramset", w, 1.0);
    I(a, b) <+ w * V(a, b);
  end
endmodule
