// §6.4.2, two rules about ports, one paramset name over two modules:
//
//   selection: "The underlying module shall have a port declared for each port
//               connected in the instance line."
//   tie-break: "The paramset with the fewest ports not connected in the
//               instance line shall be selected." (third of the tie rules,
//               "applied in order until a unique paramset has been selected")
//
// Paramset b4_pps over b4_pps_two(a, b), and paramset b4_pps over
// b4_pps_three(a, b, c). Each declares one parameter g and passes it on as
// `.k = g`, so neither has a local parameter and both are always in range.
//
//   u3 connects .a .b .c: b4_pps_two declares no port c, so only the paramset
//      over b4_pps_three is applicable (the selection rule). k = 3.0.
//   u2 connects .a .b:    both are applicable. Tie rule 1: zero un-overridden
//      parameters each (g is overridden). Tie rule 2: zero ranged local
//      parameters each. Tie rule 3: b4_pps_two leaves 0 ports unconnected,
//      b4_pps_three leaves 1 (c), so the 2-port module is selected. k = 2.0.
//
// Each module checks the k only its intended instance gives it: were u2
// resolved to the 3-port module, that module would print k = 2.0 against its
// want 3.0, and the 2-port module would print nothing (`//! checks 2` counts
// one line from each).
//
//! lrm 6.4.2
//! lrm 6.4.2:6
//! lrm 6.4.2:9
//! bias V(p) = 0.75, V(n) = 0.25, V(q) = 0.0
//! checks 2
`include "check.vh"
module b4_pps_top(p, n, q);
  inout p, n, q; electrical p, n, q;
  b4_pps #(.g(3.0)) u3(.a(p), .b(n), .c(q));
  b4_pps #(.g(2.0)) u2(.a(p), .b(n));
endmodule

paramset b4_pps b4_pps_two;
  parameter real g = 1.0;
  .k = g;
endparamset

paramset b4_pps b4_pps_three;
  parameter real g = 1.0;
  .k = g;
endparamset

module b4_pps_two(a, b);
  inout a, b; electrical a, b;
  parameter real k = 0.0;
  analog begin
    `CHECKX("only u2 (two ports connected, none left open) reaches the 2-port module", k, 2.0);
    I(a, b) <+ k * V(a, b);
  end
endmodule

module b4_pps_three(a, b, c);
  inout a, b, c; electrical a, b, c;
  parameter real k = 0.0;
  analog begin
    `CHECKX("only u3 (port c connected) reaches the 3-port module", k, 3.0);
    I(a, b) <+ k * V(a, b);
  end
endmodule
