// LRM §6.3.6, first automatic rule: "All contributions to a branch flow
// quantity in the analog block shall be multiplied by $mfactor." Nothing
// overrides $mfactor here, so Table 9-29 fixes it at the top-level value 1.0
// and the rule is the identity — the branch carries the plain Ohm's-law
// current, NOT a scaled one.
//
// Biased at V(p)-V(n) = 0.5 - 0.25 = 0.25 across 1k (§2.6 scale factor: 1000),
// that current is 0.25/1000 = 2.5e-4 A. Both checks are exact: 0.5, 0.25 and
// 1000 are binary-exact and the quotient is correctly rounded.
//
//! lrm 6.3.6
//! bias V(p) = 0.5, V(n) = 0.25
`include "check.vh"
module ch6_mfactor_flow_contribution(p, n);
  inout p, n; electrical p, n;
  analog begin
    `CHECKX("$mfactor is 1.0, so the flow scaling rule is an identity", $mfactor, 1.0);
    `CHECKX("the flow contributed across 1k", V(p, n) / 1k, 2.5e-4);
    I(p, n) <+ V(p, n) / 1k;
  end
endmodule
