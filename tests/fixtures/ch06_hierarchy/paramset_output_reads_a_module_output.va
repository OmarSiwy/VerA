// §6.4.3: "A paramset output variable's value may be computed from values of
// any output parameters of the module by using the special syntax
// .module_output_variable_identifier." The clause's example is
// `ft = .gm/(`M_TWO_PI*(.cpi + .cmu));` in paramset `smnpn`.
//
// Observed with §9.16 $simprobe from a sibling instance, as in
// paramset_hidden_output_variable_takes_the_fallback.va: "query that instance
// for an output variable called param_name".
//
// BY HAND, with V(a,b) = 0.75 - 0.25 = 0.5:
//   module output variable  gm = scale * V(a,b) = 4.0 * 0.5 = 2.0
//                            (scale = 4.0 is set by the paramset)
//   paramset output         ft = 3.0 * .gm      = 3.0 * 2.0 = 6.0
// so $simprobe("u", "ft", -1.0) is 6.0 and $simprobe("u", "gm", -1.0) is 2.0.
// The second is the control: the module's output variable is reachable
// through the paramset instance (no paramset variable named gm hides it).
// paramset_output_unsupported.va accepts the same construct but asserts only
// gm and scale, never ft.
//
//! lrm 6.4.3
//! lrm 6.4.3:2
//! lrm 9.16
//! bias V(p) = 0.75, V(n) = 0.25
//! checks 3
`include "check.vh"
module b4_pmo_top(p, n);
  inout p, n; electrical p, n;
  b4_pmo_ps u(p, n);
  b4_pmo_mon mon(p, n);
endmodule

paramset b4_pmo_ps b4_pmo_dev;
  parameter real s = 4.0;
  (* desc = "three times the module's transconductance" *) real ft;
  .scale = s;
  ft = 3.0 * .gm;
endparamset

module b4_pmo_dev(a, b);
  inout a, b; electrical a, b;
  parameter real scale = 9.0;
  (* desc = "transconductance" *) real gm;
  analog begin
    gm = scale * V(a, b);
    `CHECKX("the paramset set the parameter gm is computed from", scale, 4.0);
    I(a, b) <+ gm;
  end
endmodule

module b4_pmo_mon(a, b);
  inout a, b; electrical a, b;
  real got_gm, got_ft;
  analog begin
    got_gm = $simprobe("u", "gm", -1.0);
    got_ft = $simprobe("u", "ft", -1.0);
    `CHECKX("the module's output variable gm, through the paramset instance", got_gm, 2.0);
    `CHECKX("the paramset's output ft = 3.0 * .gm", got_ft, 6.0);
    I(a, b) <+ 0.0 * V(a, b);
  end
endmodule
