// §6.3 says a defparam wins an inline override, and paramset SELECTION uses
// that winning value. §6.4.2 admits low for 0<=w<4 and high for 4<=w<=10.
// High deliberately has an inadmissible default, so an untouched instance
// selects low. Its module assignment is gain=2*w; high uses gain=3*w.
//
// Named, ordered, empty-named, untouched-inline, and default instances use
// w=7,6,5,2,1 respectively. Thus gain=21,18,15,4,2. At V(p)=1/2 V the five
// currents are 10.5,9,7.5,2,1 A. The two same-spelling defparams for by_name
// also pin source order: the later 7 wins 5, then wins the inline 2.
//! lrm 6.3
//! lrm 6.3:1001
//! lrm 6.3.1
//! lrm 6.4.2
//! lrm 6.4.2:4
//! bias V(p) = 0.5
//! checks 10
`include "check.vh"
module ps_outer_precedence(p);
  inout p; electrical p;
  ps_outer_bin #(.w(2.0)) by_name(p);
  ps_outer_bin #(2.0) by_order(p);
  ps_outer_bin #(.w()) empty_named(p);
  ps_outer_bin #(.w(2.0)) untouched(p);
  ps_outer_bin defaults(p);
  defparam by_name.w=5.0, by_order.w=6.0, empty_named.w=5.0;
  defparam by_name.w=7.0;
  analog begin
    `CHECKX("named override selects high from defparam", by_name.gain, 21.0);
    `CHECKX("ordered override selects high from defparam", by_order.gain, 18.0);
    `CHECKX("empty named binding takes the defparam", empty_named.gain, 15.0);
    `CHECKX("an untouched inline binding selects low", untouched.gain, 4.0);
    `CHECKX("an untouched default selects low", defaults.gain, 2.0);
    `CHECKX("named selected behavior executes", I(by_name.br), 10.5);
    `CHECKX("ordered selected behavior executes", I(by_order.br), 9.0);
    `CHECKX("empty named selected behavior executes", I(empty_named.br), 7.5);
    `CHECKX("untouched inline behavior executes", I(untouched.br), 2.0);
    `CHECKX("default behavior executes", I(defaults.br), 1.0);
    I(p) <+ 0.0;
  end
endmodule
paramset ps_outer_bin ps_outer_leaf;
  parameter real w=1.0 from [0:4);
  .gain=2.0*w;
endparamset
paramset ps_outer_bin ps_outer_leaf;
  parameter real w=0.0 from [4:10];
  .gain=3.0*w;
endparamset
module ps_outer_leaf(p);
  inout p; electrical p;
  parameter real gain=-1.0;
  branch (p) br;
  analog I(br) <+ gain*V(br);
endmodule
