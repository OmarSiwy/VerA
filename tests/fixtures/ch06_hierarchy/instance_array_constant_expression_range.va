// §6.2.2: "The instantiations of modules can contain a range specification.
// This allows an array of instances to be created." The range is annex A's
// `range ::= [ msb_constant_expression : lsb_constant_expression ]`, and an
// element is reached by Syntax 6-9's `hierarchical_identifier ::= [ $root . ]
// { identifier [ [ constant_expression ] ] . } identifier`. Both positions
// take a CONSTANT EXPRESSION, not a literal, so every §4.2 operator is in
// reach. Four of them, one position each, with the value by hand:
//
//   range msb   (1 << 2) - 1      §4.2.11 "Both the << and >> shift operators
//                                 fill the vacated bit positions with zeroes",
//                                 and its own example gives 1 << 2 = 0100 = 4;
//                                 4 - 1 = 3. The array is u[3:0].
//   u[7 % 2]    1                 §4.2.4 "the remainder when the first operand
//                                 is divided by the second"
//   u[2 ** 1]   2                 §4.2.1.3: neither operand is real, so the
//                                 power is an integer one; 2
//   u[1 > 0 ? 3 : 0]   3          §4.2.12: 1 > 0 is true, so expression2
//
// THE COUNT IS ASSERTED, which instance_array_unsupported.va says it cannot
// be. Every element's `g` is defparam'd from 9.0 to 5.0, and each defparam
// names one element. An element the range did not create makes its defparam
// name nothing (E0907); an element beyond the four runs with g = 9.0 and fails
// the check below. So passing means exactly u[0] .. u[3]. Each stamps
// 5.0 * 0.5 = 2.5 across the 0.5 V bias.
//
// GROUND TRUTH before the shared constant kernel: E0231 at the indices (the
// parser's folder knew + - * / only), and behind it E0909 at the range (the
// elaboration's copy of the same folder; audit R6, probe ia).
//
//! lrm 6.2.2
//! lrm 6.2.2:1004
//! lrm 6.7
//! lrm 4.2.11
//! lrm 4.2.12
//! bias V(p) = 0.75, V(n) = 0.25
//! checks 8
`include "check.vh"
module ch6_iacr_parent(p, n);
  inout p, n; electrical p, n;
  ch6_iacr_kid u[(1 << 2) - 1 : 0](p, n);
  defparam u[0].g = 5.0, u[7 % 2].g = 5.0, u[2 ** 1].g = 5.0, u[1 > 0 ? 3 : 0].g = 5.0;
endmodule

module ch6_iacr_kid(a, b);
  inout a, b; electrical a, b;
  parameter real g = 9.0;
  analog begin
    `CHECKX("every element of u[3:0] was reached by its constant-expression index", g, 5.0);
    `CHECKX("so each element stamps the overridden value", g * V(a, b), 2.5);
    I(a, b) <+ g * V(a, b);
  end
endmodule
