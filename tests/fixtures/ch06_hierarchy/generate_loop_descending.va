// §6.6.1 loop generate with a DESCENDING index. Syntax 6-8 puts no direction on
// `genvar_iteration ::= genvar_identifier = genvar_expression`, so `i = i - 1` is
// as legal as `i = i + 1`, and §6.9.1 fixes what the direction means: "the order
// in which the loop is unrolled during elaboration determines the concatenation
// order" of the analog blocks. So a descending loop is not just four copies — it
// is four copies in a specific, observable order. Legal construct, so a run
// fixture and not the `//! reject` it used to be.
//
// (The old version declared `electrical [0:2] p` and its reject substring
// `identifier` fired on the VECTOR PORT, before the parser ever reached the loop.
// Scalar ports now, so the loop is the only thing under test; vector nets are a
// separate gap held by vector_ports_range_equal.va.)
//
// `code` appends a base-10 digit per copy, which records the values AND their
// order in one integer:
//
//   i = 2 -> code =   0*10 + 3 =   3
//   i = 1 -> code =   3*10 + 2 =  32
//   i = 0 -> code =  32*10 + 1 = 321
//
// 321 is the conforming answer. ASCENDING unrolling of the same body gives 123,
// which is the whole point of the file — its sibling
// generate_implicit_localparam.va asserts that 123 for the ascending loop, so the
// pair cannot both pass under a compiler that ignores the iteration direction.
//
//! lrm 6.6.1
//! lrm 6.9.1
//! bias V(p) = 0.75, V(n) = 0.25
//! xfail VerA's parser reads a generate block body as an analog statement, so the `analog` keyword inside `generate` dies at E0209 "expected an expression: found `analog`"
`include "check.vh"
module ch6_gen_down(p, n);
  inout p, n; electrical p, n; genvar i;
  integer code;
  analog code = 0;
  generate
    for (i = 2; i >= 0; i = i - 1) begin : stage
      analog begin
        code = code * 10 + (i + 1);
        I(p, n) <+ 0.0;
      end
    end
  endgenerate
  analog `CHECKI("a descending loop unrolls 2, 1, 0 in that order", code, 321);
endmodule
