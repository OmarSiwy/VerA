//! reject identifier
module ch6_gen_down(p); inout p; electrical[0:2] p; genvar i; generate for(i=2;i>=0;i=i-1) I(p[i])<+V(p[i]); endgenerate endmodule
