// §6.3.6 $mfactor automatic scaling, the first rule: "If an instance of a
// module has a non-unity value of $mfactor, the following rules are applied
// automatically by the simulator: All contributions to a branch flow quantity
// in the analog block shall be multiplied by $mfactor." The clause gives the
// reason: the result "is identical to the behavior of a quantity $mfactor of
// identical modules with the same connections".
//
// THE CIRCUIT. The child is a 1 ohm resistor, `I(a,b) <+ V(a,b)/r`, placed
// with `.$mfactor(3.0)` between the parent's internal node x and n. The parent
// joins p to x with a 0 V source, `V(p,x) <+ 0.0`, whose branch flow is an
// ammeter: by Kirchhoff's flow law at x, everything the resistor draws from x
// arrives through that branch.
//
// BY HAND, with V(p) = 1 V and V(n) = 0 V held and the rest solved:
//   V(x)            = V(p) - 0 = 1.0 V
//   one copy        = V(x,n)/r = 1.0/1.0 = 1.0 A
//   three copies    = 3 * 1.0 = 3.0 A   (the rule: the contribution times $mfactor)
//   I(p,x)          = 3.0 A             (the parent's own $mfactor is 1.0, so its
//                                        probe is not divided)
// An implementation that ignored $mfactor reads 1.0 A. The tolerance is
// absolute 1e-12, far below the 2 A gap and below the --perturb step.
//
//! lrm 6.3.6
//! lrm 6.3.6:3
//! bias V(p) = 1.0, V(n) = 0.0
//! solve
//! checks 2
`include "check.vh"
module b4_mfc_top(p, n);
  inout p, n; electrical p, n, x;
  b4_mfc_res #(.$mfactor(3.0)) u(x, n);
  analog begin
    V(p, x) <+ 0.0;
    `CHECK("the ammeter carries three copies of the 1 A one copy draws", I(p, x), 3.0, 1e-12);
  end
endmodule

module b4_mfc_res(a, b);
  inout a, b; electrical a, b;
  parameter real r = 1.0 from (0:inf);
  analog begin
    `CHECKX("Table 9-29: the instance's $mfactor is 1.0 * 3.0", $mfactor, 3.0);
    I(a, b) <+ V(a, b) / r;
  end
endmodule
