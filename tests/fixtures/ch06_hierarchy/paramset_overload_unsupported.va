// §6.4.2: "Paramset identifiers need not be unique: multiple paramsets can be
// declared using the same paramset_identifier ... During elaboration, the
// simulator shall choose an appropriate paramset from the set that shares a given
// name for every instance that references that name." Overloading is defined
// behaviour with a printed selection algorithm, so refusing it is not conformance
// and this is a run fixture, not the `//! reject` it used to be.
//
// The selection rule being pinned is the second bullet of §6.4.2: "The parameters
// of the paramset, with overrides and defaults, shall be all within the allowed
// ranges specified in the paramset parameter declaration." The two paramsets below
// are the LRM's own short-channel / long-channel pair reduced to one parameter
// with DISJOINT ranges, so exactly one of them admits the instance's l = 0.5 and
// the choice is forced, not a tie broken by the later rules:
//
//   ch6_sel  #1   l from [1.0:inf)      excludes 0.5   .k = 10.0
//   ch6_sel  #2   l from [0.25:1.0)     admits  0.5    .k = 20.0
//
// So k must be 20.0. A compiler that took the first declaration textually, or the
// last, without checking the range reports 10.0 half the time — which is why the
// admissible paramset is the SECOND one, where a naive first-match also fails.
//
// With V(p,n) = 0.5 the module stamps 20.0 * 0.5 = 10.0.
//
//! lrm 6.4.2
//! bias V(p) = 0.75, V(n) = 0.25
//! xfail VerA compiles one flat module: the paramset DECLARATION is now read past and dropped (§6.4 gives it effect only through an instance), but the instantiation that would select it is refused at E0204 "module instantiation is not supported"
`include "check.vh"
module ch6_overload_user(p, n);
  inout p, n; electrical p, n;
  ch6_sel #(.l(0.5)) u(p, n);
endmodule

paramset ch6_sel ch6_sel_base;   // long-channel: l = 0.5 is out of range
  parameter real l = 1.0 from [1.0:inf);
  .k = 10.0;
endparamset

paramset ch6_sel ch6_sel_base;   // short-channel: the only one that admits l = 0.5
  parameter real l = 0.25 from [0.25:1.0);
  .k = 20.0;
endparamset

module ch6_sel_base(a, b);
  inout a, b; electrical a, b;
  parameter real k = 9.0;
  analog begin
    `CHECKX("the paramset whose range admits the override is the one selected", k, 20.0);
    `CHECKX("so the module stamps the selected paramset's value", k * V(a, b), 10.0);
    I(a, b) <+ k * V(a, b);
  end
endmodule
