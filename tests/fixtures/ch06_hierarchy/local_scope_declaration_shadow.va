// §6.8 scope rules, the LOCAL half: "If an identifier is referenced directly
// (without a hierarchical path) within a named block ... IF IT IS DECLARED
// LOCALLY, THE LOCAL ITEM SHALL BE USED; if not, the search shall continue upward
// until an item by that name is found or until a module boundary is encountered."
//
// local_scope_shadow.va is the second clause — an inner block that declares
// nothing and reads the module's `value`. This file is the first, which is the one
// a broken scope table gets wrong: `begin : inner` DECLARES its own `real value`,
// so both names exist at once and the inner reference must bind to the inner
// declaration. §6.8 lists a named block as one of the things that "define a new
// scope", which is what makes two declarations of `value` legal here and illegal
// in one scope (duplicate_declaration_rejected.va).
//
// Two assertions, because there are two ways to fail and they are opposite:
//
//   inside the block, `value` is 2.25 — a compiler that resolved the reference
//   upward, ignoring the local declaration, reports 1.0;
//
//   after `end`, `value` is 1.0 again — a compiler that kept one variable for both
//   declarations (one flat map, last writer wins) reports 2.25, and it would pass
//   the first check and both of local_scope_shadow.va's.
//
// 1.0 and 2.25 are binary-exact, and 2.25 is not reachable from 1.0 by any
// arithmetic in the file, so a leaked write is unambiguous. Held at V(p) = 0.5 the
// stamp is the OUTER value, 1.0 * 0.5 = 0.5.
//
//! lrm 6.8
//! lrm 6.8:3
//! lrm 6.8:4
//! bias V(p) = 0.5
`include "check.vh"
module ch6_scope_declaration_shadow(p);
  inout p; electrical p;
  real value;
  analog begin
    value = 1.0;
    begin : inner
      real value;
      value = 2.25;
      `CHECKX("the locally declared value shadows the enclosing one", value, 2.25);
    end
    `CHECKX("and the enclosing value survives the block unchanged", value, 1.0);
    I(p) <+ value * V(p);
  end
endmodule
