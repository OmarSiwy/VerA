// §6.7.1, last bullet: "It shall be an error to assign to an analog variable
// using hierarchical notation." This is the write half of the prohibition whose
// read half is oomr_variable_read_rejected.va, and like it the rejection is
// correct conformance — no `//! xfail`. §6.7.1 permits hierarchical access to
// branches, parameters and analog functions, and Annex C.8 keeps all of Clause 6
// in the Verilog-A subset; only analog VARIABLES are excluded.
//
// `device` is a real instance and `local_value` a real variable of it, so the
// path resolves and the only defect is the hierarchical write. VerA refuses it on
// the assignment TARGET — E0316 quoting §5.7's "Hierarchical assignment of a
// variable from another scope/module is not allowed", which is §6.7.1's last
// bullet said from the other side.
//
//! lrm 6.7.1
//! lrm 6.7.1:4
//! lrm 5.7
//! lrm 5.7:3
//! reject-only E0316
//! neighbour oomr_parameter_unsupported.va
`include "disciplines.vams"
module ch6_oomr_variable_assign(p);
  inout p; electrical p;
  ch6_oomr_variable_assign_child device(p);
  analog begin
    device.local_value = V(p);
    I(p) <+ V(p);
  end
endmodule

module ch6_oomr_variable_assign_child(a);
  inout a; electrical a;
  real local_value;
  analog begin
    local_value = 1.0;
    I(a) <+ V(a);
  end
endmodule
