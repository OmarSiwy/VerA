// §6.7.1, last bullet: "It shall be an error to assign to an analog variable
// using hierarchical notation." This is the write half of the prohibition whose
// read half is oomr_variable_read_rejected.va, and like it the rejection is
// correct conformance — no `//! xfail`. The first line of this file used to say
// "out-of-module references are not permitted in Verilog-A", which is false:
// §6.7.1 permits hierarchical access to branches, parameters and analog functions,
// and Annex C.8 keeps all of Clause 6 in the Verilog-A subset. Only analog
// VARIABLES are excluded.
//
// The diagnostic is now the rule, or near enough: the `.` PARSES (§5.5.3's nature
// attribute reference needed a dotted name), so the refusal lands on the
// assignment TARGET — E0316 quoting §5.7's "Hierarchical assignment of a variable
// from another scope/module is not allowed", which is §6.7.1's last bullet said
// from the other side. It used to be E0214 "expected `<+` or `=`", a §5.6
// contribution syntax error reached because the parser could not see
// `device.local_value` as an lvalue at all.
//
//! lrm 6.7.1
//! lrm 5.7
//! reject E0316
module ch6_oomr_variable_assign(p);
  inout p; electrical p;
  analog begin
    device.local_value = V(p);
    I(p) <+ V(p);
  end
endmodule
