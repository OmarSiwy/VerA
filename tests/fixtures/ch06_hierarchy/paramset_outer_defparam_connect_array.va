// §6.9.3 inserts connect modules AFTER paramset selection; §6.3 requires
// selection to use defparam values. Receiver k=0 has an electrical port;
// k=1 has a discrete port requiring an a2d with 1 kohm analog input loading.
//
// The scalar's inline k=1 is replaced by 0: no a2d is inserted on a. The
// array starts at k=0, but u[0].k=1 and u[1].k=0 require exactly one a2d on b.
// Each net also has a 1 kohm shunt and 1 mA injected by the parent. Thus
// V(a)=1mA*1kohm=1 V; V(b)=1mA*(1kohm||1kohm)=0.5 V. Deciding once for the
// whole array, or before the outer overrides, cannot produce this pair.
//! lrm 6.3
//! lrm 6.4.2
//! lrm 6.9.3
//! lrm 6.9.3:1
//! solve
//! checks 2
`include "check.vh"
connectmodule ps_outer_a2d(el, d);
  input el; output d;
  electrical el; ddiscrete d; reg d;
  analog I(el) <+ V(el)/1000.0;
  initial d=1'b0;
endmodule
module ps_outer_digital(d);
  input d; ddiscrete d;
  parameter integer k=0;
endmodule
module ps_outer_analog(a);
  input a; electrical a;
  parameter integer k=0;
  analog I(a) <+ 0.0;
endmodule
paramset ps_outer_receiver ps_outer_digital;
  parameter integer k=0 from [1:inf);
  .k=k;
endparamset
paramset ps_outer_receiver ps_outer_analog;
  parameter integer k=0 from (-inf:1);
  .k=k;
endparamset
module ps_outer_connect_top;
  electrical a,b;
  ps_outer_receiver #(.k(1)) scalar(a);
  ps_outer_receiver #(.k(0)) u[1:0](b);
  defparam scalar.k=0, u[0].k=1, u[1].k=0;
  analog begin
    I(a) <+ V(a)/1000.0-1e-3;
    I(b) <+ V(b)/1000.0-1e-3;
    `CHECK("scalar defparam removed the mixed connection", V(a), 1.0, 1e-12);
    `CHECK("only one array element needs a bridge", V(b), 0.5, 1e-12);
  end
endmodule
connectrules ps_outer_connect_rules;
  connect ps_outer_a2d;
endconnectrules
