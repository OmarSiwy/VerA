// §6.3.6, the fifth automatic rule: "The module's value of $mfactor is also
// propagated to any module instantiated by the original module, according to the
// rules found in 9.18." Table 9-29 gives the rule as a PRODUCT —
// $mfactor_resolved = $mfactor_specified * $mfactor_hier, top-level value 1.0 —
// and §9.18 spells it out: "the product of the multiplicity factor specified for
// the instance (or 1.0, if no override was specified) times the value for the
// parent module that instantiated the module, times the parent's parent's value,
// and so on, until the top level is reached."
//
// This is legal, printed source — §9.18 Example 1 is this exact three-deep chain,
// written `module_b #(.$mfactor(2)) B1(p,n);` — so the file is a run fixture and
// not the `//! reject` it used to be.
//
// The chain here is deliberately three levels so the rule is a product and not a
// copy:
//
//   ch6_mfp_parent   top level, nothing instantiates it        $mfactor = 1.0
//   ch6_mfp_mid      instantiated with .$mfactor(2.0)          1.0 * 2.0 =  2.0
//   ch6_mfp_leaf     instantiated with .$mfactor(7.0)          2.0 * 7.0 = 14.0
//
// A compiler that used only the innermost specified value reports 7.0 at the leaf;
// one that summed instead of multiplying reports 9.0; one that did not propagate
// at all reports 1.0. Only the product gives 14.0. The leaf also computes the
// §9.18 effective-resistance idiom `r / $mfactor` with r = 1.0, whose double is
// 1.0/14.0 = 0.07142857142857142 — not exact in binary, hence CHECKR.
//
// $mfactor's own automatic current scaling (§6.3.6 rule 1) is deliberately NOT
// asserted here: VerA's position, written at src/backend/codegen.zig:2552, is that
// the host scales the whole stamp, so it is not a device-visible number. What is
// device-visible is the value $mfactor returns, and that is what this pins.
//
//! lrm 6.3.6
//! lrm 9.18
//! bias V(p) = 0.75, V(n) = 0.25
//! xfail VerA compiles one flat module, so a module instantiation is refused outright at E0204 "module instantiation is not supported"
`include "check.vh"
module ch6_mfp_parent(p, n);
  inout p, n; electrical p, n;
  ch6_mfp_mid #(.$mfactor(2.0)) u(p, n);
  analog `CHECKX("the top of the hierarchy starts at Table 9-29's 1.0", $mfactor, 1.0);
endmodule

module ch6_mfp_mid(a, b);
  inout a, b; electrical a, b;
  ch6_mfp_leaf #(.$mfactor(7.0)) v(a, b);
  analog `CHECKX("1.0 from the parent times the 2.0 specified here", $mfactor, 2.0);
endmodule

module ch6_mfp_leaf(a, b);
  inout a, b; electrical a, b;
  parameter real r = 1.0;
  analog begin
    `CHECKX("$mfactor is the product down the whole chain, 1.0*2.0*7.0", $mfactor, 14.0);
    `CHECKR("so the effective resistance r/$mfactor is 1/14", r / $mfactor, 0.07142857142857142, 1e-15);
    I(a, b) <+ V(a, b) / r;
  end
endmodule
