// LRM §6.3.6 / §9.18: $mfactor is implicitly declared for every module, and
// Table 9-29 gives its TOP-LEVEL value as 1.0 — "the multiplicity factor
// specified for the instance (or 1.0, if no override was specified) times the
// value for the parent module". This instance is the top of the hierarchy and
// specifies nothing, so $mfactor is exactly 1.0, which is also why the §6.3.6
// automatic scaling rules are identities here.
//
// The contribution keeps `0.0 * $mfactor` so the system parameter is read from
// the residual path as well as from the assertion.
//
//! lrm 6.3.6
//! lrm 9.18
//! lrm 6.3.6:1
//! lrm 9.18:1000
`include "check.vh"
module ch6_mfactor(p);
  inout p; electrical p;
  analog begin
    `CHECKX("$mfactor of an un-overridden top-level instance", $mfactor, 1.0);
    I(p) <+ V(p) + 0.0 * $mfactor;
  end
endmodule
