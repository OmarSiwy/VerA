// AMS A.4.1's parameter_value_assignment requires at least one expression or
// named assignment. Empty #() differs from omitting the list or writing .a(),
// both of which are exercised by parameter_list_forms.va.
//! lrm A.4.1
//! reject E0246
module parameter_list_empty_leaf(p);
  inout p; electrical p;
  parameter real a=3;
  analog I(p) <+ a*V(p);
endmodule
module parameter_list_empty_override(p);
  inout p; electrical p;
  parameter_list_empty_leaf #() child(p);
endmodule
