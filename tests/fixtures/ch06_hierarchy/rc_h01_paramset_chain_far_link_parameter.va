// §6.4: "The second identifier may instead be the name of a second paramset. A
// chain of paramsets may be defined, but the last paramset in the chain shall
// reference a module." §6.4.1: the `.module_parameter_identifier = ...` syntax
// "is used to assign values to the parameters of the associated module. The
// right-hand side can be composed of numbers, parameters, and hierarchical
// out-of-module references to local parameters of a different module."
//
// h01_02_paramset_chain.va with one change: the far link's statement reads the
// far link's OWN parameter instead of a literal. Nothing in §6.4 suspends
// §6.4.1's "parameters" on the right-hand side because the paramset is reached
// through a chain, so `.j = jval` assigns the module's j the value of jval.
//
// THE NUMBER. No instance overrides jval, so it is its default 2.0; j = 2.0, and
// at the biased 0.5 V the contribution j*V is 2.0 * 0.5 = 1.0 A.
//
// Every paramset declares at least one item (Syntax 6-4 / A.1.9,
// `paramset_item_declaration { paramset_item_declaration }`); both links do.
//
// Until 2026-10-08 VerA refused `.j = jval;` with E0314 "unknown identifier":
// it evaluated a far link's statements in the near link's scope. Each link
// now has its own (`elaborate/paramset.zig` `paramsetOverrides`).
//
//! lrm 6.4
//! lrm 6.4:1
//! lrm 6.4.1
//! bias V(p) = 0.5
//! checks 2
`include "check.vh"
module rc_h01_chain_param(p, n);
  inout p, n; electrical p, n;
  rc_h01p_fast u(p, n);
endmodule

paramset rc_h01p_fast rc_h01p_slow;
  real link_tag;
  link_tag = 1.0;
endparamset

paramset rc_h01p_slow rc_h01p_base;
  parameter real jval = 2.0;
  .j = jval;
endparamset

module rc_h01p_base(a, b);
  inout a, b; electrical a, b;
  parameter real j = 0.0;
  analog begin
    `CHECKX("the far link's own parameter reached the module through the chain", j, 2.0);
    `CHECKX("so the conductance is 2.0 and the current 1.0 A at 0.5 V", j * V(a, b), 1.0);
    I(a, b) <+ j * V(a, b);
  end
endmodule
