// §6.9.4 "The following algorithm defines an order that produces the correct
// hierarchy: ... The hierarchy below each starting point is expanded as much as
// possible without elaborating generate constructs. All parameters encountered
// during this expansion are given their final values by applying initial
// values, parameter overrides, defparam statements, and paramset selections.
// ... Each generate construct encountered in step 2 is revisited, and the
// generate scheme is evaluated."
//
// The positive consequence of that order: a generate scheme sees the value a
// defparam gave its parameter, never the declared default, because step 2
// applies every resolvable defparam before step 3 evaluates any generate
// scheme. (oomr_in_parameter_declaration_rejected.va is the clause's only other
// cite, and it is a rejection.)
//
// DERIVATION. The child declares `sel = 0`; the parent's defparam sets `u.sel`
// to 1. The child's conditional generate picks the `sel != 0` arm, which
// contributes V(a, b) <+ 0.75; the default arm would contribute 0.25. The
// parent pins n = 0 and leaves p to the device, so V(p) = 0.75 exactly.
//
//! lrm 6.9.4
//! lrm 6.9.4:1
//! bias V(n) = 0.0
//! solve
`include "check.vh"
module ch6_elaboration_order_parent(p, n);
  inout p, n;
  electrical p, n;
  ch6_elaboration_order_child u(p, n);
  defparam u.sel = 1;
  analog begin
    `CHECKX("§6.9.4 the generate scheme saw the defparam'd value", V(p, n), 0.75);
  end
endmodule

module ch6_elaboration_order_child(a, b);
  inout a, b;
  electrical a, b;
  parameter integer sel = 0;
  generate
    if (sel != 0) begin : picked
      analog V(a, b) <+ 0.75;
    end else begin : fallback
      analog V(a, b) <+ 0.25;
    end
  endgenerate
endmodule
