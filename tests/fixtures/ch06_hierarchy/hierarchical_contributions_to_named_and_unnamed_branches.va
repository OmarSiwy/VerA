// §6.7.1: "Potential and flow contributions to named and unnamed branches can
// be done hierarchically."
//
// Two child instances, each owning a different kind of branch, and the top
// contributing into each through the child's hierarchical name:
//
//   named    branch (x, b) br, potential-sourced 0.5 V by the child.
//            The top's `V(n1.br) <+ 1.8` is the SAME branch, so §5.6.1.2
//            accumulation gives V(br) = 2.3 V. A compiler that made a new
//            parent branch instead would build two parallel potential sources
//            (0.5 V and 1.8 V) — a voltage-source loop, not 2.3.
//   unnamed  the child's unnamed (x, y) branch carries V(x,y)/1k. The top's
//            `I(m1.branch(x, y)) <+ 1m` reaches THAT branch: with V(x) = 3 V and
//            a 1k load at y, Kirchhoff gives V(y) = 2.0 V and a branch flow of
//            2.0 mA. A new parent branch would leave the child's own flow at
//            1.0 mA while V(y) still read 2.0, so the flow check pins which
//            branch received it.
//
// The named half is the potential contribution and the unnamed half the flow
// contribution; both assertions are on the child's own branch, not on a parent
// copy of it.
//
//! lrm 6.7.1
//! lrm 6.7.1:1004
//! bias V(g) = 0.0
//! solve
//! checks 5
`include "check.vh"
module ch6_hc_top(g);
  inout g; electrical g;
  ch6_hc_named n1(g);
  ch6_hc_unnamed m1(g);
  analog begin
    V(n1.br) <+ 1.8;
    I(m1.branch(x, y)) <+ 1m;
    I(g) <+ 0.0;
  end
endmodule

module ch6_hc_named(b);
  inout b; electrical b, x;
  branch (x, b) br;
  analog begin
    V(br) <+ 0.5;
    I(x) <+ V(x)/1000.0;
    I(b) <+ 0.0;
    `CHECK("the top's 1.8 V adds to the child's 0.5 V on the named branch", V(br), 2.3, 1e-12);
    `CHECK("the node the branch drives follows the sum", V(x), 2.3, 1e-12);
    `CHECK("so the load current returns through the child's own branch", I(br), -2.3e-3, 1e-12);
  end
endmodule

module ch6_hc_unnamed(b);
  inout b; electrical b, x, y;
  analog begin
    V(x) <+ 3.0;
    I(x, y) <+ V(x, y)/1000.0;
    I(y) <+ V(y)/1000.0;
    I(b) <+ 0.0;
    `CHECK("the top's milliamp landed on the child's unnamed branch", I(x, y), 2.0e-3, 1e-12);
    `CHECK("and Kirchhoff at the loaded node gives 2 V", V(y), 2.0, 1e-12);
  end
endmodule
