// §6.3.1 forbids defparam in or under a paramset INSTANCE. §6.9.4 relies on
// that instantiated hierarchy, and §6.6.2 instantiates only a selected arm.
// Unused paramset definitions and unselected arms create no such hierarchy.
//
// The same ps_dp_legal_body has a valid ordinary instance and a defparam:
// child.gain=5 overrides the default 1. The separately overridden leaf has
// gain=7 instead of its inline 2. The valid paramset selects gain=3 and its
// enabled=0 arm, leaving the descendant with defparam uninstantiated. The top
// also leaves a whole invalid paramset instance uninstantiated with select=0.
// A zero-volt source connects p to sum_node, fixing both at 1/2 V. The branch
// currents are 5/2, 7/2, and 3/2 A. By KCL the source supplies their sum, 15/2 A;
// an extra contribution from either unselected hierarchy changes that current.
// A.1.9: a paramset needs >= 1 paramset_item_declaration (corrected 2026-10-08)
//! lrm 6.3.1
//! lrm 6.4
//! lrm 6.6.2
//! lrm 6.3
//! lrm 6.3:1
//! solve
//! bias V(p) = 0.5
//! checks 7
`include "check.vh"
module ps_dp_legal_top(p);
  inout p; electrical p, sum_node;
  parameter integer select = 0;
  ps_dp_legal_body ordinary(sum_node);
  ps_dp_legal_leaf #(.gain(2.0)) overridden(sum_node);
  defparam overridden.gain = 7.0;
  ps_dp_legal_card valid(sum_node);
  if (select) begin : absent
    ps_dp_legal_unused_card inactive(sum_node);
  end
  analog begin
    V(p, sum_node) <+ 0.0;
    `CHECKX("ordinary descendant defparam wins", ordinary.child.gain, 5.0);
    `CHECKX("outer defparam wins the inline assignment", overridden.gain, 7.0);
    `CHECKX("the valid paramset assignment arrives", valid.gain, 3.0);
    `CHECKX("ordinary defparam behavior executes", I(ordinary.child.br), 2.5);
    `CHECKX("outer defparam behavior executes", I(overridden.br), 3.5);
    `CHECKX("the selected legal arm executes", I(valid.present_child.good.br), 1.5);
    `CHECKX("only the three selected branches contribute", I(p, sum_node), 7.5);
  end
endmodule
paramset ps_dp_legal_card ps_dp_legal_wrapper;
  parameter real unused_item = 0;
  .gain = 3.0;
  .enabled = 0;
endparamset
paramset ps_dp_legal_unused_card ps_dp_legal_body;
  parameter real unused_item = 0;
  .marker = 2.0;
endparamset
// This additional association is never instantiated anywhere in the design.
paramset ps_dp_legal_unreferenced_card ps_dp_legal_body;
  parameter real unused_item = 0;
  .marker = 4.0;
endparamset
module ps_dp_legal_wrapper(p);
  inout p; electrical p;
  parameter real gain = 1.0;
  parameter integer enabled = 1;
  if (enabled) begin : absent_child
    ps_dp_legal_body bad(p);
  end else begin : present_child
    ps_dp_legal_leaf #(.gain(gain)) good(p);
  end
endmodule
module ps_dp_legal_body(p);
  inout p; electrical p;
  parameter real marker = 0.0;
  ps_dp_legal_leaf child(p);
  defparam child.gain = 5.0;
endmodule
module ps_dp_legal_leaf(p);
  inout p; electrical p;
  parameter real gain = 1.0;
  branch (p) br;
  analog I(br) <+ gain * V(br);
endmodule
