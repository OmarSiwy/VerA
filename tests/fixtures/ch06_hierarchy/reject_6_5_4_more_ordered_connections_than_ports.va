// §6.5.4: "One way to connect the ports listed in a module instantiation with
// the ports defined by the instantiated module is via an ordered list—that is,
// the ports listed for the module instance shall be in the same order as the
// ports listed in the module definition."
//
// ch6_ord_child defines two ports, (a, b). The instance lists three
// connections, (p, n, n); the third is in no position of the definition's
// port list, so it cannot be "in the same order as the ports listed in the
// module definition". `(p, n)` is the legal form.
//
// VerA reports E0906 "`ch6_ord_child` declares 2 ports, and this instance
// connects 3".
//
//! lrm 6.5.4
//! reject-only E0906
`include "disciplines.vams"
module ch6_ord_child(a, b);
  inout a, b;
  electrical a, b;
  analog I(a, b) <+ V(a, b);
endmodule

module ch6_ord_too_many(p, n);
  inout p, n;
  electrical p, n;
  ch6_ord_child c1(p, n, n);     // illegal: a third connection for two ports
endmodule
