// §6.5.2 port declarations, written in the header instead of the body: the
// direction (§6.5.2.2) and the discipline (§6.5.2.1) of every port are given
// once, in the module's list of ports. §6.5.2.1 is what makes a port reachable
// from behavioral code at all — "if the type of a port is not declared, the
// port can only be used in a structural description" — so the test of an ANSI
// header is that V() reads the right net through it.
//
// The three ports are biased to three different potentials, so a header that
// bound them in the wrong order, or dropped the `electrical` on one, cannot
// still report 1.5 at `sense` and 1.25 across the (sense, p) branch.
//
//! lrm 6.5.2
//! lrm 6.5.2.1
//! lrm 6.5.2.2
//! lrm 6.5
//! lrm 6.5.2.1:1000
//! bias V(sense) = 1.5, V(p) = 0.25, V(out) = -0.5
`include "check.vh"
module ch6_ansi(input electrical sense, inout electrical p, output electrical out);
  analog begin
    `CHECKX("the input port's discipline makes it probeable", V(sense), 1.5);
    `CHECKX("the inout port is a distinct net", V(p), 0.25);
    `CHECKX("branch across two header-declared ports", V(sense, p), 1.25);
    I(p) <+ V(sense);
    V(out) <+ V(p);
  end
endmodule
