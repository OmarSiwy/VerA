// §6.4.2's SECOND phase. Both paramsets below are applicable — the selection
// rules ("the following rules shall be enforced") rule neither out, since
// `l = 1.0` is in both ranges and `l` is a parameter of both — so "The rules
// above may not be sufficient for the simulator to pick a unique paramset, in
// which case the following rules shall be applied in order until a unique
// paramset has been selected", of which the first is: "The paramset with the
// fewest number of un-overridden parameters shall be selected."
//
// The instance overrides only `l`. The first paramset declares {l, extra} and
// leaves `extra` un-overridden (count 1); the second declares {l} alone
// (count 0), so the SECOND is selected and k = 20.0. This is the clause's own
// m3 example reduced to one knob — there the default paramset {l, w} beats the
// long-channel {l, w, ad, as} for exactly this count — and the winner is
// deliberately the LATER declaration, so a compiler that takes the first
// applicable paramset in declaration order (the bug this file pins) reports
// 10.0 and fails.
//
// The target module's own k default is 9.0, so a paramset that never fired is
// visible rather than accidentally right. With V(p,n) = 0.5 the module stamps
// 20.0 * 0.5 = 10.0.
//
//! lrm 6.4.2
//! lrm 6.4.2:7
//! bias V(p) = 0.75, V(n) = 0.25
`include "check.vh"
module ch6_tb_user(p, n);
  inout p, n; electrical p, n;
  ch6_tb_bin #(.l(1.0)) u(p, n);
endmodule

paramset ch6_tb_bin ch6_tb_base;   // {l, extra}: one un-overridden parameter
  parameter real l = 1.0 from [0.5:2.0];
  parameter real extra = 2.0;
  .k = 10.0;
endparamset

paramset ch6_tb_bin ch6_tb_base;   // {l}: zero un-overridden parameters — selected
  parameter real l = 1.0 from [0.5:2.0];
  .k = 20.0;
endparamset

module ch6_tb_base(a, b);
  inout a, b; electrical a, b;
  parameter real k = 9.0;
  analog begin
    `CHECKX("the paramset with the fewest un-overridden parameters is selected", k, 20.0);
    `CHECKX("so the module stamps the selected paramset's value", k * V(a, b), 10.0);
    I(a, b) <+ k * V(a, b);
  end
endmodule
