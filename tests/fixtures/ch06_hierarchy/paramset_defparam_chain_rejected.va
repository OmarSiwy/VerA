// §6.4 permits chains but still forbids a defparam under the associated module.
// The near link deliberately has no .parameter assignment, so this tests no
// unspecified precedence between two links. The far link reaches a module
// containing defparam. h01_02_paramset_chain.va is the behavioral legal chain.
//! lrm 6.4
//! lrm 6.3.1
//! reject E0926
module ps_dp_chain_top(p);
  inout p; electrical p;
  ps_dp_chain_near u(p);
endmodule
paramset ps_dp_chain_near ps_dp_chain_far;
  real tag;
  tag = 1.0;
endparamset
paramset ps_dp_chain_far ps_dp_chain_body;
  .gain = 2.0;
endparamset
module ps_dp_chain_body(p);
  inout p; electrical p;
  parameter real gain = 1.0;
  ps_dp_chain_leaf child(p);
  defparam child.gain = gain;
endmodule
module ps_dp_chain_leaf(p);
  inout p; electrical p;
  parameter real gain = 1.0;
  analog I(p) <+ gain * V(p);
endmodule
