// §6.6.2 case-generate. Syntax 6-8 defines it —
// `case_generate_construct ::= case ( constant_expression ) case_generate_item
// { case_generate_item } endcase` and `case_generate_item ::= constant_expression
// { , constant_expression } : generate_block_or_null | default [ : ]
// generate_block_or_null` — and §6.6 makes it one of the two conditional generate
// constructs that "instantiate at most one generate block from a set of
// alternative generate blocks". Defined syntax with defined semantics, so this is
// a run fixture and not the `//! reject` it used to be.
//
// The scheme is evaluated at elaboration, AFTER §6.3 parameter overrides, so the
// arm has to follow the override and not the declaration: `mode` defaults to 1 and
// is overridden to 2 below. The alternatives are laid out so that every plausible
// wrong answer is a different number —
//
//   arm = 0   no alternative elaborated (the seed, so this is never an undefined read)
//   arm = 1   the `1:` item, i.e. the condition was resolved against the DEFAULT
//   arm = 2   the `2, 3:` item — the only conforming answer
//   arm = 9   the `default` item, i.e. the comma-separated label list was not matched
//
// The `2, 3:` label is a list on purpose: it is the part of Syntax 6-8 that a
// case-generate has and an if-generate does not, and a compiler that matched only
// single-expression labels lands on `default` and reports 9.
//
// Each block holds `analog begin ... end`, because §6.6 makes a generate block "a
// collection of one or more module items" and a bare assignment is a statement.
//
//! lrm 6.6.2
//! lrm 6.6
//! param mode = 2
//! bias V(p) = 0.75, V(n) = 0.25
//! xfail VerA has no case_generate_construct: `case` at module scope is E0205 "unsupported module item: found `case`". Loop and if-generate now hold module items; only this third scheme is missing
`include "check.vh"
module ch6_generate_case(p, n);
  inout p, n; electrical p, n;
  parameter integer mode = 1;
  integer arm;
  analog arm = 0;
  generate
    case (mode)
      1: begin
        analog begin arm = 1; I(p, n) <+ V(p, n); end
      end
      2, 3: begin
        analog begin arm = 2; I(p, n) <+ 2.0 * V(p, n); end
      end
      default: begin
        analog begin arm = 9; I(p, n) <+ 0.0; end
      end
    endcase
  endgenerate
  analog `CHECKI("the overridden mode selects the comma-listed alternative", arm, 2);
endmodule
