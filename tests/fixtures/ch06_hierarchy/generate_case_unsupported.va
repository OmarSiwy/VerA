//! reject unsupported module item
// EXPECT: error -- case-generate is not implemented.
module ch6_generate_case(p);
  inout p; electrical p;
  parameter integer mode = 1;
  generate
    case (mode)
      1: I(p) <+ V(p);
      default: I(p) <+ 0.0;
    endcase
  endgenerate
endmodule
