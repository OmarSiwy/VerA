// §6.3.6: "The five geometrical system parameters ($xposition, $yposition,
// $angle, $hflip, $vflip) do not have any automatic effect on the simulation."
// The parameters carry values a model may read; the simulator adds no effect
// of its own. The differential below is the observation: two identical devices
// across the same potential, with DIFFERENT geometry, must conduct the same
// current.
//
//   u1  defaults        $xposition=0, $yposition=0, $angle=0, flips +1
//   u2  overridden      $xposition=5, $yposition=-3, $angle=90, flips -1
//
// Each leaf asserts the geometry it actually received (so a compiler that
// dropped the overrides cannot pass by accident) and stamps V/1k. With both
// nodes held at 0.5 V the two branch currents are 0.5 mA; an automatic effect
// driven by any of the five would separate them.
//
//! lrm 6.3.6
//! lrm 6.3.6:1002
//! bias V(p) = 0.5
//! bias V(n) = 0.0
//! bias V(q) = 0.5
//! checks 5
`include "check.vh"
module ch6_geo_eff_top(p, n, q);
  inout p, n, q; electrical p, n, q;
  ch6_geo_eff_default u1(p, n);
  ch6_geo_eff_moved #(.$xposition(5.0), .$yposition(-3.0), .$angle(90.0),
                      .$hflip(-1.0), .$vflip(-1.0)) u2(q, n);
  analog begin
    `CHECK("different geometry, same current", I(u1.br) - I(u2.br), 0.0, 1e-9);
    I(p) <+ 0.0;
    I(q) <+ 0.0;
  end
endmodule

module ch6_geo_eff_default(a, b);
  inout a, b; electrical a, b;
  branch (a, b) br;
  analog begin
    `CHECKX("u1 keeps the top-level geometry", $xposition, 0.0);
    `CHECKX("and the top-level angle", $angle, 0.0);
    I(br) <+ V(br) / 1k;
  end
endmodule

module ch6_geo_eff_moved(a, b);
  inout a, b; electrical a, b;
  branch (a, b) br;
  analog begin
    `CHECKX("u2 received the x position override", $xposition, 5.0);
    `CHECKX("and the angle override", $angle, 90.0);
    I(br) <+ V(br) / 1k;
  end
endmodule
