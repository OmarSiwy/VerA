// IEEE1364-2005 12.2.2.2, also AMS6.3.3.
// Empty .gain() retains gain3; .offset(7) overrides only offset.
//! lrm 6.3.3
//! lrm 6.3.3:1
//! lrm 6.3.3:2
//! lrm 6.3.3:1001
//! checks 2
// inherited IEEE 1364-2005 12.2.2.2
`include "check.vh"
module audit_hierarchy_empty_named_parameter(p);
  inout p; electrical p;
  audit_empty_leaf #(.gain(),.offset(7.0)) u(p);
endmodule
module audit_empty_leaf(p);
  inout p; electrical p;
  parameter real gain=3.0,offset=2.0;
  analog begin
    `CHECKX("empty named default",gain,3.0);
    `CHECKX("other named override",offset,7.0);
    I(p)<+(gain+offset)*V(p);
  end
endmodule
