// §3.4.7 permits an alias when overriding a parameter; §6.3 gives a defparam
// precedence when both overrides use that SAME alias. Equations use w, never
// width. §4.2.1.1 rounds 5.5 to integer 6 before selection and assignment.
//
// The three paramset instances have w=7,6,5, all in the high bin [4:10],
// whose gain=3*w gives 21,18,15. An ordinary module's defparam through its
// alias sets gain=4. At V(p)=1/2 their currents are 10.5,9,7.5,2 A.
//! lrm 3.4.7
//! lrm 6.3
//! lrm 6.4.2
//! lrm 6.4.2:4
//! bias V(p) = 0.5
//! checks 8
`include "check.vh"
module ps_outer_alias(p);
  inout p; electrical p;
  ps_alias_bin #(.width(2)) same_alias(p);
  ps_alias_bin alias_only(p);
  ps_alias_bin original_only(p);
  ps_alias_leaf ordinary(p);
  defparam same_alias.width=7, alias_only.width=5.5, original_only.w=5;
  defparam ordinary.g=4.0;
  analog begin
    `CHECKX("same alias defparam wins inline", same_alias.gain, 21.0);
    `CHECKX("alias conversion precedes selection", alias_only.gain, 18.0);
    `CHECKX("the original name remains legal", original_only.gain, 15.0);
    `CHECKX("ordinary module uses the same alias binding", ordinary.gain, 4.0);
    `CHECKX("same alias behavior executes", I(same_alias.br), 10.5);
    `CHECKX("alias-only behavior executes", I(alias_only.br), 9.0);
    `CHECKX("original-only behavior executes", I(original_only.br), 7.5);
    `CHECKX("ordinary alias behavior executes", I(ordinary.br), 2.0);
    I(p) <+ 0.0;
  end
endmodule
paramset ps_alias_bin ps_alias_leaf;
  parameter integer w=1 from [0:4);
  aliasparam width=w;
  .gain=2.0*w;
endparamset
paramset ps_alias_bin ps_alias_leaf;
  parameter integer w=0 from [4:10];
  aliasparam width=w;
  .gain=3.0*w;
endparamset
module ps_alias_leaf(p);
  inout p; electrical p;
  parameter real gain=1.0;
  aliasparam g=gain;
  branch (p) br;
  analog I(br) <+ gain*V(br);
endmodule
