// §6.6.2 if-generate with a true constant condition and no else. "At most one
// generate block instantiated from a set of alternatives" — here the set has
// one member and the condition selects it, so the block's items become module
// items and its analog block runs. `arm` reading 0 would mean the elaborator
// dropped the only alternative it had.
//
// The body is `analog begin ... end`: §6.6 makes a generate block "a collection
// of one or more module items", and Syntax 6-8 lists analog_construct as one. A
// bare `arm = 1;` there is a statement, not a module item — this file used to
// write one, which pinned a VerA extension instead of the LRM.
//
//! lrm 6.6
//! lrm 6.6.2
//! bias V(p) = 0.5
//! xfail VerA's parser reads a generate block body as an analog statement, so the `analog` keyword inside `generate` dies at E0209 "expected an expression: found `analog`"
`include "check.vh"
module ch6_gen_true(p);
  inout p; electrical p;
  integer arm;
  analog arm = 0;
  generate if (1) begin analog begin arm = 1; I(p) <+ V(p); end end endgenerate
  analog `CHECKI("if(1) elaborates its block", arm, 1);
endmodule
