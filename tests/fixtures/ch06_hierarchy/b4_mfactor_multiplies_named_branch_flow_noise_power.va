// §6.3.6 $mfactor automatic scaling, the third rule: "Contributions to a branch
// flow quantity using the noise functions (white_noise, flicker_noise,
// noise_table) shall have the noise power multiplied by $mfactor." The rule
// names any branch flow quantity, and §3.12: "A branch is a path between two
// nets. If both nets are conservative, then the branch is a conservative
// branch and it defines a branch potential and a branch flow ... Explicitly
// declared branches are referred to as named branches."
// b4_mfactor_multiplies_flow_noise_power.va is the same design on the unnamed
// branch I(a, b); this one declares `branch (a, b) br;` and contributes to
// I(br).
//
// The child contributes `white_noise(1.0, "w")` to the flow of br, 1 A^2/Hz for
// one copy (§4.6.4.1: "generates white noise with a power of pwr"), and is
// placed with `.$mfactor(3.0)` directly across the parent's ports p and n. A
// noise source has no value outside a small-signal noise analysis (§4.6.4), so
// the assertion is on what the device publishes to the host: the `//! noise`
// line reads the source's effective density from `noisePsd`.
//
// BY HAND: 3 * 1.0 = 3.0 A^2/Hz on the branch (p,n). Unscaled it reads 1.0;
// divided (the potential rule applied to a flow) it reads 0.333. Until
// 2026-10-08 VerA published 0.333 here: §6.3.6's flow rule did not reach a
// named branch, and the amplitude's 1/sqrt(3) went in alone.
//
// THE COUNT, from tb/runner.zig: one CHECKX, then the runner's noise lines
// for one `//! noise` entry: the table count, the row's topology, its name
// and its white density. 1 + 4 = 5.
//
//! lrm 6.3.6
//! lrm 6.3.6:5
//! lrm 3.12
//! noise thermal(p,n)#0 name=w white=3.0
//! analysis noise
//! bias V(p) = 0.0, V(n) = 0.0
//! checks 5
`include "check.vh"
module b4_mfnb_top(p, n);
  inout p, n; electrical p, n;
  b4_mfnb_src #(.$mfactor(3.0)) u(p, n);
endmodule

module b4_mfnb_src(a, b);
  inout a, b; electrical a, b;
  branch (a, b) br;
  analog begin
    `CHECKX("Table 9-29: the instance's $mfactor is 1.0 * 3.0", $mfactor, 3.0);
    I(br) <+ white_noise(1.0, "w");
  end
endmodule
