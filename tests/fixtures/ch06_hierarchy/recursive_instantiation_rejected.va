// §6.6.2: "Conditional generate constructs make it possible for a module to
// contain an instantiation of itself. ... With proper use of parameters, the
// resulting recursion can be made to terminate, resulting in a legitimate model
// hierarchy."
//
// The recursion is legal only because a generate condition can END it. Below,
// `ch6_self` instantiates itself unconditionally: every level creates another
// level, the instance tree (§6.2.2) is infinite, and there is no legitimate
// hierarchy to elaborate. No parameter can stop it, since nothing tests one.
// VerA names the cycle, module by module, and the instance that closes it;
// there is no depth limit for it to hit instead (instance_tree_65_levels.va,
// the legal neighbour, nests 65 distinct modules).
//
//! lrm 6.6.2
//! lrm 6.2.2
//! reject-only E0905
//! reject-only `ch6_self` → `ch6_self` closes at `again`
//! neighbour instance_tree_65_levels.va
`include "disciplines.vams"
module ch6_self(p, n);
  inout p, n; electrical p, n;
  ch6_self again(p, n);
  analog I(p, n) <+ V(p, n);
endmodule
