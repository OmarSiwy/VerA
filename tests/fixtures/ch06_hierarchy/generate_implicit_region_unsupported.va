// §6.6, verbatim: "The keywords generate and endgenerate may be used in a module
// to define a generate region ... USE OF GENERATE REGIONS IS OPTIONAL. THERE IS NO
// SEMANTIC DIFFERENCE IN THE MODULE WHEN A GENERATE REGION IS USED. A parser may
// choose to recognize the generate region to produce different error messages for
// misused generate construct keywords."
//
// The clause's own `nmosfet` example carries the comment `// "generate" and
// "endgenerate" keywords are not required`, and Syntax 6-8 backs it up: a
// `conditional_generate_construct` is a `module_or_generate_item`, so it stands
// wherever a module item stands. The `generate_region` production only wraps a run
// of them.
//
// Every other generate fixture in this chapter writes the keywords, so the bare
// form — the one the LRM says is equivalent — was untested. "No semantic
// difference" is the requirement, so this file is deliberately generate_if.va with
// the two keywords deleted and nothing else changed: same override of `enabled` to
// 0, same else-arm, same want of 2. If the two files ever disagree, the keywords
// acquired a meaning the LRM says they do not have.
//
// `arm` is seeded to 0 by an earlier analog block (§6.9.1 concatenates them in
// source order), so "no block elaborated at all" reports 0 rather than reading an
// undefined variable, and the three outcomes stay distinguishable.
//
//! lrm 6.6
//! param enabled = 0
//! bias V(p) = 0.5
//! xfail VerA gates the for/if/begin module-item arm on being inside a generate region (frontend/parser.zig), so a bare `if` at module level is E0205 "unsupported module item: found `if`"
`include "check.vh"
module ch6_generate_implicit_region(p);
  inout p; electrical p;
  parameter integer enabled = 1;
  integer arm;
  analog arm = 0;
  if (enabled) begin
    analog begin
      arm = 1;
      I(p) <+ V(p);
    end
  end else begin
    analog begin
      arm = 2;
      I(p) <+ 0.0;
    end
  end
  analog `CHECKI("an if-generate without the region keywords picks the same arm", arm, 2);
endmodule
