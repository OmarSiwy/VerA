// §6.3.6 $mfactor automatic scaling, the second rule: "The value returned by
// any branch flow probe in the analog block, including those used in indirect
// assignments, shall be divided by $mfactor." With the first rule it keeps the
// instance "identical to the behavior of a quantity $mfactor of identical
// modules with the same connections": each copy sees its own share of the flow.
//
// THE CIRCUIT. The child is a short, `V(a,b) <+ 0.0`, placed with
// `.$mfactor(2.0)` from the parent's internal node x to p. The parent pushes a
// fixed 2 A from p into x with `I(p,x) <+ 2.0` (§5.6.1.1: positive flow enters
// the branch at its first net and leaves at its second, so it is delivered to
// x). The only way back from x is through the child's branch.
//
// BY HAND, with V(p) = 0 held and the rest solved:
//   V(x)                    = V(p) + 0 = 0 V
//   flow through the child  = 2.0 A in total, from a (= x) to b (= p)
//   two copies in parallel  = 2.0 / 2 = 1.0 A each
//   I(a,b) in the child     = 1.0 A   (the rule: the probe divided by $mfactor)
// An implementation that did not divide reads 2.0 A; one that divided twice,
// 0.5 A. Absolute tolerance 1e-12.
//
//! lrm 6.3.6
//! lrm 6.3.6:4
//! bias V(p) = 0.0
//! solve
//! checks 2
`include "check.vh"
module b4_mfp_top(p);
  inout p; electrical p, x;
  b4_mfp_short #(.$mfactor(2.0)) u(x, p);
  analog I(p, x) <+ 2.0;
endmodule

module b4_mfp_short(a, b);
  inout a, b; electrical a, b;
  analog begin
    V(a, b) <+ 0.0;
    `CHECKX("Table 9-29: the instance's $mfactor is 1.0 * 2.0", $mfactor, 2.0);
    `CHECK("each of the two copies carries half of the 2 A", I(a, b), 1.0, 1e-12);
  end
endmodule
