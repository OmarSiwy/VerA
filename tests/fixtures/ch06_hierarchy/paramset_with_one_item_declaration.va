// The legal neighbour of paramset_without_item_declaration_rejected.va.
// Syntax 6-4 (A.1.9) requires `paramset_item_declaration
// { paramset_item_declaration }` before the statements; this body has exactly
// one, a parameter nothing overrides, and one statement.
//
// BY HAND. The instance names the paramset, so §6.4.1's `.k = 2.0;` assigns
// the module's k (default 1.0): k = 2.0, and at V(a,b) = 0.5 the module
// stamps 2.0 * 0.5 = 1.0.
//
//! lrm A.1.9
//! lrm 6.4
//! lrm 6.4.1
//! bias V(p) = 0.75, V(n) = 0.25
//! checks 2
`include "check.vh"
module ch6_noitem_top(p, n);
  inout p, n; electrical p, n;
  ch6_noitem_ps u(p, n);
endmodule

paramset ch6_noitem_ps ch6_noitem_dev;
  parameter real unused_item = 0;
  .k = 2.0;
endparamset

module ch6_noitem_dev(a, b);
  inout a, b; electrical a, b;
  parameter real k = 1.0;
  analog begin
    `CHECKX("the paramset's statement assigned the module's k", k, 2.0);
    `CHECKX("so the module stamps 2.0 * 0.5", k * V(a, b), 1.0);
    I(a, b) <+ k * V(a, b);
  end
endmodule
