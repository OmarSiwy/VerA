// §6.7 flattens a hierarchy by joining the instance path to the declaration
// with a period, and §2.8.1 makes that join ambiguous: "escaped identifiers
// shall start with the backslash character and end with white space", so every
// printable character in between is part of the NAME — including a period. The
// net `\x.y` declared in `mid` is therefore the identifier `x.y`, and a raw join
// under instance `u` spells it `u.x.y`, which is byte-for-byte what `mid`'s own
// instance `x` gives its net `y`.
//
// They are two different nets and §6.7 says so: one is `u`'s declaration, the
// other is a declaration one level further down. A compiler that joins raw gives
// them one node, and the transcript below is how that shows.
//
// THE CIRCUIT. `top` drives 3 V onto `a`. Two independent dividers hang off it,
// one per net:
//
//   through mid's instance x    a ──1k── u.x.y ──1k── gnd   ⇒ 1.5 V
//   through mid's own net       a ──1k── u.x y ──2k── gnd   ⇒ 2.0 V
//
// Merged onto one node w, the four resistors are in parallel: 2 mS to `a` and
// 1.5 mS to ground, so w sits at 3·(2/3.5) = 1.714… V and BOTH checks miss. The
// two ratios are deliberately different — a fixture where both dividers were
// 1:1 would read 1.5 V either way and prove nothing.
//
// The CHECKs are inside the children rather than written as §6.7.1 hierarchical
// accesses from `top`, so what is being tested is the flat NAMESPACE and not the
// reference syntax; `hier_access.va` covers the other direction.
//
//! lrm 6.7
//! lrm 2.8.1
//! lrm 2.8.1:1
//! analysis dc
//! solve
`include "check.vh"

module ch6_leaf(q);
  inout q; electrical q;
  electrical y;
  analog begin
    I(q, y) <+ V(q, y) / 1000.0;
    I(y)    <+ V(y) / 1000.0;
    `CHECK("the leaf's own y is a 1:1 divider off a", V(y), 1.5, 1e-9);
  end
endmodule

module ch6_mid(p);
  inout p; electrical p;
  electrical \x.y ;
  ch6_leaf x(p);
  analog begin
    I(p, \x.y ) <+ V(p, \x.y ) / 1000.0;
    I(\x.y )    <+ V(\x.y ) / 2000.0;
    `CHECK("the escaped net is a 2:1 divider off a, not the leaf's node", V(\x.y ), 2.0, 1e-9);
  end
endmodule

module ch6_escaped_period(a);
  inout a; electrical a;
  ch6_mid u(a);
  analog V(a) <+ 3.0;
endmodule
