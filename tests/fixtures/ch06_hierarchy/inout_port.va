// §6.5.2.2 a port declared `inout`, with its discipline given in the header
// (§6.5.2.1). A port of a continuous discipline is a solvable node: its
// potential is an unknown of the system, and the analog block reads that
// unknown through the discipline's access function. Held at -0.75 V, V(p) is
// -0.75 — a port bound to the wrong unknown, or one whose declaration was
// dropped so the probe read a fresh internal net, answers 0.
//
//! lrm 6.5.2.2
//! lrm 6.5.2.1
//! lrm 6.5.2.1:1000
//! bias V(p) = -0.75
`include "check.vh"
module ch6_inout(inout electrical p);
  analog begin
    `CHECKX("the inout port's potential is the biased unknown", V(p), -0.75);
    I(p) <+ V(p);
  end
endmodule
