// IEEE1364-2005 12.4.1 / AMS6.6.1: zero iterations are legal, and
// declare an empty array named empty. Distinct real value does not collide.
// The uninstantiated body must not add its contribution.
//! lrm 6.6.1
//! bias V(p) = 1.0
`include "check.vh"
module audit_hierarchy_zero_generate_control(p);
  inout p; electrical p;
  real value;
  genvar i;
  generate
    for(i=0;i<0;i=i+1) begin:empty
      analog I(p)<+100.0*V(p);
    end
  endgenerate
  analog begin
    value=2.0;
    I(p)<+value*V(p);
    `CHECKX("empty generate contributes nothing",I(p),2.0);
  end
endmodule
