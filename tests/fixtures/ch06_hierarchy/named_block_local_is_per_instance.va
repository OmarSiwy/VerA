// §5.3.2: "All named block variables are static -- that is, an unique location
// exists for all variables and leaving or entering the block do not affect the
// values stored in them." Two instances of one module are two scopes (§6.7),
// so the block `seg` is `u1.seg` in one and `u2.seg` in the other, and each
// instance's `held` is its own location.
//
// DERIVATION. Each instance stores its own parameter g into `held` under
// `@(initial_step)` and reads it back at every point:
//
//   t = 0    initial_step fires (§5.10.2: "active during the solution of the
//            first point ... of every analysis"): u1 stores 1, u2 stores 2,
//            and each reads what it stored.
//   t = 1n   no event; §5.10 retention keeps what t = 0 stored, so u1 reads
//            1 and u2 reads 2.
//
// One location shared by both instances (the two labels flattened to the same
// name) would hold u2's 2 at t = 1n, and u1 would read 2 where it wants 1.
// The want is the instance's own g, so the check is an identity (CHECKEQ).
//
//! lrm 5.3.2
//! lrm 6.7
//! lrm 5.10.2
//! analysis tran
//! time 0, 1n
`include "check.vh"
module nbl_top(p);
  inout p; electrical p;
  nbl_kid #(.g(1.0)) u1(p);
  nbl_kid #(.g(2.0)) u2(p);
endmodule

module nbl_kid(a);
  inout a; electrical a;
  parameter real g = 0.0;
  analog begin
    begin : seg
      real held;
      @(initial_step) held = g;
      `CHECKEQ("each instance's named-block local keeps its own value", held, g, 0.0);
    end
    I(a) <+ V(a);
  end
endmodule
