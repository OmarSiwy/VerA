// The legal neighbour of b4_named_block_reads_a_sibling_block_name_rejected.va.
// §6.8: "If an identifier is referenced directly (without a hierarchical path)
// within a named block or generate block, it shall be declared either locally
// or within a module or block higher in the same branch of the name tree."
//
// h is declared in the module, which is higher in the branch that holds block
// `b`, so the bare `h` in `b` resolves to it. Block `a` assigns it first
// (§5.3.2 sequential blocks run in order).
//
// BY HAND: h = V(p) = 0.25 in block a; block b reads it, r = 0.25.
//
//! lrm 6.8
//! lrm 6.8:3
//! bias V(p) = 0.25
//! checks 1
`include "check.vh"
module b4_nbs(p);
  inout p; electrical p;
  real h;
  analog begin
    begin : a
      h = V(p);
    end
    begin : b
      real r;
      r = h;
      `CHECKX("a bare name in block b resolves to the module's h", r, 0.25);
      I(p) <+ r;
    end
  end
endmodule
