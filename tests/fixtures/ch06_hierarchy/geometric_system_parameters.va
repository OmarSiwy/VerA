// §6.3.6 the five geometrical system parameters, implicitly declared for every
// module and read with the names below (§9.18). They "do not have any automatic
// effect on the simulation" — the model reads them itself — so the only thing
// pinned here is the value they carry, which Table 9-29 fixes:
//
//   $angle      top-level value 0 degrees      0 <= $angle < 360
//   $hflip      top-level value +1             +1 or -1
//   $vflip      top-level value +1             +1 or -1
//   $xposition  top-level value 0.0 m          any
//   $yposition  top-level value 0.0 m          any
//
// This module is a top-level module (§6.2.1: nothing instantiates it), and
// nothing overrides these, so each one resolves to exactly its top-level value.
// +1 for the flips is the load-bearing digit: it is the "not mirrored" identity
// for a MULTIPLICATIVE rule ($hflip_specified * $hflip_hier), so a zero default
// would silently collapse every layout-dependent model that uses it.
//
//! lrm 6.3.6
//! lrm 9.18
//! lrm 6.3.6:1
//! lrm 6.3.6:1003
//! lrm 9.18:1000
//! bias V(p) = 0.5
`include "check.vh"
module ch6_geometry(p);
  inout p; electrical p;
  analog begin
    `CHECKX("$mfactor is implicitly declared with identity value", $mfactor, 1.0);
    `CHECKX("$xposition top-level offset", $xposition, 0.0);
    `CHECKX("$yposition top-level offset", $yposition, 0.0);
    `CHECKX("$angle top-level rotation, degrees", $angle, 0.0);
    `CHECKX("$hflip is the multiplicative identity +1", $hflip, 1.0);
    `CHECKX("$vflip is the multiplicative identity +1", $vflip, 1.0);
    I(p) <+ V(p) + 0.0*$xposition + 0.0*$yposition + 0.0*$angle + 0.0*$hflip + 0.0*$vflip;
  end
endmodule
