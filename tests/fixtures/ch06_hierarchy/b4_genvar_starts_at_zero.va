// The legal neighbour of b4_genvar_set_to_x_rejected.va. §6.6.1: "It shall be
// an error if any bit of the genvar is set to x or z." Here the genvar starts
// at 0 (every bit 0 or 1), runs 0 only (`i < 1`), and stops.
//
// BY HAND: one generated block, which adds 1 to n; so n = 1.
//
//! lrm 6.6.1
//! bias V(p) = 0.5
//! checks 1
`include "check.vh"
module b4_gsx(p);
  inout p; electrical p;
  genvar i;
  integer n;
  analog n = 0;
  generate
    for (i = 0; i < 1; i = i + 1) begin : g
      analog n = n + 1;
    end
  endgenerate
  analog begin
    `CHECKI("the genvar runs 0 once", n, 1);
    I(p) <+ V(p);
  end
endmodule
