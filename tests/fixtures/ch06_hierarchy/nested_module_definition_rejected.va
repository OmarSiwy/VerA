// §6.1 Overview:
//
//   "To describe a hierarchy of modules, the user provides textual definitions
//    of various modules. EACH MODULE DEFINITION STANDS ALONE; THE DEFINITIONS
//    ARE NOT NESTED. Statements within the module definitions create instances
//    of other modules, thus describing the hierarchy."
//
// §6.2.2 says it again, and says what to do instead:
//
//   "Module definitions do not nest. That is, one module definition does not
//    contain the text of another module definition within its
//    module...endmodule keyword pair. A module definition nests another module
//    by instantiating it."
//
// and the grammar agrees: a module_declaration is an A.1.2 `description`, and
// no `module_item` / `non_port_module_item` alternative of Syntax 6-1 derives
// `module_declaration`.
//
// Below, `ch6_nested_inner` is written INSIDE `ch6_nested_outer`'s
// module...endmodule pair. `hierarchy_overview_instances_and_overrides.va` is the
// legal form of the same design: the two definitions side by side, the outer one
// instantiating the inner.
//
// EXACTLY ONE RULE IS BROKEN. The directive pins the diagnostic that says so —
// the parser meets `module` where only a module item may stand.
//
//! lrm 6.1
//! lrm 6.2.2
//! lrm 6.1:1000
//! reject E0240
//! reject found `module`
//! neighbour hierarchy_overview_instances_and_overrides.va
module ch6_nested_outer(p);
  inout p; electrical p;
  module ch6_nested_inner(q);
    inout q; electrical q;
    analog I(q) <+ V(q);
  endmodule
  analog I(p) <+ V(p);
endmodule
