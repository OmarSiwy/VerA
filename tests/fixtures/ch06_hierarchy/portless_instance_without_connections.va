// §6.2.2: an instance of a module defined without ports still writes its
// connection list, and with no ports the list is empty. The rule's own wording
// is "The parentheses, however, are always required": `u()` is the legal
// spelling, `u` alone is missing_parens_portless_instance_rejected.va.
//
// The child is portless, so there is no net to observe through; what the check
// reads is that the instance exists with its parameter table. `u.g` is a
// hierarchical parameter access (§6.7.1), 2.0 against the declared default.
//
//! lrm 6.2.2
//! bias V(p) = 0.5
//! checks 1
`include "check.vh"
module ch6_portless_kid;
  parameter real g = 2.0;
endmodule

module ch6_portless_top(p);
  inout p; electrical p;
  ch6_portless_kid u();
  analog begin
    `CHECKX("a portless instance is written with empty parentheses", u.g, 2.0);
    I(p) <+ 0.0;
  end
endmodule
