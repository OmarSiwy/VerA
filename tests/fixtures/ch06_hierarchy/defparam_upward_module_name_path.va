// IEEE 1364-2005 12.2.1: "parameter values can be changed in any module
// instance throughout the design using the hierarchical name of the
// parameter", and 12.6 (Syntax 12-7): a hierarchical name may start
// `module_identifier.item_name`, the name of a module above it. A top-level
// module's instance name is its module name (12.1.1), so a path whose first
// identifier is the top module's name runs down again from the top.
// AMS 6.3.1 inherits defparam.
// By hand: `mid` (instance m) writes `defparam defparam_upward_module_name_path.u1.g
// = 4.0`. The first identifier is not an instance of mid; it is the top
// module's name, so the target is the top's u1, whose g becomes 4.0. mid's
// own child is also named u1 and keeps its default 1.0: a resolver that
// reads the path downward from mid hits m.u1 instead (and finds no
// `defparam_upward_module_name_path` instance there, the E0907 this pins).
// Both values are exact in binary.
// defparam_path_names_nothing_rejected.va is the invalid neighbour.
//! lrm 6.3.1
//! inherited IEEE 1364-2005 12.2.1 12.6
//! bias V(p) = 0.75, V(n) = 0.25
//! checks 2
`include "check.vh"
module dpu_leaf(a, b);
  inout a, b; electrical a, b;
  parameter real g = 1.0;
  analog I(a, b) <+ g * V(a, b);
endmodule
module dpu_mid(a, b);
  inout a, b; electrical a, b;
  defparam defparam_upward_module_name_path.u1.g = 4.0;
  dpu_leaf u1(a, b);
endmodule
module defparam_upward_module_name_path(p, n);
  inout p, n; electrical p, n;
  dpu_mid m(p, n);
  dpu_leaf u1(p, n);
  analog begin
    `CHECKX("the upward path names the top's u1", u1.g, 4.0);
    `CHECKX("mid's own u1 keeps its default", m.u1.g, 1.0);
  end
endmodule
