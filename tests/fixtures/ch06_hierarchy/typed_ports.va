// LRM 6.5 / 3.6 with annex D.1: one module may carry ports of DIFFERENT
// continuous disciplines, and each port's access functions come from its own
// discipline's natures — `V`/`I` from electrical (Voltage/Current), `Temp`/`Pwr`
// from thermal (Temperature/Power). The probe therefore reads the potential of
// the node that port names, in that discipline's units.
//
// p is held at 0.6 V and heat at 350 K: V(p) = 0.6 and Temp(heat) = 350. Bind
// either access function to the other node and both numbers move.
//
//! lrm 6.5.2.1
//! lrm 6.5.2.1:1000
//! bias V(p) = 0.6
//! bias heat = 350
`include "check.vh"
module ch6_typed(p, heat);
  inout electrical p;
  inout thermal heat;
  analog begin
    `CHECK("V reads the electrical port's potential", V(p), 0.6, 1e-15);
    `CHECKX("Temp reads the thermal port's potential, in kelvin", Temp(heat), 350.0);
    I(p) <+ V(p);
    Pwr(heat) <+ Temp(heat);
  end
endmodule
