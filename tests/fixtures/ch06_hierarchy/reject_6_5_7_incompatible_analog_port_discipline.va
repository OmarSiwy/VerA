// §6.5.7: "All digital ports connected to a net shall be of compatible
// disciplines, as shall all analog ports connected to a net."
//
// The child's port p is `thermal`; the parent connects it to `a`, declared
// `electrical`. §3.11.1's potential incompatibility rule makes these
// incompatible (different potential natures, no common base, different
// units), so the connection is an error. The child has no analog block, so no
// access-function lookup is involved: the port connection itself is the
// only defect.
//
// VerA reports E0355 "incompatible disciplines: port `c1.p` is of discipline
// `thermal` and is connected to `a`, of discipline `electrical`".
//
//! lrm 6.5.7
//! lrm 6.5.7:1
//! reject-only E0355
//! neighbour compatible_port_disciplines_share_potential.va
`include "disciplines.vams"
module ch6_thermal_child(p);
  inout p;
  thermal p;
endmodule

module ch6_incompatible_port(a);
  inout a;
  electrical a;
  ch6_thermal_child c1(a);       // illegal: thermal port on an electrical net
  analog I(a) <+ V(a);
endmodule
