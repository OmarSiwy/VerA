// IEEE1364-2005 12.2.1, also AMS6.3.1.
// Same-file defparams: last text assignment7 wins over earlier5 and inline2.
// There is no cross-file ordering premise; IEEE makes that case undefined.
//! lrm 6.3.1
//! lrm 6.3
//! lrm 6.3:1
// inherited IEEE 1364-2005 12.2.1
`include "check.vh"
module audit_hierarchy_defparam_source_order(p);
  inout p; electrical p;
  audit_last_leaf #(.gain(2.0)) u(p);
  defparam u.gain=5.0;
  defparam u.gain=7.0;
endmodule
module audit_last_leaf(p);
  inout p; electrical p;
  parameter real gain=1.0;
  analog begin
    `CHECKX("last same-file defparam",gain,7.0);
    I(p)<+gain*V(p);
  end
endmodule
