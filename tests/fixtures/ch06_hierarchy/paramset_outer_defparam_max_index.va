// §6.2.2 permits a singleton array: equal bounds create one instance. The
// literal max-i64 index fits VerA's constant carrier; advancing the loop past
// its only element must not overflow. One normal array receives an outer
// defparam w=7 over inline w=2, selecting gain=3*7=21. A selected if-generate
// contains a second singleton array with inline w=7 and the same gain.
// At V(p)=1/2 each leaf carries 10.5 A and checks both its gain and current;
// exactly four verdicts prove both array paths executed their one element.
// A variable range remains invalid (instance_array_range_variable_rejected).
//! lrm 6.2.2
//! lrm 6.3.1
//! lrm 6.4.2
//! lrm 6.6.2
//! lrm 6.4.2:4
//! bias V(p) = 0.5
//! checks 4
`include "check.vh"
module ps_outer_max_index(p);
  inout p; electrical p;
  ps_outer_max_bin #(.w(2.0)) u[9223372036854775807:9223372036854775807](p);
  defparam u[9223372036854775807].w=7.0;
  generate if (1) begin
    ps_outer_max_bin #(.w(7.0)) v[9223372036854775807:9223372036854775807](p);
  end endgenerate
endmodule
paramset ps_outer_max_bin ps_outer_max_leaf;
  parameter real w=1.0 from [0:4);
  .gain=2.0*w;
endparamset
paramset ps_outer_max_bin ps_outer_max_leaf;
  parameter real w=0.0 from [4:10];
  .gain=3.0*w;
endparamset
module ps_outer_max_leaf(p);
  inout p; electrical p;
  parameter real gain=1.0;
  branch (p) br;
  analog begin
    I(br)<+gain*V(br);
    `CHECKX("the singleton chose the high member", gain, 21.0);
    `CHECKX("the singleton's behavior executes", I(br), 10.5);
  end
endmodule
