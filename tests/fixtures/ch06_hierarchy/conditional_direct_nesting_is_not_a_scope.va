// §6.6.2 "Direct nesting": "If a generate block in a conditional generate
// construct consists of only one item that is itself a conditional generate
// construct and if that item is not surrounded by begin/end keywords, then
// this generate block is not treated as a separate scope."
//
// The path `$simparam$str("path")` (§9.15) reports is the direct observation:
// it names every enclosing scope, so a separate outer scope would add a
// segment before the inner block's own name. With the exception, the inner
// unnamed block belongs to the MODULE's scope, `top.genblk1`; without it the
// path would read `top.genblk1.genblk1`.
//
// Three constructs, each selected:
//   1  if (1) if (1) analog ...             direct     -> top.genblk1
//   2  if (1) begin if (1) analog ... end   begin/end  -> top.genblk2.genblk1
//   3  if (0) ... else if (1) analog ...    direct     -> top.genblk3
// Construct 2 is the control: the SAME inner conditional wrapped in begin/end
// IS a separate scope, so its unnamed inner block is numbered from one again
// inside genblk2. Construct 3 shows the else-if form of the exception, where
// the inner conditional is the whole else arm.
//
//! lrm 6.6.2
//! lrm 6.6.2:1002
//! bias V(p) = 0.5
//! checks 3
`include "check.vh"
module ch6_cond_direct_top(p);
  inout p; electrical p;
  string s;

  if (1)
    if (1) analog begin
      s = $simparam$str("path");
      `CHECKI("direct nesting is not a scope: the inner block is top.genblk1", s == "ch6_cond_direct_top.genblk1", 1);
    end

  if (1) begin
    if (1) analog begin
      s = $simparam$str("path");
      `CHECKI("begin/end makes the outer block a scope: top.genblk2.genblk1", s == "ch6_cond_direct_top.genblk2.genblk1", 1);
    end
  end

  if (0) analog begin
    I(p) <+ 0.0;
  end
  else if (1) analog begin
    s = $simparam$str("path");
    `CHECKI("an else-if is direct nesting too: top.genblk3", s == "ch6_cond_direct_top.genblk3", 1);
  end

  analog I(p) <+ V(p);
endmodule
