// §6.5.2.2: "Implementations can limit the maximum number of ports in a
// module definition, but shall support a minimum of 256 ports." This module
// has 257 ports (one vector, §6.5.2 one per element) and one internal net,
// 258 solver unknowns. Until #29 VerA refused it (E1003): the emitted `U`
// was an `enum(u8)`, so 256 unknowns counted ports and internal nets
// together. `U` is now as wide as the count needs (here `enum(u9)`).
//
// Every port element is a 1 ohm resistor to `mid` (the genvar loop, §5.9.3),
// so KCL at a free port is V(bus[k]) - V(mid) = 0 and at mid the sum of
// V(bus[k]) - V(mid) over all 257 is 0. Four ports are pinned, the rest and
// mid solved. A free port carries no current, so by hand:
//   V(mid) = (1.0 + 0.5 + 0.25 + 0.25) / 4 = 0.5
//   V(bus[k]) = V(mid) = 0.5 for every free k
// bus[255] and bus[256] are the unknowns past the old enum(u8), and mid is
// the 258th: a host that dropped one would see a different average. The
// solve is a 258-unknown linear system, so the checks carry a tolerance.
//
//! lrm 6.5.2.2
//! lrm 6.5.2.2:1001
//! bias V(bus[0]) = 1.0, V(bus[128]) = 0.5, V(bus[255]) = 0.25, V(bus[256]) = 0.25
//! solve
//! checks 4
`include "check.vh"
module ch6_ports_past_256(bus);
  inout [0:256] bus;
  electrical [0:256] bus;
  electrical mid;
  genvar k;
  analog begin
    for (k = 0; k <= 256; k = k + 1)
      I(bus[k], mid) <+ V(bus[k], mid);
    `CHECK("the internal net past the 257 ports", V(mid), 0.5, 1e-12);
    `CHECK("a free port below 256", V(bus[1]), 0.5, 1e-12);
    `CHECK("a free port past 128", V(bus[200]), 0.5, 1e-12);
    `CHECK("a pinned port past 255", V(bus[256]), 0.25, 1e-12);
  end
endmodule
