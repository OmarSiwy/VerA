// The legal neighbour of b4_genvar_iteration_assigns_another_genvar_rejected.va.
// §6.6.1: "Both the initialization and iteration assignments shall assign to
// the same genvar." Here both assign i, and the condition `i < 0` is false at
// the start, so the loop generate instantiates zero generate blocks. That is
// legal (§6.6: "The elaboration of a generate construct results in zero or more
// instances of a generate block").
//
// BY HAND. n starts at 0 in the first analog block; the generated block, which
// would add 1 per instance, is instantiated zero times; so n is still 0 when
// the last analog block reads it (§6.9.1: analog blocks concatenate in order,
// after the generate constructs have been evaluated).
//
//! lrm 6.6.1
//! bias V(p) = 0.5
//! checks 1
`include "check.vh"
module b4_gzt(p);
  inout p; electrical p;
  genvar i, j;
  integer n;
  analog n = 0;
  generate
    for (i = 0; i < 0; i = i + 1) begin : g
      analog n = n + 1;
    end
  endgenerate
  analog begin
    `CHECKI("a loop generate whose condition is false at the start instantiates nothing", n, 0);
    I(p) <+ V(p);
  end
endmodule
