// IEEE 1364-2005 4.10.1: when parameters occur in the module parameter
// port list, parameter declarations in the body become local parameters.
// Thus a named instance override of body_value is illegal even though its
// declaration uses parameter rather than localparam. AMS 1.1 inherits this
// rule; AMS 6.2 supplies the header form and 3.4.5 the local-parameter rule.
// A header-only default test cannot observe this body/header distinction.
//! lrm 3.4.5
//! lrm 6.2
//! reject E0907
//! xfail PARAM-HEADER-001: body parameters remain overridable after a parameter header
module header_body_parameter_target #(parameter real header_value = 2.0) ();
  parameter real body_value = 2.0 * header_value;
  analog begin end
endmodule
module audit_header_body_parameter_override_rejected;
  header_body_parameter_target #(.body_value(9.0)) child();
endmodule
