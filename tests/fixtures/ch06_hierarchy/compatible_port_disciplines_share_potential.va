// §6.5.7 "All digital ports connected to a net shall be of compatible
// disciplines, as shall all analog ports connected to a net." When two modules
// share a common analog net through their inout ports, both must observe the
// same potential through that net, confirming compatibility of their ports'
// disciplines and the net they connect to.
//
//! lrm 6.5.7
//! lrm 6.5
//! lrm 6.5:1000
//! bias V(shared) = 0.8
//! print none
`include "check.vh"
module ch6_port_connection_rules(shared);
  inout shared;
  electrical shared;

  ch6_port_connection_rules_peer peer1(shared);
  ch6_port_connection_rules_peer peer2(shared);

  analog begin
    `CHECKX("all analog ports on a shared net observe the same discipline", V(shared), 0.8);
    I(shared) <+ 0.0;
  end
endmodule

module ch6_port_connection_rules_peer(net);
  inout net;
  electrical net;

  analog begin
    `CHECKX("peer module reads the same potential from the shared net", V(net), 0.8);
    I(net) <+ 0.0;
  end
endmodule
