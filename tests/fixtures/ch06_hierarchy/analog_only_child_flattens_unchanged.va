// §6.2.2 the control for child_initial_block_is_carried.va and
// top_initial_block_with_a_child.va: a hierarchy with NO discrete item anywhere.
// Carrying a child's discrete half into the flattened module must leave this
// case where it was — the child's discrete lists are empty, so the flattened
// module gains nothing and lowering sees the same analog blocks in the same
// order. (The byte-identical emitted device for every existing hierarchy
// fixture is the other half of that claim; this file states it as behaviour.)
//
// DERIVATION. Two instances of one conductance, overridden per instance (§6.3):
// u1 has r = 2 and u2 has r = 4, both across (p, n). With V(p,n) = 0.5:
//
//     u1  V / r = 0.5 / 2 = 0.25
//     u2  V / r = 0.5 / 4 = 0.125
//
// Each instance keeps its own parameter (two instances are two devices), all
// values exact in binary.
//
//! lrm 6.2.2
//! lrm 6.3
//! lrm 6.3.3
//! lrm 6.3.3:1
//! bias V(p) = 0.75, V(n) = 0.25
`include "check.vh"
module ch6_analog_only(p, n);
  inout p, n; electrical p, n;
  ch6_ao_res #(.r(2.0)) u1(p, n);
  ch6_ao_res #(.r(4.0)) u2(p, n);
endmodule

module ch6_ao_res(a, b);
  inout a, b; electrical a, b;
  parameter real r = 1.0;
  analog begin
    // Two instances, one want each, so the want is picked by r — CHECKEQ, not
    // CHECKX, because a literal want cannot name which instance is printing.
    `CHECKEQ("each instance stamps V over its own r",
            V(a, b) / r, (r == 2.0) ? 0.25 : 0.125, 0.0);
    `CHECKI("and the two instances kept two values of r", (r == 2.0) || (r == 4.0), 1);
    I(a, b) <+ V(a, b) / r;
  end
endmodule
