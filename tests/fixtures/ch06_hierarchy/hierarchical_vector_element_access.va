// §6.7.1: "Potential and flow access for named and unnamed branches
// (including port branches) can be done hierarchically", and §5.5.2 lets an
// access function name one element of a vector net: `V(in[1])`. Together they
// give `V(u.v[1])` — one element of a child instance's vector net, reached by
// its hierarchical path. A.8.9's hierarchical net reference admits the select
// on the path's last segment.
//
// The child's vector port v is bound to the top's vector port b, so u.v[k]
// is b[k], and with the bias V(b[1]) = 0.75 and V(b[0]) = 0.25:
//
//     V(u.v[1]) = 0.75,  V(u.v[0]) = 0.25,  V(u.v[1], u.v[0]) = 0.5
//
// all dyadic, so exact.
//
//! lrm 6.7.1
//! lrm 5.5.2
//! lrm 6.7.1:1
//! lrm 6.7:1001
//! bias V(b[1]) = 0.75, V(b[0]) = 0.25
`include "check.vh"
module ch6_hier_vec_child(v);
  inout [1:0] v;
  electrical [1:0] v;
  analog I(v[1], v[0]) <+ V(v[1], v[0]) / 1k;
endmodule

module ch6_hier_vec_top(b);
  inout [1:0] b;
  electrical [1:0] b;
  ch6_hier_vec_child u(b);
  analog begin
    `CHECKX("V(u.v[1]) is element 1 of the child's vector, the top's b[1]", V(u.v[1]), 0.75);
    `CHECKX("V(u.v[0]) is element 0, the top's b[0]", V(u.v[0]), 0.25);
    `CHECKX("the element pair", V(u.v[1], u.v[0]), 0.5);
  end
endmodule
