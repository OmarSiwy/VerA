// §6.6's table of generate kinds: a conditional generate (if-generate,
// case-generate) has "At most one generate block instantiated from a set of
// alternatives", and "An instance of a generate block ... brings the objects,
// behavioral constructs, and MODULE INSTANCES within the block into existence".
// §6.2.1 says the same from the other end: a module instantiated only inside a
// generate block "that is not itself instantiated" is still not a top-level
// module — the instantiation statement exists, the instance does not.
//
// So with `sel = 0` exactly one leaf exists, the else arm's `u_off` with
// id = 2, and its one check reads id = 2. The wrong answers are all
// different: u_on's check running at all (id = 1) says the unselected arm's
// instance was built; no check running (`//! checks 1` unmet) says neither was.
// A.4.2 `generate_block ::= module_or_generate_item | begin ... end` and A.1.4
// `module_or_generate_item` lists `module_instantiation`, so both arms are
// legal as written.
//
// VerA had no generate scope for an instance (E0235, "not supported inside a
// generate block"); before that it hoisted both instances to the module and
// elaborated both, which is the id = 1 failure above. Since 2026-09-24 each
// arm's instance is elaborated with the arm's scheme as a gate on its analog
// blocks (`Flatten.genInstances`), so only the selected leaf behaves.
//
//! lrm 6.6
//! lrm 6.6.2
//! lrm 6.6.2:1003
//! checks 1
//! bias V(p) = 0.5
`include "check.vh"
module ch6_generate_if_instance(p);
  inout p; electrical p;
  parameter integer sel = 0;
  generate
    if (sel) begin : on
      ch6_generate_if_leaf #(.id(1)) u_on(p);
    end else begin : off
      ch6_generate_if_leaf #(.id(2)) u_off(p);
    end
  endgenerate
endmodule
module ch6_generate_if_leaf(p);
  inout p; electrical p;
  parameter integer id = 0;
  analog begin
    `CHECKI("only the selected arm's instance is elaborated", id, 2);
    I(p) <+ V(p);
  end
endmodule
