// The legal neighbour of b4_paramset_selection_ignores_module_ranges_rejected.va.
//
// Two paramsets named b4_psm over one module b4_psm_res (r = 1.0 from (0:inf)):
//   A: parameter l in [0:2];                         assigns .r = 2.0
//   B: parameter l in [0:2], parameter extra = 0.0;  assigns .r = 1.0
// The instance overrides l = 1.0 only. Both are applicable (§6.4.2's
// selection rules: l is a parameter of both and in range in both). Tie rule 1,
// "The paramset with the fewest number of un-overridden parameters shall be
// selected": A has 0, B has 1 (extra), so A is selected.
//
// BY HAND: r = 2.0 (B would give 1.0, the module default is also 1.0, so the
// want 2.0 can only come from A), and with V(p,n) = 0.5 the resistor stamps
// 0.5 / 2.0 = 0.25.
//
//! lrm 6.4.2
//! lrm 6.4.2:7
//! bias V(p) = 0.75, V(n) = 0.25
//! checks 2
`include "check.vh"
module b4_psm_top(p, n);
  inout p, n; electrical p, n;
  b4_psm #(.l(1.0)) u(p, n);
endmodule

paramset b4_psm b4_psm_res;   // A: selected (zero un-overridden parameters)
  parameter real l = 1.0 from [0:2];
  .r = 2.0;
endparamset

paramset b4_psm b4_psm_res;   // B: one un-overridden parameter
  parameter real l = 1.0 from [0:2];
  parameter real extra = 0.0;
  .r = 1.0;
endparamset

module b4_psm_res(a, b);
  inout a, b; electrical a, b;
  parameter real r = 1.0 from (0:inf);
  analog begin
    `CHECKX("the paramset with fewer un-overridden parameters is selected", r, 2.0);
    `CHECKX("so the resistor stamps 0.5 / 2.0", V(a, b) / r, 0.25);
    I(a, b) <+ V(a, b) / r;
  end
endmodule
