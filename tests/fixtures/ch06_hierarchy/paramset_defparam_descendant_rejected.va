// §6.3.1 forbids defparam "in a hierarchy in or under a paramset instance".
// The associated module has no defparam of its own: the statement is two
// ordinary-module instance levels below it, in an instance array element.
// Both elements remain below the paramset and must be refused with E0926.
// The legal neighbor runs ordinary defparam descendants outside a paramset.
//! lrm 6.3.1
//! lrm 6.4
//! reject E0926
module ps_dp_deep_top(p);
  inout p; electrical p;
  ps_dp_deep_card u(p);
endmodule
paramset ps_dp_deep_card ps_dp_deep_wrapper;
  .gain = 2.0;
endparamset
module ps_dp_deep_wrapper(p);
  inout p; electrical p;
  parameter real gain = 1.0;
  ps_dp_deep_middle #(.gain(gain)) middle(p);
endmodule
module ps_dp_deep_middle(p);
  inout p; electrical p;
  parameter real gain = 1.0;
  ps_dp_deep_body #(.gain(gain)) bodies[1:0](p);
endmodule
module ps_dp_deep_body(p);
  inout p; electrical p;
  parameter real gain = 1.0;
  ps_dp_deep_leaf child(p);
  defparam child.gain = gain;
endmodule
module ps_dp_deep_leaf(p);
  inout p; electrical p;
  parameter real gain = 1.0;
  analog I(p) <+ gain * V(p);
endmodule
