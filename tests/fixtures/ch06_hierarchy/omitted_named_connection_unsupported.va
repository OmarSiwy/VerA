// §6.2.2: "When connecting ports by name, an unconnected port can be indicated
// either by OMITTING IT IN THE PORT LIST or by providing no expression in the
// parentheses". This file pins the first spelling — `mid` simply does not appear
// — and empty_named_connection_unsupported.va pins the second, `.mid()`. The LRM
// makes them equivalent, so the two files assert the identical 1, 0, 1 and a
// compiler that supported only one of the forms fails exactly one of them.
//
// Legal source, so a run fixture rather than the `//! reject` it used to be. The
// omission is also what makes named association strictly more than ordered: there
// is no positional list in which the second of three ports can be skipped.
//
// With p = 0.75 V and n = 0.25 V, V(a,b) = 0.5 exactly.
//
//! lrm 6.2.2
//! lrm 6.5.6
//! bias V(p) = 0.75, V(n) = 0.25
//! xfail VerA compiles one flat module, so a module instantiation is refused outright at E0204 "module instantiation is not supported"
`include "check.vh"
module ch6_omitted_named_parent(p, n);
  inout p, n; electrical p, n;
  ch6_omitted_child u(.a(p), .b(n));
endmodule

module ch6_omitted_child(a, mid, b);
  inout a, mid, b; electrical a, mid, b;
  analog begin
    `CHECKI("a named connection to a net is connected", $port_connected(a), 1);
    `CHECKI("a port OMITTED from the named list is unconnected", $port_connected(mid), 0);
    `CHECKI("the ports that are named are unaffected by the omission", $port_connected(b), 1);
    `CHECKX("and the named bindings still straddle the biased pair", V(a, b), 0.5);
    I(a, b) <+ V(a, b);
  end
endmodule
