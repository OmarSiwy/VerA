// Signedness is a property of the COMPARISON, not of either operand alone.
//
// The rule, printed in ch4 immediately after the bitwise operator tables (§4.2.9
// in the 2.4 text) and governing the operators of §4.2.5 and §4.2.7:
//
//   "When one or both operands are unsigned, the expression shall be interpreted
//    as a comparison between unsigned values. If the operands are of unequal bit
//    lengths, the smaller operand shall be zero-extended to the size of the
//    larger operand."
//   "When both operands are signed, the expression shall be interpreted as a
//    comparison between signed values. If the operands are of unequal bit
//    lengths, the smaller operand shall be sign-extended to the size of the
//    larger operand."
//
// §3.2 fixes the width on the other side: integer "variables can hold values
// ranging from -2^31 to 2^31-1", i.e. 32 bits, signed. An unbased decimal literal
// is signed; a based literal without `s` is unsigned.
//
// FOUR CASES, hand-derived. a = -1, whose 32-bit pattern is 32'hFFFFFFFF.
//
//   r1 = (a < 1)              both signed      -1 < 1                  -> 1
//   r2 = (a < 32'd1)          one unsigned     4294967295 < 1          -> 0
//   r3 = ((a + 0) < 32'd1)    one unsigned     the addition is signed and
//                                              32-bit, giving the same
//                                              0xFFFFFFFF, and the COMPARISON
//                                              is still unsigned             -> 0
//   r4 = (a == 32'hFFFFFFFF)  one unsigned     0xFFFFFFFF == 0xFFFFFFFF -> 1
//
// r1 is the control: it is the same operator on the same variable and it must
// stay 1, so a failure of r2/r3/r4 cannot be read as "comparisons are broken".
// r3 is r2 with one arithmetic node in between and is the case the plan calls
// out: the context has to survive a compound expression, not just a bare operand.
//
// r5 is the neighbouring rule, kept as a second control because it is the one the
// carrier width is most likely to break. §4.2.11: "the << and >> shift operators
// fill the vacated bit positions with zeroes (0)", so -1 >> 1 over a 32-bit
// operand is 0x7FFFFFFF = 2147483647, and NOT the -1 an arithmetic shift of a
// 64-bit carrier would give.
//
// GROUND TRUTH TODAY: green, all five. r2, r3 and r4 used to come out 1, 1 and 0
// — VerA emitted the signed i64 comparison unconditionally, so -1 stayed -1 and
// lost to both 1 and 0xFFFFFFFF, and the four shapes here are outside E0364's
// one known refusal so they compiled and answered wrongly rather than diagnose.
// Lowering zero-extends each operand from its own width
// (`constfold.UnsignedCompare`), which leaves both non-negative and turns the
// signed opcodes into §4.2.9's unsigned comparison.
//
//! lrm 4.2.9
//! lrm 4.2.9:2
//! lrm 4.2.9:3
//! lrm 4.2.9:4
//! lrm 4.2.5
//! lrm 4.2.7
//! lrm 4.2.9:1
//! bias V(p) = 0.5
`include "check.vh"
module h01_mixed_sign(p, n);
  inout p, n; electrical p, n;
  integer a, r1, r2, r3, r4, r5;
  analog begin
    a = -1;
    r1 = (a < 1);
    r2 = (a < 32'd1);
    r3 = ((a + 0) < 32'd1);
    r4 = (a == 32'hFFFFFFFF);
    r5 = (a >> 1);
    `CHECKI("both operands signed: -1 < 1", r1, 1);
    `CHECKI("one operand unsigned: 4294967295 < 1 is false", r2, 0);
    `CHECKI("the unsigned context survives an arithmetic node", r3, 0);
    `CHECKI("equality against the same 32-bit pattern is true", r4, 1);
    `CHECKI("a logical right shift fills with zero over 32 bits", r5, 2147483647);
    I(p, n) <+ V(p, n);
  end
endmodule
