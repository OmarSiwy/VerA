// §6.5.5 Connecting module ports by name, the third rule: "The port expression
// shall be the name used by the instantiating module (simple net identifier,
// scalar member, sub-range, or concatenation)." All four shapes, each on its
// own port of one instance:
//
//   .v(bus[1])     scalar member of the parent's vector bus
//   .w(bus[3:2])   sub-range of it, onto a 2-bit port
//   .c({x, y})     concatenation of two scalars, onto a 2-bit port
//   .r(p)          simple net identifier
//
// THE CHILD drives each port bit with a distinct potential against r:
//   V(v) = 0.5,  V(w[1]) = 0.25,  V(w[0]) = 0.125,  V(c[1]) = 2.0,  V(c[0]) = 4.0
// The parent holds p = 0 and solves its own nets (`//! solve`), then reads
// them, so what it reads is decided by which net each port bit was bound to.
//
// BIT ORDER. IEEE 1364-2005 12.3.9.2 (inherited; matching_size_concatenation.va
// relies on the same) makes a port connection a continuous assignment, which
// for equal widths pairs bits by position, left-most index to left-most index.
// bus is `[3:1]`, so the sub-range bus[3:2] has MSB bus[3]; {x, y} has MSB x:
//   V(bus[1]) = 0.5      (v)
//   V(bus[3]) = 0.25     (w[1], the port MSB)
//   V(bus[2]) = 0.125    (w[0])
//   V(x)      = 2.0      (c[1], the port MSB)
//   V(y)      = 4.0      (c[0])
// A reversed sub-range or concatenation swaps a pair; an index off by one
// moves 0.5 onto bus[2] or bus[3]. All values are exact in binary.
//
//! lrm 6.5.5
//! lrm 6.5.5:1
//! lrm 6.5.5:2
//! bias V(p) = 0.0
//! solve
//! checks 5
`include "check.vh"
module b4_npe_top(p);
  inout p; electrical p;
  electrical [3:1] bus;
  electrical x, y;
  b4_npe_kid u(.v(bus[1]), .w(bus[3:2]), .c({x, y}), .r(p));
  analog begin
    `CHECKX("a scalar member: .v(bus[1])", V(bus[1]), 0.5);
    `CHECKX("a sub-range: port MSB w[1] on bus[3]", V(bus[3]), 0.25);
    `CHECKX("a sub-range: port LSB w[0] on bus[2]", V(bus[2]), 0.125);
    `CHECKX("a concatenation: port MSB c[1] on x", V(x), 2.0);
    `CHECKX("a concatenation: port LSB c[0] on y", V(y), 4.0);
  end
endmodule

module b4_npe_kid(v, w, c, r);
  inout v, r;
  inout [1:0] w, c;
  electrical v, r;
  electrical [1:0] w, c;
  analog begin
    V(v, r) <+ 0.5;
    V(w[1], r) <+ 0.25;
    V(w[0], r) <+ 0.125;
    V(c[1], r) <+ 2.0;
    V(c[0], r) <+ 4.0;
  end
endmodule
