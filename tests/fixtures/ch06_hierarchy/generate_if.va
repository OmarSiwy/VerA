// §6.6.2 if-generate over a PARAMETER: "generate constructs provide the ability
// for parameter values to affect the structure of the model", and the scheme is
// evaluated during elaboration, after §6.3 parameter overrides are applied. So
// the arm that survives has to follow the override, not the declared default.
//
// `enabled` defaults to 1 and is overridden to 0 below, which selects the ELSE
// block — a model that hard-took the then-arm, or that resolved the condition
// against the 1 in the declaration, reports arm = 1 here. `arm` is seeded to 0
// first (§6.9.1 concatenates analog blocks in source order) so "no block
// elaborated" is also a visible failure rather than an undefined read.
//
//! param enabled = 0
//! bias V(p) = 0.5
`include "check.vh"
module ch6_generate_if(p);
  inout p; electrical p;
  parameter integer enabled = 1;
  integer arm;
  analog arm = 0;
  generate
    if (enabled) begin
      arm = 1;
      I(p) <+ V(p);
    end else begin
      arm = 2;
      I(p) <+ 0.0;
    end
  endgenerate
  analog `CHECKI("the override, not the default, picks the arm", arm, 2);
endmodule
