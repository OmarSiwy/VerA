// §6.9.2 Elaboration and paramsets: "If a generate construct contains an
// instantiation of an overloaded paramset, paramset selection is performed
// after the generate construct has been evaluated. The evaluation of the
// generate construct may influence the values and connections of the
// paramset instance, and hence the selection of matching paramset and
// module." The strongest form of that sentence is an override whose value
// only exists inside the generate block: a localparam declared there
// (§6.6.2: a generate block is a scope, and IEEE 1364-2005 12.4 lets it
// declare local parameters).
//
// `ch6_pgl_sel` is overloaded as in paramset_selected_after_generate.va: w in
// [5, inf) sets gain 2.0, w in (-inf, 5) sets gain 3.0. The top's
// `wbase = 5.0`, so by hand:
//   g1 (then-arm, big = 1): localparam w1 = 2.0 * wbase = 10.0 -> gain 2.0
//   g2 (else-arm, big = 1): localparam w4 = wbase - 4.0 =  1.0, and
//                           localparam w = w4 = 1.0               -> gain 3.0
// The unselected arms' localparams pick the OTHER member, so reading the
// wrong arm is visible. In g2 the override reads `w`, a localparam defined
// by an earlier one of the same block, and its name is also the paramset
// parameter it overrides: the block's `w` is read, not anything else's.
// (Each arm's localparams have their own names: two generate blocks that
// declare the same localparam name collide as device fields today, a
// separate §6.6.3 defect this file keeps out of its way.)
// A selection that cannot see the block's localparam keeps both members
// applicable (the E0914 this pins). All values are exact in binary.
// paramset_generate_localparam_out_of_scope_rejected.va is the invalid
// neighbour: the same name read outside its block names nothing.
//! lrm 6.9.2
//! lrm 6.9.2:1
//! lrm 6.6.2
//! lrm 6.4.2
//! bias V(p) = 0.75, V(n) = 0.25
//! checks 2
`include "check.vh"
paramset ch6_pgl_sel ch6_pgl_leaf;
  parameter real w = 10.0 from [5.0:inf);
  .w = w;
  .gain = 2.0;
endparamset

paramset ch6_pgl_sel ch6_pgl_leaf;
  parameter real w = 1.0 from (-inf:5.0);
  .w = w;
  .gain = 3.0;
endparamset

module ch6_pgl_leaf(a, b);
  inout a, b;
  electrical a, b;
  parameter real gain = 1.0, w = 0.0;
  analog I(a, b) <+ gain * V(a, b);
endmodule

module ch6_pgl_top(p, n);
  inout p, n;
  electrical p, n;
  parameter integer big = 1;
  parameter real wbase = 5.0;
  if (big) begin : g1
    localparam real w1 = 2.0 * wbase;
    ch6_pgl_sel #(.w(w1)) u1(p, n);
  end else begin : g1
    localparam real w2 = wbase - 4.0;
    ch6_pgl_sel #(.w(w2)) u2(p, n);
  end
  if (!big) begin : g2
    localparam real w3 = 2.0 * wbase;
    ch6_pgl_sel #(.w(w3)) u3(p, n);
  end else begin : g2
    localparam real w4 = wbase - 4.0;
    localparam real w = w4;
    ch6_pgl_sel #(.w(w)) u4(p, n);
  end
  analog begin
    `CHECKX("g1's localparam w1 = 10 selects the member that sets gain 2", g1.u1.gain, 2.0);
    `CHECKX("g2's localparam w = w4 = 1 selects the member that sets gain 3", g2.u4.gain, 3.0);
    I(p, n) <+ 0.0;
  end
endmodule
