// §6.4.1: "Paramset statements may assign values to variables declared in the
// paramset; the values need not be constant expressions. ... Paramset
// variables may be used to provide output variables (see 6.4.3)." §6.4.3:
// "Integer or real variables in the paramset declared with descriptions are
// considered output variables", and "the paramset's value is reported for
// instances using the paramset".
//
// The observable is §9.16 $simprobe from a sibling: "the simulator will look
// for an instance called inst_name in the parent of the current instance ...
// it will then query that instance for an output variable called param_name."
// paramset_hidden_output_variable_takes_the_fallback.va uses the same probe to
// read a module's output variable through a paramset instance.
//
// THE PARAMSET. `(* desc *) real dbl` is assigned twice: `dbl = l;` and then
// `dbl = dbl * 2.0;`, whose right-hand side reads a variable and so is not a
// constant expression (the permission the first sentence grants).
//
// BY HAND. The instance overrides l = 1.5:
//   dbl = 1.5, then dbl = 1.5 * 2.0 = 3.0
// so $simprobe("u", "dbl", -1.0) returns 3.0. The fallback -1.0 is what §9.16
// returns when no output variable `dbl` resolves; 1.5 would mean the second
// statement was lost. The module's parameter k = l = 1.5 is the control that
// the paramset was selected at all.
//
//! lrm 6.4.1
//! lrm 6.4.1:5
//! lrm 6.4.1:7
//! lrm 6.4.3
//! lrm 6.4.3:1001
//! lrm 9.16
//! bias V(p) = 0.75, V(n) = 0.25
//! checks 3
`include "check.vh"
module b4_pvo_top(p, n);
  inout p, n; electrical p, n;
  b4_pvo_ps #(.l(1.5)) u(p, n);
  b4_pvo_mon mon(p, n);
endmodule

paramset b4_pvo_ps b4_pvo_dev;
  parameter real l = 1.0 from (0:inf);
  (* desc = "twice the paramset's l" *) real dbl;
  .k = l;
  dbl = l;
  dbl = dbl * 2.0;
endparamset

module b4_pvo_dev(a, b);
  inout a, b; electrical a, b;
  parameter real k = 9.0;
  (* desc = "module output hidden by the paramset output" *) real dbl;
  analog begin
    dbl = 19.0;
    `CHECKX("the underlying module has a different same-name output", dbl, 19.0);
    `CHECKX("the paramset was selected and passed l through", k, 1.5);
    I(a, b) <+ k * V(a, b);
  end
endmodule

module b4_pvo_mon(a, b);
  inout a, b; electrical a, b;
  real got;
  analog begin
    got = $simprobe("u", "dbl", -1.0);
    `CHECKX("the paramset variable is reported as u's output variable", got, 3.0);
    I(a, b) <+ 0.0 * V(a, b);
  end
endmodule
