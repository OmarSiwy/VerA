// §6.8: "If an identifier is referenced directly (without a hierarchical path)
// within a named block ... if it is declared locally, the local item shall be
// used". A named block is a new scope, so a block-local VARIABLE may reuse the
// name of a module PARAMETER — two kinds of item, two scopes, legal — which is
// the boundary parameter_variable_same_name_rejected.va is refused across.
//
// Inside `inner`, `k` is the local variable, 2.25; after `end` it is the
// parameter again, 1.0. Both are binary-exact and neither is reachable from the
// other by arithmetic in the file.
//
//! lrm 6.8
//! lrm 6.8:3
//! lrm 6.8:4
//! bias V(p) = 0.5
`include "check.vh"
module ch6_scope_variable_shadows_parameter(p);
  inout p; electrical p;
  parameter real k = 1.0;
  analog begin
    begin : inner
      real k;
      k = 2.25;
      `CHECKX("the block's variable shadows the module parameter", k, 2.25);
    end
    `CHECKX("and the parameter is unchanged outside the block", k, 1.0);
    I(p) <+ k * V(p);
  end
endmodule
