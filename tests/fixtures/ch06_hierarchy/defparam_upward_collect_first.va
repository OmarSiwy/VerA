// IEEE 1364-2005 12.2.1: "Using the defparam statement, parameter values can
// be changed in any module instance throughout the design using the
// hierarchical name of the parameter." 12.8.1 b) fixes WHEN: while the
// hierarchy is expanded, "All parameters encountered during this expansion
// are given their final values by applying initial values, parameter
// overrides, and defparam statements. In other words, any defparam statement
// whose target can be resolved within the hierarchy elaborated so far must
// have its target resolved and its value applied." So a defparam's target
// takes the defparam's value wherever the target sits relative to the
// defparam: above it, beside it, or the declaring instance itself.
// AMS 6.3.1 inherits defparam.
//
// THE DESIGN. The top instantiates u1 (a leaf) and then m (a dpc_mid); m
// instantiates u (a leaf whose g is m's own k, `#(.g(k))`) and w (a
// dpc_writer). w writes four defparams, each naming a parameter that an
// instance-order walk reaches BEFORE it reaches w:
//
//   (a) defparam_upward_collect_first.u1.g = 2.0 * two
//                                                the top's u1, a sibling of
//       w's ancestor m written before it (12.6: the top module's name, then
//       down; 12.1.1 makes a top-level module's instance name its name)
//   (b) dpc_mid.k = 3.0                           w's parent m (Syntax 12-7,
//       `module_identifier.item_name`, upward)
//   (c) w.g = 0.5                                 w itself (12.6 b): the
//       parent module's outermost scope holds the instance w)
//   (d) defparam_upward_collect_first.gt = 2.0    a parameter of the top
//
// BY HAND. (a)'s value reads `two`, a parameter of w, "declared in the same
// module as the defparam statement" as 12.2.1 requires; w.two = 2.0, so the
// value is 4.0. The others are literals. Each target's final value is its
// defparam's (12.2.1: the defparam "changes" the value; 6.3.1: it beats an
// instance's own `#()`): u1.g = 4.0, m.k = 3.0, m.w.g = 0.5, gt = 2.0.
// m's `#(.g(k))` hands u the FINAL k, so m.u.g = 3.0, not its default 1.0.
// Every value is exact in binary. Five checks.
//
// Until 2026-10-08 VerA bound each instance's parameters as it inlined it and
// refused all four with E0907 ("elaborated before this defparam was
// reached"); a first walk now collects every defparam
// (`elaborate/override.zig` `seedDefparams`), as the digital engine's
// `bindDefparam` does. defparam_upward_module_name_path.va is the case that
// always worked (a sibling written AFTER the declaring instance);
// defparam_path_names_nothing_rejected.va is the invalid neighbour.
//
//! lrm 6.3.1
//! inherited IEEE 1364-2005 12.2.1 12.6 12.8.1
//! bias V(p) = 0.75, V(n) = 0.25
//! checks 5
`include "check.vh"
module dpc_leaf(a, b);
  inout a, b; electrical a, b;
  parameter real g = 1.0;
  analog I(a, b) <+ g * V(a, b);
endmodule
module dpc_writer(a, b);
  inout a, b; electrical a, b;
  parameter real g = 1.0;
  parameter real two = 2.0;
  defparam defparam_upward_collect_first.u1.g = 2.0 * two;
  defparam dpc_mid.k = 3.0;
  defparam w.g = 0.5;
  defparam defparam_upward_collect_first.gt = 2.0;
  analog I(a, b) <+ g * V(a, b);
endmodule
module dpc_mid(a, b);
  inout a, b; electrical a, b;
  parameter real k = 1.0;
  dpc_leaf #(.g(k)) u(a, b);
  dpc_writer w(a, b);
endmodule
module defparam_upward_collect_first(p, n);
  inout p, n; electrical p, n;
  parameter real gt = 1.0;
  dpc_leaf u1(p, n);
  dpc_mid m(p, n);
  analog begin
    `CHECKX("(a) a sibling elaborated before the declaring instance", u1.g, 4.0);
    `CHECKX("(b) the declaring instance's parent", m.k, 3.0);
    `CHECKX("(b) and what the parent hands down through #(.g(k))", m.u.g, 3.0);
    `CHECKX("(c) the declaring instance itself", m.w.g, 0.5);
    `CHECKX("(d) a parameter of the top", gt, 2.0);
    I(p, n) <+ gt * V(p, n);
  end
endmodule
