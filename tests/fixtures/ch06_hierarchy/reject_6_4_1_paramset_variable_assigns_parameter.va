// §6.4.1: "Paramset statements may assign values to variables declared in the
// paramset; the values need not be constant expressions. However, these
// variables shall not be used to assign values to the module's parameters."
//
// `t` is a paramset variable, legally assigned `rr * 2.0`, and then used on
// the right of `.r = t;`. The module-parameter assignment must be a
// paramset_constant_expression of numbers, parameters and out-of-module
// localparam references; `.r = rr * 2.0;` is the legal form.
//
// VerA reports E0237 at `t` in `.r = t`: "reads the paramset variable `t`,
// and paramset variables shall not assign the module's parameters". (It
// used to report E0314 "unknown identifier", which was true of the cloned
// override and misleading about a declared variable. The same paramset with
// `.r = rr;` compiles.)
//
//! lrm 6.4.1
//! lrm 6.4.1:6
//! reject-only E0237
//! neighbour b4_paramset_statement_without_event_control.va
`include "disciplines.vams"
module ch6_ps_var_res(p, n);
  inout p, n;
  electrical p, n;
  parameter real r = 1.0;
  analog I(p, n) <+ V(p, n) / r;
endmodule

paramset ch6_ps_var ch6_ps_var_res;
  parameter real rr = 2.0;
  real t;
  t = rr * 2.0;
  .r = t;                     // illegal: a paramset variable sets a parameter
endparamset

module top_ps_var(p, n);
  inout p, n;
  electrical p, n;
  ch6_ps_var #(.rr(3.0)) x1(p, n);
endmodule
