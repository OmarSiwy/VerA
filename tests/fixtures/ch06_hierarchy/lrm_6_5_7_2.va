// §6.5.7.2: "A signal appearing in the connection list of a module
// instantiation need not appear in any port declaration or discipline
// declaration." This file asserts that undeclared interconnects compile and
// connect properly: the child receives the connection despite no explicit
// discipline declaration in the parent.
//
// `//! solve` is load-bearing and is not decoration. The harness's default
// netlist ties every unknown no `//!` line names to the reference, so without
// it `undeclared_sig` is held at 0 and the parent's potential contribution has
// nothing to move — the fixture then reads 0 and looks like an elaboration bug.
// It is not one: `undeclared_sig` resolves to `electrical` from the child's
// port and gets both a node and a branch-flow unknown. What the fixture needs
// is for the SOLVER to determine it, which is what §5.6 says a contribution
// asks for.
//
//! lrm 6.5.7.2
//! lrm 6.5.7.2:1000
//! bias V(p) = 0.5
//! solve
`include "check.vh"
module ch6_parent;
  // Note: `undeclared_sig` is NOT declared anywhere in this module.
  // It appears only in the instantiation's connection list below.
  ch6_undeclared_child u(undeclared_sig);
  electrical p;
  analog begin
    V(undeclared_sig) <+ V(p);
    I(p) <+ 1.0;
  end
endmodule

module ch6_undeclared_child(sig);
  inout sig; electrical sig;
  analog begin
    `CHECKX("an undeclared interconnect in the parent connects to the child", V(sig), 0.5);
    I(sig) <+ 0.0;
  end
endmodule
