// §6.6.3 External names for unnamed generate blocks:
//
//   "Although an unnamed generate block has no name that can be used in a
//    hierarchical name, it needs to have a name by which EXTERNAL INTERFACES can
//    refer to it. ... Each generate construct in a given scope is assigned a
//    number. The number is 1 for the construct that appears textually first in
//    that scope and increases by 1 for each subsequent construct. All unnamed
//    generate blocks are given the name genblk<n> where <n> is the assigned
//    number. If such a name would conflict with an explicitly declared name,
//    leading zeroes are added until the name does not conflict. ... Each
//    generate construct is assigned its number even if it does not contain any
//    unnamed generate blocks."
//
// `external_genblk_reference_unsupported.va` pins the first half — the name is
// NOT usable in a hierarchical name. This file pins the other half, the name
// itself, through an external interface the language does define: §9.15
// Table 9-28's `$simparam$str("path")`, "the hierarchical path to the
// $simparam$str function", whose worked example (`testbench.dut1.mytask`)
// spells a path through every enclosing scope. A call written INSIDE a generate
// block therefore reports that block's external name.
//
// The module below is §6.6.3's own `module top`, construct for construct, with
// an analog block in each generate block where the clause declares a net (a net
// declaration has no call site to report from). The clause's trailing comments
// give every expected name, and they are the want column:
//
//   construct 1  if (genblk2) ... else ...     -> genblk1             (else arm runs)
//   construct 2  if (genblk2) ... else ...     -> genblk02            (`genblk2` is a parameter)
//   construct 3  for ... begin : g1            -> g1[0]               (named: its own name)
//                  nested if (1)               -> g1[0].genblk1       (first construct of g1's scope)
//   construct 4  for ... (unnamed)             -> genblk4[0]          ("the fourth generate construct")
//                  nested if (1)               -> genblk4[0].genblk1
//   construct 5  if (1)                        -> genblk5
//
// Construct 3 is why the numbering counts constructs and not unnamed blocks: had
// it counted only unnamed ones, construct 4 would be genblk3. And construct 2 is
// the zero-padding rule. The top-level instance's name is its module name
// (§9.15's example: "testbench"), so every path starts `ch6_genblk_top.`.
//
// `//! checks 6`: exactly one check per selected generate block, the two
// unselected arms (genblk2 = 0) contributing none.
//
//! lrm 6.6.3
//! lrm 6.6.1
//! lrm 6.6.2
//! lrm 9.15
//! lrm 6.6.2:1
//! lrm 6.6.3:1000
//! lrm 9.15:4
//! checks 6
//! bias V(p) = 0.5
`include "check.vh"
module ch6_genblk_top(p);
  inout p;
  electrical p;
  parameter integer genblk2 = 0;
  genvar i;
  string s;

  // The following generate block is implicitly named genblk1
  if (genblk2) analog begin
    s = $simparam$str("path");
    `CHECKI("construct 1, then-arm (not selected)", s == "ch6_genblk_top.genblk1", 1);
  end
  else analog begin
    s = $simparam$str("path");
    `CHECKI("construct 1 is genblk1", s == "ch6_genblk_top.genblk1", 1);
  end

  // The following generate block is implicitly named genblk02
  // as genblk2 is already a declared identifier
  if (genblk2) analog begin
    s = $simparam$str("path");
    `CHECKI("construct 2, then-arm (not selected)", s == "ch6_genblk_top.genblk02", 1);
  end
  else analog begin
    s = $simparam$str("path");
    `CHECKI("construct 2 is genblk02, zero-padded past the parameter genblk2", s == "ch6_genblk_top.genblk02", 1);
  end

  // The following generate block would have been named genblk3
  // but is explicitly named g1
  for (i = 0; i < 1; i = i + 1) begin : g1
    analog begin
      s = $simparam$str("path");
      `CHECKI("construct 3 keeps its declared name, indexed", s == "ch6_genblk_top.g1[0]", 1);
    end
    // The following generate block is implicitly named genblk1
    // as the first nested scope inside of g1
    if (1) analog begin
      s = $simparam$str("path");
      `CHECKI("inside g1 the numbering starts again", s == "ch6_genblk_top.g1[0].genblk1", 1);
    end
  end

  // The following generate block is implicitly named genblk4 since
  // it belongs to the fourth generate construct in scope "top".
  for (i = 0; i < 1; i = i + 1)
    // The following generate block is implicitly named genblk1
    // as the first nested generate block in genblk4
    if (1) analog begin
      s = $simparam$str("path");
      `CHECKI("construct 4 is genblk4 although construct 3 was named", s == "ch6_genblk_top.genblk4[0].genblk1", 1);
    end

  // The following generate block is implicitly named genblk5
  if (1) analog begin
    s = $simparam$str("path");
    `CHECKI("construct 5 is genblk5", s == "ch6_genblk_top.genblk5", 1);
  end

  analog I(p) <+ V(p);
endmodule
