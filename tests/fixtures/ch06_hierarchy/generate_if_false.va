// §6.6.2 if-generate with a false constant condition. The generate scheme is
// evaluated at elaboration, so `if (0)` does not produce a runtime branch: the
// then-block is never instantiated and the else-block is, exactly as if only
// the else-block had been written. `arm` must therefore read 2 — 1 says the
// wrong alternative was elaborated, 0 says neither was.
//
// Both bodies are `analog begin ... end`: §6.6 makes a generate block "a
// collection of one or more module items", and Syntax 6-8 lists analog_construct
// as one. A bare `arm = 1;` there is a statement, not a module item — this file
// used to write one, which pinned a VerA extension instead of the LRM.
//
//! lrm 6.6
//! lrm 6.6.2
//! bias V(p) = 0.5
//! xfail VerA's parser reads a generate block body as an analog statement, so the `analog` keyword inside `generate` dies at E0209 "expected an expression: found `analog`"
`include "check.vh"
module ch6_gen_false(p);
  inout p; electrical p;
  integer arm;
  analog arm = 0;
  generate
    if (0) begin analog begin arm = 1; I(p) <+ 1.0; end end
    else   begin analog begin arm = 2; I(p) <+ V(p); end end
  endgenerate
  analog `CHECKI("if(0) elaborates the else block", arm, 2);
endmodule
