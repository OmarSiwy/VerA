// §7.2.2: "assignment statements within an initial or always block" are in the
// discrete context — in the TOP module as anywhere else. Instantiating a child
// (§6.2.2) changes nothing about the top's own items: the child adds a device in
// parallel, it does not take the parent's `initial` away.
//
// DERIVATION. `j` is assigned only in the discrete context (§7.2.2's domain
// rule), once, before the analysis: j = 2. The top stamps I = j * V(p,n) and the
// child a 1 ohm resistor across the same pair, so with V(p,n) = 0.5:
//
//     top   j * V = 2 * 0.5 = 1.0
//     child V / 1 = 0.5
//
// all exact in binary.
//
// THE DEFECT THIS PINS. With no children the top is handed to lowering as
// parsed, `initial` included. With one, elaboration synthesizes a new module,
// and that module used to be built without the top's `discrete` list — so the
// top's own `initial` vanished the moment the file instantiated anything, and
// j read §3.2's analog default, 0.
//
//! lrm 7.2.2
//! lrm 6.2.2
//! bias V(p) = 0.75, V(n) = 0.25
`include "check.vh"
module ch6_top_initial(p, n);
  inout p, n; electrical p, n;
  integer j;
  initial j = 2;
  ch6_ti_res u(p, n);
  analog begin
    `CHECKI("the top's initial block survives instantiating a child", j, 2);
    `CHECKX("so the top stamps j * V", j * V(p, n), 1.0);
    I(p, n) <+ j * V(p, n);
  end
endmodule

module ch6_ti_res(a, b);
  inout a, b; electrical a, b;
  analog begin
    `CHECKX("the child is an ordinary 1 ohm resistor", V(a, b) / 1.0, 0.5);
    I(a, b) <+ V(a, b) / 1.0;
  end
endmodule
