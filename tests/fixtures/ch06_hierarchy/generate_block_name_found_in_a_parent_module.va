// §6.8: "if the item is a named block or generate block, it continues to
// search higher-level modules until found." IEEE 1364-2005 12.7, which §6.8
// restates: "If an identifier is referenced with a hierarchical name, the path
// can start with a module name, instance name, task, function, named block, or
// named generate block. The names shall be searched first at the current level
// and then in higher level modules until found." §6.7.1: "Access of
// parameters can be done hierarchically."
//
// THE DESIGN. The top has a named if-generate block `gb` holding a local
// parameter k = 2.5 (a localparam is a module_or_generate_item, which a
// generate block may contain; a `parameter` it may not, §6.6). The child,
// instantiated in the top outside gb, reads `gb.k`.
//
// BY HAND. `gb` is not declared in the child. It names a generate block, so
// the search does not stop at the child's module boundary: one module up, the
// top declares the generate block gb, and gb.k = 2.5. The condition `1` is
// true, so gb is instantiated.
//
// With V(a,b) = 0.5 the child stamps 2.5 * 0.5 = 1.25.
//
//! lrm 6.8
//! lrm 6.8:5
//! lrm 6.7.1
//! bias V(p) = 0.75, V(n) = 0.25
//! checks 2
`include "check.vh"
module b4_gbp_top(p, n);
  inout p, n; electrical p, n;
  generate
    if (1) begin : gb
      localparam real k = 2.5;
    end
  endgenerate
  b4_gbp_kid u(p, n);
endmodule

module b4_gbp_kid(a, b);
  inout a, b; electrical a, b;
  real kk;
  analog begin
    kk = gb.k;
    `CHECKX("the generate block name gb is found one module up", kk, 2.5);
    `CHECKX("so the child stamps 2.5 * 0.5", kk * V(a, b), 1.25);
    I(a, b) <+ kk * V(a, b);
  end
endmodule
