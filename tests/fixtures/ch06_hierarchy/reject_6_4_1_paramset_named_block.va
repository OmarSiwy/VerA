// §6.4.1: "Restrictions on statements in a paramset are similar to those for
// analog functions. Specifically, a paramset: ... Shall not use named blocks."
//
// `begin : blk ... end` is a named block around an otherwise legal paramset
// variable assignment. The same statement without the block label compiles.
//
// VerA refuses it with E0237 "a paramset statement uses what 6.4.1 forbids:
// a named block".
//
//! lrm 6.4.1
//! lrm 6.4.1:3
//! reject-only named block
//! neighbour b4_paramset_statement_without_event_control.va
`include "disciplines.vams"
module ch6_ps_block_res(p, n);
  inout p, n;
  electrical p, n;
  parameter real r = 1.0;
  analog I(p, n) <+ V(p, n) / r;
endmodule

paramset ch6_ps_block ch6_ps_block_res;
  parameter real rr = 2.0;
  real t;
  begin : blk                 // illegal: a named block in a paramset
    t = rr;
  end
  .r = rr;
endparamset

module top_ps_block(p, n);
  inout p, n;
  electrical p, n;
  ch6_ps_block #(.rr(3.0)) x1(p, n);
endmodule
