// §6.6.2 Conditional generate constructs: "Even if the begin-end keywords are
// absent, it is still a generate block, which, like all generate blocks,
// comprises a separate scope and a new level of hierarchy when it is
// instantiated." So an instance inside the named block `g1` is `g1.u1`, one
// level below the module — IEEE 1364 §12.4.2, which §6.6 inherits, names the
// gate of the selected block `u1` in module `test` as `test.u1.g1`. §6.7.1:
// "Access of parameters can be done hierarchically", so the top reads the
// instance's parameter as `g1.u1.gain`.
//
// THE DIGIT. `big` = 1 selects g1, whose instance overrides gain to 2.0; the
// leaf's own default is 1.0. So g1.u1.gain = 2.0, exact in binary.
//
// Split out of paramset_selected_after_generate.va by the reconciler,
// 2026-10-08, where that file read `u1.gain`; it now reads `g1.u1.gain`
// itself (4875be93, which also made this file pass). This file keeps the
// name check without a paramset in the way.
//
//! lrm 6.6.2
//! lrm 6.7.1
//! lrm 6.7:1004
//! bias V(p) = 0.75, V(n) = 0.25
//! checks 1
`include "check.vh"
module ch6_gen_name_leaf(a, b);
  inout a, b;
  electrical a, b;
  parameter real gain = 1.0;
  analog I(a, b) <+ gain * V(a, b);
endmodule

module ch6_gen_name_top(p, n);
  inout p, n;
  electrical p, n;
  parameter integer big = 1;
  if (big) begin : g1
    ch6_gen_name_leaf #(.gain(2.0)) u1(p, n);
  end
  analog begin
    `CHECKX("the instance in generate block g1 is named g1.u1", g1.u1.gain, 2.0);
    I(p, n) <+ 0.0;
  end
endmodule
