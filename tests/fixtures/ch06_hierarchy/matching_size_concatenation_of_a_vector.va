// §6.5.7.1 "a vector port can be connected to a vector net or concatenated
// net expression of the matching width." A concatenation's operand may itself
// be a vector net: IEEE 1364-2005 §5.1.14 makes {b, x} the bits of b followed
// by x, so with b [2:0] it is 4 bits wide and matches a [3:0] port.
// matching_size_concatenation.va is the all-scalar shape.
//
// The cell drives every bit of its port against the top's p (held at 0.25):
//   V(o[3]) = 0.5, V(o[2]) = 1.0, V(o[1]) = 2.0, V(o[0]) = 4.0
// and IEEE 1364-2005 12.3.9.2 pairs o[3] with the concatenation's msb, b[2].
// By hand:
//   V(b[2]) = 0.75, V(b[1]) = 1.25, V(b[0]) = 2.25, V(x) = 4.25
// A vector operand counted as one bit makes the connection 2 wide (E0925);
// one read in the wrong order swaps b[2] and b[0]. Dyadic, so exact.
//
//! lrm 6.5.7.1
//! lrm 6.5.7.1:1
//! bias V(p) = 0.25
//! solve
//! checks 4
`include "check.vh"
module ch6_cat_vec_top(p);
  inout p; electrical p;
  electrical [2:0] b;
  electrical x;
  ch6_cat_vec_cell u(.o({b, x}), .c(p));
  analog begin
    `CHECKX("{b, x}: o[3] on b[2]", V(b[2]), 0.75);
    `CHECKX("{b, x}: o[2] on b[1]", V(b[1]), 1.25);
    `CHECKX("{b, x}: o[1] on b[0]", V(b[0]), 2.25);
    `CHECKX("{b, x}: o[0] on x", V(x), 4.25);
  end
endmodule

module ch6_cat_vec_cell(o, c);
  inout [3:0] o; inout c;
  electrical [3:0] o; electrical c;
  analog begin
    V(o[3], c) <+ 0.5;
    V(o[2], c) <+ 1.0;
    V(o[1], c) <+ 2.0;
    V(o[0], c) <+ 4.0;
  end
endmodule
