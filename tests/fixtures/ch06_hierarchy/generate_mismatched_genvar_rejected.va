// LRM 6.6.1: the genvar loop init, condition and step must all use the same
// genvar; `j` in the step is not a constant expression of `i`.
//! lrm 6.6.1
//! reject E0419
// EXPECT: error -- LRM 6.6.1 requires the same genvar in the loop init,
// condition and step; this uses `i` in the init and `j` in the step.
module ch6_generate_mismatched_genvar(p);
  inout p; electrical p; genvar i, j;
  generate
    for (i = 0; i < 2; j = j + 1) I(p) <+ i * V(p);
  endgenerate
endmodule
