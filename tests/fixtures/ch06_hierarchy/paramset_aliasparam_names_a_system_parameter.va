// A.1.9 makes `aliasparam_declaration` a paramset_item_declaration, the same
// production a module uses (A.2.1.1), and §3.4.7 gives that production its
// system-parameter form: "Parameter aliases may also be declared for the
// hierarchical parameter system functions (see 9.18) as in the example
// below: aliasparam m = $mfactor;". Nothing restricts the form to modules, so
// a paramset may declare it too.
//
// What is asserted is that the paramset compiles with the alias in it and
// still does its job: the instance selects it, and its `.tag = 1` reaches the
// module (exact integer).
//
//! lrm 3.4.7
//! lrm 3.4.7:7
//! lrm 6.4
//! bias V(a) = 0.5
`include "check.vh"
module ch6_ps_alias_top(a, b);
  inout a, b; electrical a, b;
  ch6_ps_alias u(a, b);
endmodule

paramset ch6_ps_alias ch6_ps_alias_core;
  aliasparam m = $mfactor;
  .tag = 1;
endparamset

module ch6_ps_alias_core(p, n);
  inout p, n; electrical p, n;
  parameter integer tag = 0;
  analog begin
    `CHECKI("the paramset with a $mfactor alias is selected", tag, 1);
    I(p, n) <+ V(p, n);
  end
endmodule
