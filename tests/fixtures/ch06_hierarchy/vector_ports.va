// §6.5.2.2: "A port can be declared in both a port type declaration and a port
// direction declaration. If a port is declared as a vector, the range
// specification between the two declarations of a port shall be identical."
//
// THIS REJECTION IS CORRECT CONFORMANCE, and this file used to say the opposite.
// The source is now the clause's own printed error case, transcribed: the LRM
// writes `input [3:0] in; electrical [0:3] in;` and labels it "error, MSB and LSB
// in the port type declaration does not evaluate to the same value as the port
// direction declaration". Only the direction keyword and the identifier differ
// here; the ranges are `[3:0]` against `[0:3]`, reversed, exactly as printed.
//
// It used to write `inout p; electrical [3:0] p;` — a range on ONE declaration
// only — and claim that was the clause's third example. It is not: all three
// examples the LRM prints carry a range on both lines, and the rule's own sentence
// is guarded by "IF a port is declared as a vector", so a missing range is a
// different and arguably permissive shape that has to be inferred from IEEE 1364
// rather than read out of this clause. Writing the LRM's own case costs nothing
// and makes the fixture portable.
//
// It reaches the verdict by a different road, and that is worth writing down
// rather than hiding. VerA's parser accepts no range on a port DIRECTION
// declaration at all, so the `[` in `inout [3:0] p` is a parse boundary (E0208,
// "expected an identifier: found `[`") and the two ranges are never compared. The
// right diagnostic for the wrong reason: the day ranged port declarations parse,
// this fixture must keep failing, and it will then be the §6.5.2.2 comparison that
// fails it, with a different code.
//
// Its sibling vector_ports_range_equal.va is the other half of the same clause —
// the pair the LRM calls VALID — and that one is genuinely blocked.
//
//! lrm 6.5.2.2
//! reject E0208
module ch6_vector(p);
  inout [3:0] p; electrical [0:3] p;
  analog begin I(p[0]) <+ V(p[1]); I(p[2]) <+ V(p[3]); end
endmodule
