// AMS6.3.3/6.4.2: empty a is not an override. Both candidates have one
// un-overridden parameter: first leaves a, second leaves c (a aliases b).
// Thus rule1 ties; second wins rule2 via its ranged localparam. Counting
// empty a as overridden would wrongly select first and return10 instead20.
//! lrm 6.3.3
//! lrm 6.4.2
//! lrm 6.3.3:2
//! lrm 6.4.2:8
//! checks 1
`include "check.vh"
module audit_hierarchy_empty_paramset_tie(p);
  inout p; electrical p;
  audit_empty_bin #(.a(),.b(4.0)) u(p);
endmodule
paramset audit_empty_bin audit_empty_bin_leaf;
  parameter real a=1.0,b=2.0;
  .k=10.0;
endparamset
paramset audit_empty_bin audit_empty_bin_leaf;
  parameter real b=2.0,c=3.0;
  aliasparam a=b;
  localparam integer selector=1 from [0:2];
  .k=20.0;
endparamset
module audit_empty_bin_leaf(p);
  inout p; electrical p;
  parameter real k=1.0;
  analog begin
    `CHECKX("empty association is not a paramset tie override",k,20.0);
    I(p)<+k*V(p);
  end
endmodule
