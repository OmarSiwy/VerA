// §6.9.2 Elaboration and paramsets: "If a generate construct contains an
// instantiation of an overloaded paramset, paramset selection is performed
// after the generate construct has been evaluated. The evaluation of the
// generate construct may influence the values and connections of the paramset
// instance, and hence the selection of matching paramset and module."
//
// THE DESIGN. A loop generate instantiates the overloaded paramset b4_pag_sel
// once per genvar value, overriding w = 1.0 + 8.0 * i, where i is §6.6.1's
// implicit localparam ("its value within each instance of the generate block
// is the value of the index variable at the time the instance was
// elaborated"). The two paramsets split on w's range and lead to different
// modules:
//   w in [5:inf)   -> b4_pag_wide
//   w in (-inf:5)  -> b4_pag_narrow
//
// BY HAND.
//   g[0].u : i = 0, w = 1.0  -> narrow, which checks w = 1.0   (1 line)
//   g[1].u : i = 1, w = 9.0  -> wide,   which checks w = 9.0   (2 lines)
// `//! checks 3` counts them: selection made before the genvar was known
// (one value for both instances) gives 2 or 4 lines, and wrong values print
// ok=0.
//
//! lrm 6.9.2
//! lrm 6.9.2:1
//! lrm 6.4.2
//! bias V(p) = 0.75, V(n) = 0.25
//! checks 3
`include "check.vh"
module b4_pag_top(p, n);
  inout p, n; electrical p, n;
  genvar i;
  generate
    for (i = 0; i < 2; i = i + 1) begin : g
      b4_pag_sel #(.w(1.0 + 8.0 * i)) u(p, n);
    end
  endgenerate
endmodule

paramset b4_pag_sel b4_pag_wide;
  parameter real w = 10.0 from [5.0:inf);
  .w = w;
endparamset

paramset b4_pag_sel b4_pag_narrow;
  parameter real w = 1.0 from (-inf:5.0);
  .w = w;
endparamset

module b4_pag_wide(a, b);
  inout a, b; electrical a, b;
  parameter real w = 0.0;
  analog begin
    `CHECKX("g[1].u, generated with w = 1 + 8*1, selects the wide paramset", w, 9.0);
    `CHECKX("and stamps its conductance 9 * 0.5", w * V(a, b), 4.5);
    I(a, b) <+ w * V(a, b);
  end
endmodule

module b4_pag_narrow(a, b);
  inout a, b; electrical a, b;
  parameter real w = 0.0;
  analog begin
    `CHECKX("g[0].u, generated with w = 1 + 8*0, selects the narrow paramset", w, 1.0);
    I(a, b) <+ w * V(a, b);
  end
endmodule
