// §6.6.1 loop generate. This loop terminates (after 5000 iterations), so it
// breaks no language rule; it needs more copies than the engine unrolls
// (4096), a resource limit that must be refused by name rather than as the
// language's "does not terminate" error (E0420) or by running out of memory.
// E0485 is that name. The legal neighbour runs exactly 4096 iterations.
//
//! lrm 6.6.1
//! reject-only E0485
//! neighbour genvar_loop_at_unroll_limit.va
module genvar_loop_beyond_unroll_limit(p);
  inout p; electrical p;
  genvar i;
  real x;
  analog begin
    x = 0.0;
    for (i = 0; i < 5000; i = i + 1) x = x + 1.0;
    I(p) <+ x;
  end
endmodule
