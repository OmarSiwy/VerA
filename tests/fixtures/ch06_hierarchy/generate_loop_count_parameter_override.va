// §6.6.1 loop generate over a PARAMETER bound. §6.6 states what generate is
// for: "the ability for parameter values to affect the structure of the
// model", and §3.4 says when a parameter's value is fixed: "parameters can be
// modified at compilation time to have values which are different from those
// specified in the declaration assignment."
//
// A genvar loop's bound decides how many copies of the generate block exist,
// so `N` is a SHAPE parameter (decided 2026-09-24 by the user: structure is
// shape). Its card value is taken at compilation — the `//! param N = 5` line
// below is the testbench's card and, for a shape parameter, the compile-time
// value, as `vera --param N=5` would give it — and the device refuses, through
// `checkShape`, any card that later moves it.
//
// THE DERIVATION, by hand. Each copy adds its own i*i, as in generate_loop.va:
//
//   N = 3 (the declaration value): 0 + 1 + 4           =  5
//   N = 5 (the card):              0 + 1 + 4 + 9 + 16  = 30
//
// so total = 30, and copies = 5. A device built to the declared default gives
// 5 and 3; one that also ran i = 5 gives 55 and 6. The squares keep a wrong
// count and a wrong set of indices from cancelling.
//
//! lrm 6.6.1
//! lrm 6.6
//! lrm 3.4
//! param N = 5
//! bias V(p) = 0.75, V(n) = 0.25
`include "check.vh"
module ch6_generate_loop_count_parameter_override(p, n);
  inout p, n; electrical p, n; genvar i;
  parameter integer N = 3;
  integer total, copies;
  analog begin
    total = 0;
    copies = 0;
  end
  generate
    for (i = 0; i < N; i = i + 1) begin : stage
      analog begin
        total = total + i * i;
        copies = copies + 1;
        I(p, n) <+ 0.0;
      end
    end
  endgenerate
  analog begin
    `CHECKI("the card's N = 5 copies, not the declaration's 3", copies, 5);
    `CHECKI("each copy contributed its own i*i, i = 0 .. 4", total, 30);
  end
endmodule
