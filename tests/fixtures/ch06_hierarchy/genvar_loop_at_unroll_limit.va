// §6.6.1: a genvar loop is unrolled at elaboration; "It shall be an error if
// the loop does not terminate." This loop terminates after exactly 4096
// iterations, what was the engine's unroll limit until 2026-10-15
// (genvar_loop_4097_iterations.va is one past it; no limit remains), so it
// is legal and must unroll in full.
//
// Derivation: x starts at 0.0 and each of the 4096 unrolled bodies adds 1.0,
// so x = 4096.0 exactly (integers below 2^53 are exact in IEEE double).
//
// Until 2026-10-08 this was refused as E0420 "did not terminate" because the
// cap was reached without re-testing the condition
// (tests/fixtures/conformance/ADVERSARIAL.tsv).
//
//! lrm 6.6.1
//! checks 1
`include "check.vh"
module genvar_loop_at_unroll_limit(p);
  inout p; electrical p;
  genvar i;
  real x;
  analog begin
    x = 0.0;
    for (i = 0; i < 4096; i = i + 1) x = x + 1.0;
    `CHECKX("4096 unrolled bodies each add 1", x, 4096.0);
    I(p) <+ 0.0;
  end
endmodule
