// §6.3.6: "there are six system parameters that are implicitly declared for
// every module: $mfactor, $xposition, $yposition, $angle, $hflip, and $vflip."
// The list is closed. `$temperature` is a §9.15 simulation-query function, not
// one of the six instance parameters, so it cannot be the target of a
// defparam. VerA reports E0907, "override names no parameter of the module".
//
// geometric_system_parameters.va is the legal neighbour, which reads all five
// geometrical parameters declared by the sentence.
//
//! lrm 6.3.6
//! lrm 6.3.6:1003
//! reject-only E0907
//! neighbour geometric_system_parameters.va
module ch6_geom_unknown_top;
  ch6_geom_unknown_child child();
  defparam child.$temperature = 300;
endmodule

module ch6_geom_unknown_child;
  analog $display("temperature=%g", $temperature);
endmodule
