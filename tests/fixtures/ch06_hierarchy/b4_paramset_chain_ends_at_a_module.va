// The legal neighbour of b4_paramset_chain_ends_at_no_module_rejected.va.
// §6.4: "The second identifier may instead be the name of a second paramset.
// A chain of paramsets may be defined in this way, but the last paramset in
// the chain shall reference a module."
//
// Chain: b4_pce_near -> b4_pce_far -> b4_pce_base, and b4_pce_base is a
// module, so the chain is legal. The near link assigns only a paramset
// variable; the far link, whose second identifier is the module, assigns
// `.j = 2.0` (h01_02_paramset_chain.va explains why the near link carries no
// module-parameter statement). With V(p,n) = 0.5 the module stamps
// 2.0 * 0.5 = 1.0; the module default j = 0.0 would stamp 0.0.
//
//! lrm 6.4
//! lrm 6.4:2
//! lrm 6.4:1
//! bias V(p) = 0.75, V(n) = 0.25
//! checks 2
`include "check.vh"
module b4_pce_top(p, n);
  inout p, n; electrical p, n;
  b4_pce_near u(p, n);
endmodule

paramset b4_pce_near b4_pce_far;
  real tag;
  tag = 1.0;
endparamset

paramset b4_pce_far b4_pce_base;
  real tag;
  .j = 2.0;
endparamset

module b4_pce_base(a, b);
  inout a, b; electrical a, b;
  parameter real j = 0.0;
  analog begin
    `CHECKX("the chain ended at the module and the far link's value arrived", j, 2.0);
    `CHECKX("so the module stamps 2.0 * 0.5", j * V(a, b), 1.0);
    I(a, b) <+ j * V(a, b);
  end
endmodule
