// §6.2.1: "Verilog-AMS incorporates hierarchical identifier prefix $root from IEEE
// Std 1800-2012 SystemVerilog. The name $root is used to unambiguously refer to a
// top-level instance or to an instance path starting from the root of the
// instantiation tree." §6.7's Syntax 6-9 puts it in the grammar —
// `hierarchical_identifier ::= [ $root . ] { identifier [ [ constant_expression ]
// ] . } identifier` — and prints `$root.mymodule.u1 // absolute name`. Defined
// syntax with defined meaning, so a run fixture and not the `//! reject` it used
// to be; the old header's claim that "Verilog-A does not permit it" has no support
// in the clause, and Annex C.8 removes hierarchy from Verilog-A only for real
// value ports.
//
// What $root is FOR is disambiguation, and that is what this file sets up rather
// than merely spelling the prefix. §6.2.1: "A.B.C can mean the local A.B.C or the
// top-level A.B.C ... The ambiguity is resolved by giving priority to the local
// scope and thereby preventing access to the top-level path." Here the mid-level
// module contains a LOCAL instance named `u`, and the top level also has an
// instance named `u`. So inside ch6_root_mid:
//
//   u.gain              resolves LOCALLY, to the mid module's own child   = 5.0
//   $root.ch6_root_top.u.gain  resolves from the root, to the top's child = 3.0
//
// Both are asserted, and their difference is asserted too, because a compiler that
// simply ignored the `$root.` prefix would return 5.0 twice and pass either
// assertion alone. Every value is exact in binary.
//
//! lrm 6.2.1
//! lrm 6.7
//! bias V(p) = 0.75, V(n) = 0.25
//! xfail VerA's parser has no hierarchical_identifier: the `.` after `$root` dies at E0207 "unexpected token: found `.`", and the instantiations the path names are refused at E0204 anyway
`include "check.vh"
module ch6_root_top(p, n);
  inout p, n; electrical p, n;
  ch6_root_leaf #(.gain(3.0)) u(p, n);
  ch6_root_mid mid(p, n);
endmodule

module ch6_root_mid(a, b);
  inout a, b; electrical a, b;
  ch6_root_leaf #(.gain(5.0)) u(a, b);
  analog begin
    `CHECKX("an unprefixed path takes the LOCAL scope first", u.gain, 5.0);
    `CHECKX("$root walks from the root of the instantiation tree instead", $root.ch6_root_top.u.gain, 3.0);
    `CHECKX("so the prefix is what distinguishes them", u.gain - $root.ch6_root_top.u.gain, 2.0);
    I(a, b) <+ 0.0;
  end
endmodule

module ch6_root_leaf(a, b);
  inout a, b; electrical a, b;
  parameter real gain = 1.0;
  analog I(a, b) <+ gain * V(a, b);
endmodule
