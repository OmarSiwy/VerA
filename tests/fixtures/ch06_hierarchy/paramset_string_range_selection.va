// §6.4.2, selection rule 2: "The parameters of the paramset, with overrides and
// defaults, shall all be within the allowed ranges specified in the paramset
// parameter declaration." §3.4.2 says how a STRING parameter's allowed range is
// written: "Valid values of string parameters are indicated differently. The
// `from` keyword may be used with a list of valid string values, or the
// `exclude` keyword may be used with a list of invalid string values."
//
// So the range of `t` in the first paramset is the one-element set {"NMOS"} and
// in the second it is {"PMOS"}, and an instance that overrides `t` with "PMOS"
// is admitted by EXACTLY ONE of them. No tie-break rule is reached: rule 2
// already leaves a single applicable paramset, which is the whole point of the
// two-bin arrangement a SPICE model card is converted into.
//
// THE NUMBER. The surviving paramset writes `.sign = -1.0`, so the module's
// `sign` is -1.0 and its contribution is I = sign*V = -1.0 * 0.5 = -0.5 A across
// a 0.5 V bias. Had the "NMOS" paramset been chosen, sign would be +1.0 and the
// current +0.5 A, so the two answers differ in SIGN and not by a tolerance.
// (The §3.4.6 worked example this is cut down from — `ebersmoll` — uses exactly
// this mapping: "the string parameter transistortype associates the string
// "PNP" with a negative one (-1) value for the variable sign".)
//
// GROUND TRUTH TODAY: green, both checks. It was refused with E0914, "2
// paramsets named `h01_type_ps` are still applicable": `Flatten.inRanges` folded
// only reals (`constReal`) and ignored `ValueRange.strings` entirely, so both
// bins admitted, both survived all three tie-breaks, and the ambiguity rule 2
// decides was manufactured rather than real. `inRanges` now has the string arm.
//
//! lrm 6.4.2
//! lrm 6.4.2:4
//! lrm 3.4.2
//! lrm 3.4.2:3
//! lrm 3.4.6
//! lrm 6.4.2:1
//! lrm 6.4.2:2
//! bias V(p) = 0.5
`include "check.vh"
module h01_string_select(p, n);
  inout p, n; electrical p, n;
  h01_type_ps #(.t("PMOS")) u(p, n);
endmodule

paramset h01_type_ps h01_type_base;
  parameter string t = "NMOS" from '{ "NMOS" };
  .sign = 1.0;
endparamset

paramset h01_type_ps h01_type_base;
  parameter string t = "PMOS" from '{ "PMOS" };
  .sign = -1.0;
endparamset

module h01_type_base(a, b);
  inout a, b; electrical a, b;
  parameter real sign = 0.0;
  analog begin
    `CHECKX("the string range of ONE paramset admits \"PMOS\"", sign, -1.0);
    `CHECKX("so the contributed current is -1.0 * 0.5 V", sign * V(a, b), -0.5);
    I(a, b) <+ sign * V(a, b);
  end
endmodule
