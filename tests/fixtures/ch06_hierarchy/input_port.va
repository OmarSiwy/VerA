// §6.5.2.2 a port declared `input`. For a continuous discipline the direction
// does not make the port one-way in the conservative sense: §6.5.2.1 gives it a
// discipline, so it is a node with a potential unknown and a flow, and the
// analog block both probes V(p) and contributes I(p) to it. Held at 1.25 V the
// probe is 1.25 and the branch conductance turns that into 1.25 A of flow — the
// input direction changes neither.
//
//! lrm 6.5.2.2
//! lrm 6.5.2.1
//! lrm 6.5.2.1:1000
//! bias V(p) = 1.25
`include "check.vh"
module ch6_input(input electrical p);
  analog begin
    `CHECKX("the input port's potential is the biased unknown", V(p), 1.25);
    I(p) <+ V(p);
  end
endmodule
