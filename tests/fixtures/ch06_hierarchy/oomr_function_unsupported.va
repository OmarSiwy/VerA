// §6.7.1, fourth bullet: "Analog user defined functions can be accessed
// hierarchically." One sentence, no qualification, so a conforming compiler
// resolves `u.half(...)` and this is a run fixture rather than the `//! reject`
// it used to be.
//
// The function is deliberately not an identity: `half(x)` returns x/2 plus the
// child's own `bias` parameter, which the instance overrides to 0.25. That makes
// the result depend on the INSTANCE the function is reached through, not merely on
// the definition — a compiler that resolved the call against the module definition
// would use bias = 0.0 and report 0.25 instead of 0.5.
//
// With p = 0.75 V and n = 0.25 V, V(p,n) = 0.5, so
//   u.half(V(p,n)) = 0.5/2 + 0.25 = 0.25 + 0.25 = 0.5
// exactly; every intermediate is a dyadic rational. The parent's stamp is that
// same 0.5 A.
//
//! lrm 6.7.1
//! lrm 6.7
//! bias V(p) = 0.75, V(n) = 0.25
//! xfail VerA's parser has no hierarchical_identifier: the `.` in `u.half(...)` dies at E0207 "unexpected token: found `.`", and the instantiation it refers to is refused at E0204 anyway
`include "check.vh"
module ch6_oomr_function(p, n);
  inout p, n; electrical p, n;
  ch6_oof_child #(.bias_v(0.25)) u(p, n);
  analog begin
    `CHECKX("an analog function called through a hierarchical name", u.half(V(p, n)), 0.5);
    I(p, n) <+ u.half(V(p, n));
  end
endmodule

module ch6_oof_child(a, b);
  inout a, b; electrical a, b;
  parameter real bias_v = 0.0;
  analog function real half;
    input x;
    real x;
    begin
      half = x / 2.0 + bias_v;
    end
  endfunction
  analog I(a, b) <+ 0.0;
endmodule
