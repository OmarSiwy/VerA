// §6.6.2: "If the generate block selected for instantiation is not named, it
// still creates a scope; but the declarations within it cannot be referenced
// using hierarchical names other than from within the hierarchy instantiated
// by the generate block itself." From within, they can: §6.8 (IEEE 1364-2005
// 12.7) looks a name up "first at the current level", and the current level
// of an analog block written inside the generate block is the block's scope.
//
// unnamed_generate_instance_reference_rejected.va with the read moved inside
// the unnamed block: `u1.gain` is spelled without the block's §6.6.3 external
// name and resolves to the block's own instance u1.
//
// BY HAND. `big` = 1 selects the block; its instance overrides gain to 2.0
// (the leaf's default is 1.0), so u1.gain = 2.0, exact in binary. One check.
//
//! lrm 6.6.2
//! lrm 6.6.2:1004
//! lrm 6.8
//! bias V(p) = 0.75, V(n) = 0.25
//! checks 1
`include "check.vh"
module ch6_gen_within_leaf(a, b);
  inout a, b;
  electrical a, b;
  parameter real gain = 1.0;
  analog I(a, b) <+ gain * V(a, b);
endmodule

module ch6_gen_within_top(p, n);
  inout p, n;
  electrical p, n;
  parameter integer big = 1;
  if (big) begin
    ch6_gen_within_leaf #(.gain(2.0)) u1(p, n);
    analog `CHECKX("from within the unnamed block, u1 is the block's instance", u1.gain, 2.0);
  end
  analog I(p, n) <+ 0.0;
endmodule
