// §6.7.1, third bullet: "Access of parameters can be done hierarchically.
// However, parameter declaration statements shall not make out-of-module
// references (e.g., for setting default values)." The permission is explicit and
// the one restriction attached to it is about parameter DECLARATIONS, which this
// file does not do — the read below is in an analog block. So the construct is
// required, and this is a run fixture rather than the `//! reject` it used to be.
// That old rejection was the sharpest inversion in the chapter: it demanded a
// diagnostic for the exact sentence that grants the feature.
//
// The child's `gain` is overridden to 3.0 on the instance, and the parent reads
// it back as `u.gain`. Reading the OVERRIDDEN value rather than the declared 1.0
// is the whole test: a compiler that resolved the hierarchical name against the
// module definition instead of the instance reports 1.0. With V(p,n) = 0.5 the
// parent's own contribution is 3.0 * 0.5 = 1.5, exact in binary.
//
// The restriction in the same bullet is deliberately respected here, so the
// fixture stays legal: `parameter real echo = u.gain;` would be the error case and
// belongs in its own file.
//
//! lrm 6.7.1
//! lrm 6.7
//! bias V(p) = 0.75, V(n) = 0.25
//! xfail VerA's parser has no hierarchical_identifier: the `.` in `u.gain` dies at E0207 "unexpected token: found `.`", and the instantiation it refers to is refused at E0204 anyway
`include "check.vh"
module ch6_oomr_parameter(p, n);
  inout p, n; electrical p, n;
  ch6_oop_child #(.gain(3.0)) u(p, n);
  analog begin
    `CHECKX("a parameter read through a hierarchical name", u.gain, 3.0);
    `CHECKX("it is the instance's value, so it drives the parent's stamp", u.gain * V(p, n), 1.5);
    I(p, n) <+ u.gain * V(p, n);
  end
endmodule

module ch6_oop_child(a, b);
  inout a, b; electrical a, b;
  parameter real gain = 1.0;
  analog I(a, b) <+ 0.0;
endmodule
