// §6.4.2, selection rule 2: "The parameters of the paramset, with overrides
// and defaults, shall be all within the allowed ranges specified in the
// paramset parameter declaration." This is the positive half: the paramset
// declares `l = 1.0 from [0.5:2.0]`; the instance overrides l = 1.5, inside
// the range, so the paramset is applicable and selected. The localparam-free
// form isolates rule 2 from rule 3 (b4_paramset_local_range_in_range.va is the
// rule-3 pair).
//
// BY HAND. `.k = 2.0 * l`, so k = 2.0 * 1.5 = 3.0 (the module default is 9.0,
// and the only paramset would be inapplicable without this override). With
// V(p,n) = 0.5 the module stamps 3.0 * 0.5 = 1.5. Both values are exact in
// binary.
//
// The rejecting neighbour paramset_parameter_outside_range_rejected.va
// overrides the same parameter with 3.0.
//
//! lrm 6.4.2
//! lrm 6.4.2:4
//! bias V(p) = 0.5
//! bias V(n) = 0.0
//! checks 2
`include "check.vh"
module ch6_ppar_top(p, n);
  inout p, n; electrical p, n;
  ch6_ppar_ps #(.l(1.5)) u(p, n);
endmodule

paramset ch6_ppar_ps ch6_ppar_dev;
  parameter real l = 1.0 from [0.5:2.0];
  .k = 2.0 * l;
endparamset

module ch6_ppar_dev(a, b);
  inout a, b; electrical a, b;
  parameter real k = 9.0;
  analog begin
    `CHECKX("the in-range override keeps the paramset applicable", k, 3.0);
    `CHECKX("so the module stamps 3.0 * 0.5", k * V(a, b), 1.5);
    I(a, b) <+ k * V(a, b);
  end
endmodule
