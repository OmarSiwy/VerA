//! reject module instantiation is not supported
// EXPECT: error -- multiple instances in one statement require hierarchy elaboration.
module ch6_multiple_instances_parent(p, n);
  inout p, n; electrical p, n;
  ch6_child first(p), second(n);
endmodule
