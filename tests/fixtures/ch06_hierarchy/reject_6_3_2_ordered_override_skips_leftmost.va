// §6.3.2: "The order of the assignments shall follow the order of declaration
// of the parameters within the module. ... It is not necessary to assign
// values to all parameters, but the left-most parameter assignment(s) cannot
// be skipped."
//
// `#(, 4.0)` leaves the first ordered slot (parameter a) empty in order to
// reach b, which is exactly the skip the clause forbids. `#(3.0, 4.0)` and
// `#(3.0)` are the legal spellings; the first compiles in this position
// (probed). A named override, `#(.b(4.0))`, is how §6.3 lets b be set alone.
//
// VerA reports E0209 "expected an expression: found `,`" at the empty slot.
//
//! lrm 6.3.2
//! lrm 6.3.2:1002
//! reject-only E0209
//! neighbour ordered_override_partial_subset.va
`include "disciplines.vams"
module ch6_skip_child(p, n);
  inout p, n;
  electrical p, n;
  parameter real a = 1.0;
  parameter real b = 2.0;
  analog I(p, n) <+ a * b * V(p, n);
endmodule

module ch6_skip_leftmost(p, n);
  inout p, n;
  electrical p, n;
  ch6_skip_child #(, 4.0) c1(p, n);    // illegal: left-most assignment skipped
endmodule
