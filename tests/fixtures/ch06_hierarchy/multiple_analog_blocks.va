// LRM §6.2: "A module definition may have multiple analog blocks. The behavior
// of multiple analog blocks shall be defined by assuming they internally
// combine into a single analog block IN THE ORDER that the analog blocks appear
// in the module description (i.e., they are concatenated in order)."
//
// `acc` makes that order observable, which per-block prints alone would not:
// the third block sees the first block's 1m (§2.6 scale factor = 1e-3) already
// summed with the second block's V(p) = 0.5, so acc = 0.501 — exact in binary,
// 0.001 + 0.5 rounding to the same double as the literal. Run the blocks out of
// order, drop one, or give each its own copy of `acc`, and the number moves.
//
// The third contribution also pins §4.5.3: "In DC analysis, ddt() returns
// zero (0)", and this is the DC operating point. The clause fixes the value at
// zero, not near it, so that line is CHECKX — a tolerance would be a slack
// nothing in the LRM authorizes, and it hides nothing it should hide.
//
//! lrm 6.2
//! lrm 6.2:7
//! lrm 6.2:8
//! lrm 4.5.3
//! lrm 6.2:9
//! lrm 6.9.1
//! lrm 6.9.1:1
//! lrm 6.9.1:2
//! lrm 6.9.1:3
//! bias V(p) = 0.5
`include "check.vh"
module ch6_concat(p);
  inout p; electrical p;
  real acc;
  analog begin
    acc = 1m;
    I(p) <+ 1m;
  end
  analog begin
    acc = acc + V(p);
    I(p) <+ V(p);
  end
  analog begin
    `CHECKX("the three analog blocks concatenate in source order", acc, 0.501);
    `CHECKX("ddt() at the dc operating point", ddt(V(p)), 0.0);
    I(p) <+ ddt(V(p));
  end
endmodule
