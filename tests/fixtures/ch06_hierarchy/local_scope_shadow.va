// LRM §6.8 scope rules, the UPWARD half: "If it is declared locally, the local
// item shall be used; if not, the search shall continue upward until an item by
// that name is found or until a module boundary is encountered." A named
// `begin : inner` opens a new scope; `value` is not declared in it, so the
// search goes up and finds the module's `value`, assigned 1.0 by the statement
// above. Held at V(p) = 0.25, `local_value` is 1.0 + 0.25 = 1.25, exact in
// binary, so equality is the right test. A compiler that gave the inner scope a
// fresh (zero) `value` would print 0.25.
//
// The other half — an inner scope that DOES declare the name, so the local item
// wins and the outer one survives the block — is local_scope_declaration_shadow.va.
//
// (This file used to cite §6.6, which is Generate constructs. The cite moved;
// the want did not.)
//
//! lrm 6.8
//! lrm 6.8:3
//! lrm 6.8:4
//! bias V(p) = 0.25
`include "check.vh"
module ch6_scope(p);
  inout p; electrical p; real value;
  analog begin
    value = 1.0;
    begin : inner
      real local_value;
      local_value = value + V(p);
      `CHECKX("inner scope reads the enclosing value", local_value, 1.25);
      I(p) <+ local_value;
    end
  end
endmodule
