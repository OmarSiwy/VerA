// A numeric host card value is an override with no Verilog width: IEEE
// 1364-2005 12.2 gives an untyped, unranged parameter "the type and range of
// the final override value", and VerA reads a card value as an unsized
// integer, 32 bits or 64 when the value needs them (specification/Vague_Decisions.md
// VD-089). The cards give wide=2^32, unsigned_word=2^31 and narrow=1. The
// explicit integer neighbor retains its declared 32-bit type.
//
// §6.3 selection uses these effective outer defparams. wide therefore selects
// the >=2^32 member (gain 3), unsigned_word selects the >=2^31 member (gain 5),
// and narrow selects the <2^32 member (gain 2). At 1/2 V their currents are
// 1.5, 2.5 and 1 A. §9.14's unsigned ceiling logarithms are 32, 31 and 0.
// 2^32 does not fit 32 signed bits, so wide reads as a 64-bit signed integer
// and ~wide is 0xFFFFFFFEFFFFFFFF: bit 63 set plus lower one bits, so its
// ceiling log is 64. (The 40-bit declaration width would give 40; a 32-bit
// truncation of the card would make wide 0 and its logarithm 0, not 32.)
//! lrm 6.3
//! lrm 6.4.2
//! lrm 9.14
//! inherited IEEE 1364-2005 12.2
//! lrm 6.4.2:4
//! lrm 9.14:1
//! param wide = 4294967296
//! param unsigned_word = 2147483648
//! param narrow = 1
//! bias V(p) = 0.5
//! checks 13
`include "check.vh"
module ps_outer_wide_card(p);
  inout p; electrical p;
  parameter wide=40'h0000000001;
  parameter unsigned_word=32'h00000001;
  parameter integer narrow=1;
  ps_outer_wide_bin wide_inst(p), narrow_inst(p);
  ps_outer_unsigned_bin unsigned_inst(p);
  defparam wide_inst.w=wide, narrow_inst.w=narrow;
  defparam unsigned_inst.w=unsigned_word;
  analog begin
    `CHECKX("inferred wide host value survives", wide, 4294967296.0);
    `CHECKX("unsigned host value stays positive", unsigned_word, 2147483648.0);
    `CHECKI("explicit integer control retains its value", narrow, 1);
    `CHECKI("wide operand logarithm", $clog2(wide), 32);
    `CHECKI("unsigned operand logarithm", $clog2(unsigned_word), 31);
    `CHECKI("explicit integer logarithm", $clog2(narrow), 0);
    `CHECKI("a card value past 32 bits is a 64-bit operand", $clog2(~wide), 64);
    `CHECKX("wide card chose its high bin", wide_inst.gain, 3.0);
    `CHECKX("unsigned card chose its high bin", unsigned_inst.gain, 5.0);
    `CHECKX("explicit integer chose its low bin", narrow_inst.gain, 2.0);
    `CHECKX("wide selected behavior executes", I(wide_inst.br), 1.5);
    `CHECKX("unsigned selected behavior executes", I(unsigned_inst.br), 2.5);
    `CHECKX("integer selected behavior executes", I(narrow_inst.br), 1.0);
    I(p)<+0.0;
  end
endmodule
paramset ps_outer_wide_bin ps_outer_wide_leaf;
  parameter real w=0.0 from [0:4294967296.0);
  .gain=2.0;
endparamset
paramset ps_outer_wide_bin ps_outer_wide_leaf;
  parameter real w=0.0 from [4294967296.0:1099511627776.0];
  .gain=3.0;
endparamset
paramset ps_outer_unsigned_bin ps_outer_wide_leaf;
  parameter real w=0.0 from [0:2147483648.0);
  .gain=4.0;
endparamset
paramset ps_outer_unsigned_bin ps_outer_wide_leaf;
  parameter real w=0.0 from [2147483648.0:4294967296.0];
  .gain=5.0;
endparamset
module ps_outer_wide_leaf(p);
  inout p; electrical p;
  parameter real gain=1.0;
  branch (p) br;
  analog I(br)<+gain*V(br);
endmodule
