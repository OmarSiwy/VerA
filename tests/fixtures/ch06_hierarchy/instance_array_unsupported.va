// §6.2.2: "The instantiations of modules can contain a range specification. This
// allows an array of instances to be created" —
// `name_of_module_instance ::= module_instance_identifier [ range ]`. §6.7's
// Syntax 6-9 then makes `adder1[5].sum` a hierarchical name, so the elements are
// separately addressable instances and not one instance with a decorative index.
// Legal source, so a run fixture and not the `//! reject` it used to be.
//
// The connection is to SCALAR nets on purpose. §6.5.7.1's matching-size rule
// would let a width-2 vector net distribute one bit per element, but VerA cannot
// declare a vector port at all (that gap is held by vector_ports_range_equal.va),
// and a fixture with two independent gaps in it tells you nothing about which one
// closed. With scalar nets the same pair reaches every element, so each of the
// two instances sees V(a,b) = 0.75 - 0.25 = 0.5 exactly and one want covers both.
//
// The shared `#(2.0)` is asserted because a parameter_value_assignment applies to
// the whole array, and $param_given is 1 for it while the array index is not an
// override of anything.
//
// WHAT IS NOT ASSERTED, AND CANNOT BE FROM INSIDE THE CHILD: the instance COUNT,
// which is the actual subject of §6.2.2's "an array of instances is created". Every
// want below holds identically for a compiler that elaborated ONE element, because
// both elements see the same scalar pair and run the same analog block. A missing
// element shows up only as fewer `ok=1` lines, and the runner has no floor on those.
// Observing the count needs either a width-2 vector net (blocked, see above) or a
// probe in the PARENT of the total current the array stamps. §6.2.2 elaboration now
// works, so the second is no longer blocked on the instantiation — it is blocked on
// there being no way to read back what a child stamped into a source branch. The
// gap is this fixture's, not the compiler's; written down so it is not mistaken for
// coverage.
//
//! lrm 6.2.2
//! bias V(p) = 0.75, V(n) = 0.25
`include "check.vh"
module ch6_instance_array_parent(p, n);
  inout p, n; electrical p, n;
  ch6_array_child #(2.0) u[0:1](p, n);
endmodule

module ch6_array_child(a, b);
  inout a, b; electrical a, b;
  parameter real gain = 1.0;
  analog begin
    `CHECKX("every element of the array is bound to the connection list", V(a, b), 0.5);
    `CHECKX("and the one #() parameterizes the whole array", gain, 2.0);
    `CHECKI("both ports of each element are connected", $port_connected(a), 1);
    I(a, b) <+ gain * V(a, b);
  end
endmodule
