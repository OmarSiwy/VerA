// §6.7.1, first bullet: "Potential and flow access for named and unnamed branches
// (including port branches) can be done hierarchically." §6.7 makes the name
// itself legal — Syntax 6-9's `hierarchical_identifier`, and Figure 6-3 lists
// `op1.inp`, `op1.inm`, `op1.out` as nameable objects of an instance. So a
// hierarchical potential probe is required, and this file is a run fixture, not
// the `//! reject` it used to be: written that way it demanded a diagnostic for
// something the clause explicitly permits.
//
// The child's ports `u.a` and `u.b` are bound to the parent's `p` and `n`, so
// they are the SAME nodes seen through a hierarchical name. That is what makes
// the digits checkable without any extra machinery: with p = 0.75 V and
// n = 0.25 V, V(u.a, u.b) must be 0.5, exactly what V(p, n) is. The identity is
// asserted as well as the value, because the two claims fail differently — a
// compiler that resolved the hierarchical name to a fresh, unconnected node gets
// 0.0 for the probe and -0.5 for the difference, while one that resolved it to
// the wrong end of the pair gets -0.5 for the probe.
//
//! lrm 6.7.1
//! lrm 6.7
//! bias V(p) = 0.75, V(n) = 0.25
//! xfail VerA's parser has no hierarchical_identifier: the `.` in `u.a` dies at E0207 "unexpected token: found `.`", and the instantiation it refers to is refused at E0204 anyway
`include "check.vh"
module ch6_oomr_branch_probe(p, n);
  inout p, n; electrical p, n;
  ch6_obp_child u(p, n);
  analog begin
    `CHECKX("a potential probe through a hierarchical name", V(u.a, u.b), 0.5);
    `CHECKX("which names the same nodes the instance is bound to", V(u.a, u.b) - V(p, n), 0.0);
    I(p, n) <+ 0.0;
  end
endmodule

module ch6_obp_child(a, b);
  inout a, b; electrical a, b;
  analog I(a, b) <+ V(a, b);
endmodule
