// §6.4.3: "As with modules, integer or real variables in the paramset that are
// declared with descriptions are considered output variables ... A paramset output
// variable's value may be computed from values of any output parameters of the
// module by using the special syntax `.module_output_variable_identifier`." The
// clause prints a worked paramset (`smnpn`) that does exactly this, so a
// conforming compiler must accept the construct and this is a run fixture, not
// the `//! reject` it used to be.
//
// WHAT THIS FIXTURE CAN AND CANNOT ASSERT. A paramset output variable is a value
// the simulator REPORTS for the instance; §6.4.3 gives no way to read it back
// inside the module, and this suite's only oracle is a `CHECK` in an analog block.
// So the number that is written down here rather than asserted is:
//
//   the module's output variable  gm = 4.0 * V(a,b) = 4.0 * 0.5 = 2.0
//   the paramset's output variable ft = 3.0 * .gm  = 3.0 * 2.0 = 6.0
//
// and a host that exposes operating-point variables must report ft = 6.0 for this
// instance, replacing any same-named module output variable per the clause's first
// bullet. What IS asserted is everything §6.4.3's rule is computed FROM: the
// module's own output variable holds 2.0, and the parameter the paramset set holds
// 4.0. If those are right and ft is wrong, the defect is in the reporting path
// alone.
//
//! lrm 6.4.3
//! bias V(p) = 0.75, V(n) = 0.25
//! xfail VerA compiles one flat module: the paramset DECLARATION is now read past and dropped (§6.4 gives it effect only through an instance), but the instantiation that would select it is refused at E0204 "module instantiation is not supported"
`include "check.vh"
module ch6_output_user(p, n);
  inout p, n; electrical p, n;
  ch6_po_ps u(p, n);
endmodule

paramset ch6_po_ps ch6_output_base;
  (* desc = "three times the module's transconductance" *) real ft;
  .scale = 4.0;
  ft = 3.0 * .gm;
endparamset

module ch6_output_base(a, b);
  inout a, b; electrical a, b;
  parameter real scale = 9.0;
  (* desc = "transconductance" *) real gm;
  analog begin
    gm = scale * V(a, b);
    `CHECKX("the paramset set the module parameter its output feeds on", scale, 4.0);
    `CHECKX("so the module's own output variable holds scale*V(a,b)", gm, 2.0);
    I(a, b) <+ gm;
  end
endmodule
