// §6.4.2 also tests local parameter ranges after overrides and defaults have
// been applied. Both candidates admit 0<=w<=10; guard=2*w selects low for
// guard<10 or high for guard>=10. Thus defparam w=7 gives guard=14 and
// gain=20+7=27; w=3 gives guard=6 and gain=10+3=13. The default w=1 gives
// guard=2 and gain=11. At 1/2 V, the currents are 13.5,6.5,5.5 A.
//! lrm 6.3
//! lrm 6.4.2
//! lrm 6.4.2:5
//! bias V(p) = 0.5
//! checks 6
`include "check.vh"
module ps_outer_defaults(p);
  inout p; electrical p;
  ps_derived_bin #(.w(2.0)) high(p);
  ps_derived_bin low(p), defaults(p);
  defparam high.w=7.0, low.w=3.0;
  analog begin
    `CHECKX("derived local range selects high", high.gain, 27.0);
    `CHECKX("derived local range selects low", low.gain, 13.0);
    `CHECKX("derived local range sees the default", defaults.gain, 11.0);
    `CHECKX("high behavior executes", I(high.br), 13.5);
    `CHECKX("low behavior executes", I(low.br), 6.5);
    `CHECKX("default behavior executes", I(defaults.br), 5.5);
    I(p) <+ 0.0;
  end
endmodule
paramset ps_derived_bin ps_derived_leaf;
  parameter real w=1.0 from [0:10];
  localparam real guard=2.0*w from [0:10);
  .gain=10.0+w;
endparamset
paramset ps_derived_bin ps_derived_leaf;
  parameter real w=1.0 from [0:10];
  localparam real guard=2.0*w from [10:20];
  .gain=20.0+w;
endparamset
module ps_derived_leaf(p);
  inout p; electrical p;
  parameter real gain=1.0;
  branch (p) br;
  analog I(br) <+ gain*V(br);
endmodule
