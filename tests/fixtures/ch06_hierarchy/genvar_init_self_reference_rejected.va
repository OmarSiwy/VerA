// §6.6.1, verbatim: "Both the initialization and iteration assignments in the loop
// generate scheme shall assign to the same genvar. THE INITIALIZATION ASSIGNMENT
// SHALL NOT REFERENCE THE LOOP INDEX VARIABLE ON THE RIGHT-HAND SIDE."
//
// `i = i + 1` in the init position does exactly that. The rule is not a
// restatement of the constant-expression requirement: `i` IS a genvar, so it is a
// legal `genvar_primary` in Syntax 6-8's `genvar_expression`, and it is precisely
// the initialization slot the LRM carves out, because at that point the loop has
// not run and the index has no value to read. A conforming compiler diagnoses it
// and there is no `//! xfail`.
//
// VerA reaches the verdict one step to the side: it tries to constant-fold the
// initial value, finds `i` unbound because nothing has assigned it yet, and
// reports E0417, "genvar loop bound is not a constant expression: initial value of
// `i`". The right verdict from the adjacent rule; its sibling
// generate_nonconstant_init_rejected.va pins the same code from the
// constant-expression side, with a runtime `integer` on the right-hand side
// instead of the index.
//
//! lrm 6.6.1
//! reject E0417
module ch6_genvar_init_self_reference(p);
  inout p; electrical p;
  genvar i;
  generate
    for (i = i + 1; i < 3; i = i + 1) I(p) <+ V(p);
  endgenerate
endmodule
