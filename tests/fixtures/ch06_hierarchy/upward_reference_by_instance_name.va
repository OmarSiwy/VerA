// §6.7.1: "Verilog-AMS HDL follows the rules for hierarchical upward
// referencing as described in 12.6 of IEEE Std 1364 Verilog with the addition
// that the scope_name shall be restricted to a hierarchical_inst_identifier."
// §6.7.1 also: "Access of parameters can be done hierarchically."
//
// IEEE 1364-2005 12.6 resolves `scope_name.item_name`:
//   a) look in the current scope for a scope named scope_name ...
//   b) "Look in the parent module's outermost scope for a scope named
//      scope_name. If found, the item name shall be resolved from that scope."
//   c) "Repeat step b), going up the hierarchy."
//
// THE HIERARCHY.
//   b4_up_top
//     u1 : b4_up_mid1
//       sib : b4_up_holder #(.k(2.5))
//       u2  : b4_up_mid2
//         u3 : b4_up_leaf     reads `sib.k`
//
// BY HAND. In u3 (module b4_up_leaf) there is no scope `sib` (step a). Its
// parent module b4_up_mid2 has none either (step b). One level up (step c),
// b4_up_mid1 has the instance `sib`, so `sib.k` is u1.sib.k = 2.5, the value
// u1 gave its instance (the holder's default is 1.0). `sib` is an instance
// name, which the AMS restriction keeps. The reference sits in an analog
// block, not a parameter declaration (§6.7.1 forbids those).
//
// With V(a,b) = 0.5 the leaf stamps 2.5 * 0.5 = 1.25.
//
//! lrm 6.7.1
//! lrm 6.7.1:5
//! bias V(p) = 0.75, V(n) = 0.25
//! checks 2
`include "check.vh"
module b4_up_top(p, n);
  inout p, n; electrical p, n;
  b4_up_mid1 u1(p, n);
endmodule

module b4_up_mid1(a, b);
  inout a, b; electrical a, b;
  b4_up_holder #(.k(2.5)) sib(a, b);
  b4_up_mid2 u2(a, b);
endmodule

module b4_up_holder(a, b);
  inout a, b; electrical a, b;
  parameter real k = 1.0;
  analog I(a, b) <+ 0.0;
endmodule

module b4_up_mid2(a, b);
  inout a, b; electrical a, b;
  b4_up_leaf u3(a, b);
endmodule

module b4_up_leaf(a, b);
  inout a, b; electrical a, b;
  real kk;
  analog begin
    kk = sib.k;
    `CHECKX("sib is found two modules up, so sib.k is u1.sib.k", kk, 2.5);
    `CHECKX("and the leaf stamps 2.5 * 0.5", kk * V(a, b), 1.25);
    I(a, b) <+ kk * V(a, b);
  end
endmodule
