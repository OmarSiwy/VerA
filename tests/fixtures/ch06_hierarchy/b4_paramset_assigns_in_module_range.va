// The legal neighbour of b4_paramset_assigns_out_of_module_range_rejected.va.
// §6.4.2: "If a paramset assigns a value to a module parameter and this value
// is outside the range specified for that module parameter, it shall be an
// error." Here the paramset assigns `.r = 2.0` to a module parameter declared
// `r = 1.0 from (0:inf)`: inside the range, no error.
//
// BY HAND: r = 2.0, and with V(p,n) = 0.5 the resistor stamps 0.5 / 2.0 = 0.25.
//
//! lrm 6.4.2
//! bias V(p) = 0.75, V(n) = 0.25
//! checks 2
`include "check.vh"
module b4_pmr_top(p, n);
  inout p, n; electrical p, n;
  b4_pmr_ps u(p, n);
endmodule

paramset b4_pmr_ps b4_pmr_res;
  parameter real s = 1.0;
  .r = 2.0;
endparamset

module b4_pmr_res(a, b);
  inout a, b; electrical a, b;
  parameter real r = 1.0 from (0:inf);
  analog begin
    `CHECKX("the paramset's in-range value reached the module", r, 2.0);
    `CHECKX("so the resistor stamps 0.5 / 2.0", V(a, b) / r, 0.25);
    I(a, b) <+ V(a, b) / r;
  end
endmodule
