// Syntax 6-8: `generate_block ::= module_or_generate_item | begin
// [ : generate_block_identifier ] { module_or_generate_item } end`, and §6.6:
// "Use of generate regions is optional." The block below is
// generate_block_attribute_then_end_of_file_rejected.va closed properly: its
// `(* a *)` prefixes an analog construct (§2.9, "a prefix attached to ... a
// module item"; VerA parses `a` and ignores it) and `end` closes the block.
//
// By hand: `if (1)` selects its only arm (§6.6.2), so the block's analog
// construct elaborates and sets `arm` to 1. §6.9.1 concatenates analog blocks
// in source order, so the seed `arm = 0` runs first and the check last: 1.
// A dropped block, or a dropped attributed item, reads 0.
//
//! lrm 6.6
//! bias V(p) = 0.5
//! checks 1
`include "check.vh"
module ch6_gen_attr_end(p);
  inout p; electrical p;
  integer arm;
  analog arm = 0;
  if (1) begin (* a *) analog begin arm = 1; I(p) <+ V(p); end end
  analog `CHECKI("the attributed item of the closed block elaborates", arm, 1);
endmodule
