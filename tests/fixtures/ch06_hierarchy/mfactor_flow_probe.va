// LRM §6.3.6, second automatic rule: "The value returned by any branch flow
// probe in the analog block, including those used in indirect assignments,
// shall be divided by $mfactor." Table 9-29 fixes $mfactor at its top-level
// 1.0 here, so the division is the identity: the probe reads the branch flow
// itself.
//
// §5.4.2 makes that flow a solver unknown of its own (codegen spells it
// `flow(p,n)`, punctuation escaped), so the testbench can hold it. Held at
// 3 mA the probe must read 3e-3 — and V(out), driven by it, is the same
// number. A stray division or multiplication by anything but 1.0 moves it.
//
//! lrm 6.3.6
//! lrm 6.3.6:4
//! sweep flowZ28pZ2cnZ29 = 0.003
`include "check.vh"
module ch6_mfactor_flow_probe(p, n, out);
  inout p, n, out; electrical p, n, out;
  analog begin
    `CHECKX("$mfactor is 1.0, so the flow probe is undivided", $mfactor, 1.0);
    `CHECKX("the flow probe reads the branch flow", I(p, n), 3.0e-3);
    V(out) <+ I(p, n);
  end
endmodule
