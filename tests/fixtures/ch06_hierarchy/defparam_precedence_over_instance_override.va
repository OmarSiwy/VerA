// §6.3 Overriding module parameter values:
//
//   "If a defparam assignment conflicts with a module instance parameter, THE
//    PARAMETER SHALL TAKE THE VALUE SPECIFIED BY THE DEFPARAM."
//
// Instance `u` below is given gain = 3.0 by its instance parameter value
// assignment AND gain = 5.0 by a defparam. The two conflict, and the clause
// resolves the conflict in the defparam's favour: 5.0. Instance `w` has only the
// instance assignment, so it keeps 3.0 — which shows the defparam reached the
// one instance it names and no other. Instance `v` has only the defparam: 7.0.
//
// The answer is observed twice: as the hierarchical parameter value (§6.7.1)
// and through the conductance the child actually stamps, I = gain * V with
// V = 0.75 - 0.25 = 0.5, so the three branch currents are 2.5, 3.5 and 1.5 —
// each exact in binary, and each different from what the losing value would
// give (1.5 for u under the instance override, 0.5 for v under the default).
//
//! lrm 6.3
//! lrm 6.3.1
//! lrm 6.3:1
//! lrm 6.3.1:1001
//! lrm 6.1:1000
//! lrm 6.7.1
//! lrm 6.7.1:1
//! bias V(p) = 0.75, V(n) = 0.25
//! checks 6
`include "check.vh"
module ch6_defparam_wins(p, n);
  inout p, n;
  electrical p, n;
  ch6_defparam_wins_leaf #(.gain(3.0)) u(p, n);
  ch6_defparam_wins_leaf v(p, n);
  ch6_defparam_wins_leaf #(.gain(3.0)) w(p, n);
  defparam u.gain = 5.0, v.gain = 7.0;
  analog begin
    `CHECKX("the defparam wins a conflict with the instance assignment", u.gain, 5.0);
    `CHECKX("a defparam alone replaces the default", v.gain, 7.0);
    `CHECKX("an instance the defparam does not name keeps its own assignment", w.gain, 3.0);
    `CHECKX("and the winning value is the one the device stamps", I(u.br), 2.5);
    `CHECKX("for the defparam-only instance too", I(v.br), 3.5);
    `CHECKX("and for the untouched one", I(w.br), 1.5);
    I(p, n) <+ 0.0;
  end
endmodule

module ch6_defparam_wins_leaf(a, b);
  inout a, b;
  electrical a, b;
  parameter real gain = 1.0;
  branch (a, b) br;
  analog I(br) <+ gain * V(br);
endmodule
