// IEEE1364-2005 12.2.3, also AMS6.3.4.
// Base a overridden4; explicit b override11 REPLACES b=a+1, so b does
// not become5. Dependent c=a*b recomputes to44. All values are exact.
//! lrm 6.3.4
//! lrm 6.3.3
//! lrm 6.3.3:1
//! lrm 6.3.4:1000
// inherited IEEE 1364-2005 12.2.3
`include "check.vh"
module audit_hierarchy_override_breaks_dependency(p);
  inout p; electrical p;
  audit_break_leaf #(.a(4.0),.b(11.0)) u(p);
endmodule
module audit_break_leaf(p);
  inout p; electrical p;
  parameter real a=2.0,b=a+1.0,c=a*b;
  analog begin
    `CHECKX("base override",a,4.0);
    `CHECKX("dependency replaced",b,11.0);
    `CHECKX("remaining dependency recomputed",c,44.0);
    I(p)<+c*V(p);
  end
endmodule
