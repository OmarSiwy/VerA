// §6.2.2 builds a finite instance tree and bounds nothing about its depth.
// d0 instantiates d1 and so on to d65, which holds the only analog block: 65
// nested instances, no module repeated, so no cycle (E0905) exists. Until
// 2026-10-15 VerA elaborated at most 64 nested instances and refused the 65th
// (E1018, retired); the walk now keeps its levels on a heap stack, so any
// finite depth elaborates (`lib/ir/elaborate/instance.zig` tests 10,000).
// instance_tree_64_levels.va is the old bound itself;
// recursive_instantiation_rejected.va is the cycle that is still refused.
//
// HAND DERIVATION. The bias pins V(p) = 0.5 and V(n) = 0 at the top, and d65
// reads them through 65 levels of port connections: V(p, n) = 0.5.
//
//! lrm 6.2.2
//! bias V(p) = 0.5, V(n) = 0
//! checks 1
`include "check.vh"
module d0(p, n);
  inout p, n; electrical p, n;
  d1 u(p, n);
endmodule
module d1(p, n);
  inout p, n; electrical p, n;
  d2 u(p, n);
endmodule
module d2(p, n);
  inout p, n; electrical p, n;
  d3 u(p, n);
endmodule
module d3(p, n);
  inout p, n; electrical p, n;
  d4 u(p, n);
endmodule
module d4(p, n);
  inout p, n; electrical p, n;
  d5 u(p, n);
endmodule
module d5(p, n);
  inout p, n; electrical p, n;
  d6 u(p, n);
endmodule
module d6(p, n);
  inout p, n; electrical p, n;
  d7 u(p, n);
endmodule
module d7(p, n);
  inout p, n; electrical p, n;
  d8 u(p, n);
endmodule
module d8(p, n);
  inout p, n; electrical p, n;
  d9 u(p, n);
endmodule
module d9(p, n);
  inout p, n; electrical p, n;
  d10 u(p, n);
endmodule
module d10(p, n);
  inout p, n; electrical p, n;
  d11 u(p, n);
endmodule
module d11(p, n);
  inout p, n; electrical p, n;
  d12 u(p, n);
endmodule
module d12(p, n);
  inout p, n; electrical p, n;
  d13 u(p, n);
endmodule
module d13(p, n);
  inout p, n; electrical p, n;
  d14 u(p, n);
endmodule
module d14(p, n);
  inout p, n; electrical p, n;
  d15 u(p, n);
endmodule
module d15(p, n);
  inout p, n; electrical p, n;
  d16 u(p, n);
endmodule
module d16(p, n);
  inout p, n; electrical p, n;
  d17 u(p, n);
endmodule
module d17(p, n);
  inout p, n; electrical p, n;
  d18 u(p, n);
endmodule
module d18(p, n);
  inout p, n; electrical p, n;
  d19 u(p, n);
endmodule
module d19(p, n);
  inout p, n; electrical p, n;
  d20 u(p, n);
endmodule
module d20(p, n);
  inout p, n; electrical p, n;
  d21 u(p, n);
endmodule
module d21(p, n);
  inout p, n; electrical p, n;
  d22 u(p, n);
endmodule
module d22(p, n);
  inout p, n; electrical p, n;
  d23 u(p, n);
endmodule
module d23(p, n);
  inout p, n; electrical p, n;
  d24 u(p, n);
endmodule
module d24(p, n);
  inout p, n; electrical p, n;
  d25 u(p, n);
endmodule
module d25(p, n);
  inout p, n; electrical p, n;
  d26 u(p, n);
endmodule
module d26(p, n);
  inout p, n; electrical p, n;
  d27 u(p, n);
endmodule
module d27(p, n);
  inout p, n; electrical p, n;
  d28 u(p, n);
endmodule
module d28(p, n);
  inout p, n; electrical p, n;
  d29 u(p, n);
endmodule
module d29(p, n);
  inout p, n; electrical p, n;
  d30 u(p, n);
endmodule
module d30(p, n);
  inout p, n; electrical p, n;
  d31 u(p, n);
endmodule
module d31(p, n);
  inout p, n; electrical p, n;
  d32 u(p, n);
endmodule
module d32(p, n);
  inout p, n; electrical p, n;
  d33 u(p, n);
endmodule
module d33(p, n);
  inout p, n; electrical p, n;
  d34 u(p, n);
endmodule
module d34(p, n);
  inout p, n; electrical p, n;
  d35 u(p, n);
endmodule
module d35(p, n);
  inout p, n; electrical p, n;
  d36 u(p, n);
endmodule
module d36(p, n);
  inout p, n; electrical p, n;
  d37 u(p, n);
endmodule
module d37(p, n);
  inout p, n; electrical p, n;
  d38 u(p, n);
endmodule
module d38(p, n);
  inout p, n; electrical p, n;
  d39 u(p, n);
endmodule
module d39(p, n);
  inout p, n; electrical p, n;
  d40 u(p, n);
endmodule
module d40(p, n);
  inout p, n; electrical p, n;
  d41 u(p, n);
endmodule
module d41(p, n);
  inout p, n; electrical p, n;
  d42 u(p, n);
endmodule
module d42(p, n);
  inout p, n; electrical p, n;
  d43 u(p, n);
endmodule
module d43(p, n);
  inout p, n; electrical p, n;
  d44 u(p, n);
endmodule
module d44(p, n);
  inout p, n; electrical p, n;
  d45 u(p, n);
endmodule
module d45(p, n);
  inout p, n; electrical p, n;
  d46 u(p, n);
endmodule
module d46(p, n);
  inout p, n; electrical p, n;
  d47 u(p, n);
endmodule
module d47(p, n);
  inout p, n; electrical p, n;
  d48 u(p, n);
endmodule
module d48(p, n);
  inout p, n; electrical p, n;
  d49 u(p, n);
endmodule
module d49(p, n);
  inout p, n; electrical p, n;
  d50 u(p, n);
endmodule
module d50(p, n);
  inout p, n; electrical p, n;
  d51 u(p, n);
endmodule
module d51(p, n);
  inout p, n; electrical p, n;
  d52 u(p, n);
endmodule
module d52(p, n);
  inout p, n; electrical p, n;
  d53 u(p, n);
endmodule
module d53(p, n);
  inout p, n; electrical p, n;
  d54 u(p, n);
endmodule
module d54(p, n);
  inout p, n; electrical p, n;
  d55 u(p, n);
endmodule
module d55(p, n);
  inout p, n; electrical p, n;
  d56 u(p, n);
endmodule
module d56(p, n);
  inout p, n; electrical p, n;
  d57 u(p, n);
endmodule
module d57(p, n);
  inout p, n; electrical p, n;
  d58 u(p, n);
endmodule
module d58(p, n);
  inout p, n; electrical p, n;
  d59 u(p, n);
endmodule
module d59(p, n);
  inout p, n; electrical p, n;
  d60 u(p, n);
endmodule
module d60(p, n);
  inout p, n; electrical p, n;
  d61 u(p, n);
endmodule
module d61(p, n);
  inout p, n; electrical p, n;
  d62 u(p, n);
endmodule
module d62(p, n);
  inout p, n; electrical p, n;
  d63 u(p, n);
endmodule
module d63(p, n);
  inout p, n; electrical p, n;
  d64 u(p, n);
endmodule
module d64(p, n);
  inout p, n; electrical p, n;
  d65 u(p, n);
endmodule
module d65(p, n);
  inout p, n; electrical p, n;
  analog begin
    `CHECK("a 65-level instance tree elaborates and runs", V(p, n), 0.5, 1e-15);
    I(p,n) <+ V(p,n);
  end
endmodule
