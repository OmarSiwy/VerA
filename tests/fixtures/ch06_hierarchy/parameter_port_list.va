// §6.2: "The OPTIONAL LIST OF PARAMETER DEFINITIONS shall specify an ordered list
// of the parameters for the module. ... The order used in defining the list of
// parameters in the module_parameter_port_list and in the list of ports can be
// significant when instantiating the module (see 6.2.2)." Annex A.1.2 gives the
// form: `module_keyword module_identifier [ module_parameter_port_list ]
// list_of_ports ;`. It is a definition form the LRM provides, so refusing it is
// not conformance and this is a run fixture, not the `//! reject` it used to be.
//
// This is the one file in the group that needs NO instantiation to be meaningful:
// a parameter declared in the port list is an ordinary parameter of the module,
// with the same default and the same §9.19 status as one declared in the body.
// That is exactly what is asserted — a compiler that parsed the header but forgot
// to install the defaults, or that treated a header parameter as pre-overridden,
// fails here without any hierarchy being involved.
//
// The digits: gain = 2.0 and enabled = 1 are the declared defaults, nothing
// overrides them, so $param_given is 0 for gain. With p = 0.75 V and n = 0.25 V,
// V(p,n) = 0.5 and the contribution is 1 ? 2.0 * 0.5 : 0.0 = 1.0, exact in binary.
//
//! lrm 6.2
//! bias V(p) = 0.75, V(n) = 0.25
//! xfail VerA's parser accepts no module_parameter_port_list; the `#` after the module identifier dies at E0207 "unexpected token: found `#`"
`include "check.vh"
module ch6_parameter_port_list #(
  parameter real gain = 2.0,
  parameter integer enabled = 1
)(p, n);
  inout p, n; electrical p, n;
  analog begin
    `CHECKX("a parameter declared in the port list keeps its default", gain, 2.0);
    `CHECKI("and so does the second one, in declaration order", enabled, 1);
    `CHECKI("nothing overrode it, so $param_given is 0", $param_given(gain), 0);
    `CHECKX("it is an ordinary parameter in an expression", (enabled ? gain : 0.0) * V(p, n), 1.0);
    I(p, n) <+ (enabled ? gain : 0.0) * V(p, n);
  end
endmodule
