// §6.3.2: "The order of the assignments shall follow the order of declaration
// of the parameters within the module. ... To assign values to a subset, the
// declarations of those parameters shall precede the declarations of the
// remaining parameters." §6.3.2 also: "It is not necessary to assign values to
// all parameters, but the left-most parameter assignment(s) cannot be skipped."
//
// The child declares a, b, c in that order. The instance writes `#(3.0)`: one
// ordered value, which binds to the left-most declared parameter a. b and c are
// not assigned and keep their defaults. The counts are deliberately distinct
// (a = 3.0, b = 2.0, c = 4.0) so a list that bound the value to b or walked the
// whole declaration list cannot land on the same answer.
//
// BY HAND: a = 3, b = 2, c = 4, sum = 9; with V(p) = 0.5 the child stamps 4.5.
//
// reject_6_3_2_ordered_override_skips_leftmost.va is the refused form, `#(,
// 4.0)`, which skips the left-most slot in order to reach b.
//
//! lrm 6.3.2
//! lrm 6.3.2:2
//! lrm 6.3.2:1002
//! bias V(p) = 0.5
//! checks 4
`include "check.vh"
module ch6_partial_top(p);
  inout p; electrical p;
  ch6_partial_kid #(3.0) u(p);
endmodule

module ch6_partial_kid(p);
  inout p; electrical p;
  parameter real a = 1.0;
  parameter real b = 2.0;
  parameter real c = 4.0;
  analog begin
    `CHECKX("the one ordered value binds the left-most parameter a", a, 3.0);
    `CHECKX("the unassigned parameter b keeps its default", b, 2.0);
    `CHECKX("the unassigned parameter c keeps its default", c, 4.0);
    `CHECKX("so the child stamps (3 + 2 + 4) * 0.5", (a + b + c) * V(p), 4.5);
    I(p) <+ (a + b + c) * V(p);
  end
endmodule
