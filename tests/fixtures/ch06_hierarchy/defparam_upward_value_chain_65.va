// IEEE 1364-2005 12.8.1 b): "any defparam statement whose target can be
// resolved within the hierarchy elaborated so far must have its target
// resolved and its value applied", and 12.2.1 lets the value read
// "references to parameters ... declared in the same module as the defparam
// statement". AMS 6.3.1 inherits defparam.
//
// THE DESIGN. The top instantiates u (a dpv_leaf) and then w (a dpv_writer).
// w's defparam sets u.g, which the walk reaches before w, to w's p65, and w's
// parameters form a chain: p0 = 1.0, p(k) = p(k-1) + 1.0. Applied before w
// is elaborated, the value reads w.p65, which is replaced by its value, which
// reads w.p64, and so on: 65 replacements to reach a value with no parameter
// left in it. Until 2026-10-15 VerA stopped after 64 and refused the
// defparam as a cycle (E0907); a cycle is now found as one
// (defparam_upward_value_cycle_rejected.va), and any chain without one is
// followed to its end.
//
// BY HAND. p(k) = 1.0 + k, so p65 = 66.0, exact in binary: u.g = 66.0.
//
//! lrm 6.3.1
//! inherited IEEE 1364-2005 12.2.1 12.8.1
//! bias V(p) = 0.5
//! checks 1
`include "check.vh"
module defparam_upward_value_chain_65(p);
  inout p; electrical p;
  dpv_leaf u(p);
  dpv_writer w(p);
  analog begin
    `CHECKX("u.g is w.p65 after 65 replacements", u.g, 66.0);
    I(p) <+ 0.0;
  end
endmodule
module dpv_leaf(c);
  inout c; electrical c;
  parameter real g = 0.0;
  analog I(c) <+ g * V(c);
endmodule
module dpv_writer(c);
  inout c; electrical c;
  parameter real p0 = 1.0;
  parameter real p1 = p0 + 1.0;
  parameter real p2 = p1 + 1.0;
  parameter real p3 = p2 + 1.0;
  parameter real p4 = p3 + 1.0;
  parameter real p5 = p4 + 1.0;
  parameter real p6 = p5 + 1.0;
  parameter real p7 = p6 + 1.0;
  parameter real p8 = p7 + 1.0;
  parameter real p9 = p8 + 1.0;
  parameter real p10 = p9 + 1.0;
  parameter real p11 = p10 + 1.0;
  parameter real p12 = p11 + 1.0;
  parameter real p13 = p12 + 1.0;
  parameter real p14 = p13 + 1.0;
  parameter real p15 = p14 + 1.0;
  parameter real p16 = p15 + 1.0;
  parameter real p17 = p16 + 1.0;
  parameter real p18 = p17 + 1.0;
  parameter real p19 = p18 + 1.0;
  parameter real p20 = p19 + 1.0;
  parameter real p21 = p20 + 1.0;
  parameter real p22 = p21 + 1.0;
  parameter real p23 = p22 + 1.0;
  parameter real p24 = p23 + 1.0;
  parameter real p25 = p24 + 1.0;
  parameter real p26 = p25 + 1.0;
  parameter real p27 = p26 + 1.0;
  parameter real p28 = p27 + 1.0;
  parameter real p29 = p28 + 1.0;
  parameter real p30 = p29 + 1.0;
  parameter real p31 = p30 + 1.0;
  parameter real p32 = p31 + 1.0;
  parameter real p33 = p32 + 1.0;
  parameter real p34 = p33 + 1.0;
  parameter real p35 = p34 + 1.0;
  parameter real p36 = p35 + 1.0;
  parameter real p37 = p36 + 1.0;
  parameter real p38 = p37 + 1.0;
  parameter real p39 = p38 + 1.0;
  parameter real p40 = p39 + 1.0;
  parameter real p41 = p40 + 1.0;
  parameter real p42 = p41 + 1.0;
  parameter real p43 = p42 + 1.0;
  parameter real p44 = p43 + 1.0;
  parameter real p45 = p44 + 1.0;
  parameter real p46 = p45 + 1.0;
  parameter real p47 = p46 + 1.0;
  parameter real p48 = p47 + 1.0;
  parameter real p49 = p48 + 1.0;
  parameter real p50 = p49 + 1.0;
  parameter real p51 = p50 + 1.0;
  parameter real p52 = p51 + 1.0;
  parameter real p53 = p52 + 1.0;
  parameter real p54 = p53 + 1.0;
  parameter real p55 = p54 + 1.0;
  parameter real p56 = p55 + 1.0;
  parameter real p57 = p56 + 1.0;
  parameter real p58 = p57 + 1.0;
  parameter real p59 = p58 + 1.0;
  parameter real p60 = p59 + 1.0;
  parameter real p61 = p60 + 1.0;
  parameter real p62 = p61 + 1.0;
  parameter real p63 = p62 + 1.0;
  parameter real p64 = p63 + 1.0;
  parameter real p65 = p64 + 1.0;
  defparam defparam_upward_value_chain_65.u.g = p65;
endmodule
