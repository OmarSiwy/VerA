// §6.3.1: "Using the defparam statement, parameter values can be changed in any
// module instance throughout the design using the hierarchical name of the
// parameter." §6.3 lists it as one of the three ways to alter a parameter value,
// and §9.19 names it explicitly as an override that makes $param_given return 1.
// So the construct is required, and this file is a run fixture rather than the
// `//! reject` it used to be — written that way it asked a conforming compiler
// for a diagnostic the LRM never authorized.
//
// §6.3 also fixes the precedence, and that is what makes this fixture more than a
// spelling test: "If a defparam assignment conflicts with a module instance
// parameter, the parameter in the module shall take the value specified by the
// defparam." The instance below overrides gain to 2.0 inline AND a defparam
// overrides it to 5.0, so 5.0 is the only conforming answer; a compiler that
// applied them in source order, or that let the inline value win, reports 2.0.
//
// The right-hand side is a constant expression over parameters "declared in the
// same module as the defparam statement" (§6.3.1), which `scale` is: 2.5 * 2.0 =
// 5.0, exact in binary. With V(p,n) = 0.5 the child stamps 5.0 * 0.5 = 2.5.
//
//! lrm 6.3.1
//! lrm 6.3
//! bias V(p) = 0.75, V(n) = 0.25
//! xfail VerA compiles one flat module, so the instantiation the defparam targets is refused first, at E0204 "module instantiation is not supported"; a bare defparam is E0205
`include "check.vh"
module ch6_defparam(p, n);
  inout p, n; electrical p, n;
  parameter real scale = 2.5;
  ch6_dp_child #(.gain(2.0)) u(p, n);
  defparam u.gain = scale * 2.0;
endmodule

module ch6_dp_child(a, b);
  inout a, b; electrical a, b;
  parameter real gain = 1.0;
  analog begin
    `CHECKX("a defparam beats a conflicting instance parameter assignment", gain, 5.0);
    `CHECKI("a defparam is an override for $param_given", $param_given(gain), 1);
    `CHECKX("so the child stamps the defparam's gain", gain * V(a, b), 2.5);
    I(a, b) <+ gain * V(a, b);
  end
endmodule
