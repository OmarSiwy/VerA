// §6.4.2 selection rule 2: "The parameters of the paramset, with overrides and
// defaults, shall all be within the allowed ranges specified in the paramset
// parameter declaration." Bin A writes its upper bound as `3 % 2`.
//
// §4.2.4: "The modulus operator, (for example a % b), gives the remainder when
// the first operand is divided by the second" — 3 divided by 2 leaves 1. Bin
// A's range is [0:1].
//
// THE NUMBERS. The instance overrides x = 7.0. 7.0 is not in [0:1], and it is
// in bin B's [5:10], so exactly one paramset survives rule 2: B, which writes
// `.tag = 2`. A folder that declines `%` cannot judge bin A at all; if that
// reads as "admits", BOTH bins survive, every tie-break sees two paramsets
// with the same override set, and §6.4.2's "shall be an error" applies.
//
// GROUND TRUTH before the shared constant kernel: exactly that — E0914, "2
// paramsets ... are still applicable" (audit F13, probe ps3). The elaboration
// folder knew + - * / and nothing else.
//
//! lrm 6.4.2
//! lrm 6.4.2:4
//! lrm 4.2.4
//! bias V(a) = 0.5
`include "check.vh"
module ch6_ps_mod_top(a, b);
  inout a, b; electrical a, b;
  ch6_ps_mod #(.x(7.0)) u(a, b);
endmodule

paramset ch6_ps_mod ch6_ps_mod_core;   // bin A: x in [0:3 % 2], which is [0:1]
  parameter real x = 0.5 from [0:3 % 2];
  .x = x; .tag = 1;
endparamset

paramset ch6_ps_mod ch6_ps_mod_core;   // bin B: x in [5:10]
  parameter real x = 7.0 from [5:10];
  .x = x; .tag = 2;
endparamset

module ch6_ps_mod_core(p, n);
  inout p, n; electrical p, n;
  parameter real x = 9.0;
  parameter integer tag = 0;
  analog begin
    `CHECKI("7.0 is outside [0:3 % 2] = [0:1] and inside [5:10]: bin B", tag, 2);
    `CHECKX("and the override reaches the module", x, 7.0);
    I(p, n) <+ V(p, n);
  end
endmodule
