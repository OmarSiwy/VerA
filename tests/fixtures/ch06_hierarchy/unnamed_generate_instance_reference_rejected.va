// §6.6.2 Conditional generate constructs: "If the selected generate block is
// named, its name declares a generate block instance and is the name for the
// scope it creates. Normal rules for hierarchical naming apply. If the
// generate block selected for instantiation is not named, it still creates a
// scope; but the declarations within it cannot be referenced using
// hierarchical names other than from within the hierarchy instantiated by the
// generate block itself." §6.6.3 gives the unnamed block the name `genblk1`
// (the first generate construct of the scope) only "by which external
// interfaces can refer to it": it "has no name that can be used in a
// hierarchical name".
//
// rc_generate_block_instance_name.va with one change: the block is unnamed,
// so the instance is reached as `genblk1.u1.gain` from the module's analog
// block, which is outside the generate block. That is the reference §6.6.2
// forbids, and VerA refuses it by name (E0998). Two legal neighbours: one
// names the block `g1` and reads `g1.u1.gain` = 2.0, which §6.6.2's "normal
// rules for hierarchical naming" allow; the other reads `u1.gain` from within
// the unnamed block.
//
//! lrm 6.6.2
//! lrm 6.6.2:1004
//! lrm 6.6.1:1004
//! lrm 6.6.3
//! reject-only E0998
//! neighbour rc_generate_block_instance_name.va
//! neighbour unnamed_generate_reference_from_within.va
`include "check.vh"
module ch6_gen_unnamed_leaf(a, b);
  inout a, b;
  electrical a, b;
  parameter real gain = 1.0;
  analog I(a, b) <+ gain * V(a, b);
endmodule

module ch6_gen_unnamed_top(p, n);
  inout p, n;
  electrical p, n;
  parameter integer big = 1;
  if (big) begin
    ch6_gen_unnamed_leaf #(.gain(2.0)) u1(p, n);
  end
  analog begin
    `CHECKX("an unnamed block's instance is not reachable as genblk1.u1", genblk1.u1.gain, 2.0);
    I(p, n) <+ 0.0;
  end
endmodule
