// §6.5.7.1 "A scalar port can be connected to a scalar net and a vector port
// can be connected to a vector net or concatenated net expression of the
// matching width. The sizes of the ports and net must match."
//
// The positive half, for the third legal shape the sentence names: a vector
// port on a CONCATENATED net expression of matching width. The vector-net and
// scalar shapes are matching_size_vector_net.va (which passes), kept separate
// so this file's xfail cannot hide them; lrm_6_5_7_1.va pins the refusal of a
// mismatch.
//
//   u_cat   2-bit port `v`  <- concatenation {s1, s0} of two scalars
//   u_cat   scalar port `c` <- the parent's scalar `p`
//
// DERIVATION. The child DRIVES each port bit with a distinct potential against
// `c`: V(v[1], c) <+ 0.5 and V(v[0], c) <+ 0.25. The parent pins p = 0.125 and
// leaves its own nets to the device (`//! solve`), then reads them back — so
// what it reads is decided by which net each port bit was bound to.
//
// Port bit order follows IEEE 1364 §12.3.9.2, which §6.5.7 inherits: a `[1:0]`
// port connected to a 2-bit expression binds its MSB to the expression's MSB.
// So s1 carries v[1] and s0 carries v[0]:
//
//   V(s1) = 0.125 + 0.5  = 0.625
//   V(s0) = 0.125 + 0.25 = 0.375
//
// Both dyadic, so exact. A reversed concatenation order swaps 0.625 and 0.375.
//
//! lrm 6.5.7.1
//! bias V(p) = 0.125
//! solve
//! xfail VerA refuses a concatenation as a port connection (E0906 "a port connection must be a net reference"); §6.5.7.1 names a "concatenated net expression of the matching width" as a legal actual for a vector port
`include "check.vh"
module ch6_matching_size_concat_parent(p);
  inout p;
  electrical p;
  electrical s1, s0;

  ch6_matching_size_concat_child u_cat({s1, s0}, p);

  analog begin
    `CHECKX("§6.5.7.1 concatenation {s1, s0}: the port MSB binds s1", V(s1), 0.625);
    `CHECKX("§6.5.7.1 concatenation {s1, s0}: the port LSB binds s0", V(s0), 0.375);
  end
endmodule

module ch6_matching_size_concat_child(v, c);
  inout [1:0] v;
  inout c;
  electrical [1:0] v;
  electrical c;
  analog begin
    V(v[1], c) <+ 0.5;
    V(v[0], c) <+ 0.25;
  end
endmodule
