// §6.4.2 selection rule 2: "The parameters of the paramset, with overrides and
// defaults, shall all be within the allowed ranges specified in the paramset
// parameter declaration." A range bound is a constant expression (A.2.5's
// `value_range_expression`), and bin A writes its lower bound as `1/2`.
//
// §4.2.1.3: "If either operand is real, the other operand is converted to
// real" — neither is, so `/` is integer division, and §4.2.4: "Integer
// division truncates any fractional part toward zero (0)." Bin A's range is
// [0:1], not [0.5:1].
//
// THE NUMBERS. The instance overrides x = 0.0. 0.0 is in [0:1], so bin A
// admits it; bin B's [-1:-0.5] does not. Exactly one paramset survives rule 2:
// A, which writes `.tag = 1`. Under the real reading [0.5:1] NEITHER bin
// admits 0.0, which is §6.4.2's no-applicable-paramset error — so a folder
// that got this wrong does not pick another bin, it refuses the design.
//
// GROUND TRUTH before the shared constant kernel: E0911, for exactly that
// reason (audit F13, probe ps2). Lowering, which judges the chosen paramset's
// range again, already read the bound as 0.
//
//! lrm 6.4.2
//! lrm 6.4.2:4
//! lrm 4.2.4
//! lrm 4.2.1.3
//! bias V(a) = 0.5
`include "check.vh"
module ch6_ps_bound_top(a, b);
  inout a, b; electrical a, b;
  ch6_ps_bound #(.x(0.0)) u(a, b);
endmodule

paramset ch6_ps_bound ch6_ps_bound_core;   // bin A: x in [1/2:1], which is [0:1]
  parameter real x = 0.5 from [1/2:1];
  .x = x; .tag = 1;
endparamset

paramset ch6_ps_bound ch6_ps_bound_core;   // bin B: x in [-1:-0.5]
  parameter real x = -1.0 from [-1:-0.5];
  .x = x; .tag = 2;
endparamset

module ch6_ps_bound_core(p, n);
  inout p, n; electrical p, n;
  parameter real x = 9.0;
  parameter integer tag = 0;
  analog begin
    `CHECKI("0.0 lies in [1/2:1] = [0:1], so bin A is selected", tag, 1);
    `CHECKX("and the override reaches the module", x, 0.0);
    I(p, n) <+ V(p, n);
  end
endmodule
