// LRM 3.4: a parameter that is not overridden at instantiation takes the value
// of the constant expression in its declaration, and 2.6 makes `k` the scale
// factor 10^3 — so `1k` is 1000, not 1 and not 1024. The testbench supplies NO
// override here, so the declaration's default is what the body sees.
//
// With the node held at 2 V, Ohm's law over that default gives
// 2 / 1000 = 0.002 A. Drop the scale factor and the number moves by 1000x.
//
//! lrm 3.4
//! bias V(p) = 2.0
`include "check.vh"
module ch6_parameter(p);
  inout p; electrical p;
  parameter real resistance = 1k from (0:inf);
  analog begin
    `CHECKX("un-overridden parameter takes its declared default, 1k = 1000", resistance, 1000.0);
    `CHECK("Ohm's law over the default resistance", V(p) / resistance, 0.002, 1e-15);
    I(p) <+ V(p) / resistance;
  end
endmodule
