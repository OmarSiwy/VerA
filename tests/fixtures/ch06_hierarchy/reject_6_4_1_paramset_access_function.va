// §6.4.1: "Restrictions on statements in a paramset are similar to those for
// analog functions. Specifically, a paramset: ... Shall not use access
// functions."
//
// The paramset statement `t = V(top_ps_access.p);` uses the access function V.
// Everything else is a legal paramset: a paramset parameter `rr`, a paramset
// variable `t`, and `.r = rr;` assigning the module parameter. Without the
// `t = V(...)` statement the file compiles (probed, as the paramset of this
// shape in the positive §6.4 fixtures does).
//
// VerA accepts this file.
//
//! lrm 6.4.1
//! reject access function
//! xfail VerA accepts a paramset statement `t = V(top_ps_access.p);`; §6.4.1 says a paramset "Shall not use access functions"
`include "disciplines.vams"
module ch6_ps_access_res(p, n);
  inout p, n;
  electrical p, n;
  parameter real r = 1.0;
  analog I(p, n) <+ V(p, n) / r;
endmodule

paramset ch6_ps_access ch6_ps_access_res;
  parameter real rr = 2.0;
  real t;
  t = V(top_ps_access.p);     // illegal: an access function in a paramset
  .r = rr;
endparamset

module top_ps_access(p, n);
  inout p, n;
  electrical p, n;
  ch6_ps_access #(.rr(3.0)) x1(p, n);
endmodule
