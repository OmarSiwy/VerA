// §6.3.6's fourth automatic rule — "Contributions to a branch potential quantity
// using the noise functions shall have the noise power DIVIDED by $mfactor", the
// opposite sense of the flow rule because m devices in parallel divide a series
// noise voltage — IS NOT PINNED BY THIS FILE. The `//! lrm 6.3.6` cite it used to
// carry has been removed rather than left to launder the gap in `--coverage`.
//
// The reasoning is written out once, in mfactor_flow_noise.va, which holds the
// third rule and is the file this one is supposed to be distinguishable from.
// In short: $mfactor is 1.0 here and cannot be moved without an instantiation
// (E0204; `tb.zig` has no directive for it), and §4.6.4 makes the noise power zero
// outside a small-signal noise analysis. 0 == 0*m == 0/m, so multiply, divide and
// "ignore $mfactor" are indistinguishable and the two files assert the same digits.
//
// What IS pinned is Table 9-29's top-level $mfactor of 1.0 and §4.6.4's zero: a
// device that leaked the declared 1e-18 V^2/Hz into the DC solution prints it here.
//
//! lrm 9.18
//! lrm 4.6.4
//! lrm 9.18:1000
`include "check.vh"
module ch6_mfactor_potential_noise(p, n);
  inout p, n; electrical p, n;
  analog begin
    `CHECKX("Table 9-29 fixes the top-level $mfactor at 1.0", $mfactor, 1.0);
    `CHECKX("white_noise returns 0 outside a noise analysis", white_noise(1e-18, "potential_noise"), 0.0);
    V(p, n) <+ white_noise(1e-18, "potential_noise");
  end
endmodule
