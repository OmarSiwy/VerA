// §6.5.7.1 "A scalar port can be connected to a scalar net and a vector port
// can be connected to a vector net or concatenated net expression of the
// matching width. The sizes of the ports and net must match."
//
// The positive half, for two of the three legal shapes the sentence names:
// a vector port on a vector net of matching width, and a scalar port on a
// scalar net. matching_size_concatenation.va is the third shape (a
// concatenated net expression); vector_port_scalar_net_width_mismatch_rejected.va pins the refusal of a mismatch.
//
//   u_vec   2-bit port `v`  <- 2-bit vector net `bus`
//   u_vec   scalar port `c` <- the parent's scalar `p`
//
// DERIVATION. The child DRIVES each port bit with a distinct potential against
// `c`: V(v[1], c) <+ 0.5 and V(v[0], c) <+ 0.25. The parent pins p = 0.125 and
// leaves its own nets to the device (`//! solve`), then reads them back — so
// what it reads is decided by which net each port bit was bound to.
//
// Port bit order follows IEEE 1364 §12.3.9.2, which §6.5.7 inherits: a `[1:0]`
// port connected to a 2-bit expression binds its MSB to the expression's MSB.
// So bus[1] carries v[1] and bus[0] carries v[0]:
//
//   V(bus[1]) = 0.125 + 0.5  = 0.625
//   V(bus[0]) = 0.125 + 0.25 = 0.375
//
// Both dyadic, so exact. A reversed bit order swaps 0.625 and 0.375, and a
// scalar port bound to anything but `p` moves both.
//
//! lrm 6.5.7.1
//! lrm 6.5.7.1:1
//! bias V(p) = 0.125
//! solve
`include "check.vh"
module ch6_matching_size_vector_parent(p);
  inout p;
  electrical p;
  electrical [1:0] bus;

  ch6_matching_size_vector_child u_vec(bus, p);

  analog begin
    `CHECKX("§6.5.7.1 vector port MSB on the vector net's MSB", V(bus[1]), 0.625);
    `CHECKX("§6.5.7.1 vector port LSB on the vector net's LSB", V(bus[0]), 0.375);
  end
endmodule

module ch6_matching_size_vector_child(v, c);
  inout [1:0] v;
  inout c;
  electrical [1:0] v;
  electrical c;
  analog begin
    V(v[1], c) <+ 0.5;
    V(v[0], c) <+ 0.25;
  end
endmodule
