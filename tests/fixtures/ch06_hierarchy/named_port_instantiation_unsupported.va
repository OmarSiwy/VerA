// §6.2.2, named port connection: `named_port_connection ::= . port_identifier (
// [ expression ] )`. The LRM's §6.2.2 example writes `comparator C1(.cout(aa0),
// .inp(in), .inm(aa2));`, so this is legal source a conforming compiler must
// accept — it was a `//! reject` before, which inverted the test.
//
// The connection list is written in DELIBERATELY the wrong textual order:
// `.b(n), .a(p)`. That is what makes this fixture different from its ordered
// sibling module_instantiation_unsupported.va rather than a copy of it. With
// p = 0.75 V and n = 0.25 V, association BY NAME gives the child V(a,b) = +0.5;
// a compiler that ignored the names and fell back on textual position would bind
// a to n and b to p and see -0.5. Both values are exact in binary, so the sign is
// the whole verdict.
//
//! lrm 6.2.2
//! bias V(p) = 0.75, V(n) = 0.25
//! xfail VerA compiles one flat module, so a module instantiation is refused outright at E0204 "module instantiation is not supported"
`include "check.vh"
module ch6_parent_named_port(p, n);
  inout p, n; electrical p, n;
  ch6_np_child u(.b(n), .a(p));
endmodule

module ch6_np_child(a, b);
  inout a, b; electrical a, b;
  analog begin
    `CHECKX("the name binds the port, not the position in the list", V(a, b), 0.5);
    `CHECKI("a port named in the list is connected", $port_connected(a), 1);
    `CHECKI("and so is the one written first", $port_connected(b), 1);
    I(a, b) <+ V(a, b);
  end
endmodule
