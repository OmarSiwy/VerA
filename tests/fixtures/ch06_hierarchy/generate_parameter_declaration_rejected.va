// §6.6, verbatim: "A generate block is a collection of one or more module items. A
// generate block MAY NOT CONTAIN PORT DECLARATIONS, PARAMETER DECLARATIONS, specify
// blocks, or specparam declarations. All other module items, including other
// generate constructs, are allowed in a generate block."
//
// Syntax 6-8 says it a second way: `module_or_generate_item` admits
// `local_parameter_declaration ;` and its `module_or_generate_item_declaration`
// lists net, reg, integer, real, time, realtime, event, genvar, task, function,
// branch and analog function declarations — no `parameter_declaration` and no
// `port declaration` anywhere in either production.
//
// The reason is elaboration order: a parameter is what a generate scheme is
// allowed to READ (§6.6, "Generate constructs provide the ability for parameter
// values to affect the structure of the model"), so a parameter created BY a
// generate block would be a value the elaborator needs before it exists. A
// localparam has no such problem — it is not overridable — which is why the
// grammar keeps that one and drops this one, and why the fixture is about
// `parameter` specifically. The permitted form is exercised by
// generate_implicit_localparam.va and external_genblk_reference_unsupported.va.
//
// Of the four constructs the sentence forbids, `parameter` is the only one this
// subset can even spell: specify blocks and specparams are digital timing
// constructs outside Verilog-A (Annex C), and a port declaration inside a generate
// block does not reach the rule because the port list it would have to name is not
// in scope. So one declaration is the whole fixture.
//
// No `//! reject <code>`: VerA has no diagnostic here, so there is no code to name.
// `DiagnosticsReported` is the weakest form that still demands a rejection;
// tighten it to the E-code the day one exists.
//
//! lrm 6.6
//! reject DiagnosticsReported
//! xfail VerA accepts a parameter declaration inside a generate block; Syntax 6-8 has no `parameter_declaration` in `module_or_generate_item`
module ch6_generate_parameter_declaration(p);
  inout p; electrical p;
  generate
    if (1) begin : g
      parameter real x = 1.0;
    end
  endgenerate
  analog I(p) <+ V(p);
endmodule
