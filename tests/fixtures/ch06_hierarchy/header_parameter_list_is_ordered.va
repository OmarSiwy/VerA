// §6.2: "The optional list of parameter definitions shall specify an ordered
// list of the parameters for the module. ... The order used in defining these
// lists can be significant when instantiating the module (see 6.2.2)." §6.3.2:
// an ordered override is "assigned in-line during module instantiation in the
// order of their declaration", and "the order of the assignments shall follow
// the order of declaration of the parameters within the module".
//
// The child declares its two parameters ONLY in the header list
// `#(parameter real zeta = 1.0, parameter real alpha = 2.0)`, so the header
// list is the whole of the declaration order. The names are deliberately in
// reverse alphabetical order, so an implementation that ordered parameters by
// name (or by any table that forgot the header's order) binds the values the
// other way round.
//
// BY HAND. The instance writes `#(3.0, 4.0)`. In header order:
//   zeta  = 3.0   (first value, first header parameter)
//   alpha = 4.0   (second value, second header parameter)
// Swapped, zeta would read 4.0 and alpha 3.0. With V(p,n) = 0.75 - 0.25 = 0.5
// the contribution is (zeta - alpha) * V = (3.0 - 4.0) * 0.5 = -0.5, which a
// swap turns into +0.5. All values are exact in binary.
//
//! lrm 6.2
//! lrm 6.2:3
//! lrm 6.3.2
//! lrm 6.3.2:1
//! bias V(p) = 0.75, V(n) = 0.25
//! checks 3
`include "check.vh"
module b4_hpo_top(p, n);
  inout p, n; electrical p, n;
  b4_hpo_child #(3.0, 4.0) u(p, n);
endmodule

module b4_hpo_child #(parameter real zeta = 1.0, parameter real alpha = 2.0) (x, y);
  inout x, y; electrical x, y;
  analog begin
    `CHECKX("the first ordered value binds the first header parameter", zeta, 3.0);
    `CHECKX("the second ordered value binds the second header parameter", alpha, 4.0);
    `CHECKX("so the order-sensitive difference is (3 - 4) * 0.5", (zeta - alpha) * V(x, y), -0.5);
    I(x, y) <+ (zeta - alpha) * V(x, y);
  end
endmodule
