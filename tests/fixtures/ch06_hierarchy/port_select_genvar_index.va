// §6.6.1 a loop generate instantiates its block once per genvar value, and
// within each copy the genvar is a constant (its implicit localparam), so a
// port connection inside the block may select with it: §5.5.2's "The index
// must be a constant expression, though it may include genvar variables". The
// two §6.5.5 forms, by name:
//   g[i].u (.v(r[i]))              a scalar member, i = 0..3
//   h[j].u (.w(q[2*j+1:2*j]))      a sub-range, j = 0..1
//
// Each cell drives its port against the top's p, held at 0.5, a value its
// own override computes from the same genvar:
//   one:  V(v, c) <+ val,  val = 0.25*(i+1)
//   pair: V(w[1], c) <+ hi, V(w[0], c) <+ lo,  hi = 2*j+2, lo = 2*j+1
// The top's nets are solved (`//! solve`), then read. By hand:
//   r[0] = 0.5 + 0.25 = 0.75     q[0] = 0.5 + 1 = 1.5
//   r[1] = 0.5 + 0.5  = 1.0      q[1] = 0.5 + 2 = 2.5
//   r[2] = 0.5 + 0.75 = 1.25     q[2] = 0.5 + 3 = 3.5
//   r[3] = 0.5 + 1.0  = 1.5      q[3] = 0.5 + 4 = 4.5
// (q[2j+1] is the pair's MSB w[1], IEEE 1364-2005 12.3.9.2.) An index read
// before the genvar has its value puts every cell on one element; a reversed
// sub-range swaps each q pair. Dyadic, so exact.
//
//! lrm 6.6.1
//! lrm 6.6.1:1003
//! lrm 5.5.2
//! lrm 5.5.2:1
//! lrm 6.5.5
//! lrm 6.5.5:2
//! bias V(p) = 0.5
//! solve
//! checks 8
`include "check.vh"
module ch6_psel_gen_top(p);
  inout p; electrical p;
  electrical [3:0] r, q;
  genvar i, j;
  generate
    for (i = 0; i < 4; i = i + 1) begin : g
      ch6_psel_gen_one #(.val(0.25 * (i + 1))) u(.v(r[i]), .c(p));
    end
    for (j = 0; j < 2; j = j + 1) begin : h
      ch6_psel_gen_pair #(.hi(2 * j + 2), .lo(2 * j + 1)) u(.w(q[2 * j + 1:2 * j]), .c(p));
    end
  endgenerate
  analog begin
    `CHECKX("g[0].u on r[0]", V(r[0]), 0.75);
    `CHECKX("g[1].u on r[1]", V(r[1]), 1.0);
    `CHECKX("g[2].u on r[2]", V(r[2]), 1.25);
    `CHECKX("g[3].u on r[3]", V(r[3]), 1.5);
    `CHECKX("h[0].u: LSB w[0] on q[0]", V(q[0]), 1.5);
    `CHECKX("h[0].u: MSB w[1] on q[1]", V(q[1]), 2.5);
    `CHECKX("h[1].u: LSB w[0] on q[2]", V(q[2]), 3.5);
    `CHECKX("h[1].u: MSB w[1] on q[3]", V(q[3]), 4.5);
  end
endmodule

module ch6_psel_gen_one(v, c);
  inout v, c; electrical v, c;
  parameter real val = 0.0;
  analog V(v, c) <+ val;
endmodule

module ch6_psel_gen_pair(w, c);
  inout [1:0] w; inout c;
  electrical [1:0] w; electrical c;
  parameter real hi = 0.0, lo = 0.0;
  analog begin
    V(w[1], c) <+ hi;
    V(w[0], c) <+ lo;
  end
endmodule
