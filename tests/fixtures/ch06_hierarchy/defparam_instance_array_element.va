// §6.3.1 defparam meets a §6.2.2 instance array. A.9.3 spells the left-hand
// side: `hierarchical_identifier ::= { identifier [ [ constant_expression ] ]
// . } identifier` — a per-segment index that names ONE element of the array,
// and §6.7's own example reads an element the same way (`adder1[5].sum`). So
// `defparam u[0].g = 5.0;` is grammatical, and it names exactly the flat
// parameter elaboration mints for element 0. VerA used to refuse the `[` with
// a syntax error (E0207), which made every element of an instance array
// unreachable by the one override mechanism §6.3.1 defines for reaching down.
//
// BOTH elements are defparam'd, to the same value, because this suite's CHECK
// carries one want per name and the two elements run the same analog block
// (instance_array_unsupported.va documents the constraint). The value CHANGES:
// the declared default is 9.0 and the defparam says 5.0, so a compiler that
// parsed the path and dropped it, or bound it to nothing, reads 9.0 and fails.
// The second assignment also exercises the comma-separated
// `list_of_defparam_assignments` with an indexed path in non-first position.
//
// With V(p,n) = 0.5 each element stamps 5.0 * 0.5 = 2.5.
//
//! lrm 6.3.1
//! lrm 6.3.1:1001
//! lrm A.9.3
//! lrm A.9.3:1000
//! lrm 6.7:1002
//! bias V(p) = 0.75, V(n) = 0.25
`include "check.vh"
module ch6_dpae_parent(p, n);
  inout p, n; electrical p, n;
  ch6_dpae_kid u[0:1](p, n);
  defparam u[0].g = 5.0, u[1].g = 5.0;
endmodule

module ch6_dpae_kid(a, b);
  inout a, b; electrical a, b;
  parameter real g = 9.0;
  analog begin
    `CHECKX("the defparam reached this array element through its indexed path", g, 5.0);
    `CHECKX("so each element stamps the overridden value", g * V(a, b), 2.5);
    I(a, b) <+ g * V(a, b);
  end
endmodule
