// §6.4.2: "When choosing an appropriate paramset, the following rules shall be
// enforced: ... The local parameters of the paramset, computed from
// parameters, shall be within the allowed ranges specified in the paramset."
//
// Two paramsets named b4_plr_ps over one module:
//   A: parameter l, localparam twice = 2.0 * l from [0:2], sets k = 10.0
//   B: parameter l, no local parameter,                     sets k = 20.0
// The instance overrides l = 1.5, inside both paramsets' range for l.
//
// BY HAND. In A, twice = 2.0 * 1.5 = 3.0, outside [0:2], so A is not
// applicable and B is the only candidate: k = 20.0, and with V(p,n) = 0.5 the
// module stamps 20.0 * 0.5 = 10.0.
//
// Why 10.0 would be wrong: were A's local range ignored, both would be
// applicable, tie on the first tie-break (each has zero un-overridden
// parameters) and A would win the second, "the greatest number of local
// parameters with specified ranges" (1 against 0). So an implementation that
// skips this rule selects A and reads k = 10.0.
//
//! lrm 6.4.2
//! lrm 6.4.2:5
//! bias V(p) = 0.75, V(n) = 0.25
//! checks 2
`include "check.vh"
module b4_plr_top(p, n);
  inout p, n; electrical p, n;
  b4_plr_ps #(.l(1.5)) u(p, n);
endmodule

paramset b4_plr_ps b4_plr_dev;   // A: its local parameter leaves its range at l = 1.5
  parameter real l = 1.0 from (0:inf);
  localparam real twice = 2.0 * l from [0:2];
  .k = 10.0;
endparamset

paramset b4_plr_ps b4_plr_dev;   // B: selected
  parameter real l = 1.0 from (0:inf);
  .k = 20.0;
endparamset

module b4_plr_dev(a, b);
  inout a, b; electrical a, b;
  parameter real k = 9.0;
  analog begin
    `CHECKX("the paramset whose local parameter stays in range is selected", k, 20.0);
    `CHECKX("so the module stamps 20.0 * 0.5", k * V(a, b), 10.0);
    I(a, b) <+ k * V(a, b);
  end
endmodule
