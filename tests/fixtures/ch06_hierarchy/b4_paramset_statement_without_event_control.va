// The legal neighbour of b4_paramset_event_control_rejected.va. §6.4.1: a
// paramset "Can use any statements available for conditional execution (see
// 5.2)", and "Paramset statements may assign values to variables declared in
// the paramset". So a paramset variable assigned inside an unnamed
// `begin ... end` is legal; the only difference from the refused file is the
// `@(initial_step)` event control in front of the assignment.
//
// What is asserted is that the paramset still drives its module: `.k = 2.0`
// replaces the module's default 9.0 (§6.4.1 "used to assign values to the
// parameters of the associated module"), and with V(p,n) = 0.5 the module
// stamps 2.0 * 0.5 = 1.0.
//
//! lrm 6.4.1
//! lrm 6.4.1:1003
//! bias V(p) = 0.75, V(n) = 0.25
//! checks 2
`include "check.vh"
module b4_pec_top(p, n);
  inout p, n; electrical p, n;
  b4_pec_ps u(p, n);
endmodule

paramset b4_pec_ps b4_pec_base;
  real v;
  .k = 2.0;
  begin
    v = 1.0;
  end
endparamset

module b4_pec_base(a, b);
  inout a, b; electrical a, b;
  parameter real k = 9.0;
  analog begin
    `CHECKX("the paramset assigned the module parameter", k, 2.0);
    `CHECKX("so the module stamps 2.0 * 0.5", k * V(a, b), 1.0);
    I(a, b) <+ k * V(a, b);
  end
endmodule
