// §6.2.2: "An expression can be used for supplying a value to a module input
// port if it is a digital port." The converse is the rule's boundary: an
// analog (continuous-discipline) input port is a net segment, and an
// expression is not a net. `u.i` is `electrical`, so `a | b` cannot supply it
// and the connection is E0906, "a port connection must be a net reference".
//
// The neighbour is the legal half: the same expression on a `ddiscrete`
// input, which the flatten synthesizes a net for and drives.
//
//! lrm 6.2.2
//! lrm 6.2.2:1002
//! reject-only E0906
//! neighbour digital_port_expression_actual.va
`include "disciplines.vams"
module ch06_analog_port_expression_actual_rejected(out);
  output out; voltage out;
  reg a, b;
  initial begin
    a = 1'b1;
    b = 1'b0;
  end
  ch06_analog_port_expression_child u(.o(out), .i(a | b));
endmodule

module ch06_analog_port_expression_child(o, i);
  output o; voltage o;
  input i; electrical i;
  analog V(o) <+ 0.0;
endmodule
