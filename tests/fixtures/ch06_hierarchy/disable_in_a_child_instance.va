// A.6.5 `disable hierarchical_block_identifier` inside an instantiated module:
// ch05_analog_behavior/a03_01_disable_resumes_after_the_named_block.va's
// derivation, one level down. Flattening renames the child's block `seg` onto
// the instance path (§6.7), so the disable written inside the child must name
// that same flattened block, or nothing encloses it (E0402).
//
// DERIVATION, with the instance's base = 1:
//
//     x = base                     1
//     begin : seg
//       x = x + 10                 11
//       @(initial_step) disable seg
//       x = x + 100                111   -- skipped when disabled
//     end
//     y = x + 1000
//
//   t = 0     initial_step fires (§5.10.2), the disable runs: x = 11,
//             y = 1011.
//   t = 1n    no event, seg runs to its end: x = 111, y = 1111.
//
//! lrm 5.3
//! lrm 5.10.2
//! lrm 6.7
//! inherited IEEE 1364-2005 10.3
//! analysis tran
//! time 0, 1n
`include "check.vh"
module dic_top(p);
  inout p; electrical p;
  dic_kid #(.base(1.0)) u(p);
endmodule

module dic_kid(a);
  inout a; electrical a;
  parameter real base = 0.0;
  real x, y;
  analog begin
    x = base;
    begin : seg
      x = x + 10.0;
      @(initial_step) disable seg;
      x = x + 100.0;
    end
    y = x + 1000.0;
    `CHECKEQ("the disable skips the rest of the child's seg and only that",
             x, ($abstime == 0.0) ? 11.0 : 111.0, 0.0);
    `CHECKEQ("and control passes out of seg, so the statement after it runs",
             y, ($abstime == 0.0) ? 1011.0 : 1111.0, 0.0);
    I(a) <+ V(a);
  end
endmodule
