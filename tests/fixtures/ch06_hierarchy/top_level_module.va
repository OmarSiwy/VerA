// §6.2.1: "Top-level modules are modules that are included in the source text,
// but do not appear in any module instantiation statement." Nothing in this file
// instantiates ch6_top, so it is the root of the instantiation tree. It gets
// elaborated and simulated anyway — appearing in the source text is the whole
// qualification — and the two things being at the root FIXES are what is asserted
// here. Both are consequences of the definition, not of the harness:
//
//   $mfactor is 1.0. Table 9-29 defines it as "the multiplicity factor specified
//   for the instance (or 1.0, if no override was specified) times the value for
//   the parent module". A top-level module has no instantiation statement, so
//   there is no instance parameter assignment to specify one, and no parent whose
//   value could multiply it. Only 1.0 is available.
//
//   $param_given is 0 for every parameter. §9.19 makes it one "if the parameter
//   was overridden, either by a defparam statement or in a module instance
//   parameter value assignment" — the second is unreachable for a module nothing
//   instantiates, and there is no defparam here. `gain` therefore keeps its
//   declared 2.0, which the contribution below uses.
//
// A compiler that gave a top-level module a parent's $mfactor, or that treated
// declared defaults as overrides, fails these. `gain * V(p)` = 2.0 * 0.375 =
// 0.75, exact in binary; its sibling param_given_absent.va pins the predicate
// itself and this file pins that being top-level is what makes it 0.
//
// The portless form of this module is module_definition.va, which cannot run.
//
//! lrm 6.2.1
//! bias V(p) = 0.375
`include "check.vh"
module ch6_top(p);
  inout p; electrical p;
  parameter real gain = 2.0;
  analog begin
    `CHECKX("a top-level instance has no parent to multiply $mfactor", $mfactor, 1.0);
    `CHECKI("nothing instantiates it, so no parameter can have been overridden", $param_given(gain), 0);
    `CHECKX("so gain keeps its declared default", gain * V(p), 0.75);
    I(p) <+ gain * V(p);
  end
endmodule
