// §6.5.1: "The port expression is optional because ports can be defined which
// do not connect to anything internal to the module." A.1.3 spells both port
// forms with the expression left out:
//
//     port ::= [ port_expression ] | . port_identifier ( [ port_expression ] )
//
// The child below declares `.x()`: the port x exists in the module definition
// and holds its position in the port list, but its expression names no net
// inside the child, so an actual connected to x reaches nothing.
//
// The top connects by order `(n, p, n)`: x takes n and drops it, a takes p,
// b takes n. With V(p) = 1.0 and V(n) = 0.25 the child reads V(a, b) = 0.75.
// A parser that dropped the null port would bind a to n and b to p (the answer
// becomes -0.75); one that kept x as a body net but connected it would read
// the same -0.75 from the other end. The child also stamps I(a, b) <+ V(a, b).
//
//! lrm 6.5.1
//! lrm 6.5.1:1001
//! bias V(p) = 1.0
//! bias V(n) = 0.25
//! checks 2
`include "check.vh"
module ch6_null_kid(.x(), a, b);
  inout a, b;
  electrical a, b;
  analog begin
    `CHECKX("x dropped its actual; a took the first non-null actual p", V(a), 1.0);
    `CHECKX("and b took the last actual n", V(b), 0.25);
    I(a, b) <+ V(a, b);
  end
endmodule

module ch6_null_top(p, n);
  inout p, n;
  electrical p, n;
  ch6_null_kid c1(n, p, n);
  analog I(p) <+ 0.0;
endmodule
