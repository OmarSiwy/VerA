// §6.6: "A generate block may not contain port declarations, parameter
// declarations, specify blocks, or specparam declarations. All other module
// items, including other generate constructs, are allowed." A.1.4
// module_or_generate_item_declaration lists event_declaration, so `event e;`
// inside the if-generate below is legal, and §6.6 makes it a declaration of
// the block's own scope, brought into existence only when the scheme
// selects the block.
//
// The block triggers its own event once at 20 ns and counts it, so `hits` is
// 0 before 20 ns and 1 after. The analog block reads it (§7.3.6.5) at 10 ns
// and 30 ns: 0, then 1. A compiler that dropped the declaration has no event
// for the trigger and the wait to share.
//
// The same file with the block's items moved to module scope passes, so the
// generate block is the only thing under test.
//
//! lrm 6.6
//! analysis tran
//! time 10n, 30n
//! xfail E0235: VerA has no generate scope for an event declaration and refuses it
`timescale 1ns/1ns
`include "disciplines.vams"
`include "check.vh"
module ch6_generate_block_event(p);
  inout p; electrical p;
  integer hits;
  initial hits = 0;
  generate
    if (1) begin : g
      event e;
      initial #20 -> e;
      always @(e) hits = hits + 1;
    end
  endgenerate
  analog begin
    `CHECKEQ("§6.6 the generated event fires once at 20 ns", hits,
             ($abstime >= 20n) ? 1 : 0, 0);
    I(p) <+ V(p);
  end
endmodule
