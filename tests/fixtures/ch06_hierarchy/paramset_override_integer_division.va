// §6.4.2 selection rule 2: "The parameters of the paramset, with overrides and
// defaults, shall all be within the allowed ranges specified in the paramset
// parameter declaration." So the override's VALUE is what selects, and the
// override here is the expression `1/2`.
//
// §4.2.1.3 types it before any range is consulted: "For operands, a common data
// type for each operand is determined before the operator is applied. If either
// operand is real, the other operand is converted to real." Neither is, so `/`
// is integer division, and §4.2.4: "Integer division truncates any fractional
// part toward zero (0)." The override is the integer 0, which the real `x`
// receives as 0.0 (§4.2.1.2).
//
// THE NUMBERS. Bin A admits [0.25:1] and bin B admits [0:0.25). 0.0 lies in B
// only, so rule 2 leaves exactly one paramset — B, which writes `.tag = 2` —
// and no tie-break is reached. Had `1/2` been the real 0.5, A would be the one
// (0.5 is in [0.25:1], not in [0:0.25)), so the two readings differ in the bin,
// not by a tolerance.
//
// GROUND TRUTH before the shared constant kernel: elaboration's range folder
// (`Flatten.constReal`) read `1/2` as 0.5 (audit F13), selected A, and then
// lowering — which already typed the division correctly — refused A's range
// with E0361 ("x is 0"). Both now fold through `frontend/constfold.zig`.
//
//! lrm 6.4.2
//! lrm 6.4.2:4
//! lrm 4.2.4
//! lrm 4.2.1.3
//! lrm 4.2.1.3:1000
//! bias V(a) = 0.5
`include "check.vh"
module ch6_ps_div_top(a, b);
  inout a, b; electrical a, b;
  ch6_ps_div #(.x(1/2)) u(a, b);
endmodule

paramset ch6_ps_div ch6_ps_div_core;   // bin A: x in [0.25, 1]
  parameter real x = 0.5 from [0.25:1];
  .x = x; .tag = 1;
endparamset

paramset ch6_ps_div ch6_ps_div_core;   // bin B: x in [0, 0.25)
  parameter real x = 0.0 from [0:0.25);
  .x = x; .tag = 2;
endparamset

module ch6_ps_div_core(p, n);
  inout p, n; electrical p, n;
  parameter real x = 9.0;
  parameter integer tag = 0;
  analog begin
    `CHECKX("the override 1/2 is integer division, 0", x, 0.0);
    `CHECKI("so bin B, [0:0.25), is the one rule 2 admits", tag, 2);
    I(p, n) <+ V(p, n);
  end
endmodule
