// §6.4.1: "The special syntax `.module_parameter_identifier =
// paramset_constant_expression ;` is used to assign values to the parameters of
// the associated module. The right-hand side can be composed of numbers,
// parameters, and HIERARCHICAL OUT-OF-MODULE REFERENCES TO LOCAL PARAMETERS OF A
// DIFFERENT MODULE. Hierarchical out-of-module references to non-local
// parameters are disallowed."
//
// The clause's own worked example is exactly this shape: a `semicoCMOS` module
// holding `localparam real tox = 3e-8;` plus two statistical offsets, read from a
// paramset as `.tox = semicoCMOS.tox + semicoCMOS.dtox_g + semicoCMOS.dtox_mm;`.
// `semicoCMOS` is a library module that nothing instantiates — it exists to own
// the process constants — so the reference resolves against the MODULE's
// localparam table and not against an instance path. This file is that example
// with the two random draws removed, so the only rule under test is the
// out-of-module read.
//
// THE NUMBER. `h01_lib.tox` is a localparam with value 3.0 and the paramset's own
// `w` keeps its default 2.0, so
//
//     k = h01_lib.tox * w = 3.0 * 2.0 = 6.0
//
// and the contribution is k*V = 6.0 * 0.5 = 3.0 A. Both factors are powers-of-two
// exact, so the product is exact in binary and `CHECKX` is the right macro.
//
// THE PROHIBITION IS NOT TESTED HERE. `h01_lib.tox` is a `localparam`; the
// clause's next sentence refuses the same syntax over a plain `parameter`, and a
// fixture for that would be a rejection, which this row keeps to a minimum. It is
// listed in tests/fixtures/ch06_hierarchy/h01_SPEC.md at 8b1514d4 as not covered.
//
// GROUND TRUTH TODAY: green, both checks. It was refused with E0901,
// "`h01_lib.tox` names nothing in the elaborated design": `Flatten` resolved a
// dotted name through the INSTANCE tree (`flatName`) and an uninstantiated
// library module has no path in it, so the one form §6.4.1 explicitly permits
// was the one form that could not resolve. `paramsetOomr` substitutes the
// declared default instead, in the `in_paramset` context only.
//
//! lrm 6.4.1
//! lrm 6.4.1:1001
//! bias V(p) = 0.5
`include "check.vh"
module h01_oomr(p, n);
  inout p, n; electrical p, n;
  h01_oomr_ps u(p, n);
endmodule

paramset h01_oomr_ps h01_oomr_base;
  parameter real w = 2.0 from (0:inf);
  .k = h01_lib.tox * w;
endparamset

module h01_oomr_base(a, b);
  inout a, b; electrical a, b;
  parameter real k = 0.0;
  analog begin
    `CHECKX("the paramset read a localparam of another module", k, 6.0);
    `CHECKX("so the current is 6.0 * 0.5 V", k * V(a, b), 3.0);
    I(a, b) <+ k * V(a, b);
  end
endmodule

// The process-constant library module. Nothing instantiates it — §6.4.1's own
// example does the same with `semicoCMOS`.
module h01_lib();
  localparam real tox = 3.0;
endmodule
