// §6.6: a generate block "brings the objects ... within the block into
// existence", and §6.6.3 / IEEE 1364-2005 §12.4.3 make each block its own
// scope, so two blocks may each declare a `localparam real ww`. Inside each
// block `ww` is that block's own.
//
// VerA used to give every block's local parameter the same device field, so
// two declarations of `ww` were two `Model` fields named `ww` and the
// generated device did not compile.
//
// DERIVATION. sel = 1 (default). Construct 1 takes its then-arm `on`
// (ww = 2.0); construct 2, `if (!sel)`, takes its else-arm `alt` (ww = 5.0).
// The unselected arms declare ww = 3.0 and ww = 7.0. Each selected arm reads
// its own: 2.0 and 5.0. A shared `ww` would make at least one read wrong.
//
// No invalid form: §12.4.3's clash rule is about two blocks of one NAME in a
// scope (generate_block_name_collision_rejected.va), not about locals.
//
//! lrm 6.6
//! lrm 6.6.3
//! inherited IEEE 1364-2005 12.4.3
//! bias V(p) = 0.5
//! checks 2
`include "check.vh"
module gbl_top(p);
  inout p; electrical p;
  parameter integer sel = 1;
  if (sel) begin : on
    localparam real ww = 2.0;
    analog `CHECKX("the selected then-arm reads its own ww", ww, 2.0);
  end else begin : off
    localparam real ww = 3.0;
    analog `CHECKX("unselected arm", ww, 3.0);
  end
  if (!sel) begin : other
    localparam real ww = 7.0;
    analog `CHECKX("unselected arm", ww, 7.0);
  end else begin : alt
    localparam real ww = 5.0;
    analog `CHECKX("the selected else-arm of a second construct reads its own ww", ww, 5.0);
  end
  analog I(p) <+ V(p);
endmodule
