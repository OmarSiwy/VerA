// §6.7.1: "Hierarchical reference of an implicit net is allowed when the
// referenced net is first coerced to a specific discipline."
//
// `implicit_link` is never declared in the top: it exists only as the actual
// on `u`'s first port (§3.6.5's structural implicit net). The child's port is
// `electrical`, so elaboration gives the implicit net that discipline — the
// coercion the sentence asks for — and the hierarchical name `u.a`, which
// designates the child's port, resolves to that parent net (§6.7.1: a port
// still has a hierarchical name that may be probed).
//
// The child holds V(a, b) at 1.25 and the top's n is biased to 0, so the probe
// `V(u.a, n)` reads exactly 1.25. An implementation that created the implicit
// net without resolving the port's discipline cannot read the probe at all;
// one that resolved `u.a` to a fresh node reads 0. The mirror fixture
// uncoerced_implicit_net_hierarchical_reference_rejected.va points an
// undeclared actual at a port with NO discipline and is refused.
//
//! lrm 6.7.1
//! lrm 6.7.1:1001
//! bias V(n) = 0.0
//! solve
//! checks 1
`include "check.vh"
module ch6_implicit_probe_top(n);
  inout n; electrical n;
  ch6_implicit_probe_kid u(implicit_link, n);
  analog begin
    `CHECKX("the hierarchical name reaches the parent's coerced implicit net",
            V(ch6_implicit_probe_top.implicit_link, n), 1.25);
  end
endmodule

module ch6_implicit_probe_kid(a, b);
  inout a, b; electrical a, b;
  analog V(a, b) <+ 1.25;
endmodule
