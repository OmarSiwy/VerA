// §6.3.4 parameter dependence: a parameter may be defined by an expression over
// other parameters, and "an update of gate_width, whether by a defparam
// statement or in an instantiation statement ... automatically updates
// gate_cap". The chain here is two deep — area depends on width, conductance
// depends on area — so an implementation that folded the dependents against the
// DECLARED default instead of the OVERRIDDEN value fails the lines below.
//
// The override is width = 3u, hence
//   area        = 3e-6 * 3e-6 = 9e-12      (m^2)
//   conductance = 9e-12 / 1e-6 = 9e-6      (S)
// Both wants are the rounded decimal; the double products are
// 9.000000000000001e-12 and 9.000000000000002e-6, which is why these are
// CHECKR and not CHECKX. Both are 1 ulp out — relative error 1.795e-16 and
// 1.882e-16 — so 1e-15 is the tolerance the arithmetic earns, the same one the
// exact `width` line uses. Anything looser stops being a check.
//
//! lrm 6.3.4
//! lrm 6.3.4:1000
//! param width = 3u
//! bias V(p) = 2.0
`include "check.vh"
module ch6_dependent(p);
  inout p; electrical p;
  parameter real width = 2u;
  parameter real area = width * width;
  parameter real conductance = area / 1u;
  analog begin
    `CHECKR("width takes the override, not its 2u default", width, 3e-6, 1e-15);
    `CHECKR("area re-derives from the overridden width", area, 9e-12, 1e-15);
    `CHECKR("conductance re-derives through two levels", conductance, 9e-6, 1e-15);
    I(p) <+ conductance * V(p);
  end
endmodule
