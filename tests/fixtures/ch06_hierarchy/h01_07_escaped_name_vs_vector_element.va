// An escaped identifier that spells a bit-select is a DIFFERENT object from the
// bit-select it spells.
//
// §2.8.1: "Escaped identifiers shall start with the backslash character (\) and
// end with white space ... They provide a means of including any of the printable
// ASCII characters in an identifier. Neither the leading backslash character nor
// the terminating white space is considered to be part of the identifier." So
// `\bus[0] ` declares a SCALAR net whose name happens to be the five characters
// `bus[0]`, brackets included.
//
// §3.6.3 declares the other one: "If a range is specified for a net, the net is
// called a vector net; otherwise it is called a scalar net." The declaration
// `electrical [0:1] bus;` declares ONE name, `bus`; `bus[0]` in an expression is a
// select on it, and the spelling `bus[0]` a simulator prints for that element is a
// GENERATED name, not a declaration in the module's namespace (§3.13.3).
//
// Two declarations, two nets, no collision. A compiler that keys its net table on
// the printed form merges them, and this circuit is built so that the merge is a
// wrong NUMBER and not a diagnostic-shaped question:
//
//   a is driven to 3 V.
//   a --1k-- bus[0] --1k-- gnd          ->  V(bus[0])  = 3 * (1/2)   = 1.5 V
//   a --1k-- \bus[0] --2k-- gnd         ->  V(\bus[0]) = 3 * (2/3)   = 2.0 V
//
// Merged onto one node the four resistors are in parallel: 2 mS up to `a` and
// 1.5 mS down to ground, so the shared node sits at 3 * (2/3.5) = 1.714… V and
// BOTH assertions miss. The two dividers are deliberately different ratios — a
// pair of 1:1 dividers would read 1.5 V either way and prove nothing.
//
// bus[1] carries a 1k to ground of its own so the unused half of the vector is
// not a floating node in the solve; nothing is asserted about it.
//
// GROUND TRUTH TODAY: green, both checks, and the solve carries two separate
// unknowns for the two nets. It was refused with E0902, "`bus[0]` is already of
// discipline `electrical`" — the escaped scalar was read as a second discipline
// declaration of the vector's element, because the node table was keyed on the
// printed form. `Lower.netKey` discriminates at the TOKEN, which is the only
// place the backslash still exists, and puts it back for a net name ending in
// `]` so the key cannot collide with a generated element spelling.
//
//! lrm 2.8.1
//! lrm 2.8.1:1
//! lrm 3.6.3
//! analysis dc
//! solve
`include "check.vh"
module h01_escaped_vs_element(a);
  inout a; electrical a;
  electrical [0:1] bus;
  electrical \bus[0] ;
  analog begin
    V(a) <+ 3.0;
    I(a, bus[0])     <+ V(a, bus[0]) / 1000.0;
    I(bus[0])        <+ V(bus[0]) / 1000.0;
    I(bus[1])        <+ V(bus[1]) / 1000.0;
    I(a, \bus[0] )   <+ V(a, \bus[0] ) / 1000.0;
    I(\bus[0] )      <+ V(\bus[0] ) / 2000.0;
    `CHECK("element 0 of the vector net is the 1:1 divider", V(bus[0]), 1.5, 1e-9);
    `CHECK("the escaped scalar of the same spelling is the 2:1 divider", V(\bus[0] ), 2.0, 1e-9);
  end
endmodule
