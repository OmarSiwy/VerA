// §6.3.5, the other half of the predicate: "$param_given() ... shall be one (1)
// if the parameter was overridden, either by a defparam statement or in a module
// instance parameter value assignment, and zero (0) otherwise" (§9.19). Its
// sibling param_given.va pins the 1; without this file the whole suite could be
// satisfied by a compiler that returns a constant 1, which is exactly the shape
// a predicate degrades to when nobody tests the false case.
//
// There is deliberately NO `//! param` line here, so `gain` keeps its declared
// default and the answer is 0. Note the default is 2.0 and not 1.0: a compiler
// that answered "was this value supplied?" by comparing against some canonical
// value rather than by recording the override would be caught by the value
// itself being unremarkable.
//
// The ternary is the consequence, and it is the NOT-given arm that is taken. At
// V(p) = 0.25 the contributed current is 1.0 * 0.25 = 0.25 exactly — a quarter
// of the 2.0 * 0.25 = 0.5 the given arm would produce, so a wrong verdict shows
// up as a factor of two and not as a rounding difference.
//
//! lrm 6.3.5
//! lrm 6.3.5:1000
//! bias V(p) = 0.25
`include "check.vh"
module ch6_param_given_absent(p);
  inout p; electrical p;
  parameter real gain = 2.0;
  analog begin
    `CHECKI("$param_given is 0 for a parameter left at its default", $param_given(gain), 0);
    `CHECKX("the not-given arm ignores gain", ($param_given(gain) ? gain * V(p) : 1.0 * V(p)), 0.25);
    I(p) <+ $param_given(gain) ? gain * V(p) : 1.0 * V(p);
  end
endmodule
