// §6.6.3 (IEEE 1364-2005 §12.4.3, inherited): a generate block is a scope.
// "Generate blocks ... can be named or unnamed" and a named block's items are
// reached through its name; an unnamed one gets `genblk<n>` "for external
// interfaces". So an instance `u` inside block `g1` is `g1.u`, and another
// `u` inside `g2` is `g2.u`: two instances, no clash.
//
// ROADMAP §5.3 (AMS 6.6.3): VerA flattened a generate block's instance under
// its own name, so `g1.u` and `g2.u` were both `u` and the second collided
// (E0362) with the first.
//
// THE CIRCUIT. Both blocks are selected (`on = 1`). g1.u loads p with 1 kohm,
// g2.u loads q with 2 kohm (each leaf: `I(a) <+ V(a)/r`), and the top drives
// 1 mA into each node. Each instance's parameter is read back hierarchically
// (§6.7.1 "Access of parameters can be done hierarchically"):
//   g1.u.r = 1000, g2.u.r = 2000
// and each node settles on its own leaf: V(p) = 1e-3 * 1000 = 1.0,
// V(q) = 1e-3 * 2000 = 2.0.
// A design that merged the two `u`s cannot compile; one that dropped the
// block name cannot resolve `g1.u.r`.
//
// Invalid neighbour: generate_block_name_collision_rejected.va (two blocks
// with one name in one scope, §6.6.3's clash rule).
//
//! lrm 6.6.3
//! lrm 6.6
//! lrm 6.7.1
//! inherited IEEE 1364-2005 12.4.3
//! solve
//! checks 4
`include "check.vh"
module gbs_leaf(a);
  inout a; electrical a;
  parameter real r = 1k;
  analog I(a) <+ V(a) / r;
endmodule
module gbs_top(p, q);
  inout p, q; electrical p, q;
  parameter integer on = 1;
  generate
    if (on) begin : g1
      gbs_leaf #(.r(1k)) u(p);
    end
    if (on) begin : g2
      gbs_leaf #(.r(2k)) u(q);
    end
  endgenerate
  analog begin
    `CHECKX("g1.u is the 1 kohm instance", g1.u.r, 1000.0);
    `CHECKX("g2.u is a second instance, the 2 kohm one", g2.u.r, 2000.0);
    I(p) <+ -1m;
    I(q) <+ -1m;
    `CHECK("p settles on g1.u's 1 kohm", V(p), 1.0, 1e-9);
    `CHECK("q settles on g2.u's 2 kohm", V(q), 2.0, 1e-9);
  end
endmodule
