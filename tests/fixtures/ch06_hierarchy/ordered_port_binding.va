// §6.5.4, verbatim: "The ports listed in a module instantiation shall be in the
// same order as the ports listed in the module definition." The clause carries
// the LRM's own worked shape — `module adc4 (out, rem, in)` instantiating
// `adc2 hi2 (out[3:2], rem_chain, in)` — so the formals are named (out, rem, in)
// here for the same reason: a compiler that bound by POSITION would get these
// right, and one that bound by NAME, by declaration order, or by sorting would
// get a different actual on at least one formal. Because the formals are named
// after their roles, a name-bound compiler is indistinguishable from a
// position-bound one — which is exactly why the three nets below carry three
// DIFFERENT voltages. The literal on each formal then says which actual arrived.
//
// WHY THREE AND NOT ONE. A single net would make every binding correct by
// construction, and a pair would catch only a swap. Three distinct values make
// all six permutations of the actual list distinguishable: the identity gives
// (4.0, 2.0, 1.0) on (out, rem, in), and each of the other five gives at least
// one formal a value none of these literals accepts. `V(out)` alone would leave
// the other two formals unread, so all three are asserted.
//
// WHAT A WRONG IMPLEMENTATION PRINTS. A compiler that reversed the list reads
// V(out) = 1.0 where 4.0 was wanted, V(rem) = 2.0 (right by accident — the
// middle of three is a fixed point of reversal, which is the other reason the
// check is not on one port), and V(in) = 4.0 where 1.0 was wanted. A compiler
// that matched by name instead reads the same three numbers here and would need
// a fourth net named like a formal to be caught, which is not what this clause
// says; §6.5.6 is the by-name clause and has its own fixture.
//
// The three volts are powers of two so the doubles are exact and CHECKX is the
// right comparison: nothing here is a solved quantity, every node is forced by
// `bias`, and the cell's own contribution is zero.
//
//! lrm 6.5.4
//! lrm 6.2.2
//! lrm 6.2.2:2
//! lrm 6.2
//! lrm 6.2:4
//! lrm 6.5.4:1
//! bias V(z) = 4.0, V(y) = 2.0, V(x) = 1.0
//! print none
`include "check.vh"
module ch6_ordered_ports_top;
  electrical z, y, x;

  ch6_ordered_ports_cell u1(z, y, x);

  analog begin
    I(z) <+ 0.0;
    I(y) <+ 0.0;
    I(x) <+ 0.0;
  end
endmodule

module ch6_ordered_ports_cell(out, rem, in);
  inout out, rem, in;
  electrical out, rem, in;

  analog begin
    `CHECKX("the first actual is bound to the first formal", V(out), 4.0);
    `CHECKX("the second actual is bound to the second formal", V(rem), 2.0);
    `CHECKX("the third actual is bound to the third formal", V(in), 1.0);
    I(out) <+ 0.0;
    I(rem) <+ 0.0;
    I(in) <+ 0.0;
  end
endmodule
