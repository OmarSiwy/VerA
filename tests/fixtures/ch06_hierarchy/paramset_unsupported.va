// §6.4 defines the paramset — "A paramset definition is enclosed between the
// keywords paramset and endparamset" — and Clause 6.4's own worked example
// converts a SPICE model card into one, instantiating it as `nch #(.l(1u),
// .w(10u)) m1 (...)`. A construct the LRM defines and instantiates in an example
// is not something a conforming compiler may refuse, so this file is a run
// fixture and no longer the `//! reject` it used to be.
//
// What is pinned is the paramset's one job: `.module_parameter_identifier =
// paramset_constant_expression ;` assigns to a parameter of the ASSOCIATED
// module, and the expression may be computed from the paramset's own parameters.
// The instance overrides only the paramset's `gain` (3.0); the paramset turns that
// into the module's `k` as 2.0 * 3.0 = 6.0, exact in binary. A compiler that
// passed the instance override straight through to the module would report 3.0;
// one that ignored the instance and used the paramset's declared default would
// report 2.0 * 1.0 = 2.0. Only 6.0 comes from running the paramset statement.
//
// The module's own `k` default is 9.0 rather than something plausible, so that a
// paramset which never fired is visible rather than accidentally right. With
// V(p,n) = 0.5 the module stamps 6.0 * 0.5 = 3.0.
//
// $param_given is NOT asserted: §9.19 fixes it for a defparam and for an instance
// parameter value assignment and says nothing about a paramset statement, so a
// number here would over-specify the LRM.
//
//! lrm 6.4
//! bias V(p) = 0.75, V(n) = 0.25
//! xfail VerA compiles one flat module: the paramset DECLARATION is now read past and dropped (§6.4 gives it effect only through an instance), but the instantiation that would select it is refused at E0204 "module instantiation is not supported"
`include "check.vh"
module ch6_ps_user(p, n);
  inout p, n; electrical p, n;
  ch6_ps #(.gain(3.0)) u(p, n);
endmodule

paramset ch6_ps ch6_ps_base;
  parameter real gain = 1.0;
  .k = 2.0 * gain;
endparamset

module ch6_ps_base(a, b);
  inout a, b; electrical a, b;
  parameter real k = 9.0;
  analog begin
    `CHECKX("the paramset statement set the module parameter from its own", k, 6.0);
    `CHECKX("so the module stamps the paramset's value", k * V(a, b), 3.0);
    I(a, b) <+ k * V(a, b);
  end
endmodule
