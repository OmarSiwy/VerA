// §6.6.2.1 "A special case exists for dc sweep simulations: a series of
// operating point analyses where one or more parameters change value between
// each analysis (see also 4.6.1 on the Analysis function). ... in analog
// simulation it is quite common to sweep a parameter during simulation to get
// information on how the parameter values influence the circuit behavior and
// hence the simulation results. In connection with the conditional generate
// construct, an implementation may choose to limit sweepable parameters to
// those that do not influence the structure of the circuit."
//
// The positive case: a parameter that does NOT influence structure (it only
// scales a contribution) is swept across two operating-point analyses, and each
// solution follows the value in force for it.
//
// DERIVATION. The device is a potential source V(out) <+ gain * V(in) on a
// signal-flow output, V(in) = 0.25:
//
//   gain = 2.0  ->  V(out) = 0.5
//   gain = 3.0  ->  V(out) = 0.75
//
// both exact. Each check is guarded by the gain it belongs to, and the declared
// default 1.0 is in neither arm, so a sweep that never applied its values prints
// no verdict at all and `//! checks 2` fails it on the count.
//
// CEILING, stated rather than hidden: a sweep stuck on its FIRST value would
// print the gain = 2.0 line twice and still meet the count. The harness has no
// cross-analysis memory a fixture can read (each point is a fresh model card,
// which is what §6.6.2.1's "series of operating point analyses" means), so the
// transcript's two `got=` columns are where a reviewer sees 0.5 then 0.75.
//
//! lrm 6.6.2.1
//! lrm 6.6.2.1:1
//! bias V(in) = 0.25
//! psweep gain = 2.0, 3.0
//! solve
//! checks 2
`include "check.vh"
module ch6_dynamic_parameter_dc_sweep(in, out);
  input in;
  output out;
  voltage in, out;
  parameter real gain = 1.0;
  analog begin
    V(out) <+ gain * V(in);
    if (gain == 2.0)
      `CHECKX("§6.6.2.1 the operating point at gain = 2.0", V(out), 0.5);
    if (gain == 3.0)
      `CHECKX("§6.6.2.1 the operating point at gain = 3.0", V(out), 0.75);
  end
endmodule
