// AMS A.1.3 requires a nonempty list of parameter declarations in a header;
// A.4.1 requires a nonempty list of one parameter-assignment form per instance.
// A localparam remains legal in the body. Omitting the whole instance list
// retains both defaults; .a() retains only a's default (§6.3.3).
// With a=3 and b=7 by default, the ordered instance uses 2+4=6, the named
// instance uses 3+5=8, and the default instance uses 3+7=10. Unit voltage at
// each independent node makes those its branch current in amperes.
// Invalid neighbours parameter_list_*_rejected.va isolate the forbidden forms.
//! lrm A.1.3
//! lrm A.4.1
//! lrm 6.3.3
//! lrm 6.3.3:2
//! lrm A.1.3:1000
//! lrm A.4.1:1000
//! bias V(x) = 1
//! bias V(y) = 1
//! bias V(z) = 1
//! checks 3
`include "check.vh"
module parameter_list_leaf #(parameter real a=3, parameter real b=7) (p);
  inout p; electrical p;
  localparam real factor=1;
  analog I(p) <+ factor*(a+b)*V(p);
endmodule
module parameter_list_forms(x,y,z);
  inout x,y,z; electrical x,y,z;
  parameter_list_leaf #(2,4) ordered(x);
  parameter_list_leaf #(.a(),.b(5)) named(y);
  parameter_list_leaf defaults(z);
  analog begin
    `CHECKX("ordered list", I(x), 6);
    `CHECKX("named list with an empty value", I(y), 8);
    `CHECKX("omitted list", I(z), 10);
  end
endmodule
