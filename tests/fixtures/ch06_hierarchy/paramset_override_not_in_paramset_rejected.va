// §6.4.2, the rules for choosing a paramset: "All parameters overridden on the
// instance shall be parameters of the paramset." §6.4 says what happens when an
// instance breaks that with its only candidate: "The paramset has only two
// parameters, l and w; an instance that attempts to override any other
// parameters of the underlying module nmos3 would generate an error."
//
// `ch6_narrow_ps` declares only `l`. The instance below overrides `k`, which is
// a parameter of the underlying module but not of the paramset, so no paramset
// named `ch6_narrow_ps` admits the instance. The legal override of a paramset's
// own parameter is h01_04_paramset_overload_lrm_table.va.
//
//! lrm 6.4
//! lrm 6.4.2
//! lrm 6.4.2:3
//! reject-only E0911
//! neighbour h01_04_paramset_overload_lrm_table.va
`include "disciplines.vams"
module ch6_narrow_user(p, n);
  inout p, n; electrical p, n;
  ch6_narrow_ps #(.k(3.0)) u(p, n);
endmodule

paramset ch6_narrow_ps ch6_narrow_base;
  parameter real l = 1.0 from [0.5:2.0];
  .k = 2.0 * l;
endparamset

module ch6_narrow_base(a, b);
  inout a, b; electrical a, b;
  parameter real k = 9.0;
  analog I(a, b) <+ k * V(a, b);
endmodule
