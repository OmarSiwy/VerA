// §6.5.4 ordered connections whose actuals are a sub-range and members of the
// instantiating module's own vector PORT, the shape of the LRM's example:
// adc4 writes `adc2 hi2 (out[3:2], rem_chain, in)` on its output port `out`,
// and adc2 writes `adc hi1 (out[1], r, in)` on its own. §6.5.5 names the same
// forms for a named list: "simple net identifier, scalar member, sub-range,
// or concatenation", and §6.5.1 lets each be "of a vector net or port declared
// within the module".
//
// THE DESIGN. The top's `bus` is mid's [3:0] port `o`. Mid connects, by order,
// o[3:2] to a 2-bit cell and o[1], o[0] to one scalar cell each. Every cell
// drives its port bits against `r`, mid's second port, which is the top's p:
//   pair:       V(w[1], r) <+ 0.5,  V(w[0], r) <+ 0.25
//   one lo1:    V(v, r) <+ 0.125
//   one lo0:    V(v, r) <+ 2.0
// p is held at 1.0 and the top's nets are solved (`//! solve`), then read.
//
// BIT ORDER. IEEE 1364-2005 12.3.9.2 pairs a port's bits left to right: the
// pair's w[1] is o[3], its w[0] is o[2]; and o[k] is bus[k] (two [3:0]
// vectors). So, by hand:
//   V(bus[3]) = 1.0 + 0.5   = 1.5
//   V(bus[2]) = 1.0 + 0.25  = 1.25
//   V(bus[1]) = 1.0 + 0.125 = 1.125
//   V(bus[0]) = 1.0 + 2.0   = 3.0
// A reversed sub-range swaps 1.5 and 1.25, a member off by one moves 1.125 or
// 3.0, and a cell whose `r` lost the top's p reads without the 1.0. Dyadic,
// so exact.
//
//! lrm 6.5.4
//! lrm 6.5.4:1
//! lrm 6.5.1
//! lrm 6.5.1:1
//! bias V(p) = 1.0
//! solve
//! checks 4
`include "check.vh"
module ch6_psel_ord_top(p);
  inout p; electrical p;
  electrical [3:0] bus;
  ch6_psel_ord_mid m(bus, p);
  analog begin
    `CHECKX("o[3:2] by order: the pair's MSB on bus[3]", V(bus[3]), 1.5);
    `CHECKX("o[3:2] by order: the pair's LSB on bus[2]", V(bus[2]), 1.25);
    `CHECKX("o[1] by order: a member of the parent's port", V(bus[1]), 1.125);
    `CHECKX("o[0] by order: a member of the parent's port", V(bus[0]), 3.0);
  end
endmodule

module ch6_psel_ord_mid(o, r);
  inout [3:0] o; inout r;
  electrical [3:0] o; electrical r;
  ch6_psel_ord_pair hi(o[3:2], r);
  ch6_psel_ord_one #(.val(0.125)) lo1(o[1], r);
  ch6_psel_ord_one #(.val(2.0)) lo0(o[0], r);
endmodule

module ch6_psel_ord_pair(w, r);
  inout [1:0] w; inout r;
  electrical [1:0] w; electrical r;
  analog begin
    V(w[1], r) <+ 0.5;
    V(w[0], r) <+ 0.25;
  end
endmodule

module ch6_psel_ord_one(v, r);
  inout v, r; electrical v, r;
  parameter real val = 0.0;
  analog V(v, r) <+ val;
endmodule
