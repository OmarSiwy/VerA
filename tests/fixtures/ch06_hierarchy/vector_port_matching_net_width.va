// §6.5.7.1 "a vector port can be connected to a vector net ... of the matching
// width." The legal twin of vector_port_scalar_net_width_mismatch_rejected.va: the parent's net is [2:0] too, so
// the port IS that net, element for element.
//
// So the child's `port_vec[0]` IS the parent's `b[0]`: with V(b[0]) held at 0.5
// by `//! bias`, reading it through the child's port name (§6.7.1 permits a
// hierarchical potential) gives 0.5. A binding that left the elements joined to
// nothing reads the child's own floating node instead.
//
//! lrm 6.5.7.1
//! lrm 6.5.7.1:1
//! lrm 6.7.1
//! lrm 6.7.1:1
//! bias V(b[0]) = 0.5, V(b[1]) = 0.0, V(b[2]) = 0.0
`include "check.vh"
module ch6_port_net_matching_width(b);
  inout [2:0] b; electrical [2:0] b;
  ch6_port_net_matching_width_child u(b);
  analog `CHECKX("§6.5.7.1 the port element is the parent's net element", V(u.port_vec[0]), 0.5);
endmodule

module ch6_port_net_matching_width_child(port_vec);
  inout [2:0] port_vec;
  electrical [2:0] port_vec;
  analog I(port_vec[0]) <+ V(port_vec[0]);
endmodule
