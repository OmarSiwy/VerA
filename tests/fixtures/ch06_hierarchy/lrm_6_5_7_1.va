// §6.5.7.1 "A scalar port can be connected to a scalar net and a vector port
// can be connected to a vector net or concatenated net expression of the
// matching width. The sizes of the ports and net must match."
//
// This fixture tests the matching size rule by attempting to connect a 3-bit
// vector port to a scalar net, which violates the requirement that port width
// must equal net width at the connection.
//
//! lrm 6.5.7.1
//! reject DiagnosticsReported
module ch6_port_net_size_mismatch_parent(p);
  inout p; electrical p;
  ch6_port_net_size_mismatch_child u(p);
endmodule

module ch6_port_net_size_mismatch_child(port_vec);
  inout [2:0] port_vec;
  electrical [2:0] port_vec;
  analog I(port_vec[0]) <+ 0.0;
endmodule
