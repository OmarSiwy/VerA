// §6.5.2.2, the case the LRM prints as VALID, and the one that shows the rule is
// EVALUATE-equal and not spell-equal:
//
//     input [0:3] in;
//     electrical [0:4-1] in;  // valid, MSB and LSB in both the port type and port
//                             // direction declaration evaluate to the same value
//
// `[0:3]` and `[0:4-1]` are different token sequences naming the same range, so a
// compiler that compared the two declarations textually — or that compared the
// constant expressions before folding them — rejects legal source. That is the
// only thing this fixture is for; its sibling vector_ports.va holds the error
// case, where the two ranges genuinely differ.
//
// The direction is `inout` rather than the LRM's `input` so every bit is a
// stampable terminal; nothing about the range rule depends on the direction
// keyword.
//
// The four bits are biased to distinct dyadic rationals — 1/8, 1/4, 1/2, 1 —
// exact in binary64, so nothing here can be a rounding artefact. The wants pin
// that bit 0 and bit 3 both exist and are DIFFERENT nets, which is precisely what
// "[0:4-1] evaluates to [0:3]" claims: a four-bit port indexed 0 through 3. A
// width of one, an off-by-one that put bit 3 out of range, or an aliasing of the
// whole port onto one net all fail here. Their difference, 0.125 - 1.0 = -0.875,
// is asserted too so that a compiler that silently returned the same net for both
// indices cannot pass by reading one of them correctly.
//
//! lrm 6.5.2.2
//! bias V(p[0]) = 0.125, V(p[1]) = 0.25, V(p[2]) = 0.5, V(p[3]) = 1.0
//! xfail VerA's parser takes no range on a port direction declaration, so `inout [0:3] p` dies at E0208 "expected an identifier: found `[`" and a conforming vector port cannot be declared at all
`include "check.vh"
module ch6_vector_range_equal(p);
  inout [0:3] p;
  electrical [0:4-1] p;
  analog begin
    `CHECKX("bit 0 of a port declared [0:3] / [0:4-1]", V(p[0]), 0.125);
    `CHECKX("bit 3 of the same port — so 4-1 folded to 3", V(p[3]), 1.0);
    `CHECKX("the two indices are distinct nets", V(p[0]) - V(p[3]), -0.875);
    I(p[0]) <+ 0.0;
  end
endmodule
