// §6.1 Overview, sentence by sentence, each made observable:
//
//   "Verilog-AMS HDL supports a hierarchical hardware description by allowing
//    modules to be embedded within other modules. Higher-level modules create
//    instances of lower-level modules and communicate with them through input,
//    output, and bidirectional ports. These module I/O ports can be SCALAR OR
//    VECTOR."
//      -> three instances of `ch6_ov_leaf` on scalar inout ports, and one of
//         `ch6_ov_bus` on a two-element VECTOR port whose elements the child
//         drives and the parent reads back through its own net.
//
//   "A mechanism is provided to customize the behavior of embedded modules using
//    parameters. The embedded module parameter default value can be modified
//    through a higher-level module's PARAMETER OVERRIDE or a hierarchy-
//    independent DEFPARAM statement."
//      -> u1 overrides by order, u2 by name, u3 through a defparam; u4 takes the
//         default. Four instances of ONE definition, four different values.
//
//   "Each module definition stands alone; the definitions are not nested.
//    Statements within the module definitions create instances of other
//    modules, thus describing the hierarchy."
//      -> the three definitions below sit side by side;
//         `nested_module_definition_rejected.va` is the refusal of the other
//         shape.
//
// BY HAND. gain: u1 = 2.0 (ordered), u2 = 3.0 (named), u3 = 5.0 (defparam),
// u4 = 1.0 (declared default). The bus child pins its elements, b[1] = 0.5 and
// b[0] = 0.25, and the parent's `bus` IS those nets once connected, so
// V(bus[1]) = 0.5 and V(bus[0]) = 0.25 on the solved point. Every value is exact
// in binary. The parameters are read hierarchically (§6.7.1: "Access of
// parameters can be done hierarchically").
//
//! lrm 6.1
//! lrm 6.3
//! lrm 6.1:1000
//! lrm 6.2
//! lrm 6.2:2
//! lrm 6.3.3
//! lrm 6.3.3:1
//! lrm 6.5
//! lrm 6.5:1000
//! bias V(p) = 0.75, V(n) = 0.25
//! solve
//! checks 6
`include "check.vh"
module ch6_overview_top(p, n);
  inout p, n;
  electrical p, n;
  electrical [1:0] bus;
  ch6_ov_leaf #(2.0) u1(p, n);
  ch6_ov_leaf #(.gain(3.0)) u2(p, n);
  ch6_ov_leaf u3(p, n);
  ch6_ov_leaf u4(p, n);
  defparam u3.gain = 5.0;
  ch6_ov_bus drv(bus);
  analog begin
    `CHECKX("a parameter overridden by order", u1.gain, 2.0);
    `CHECKX("a parameter overridden by name", u2.gain, 3.0);
    `CHECKX("a parameter altered by a defparam", u3.gain, 5.0);
    `CHECKX("an instance with no override keeps the declared default", u4.gain, 1.0);
    `CHECK("a vector port element the child drives, read by the parent", V(bus[1]), 0.5, 1e-12);
    `CHECK("and the other element, independently", V(bus[0]), 0.25, 1e-12);
    I(p, n) <+ 0.0;
  end
endmodule

module ch6_ov_leaf(a, b);
  inout a, b;
  electrical a, b;
  parameter real gain = 1.0;
  analog I(a, b) <+ gain * V(a, b);
endmodule

module ch6_ov_bus(b);
  inout [1:0] b;
  electrical [1:0] b;
  analog begin
    V(b[1]) <+ 0.5;
    V(b[0]) <+ 0.25;
  end
endmodule
