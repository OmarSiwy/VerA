// §6.6.1 loop generate: "It shall be an error if the loop does not
// terminate." This loop terminates after 4097 iterations, so it breaks no
// rule and is unrolled in full. Until 2026-10-15 VerA unrolled at most 4096
// iterations and refused this one by name (E0485, retired); a loop is now
// judged by following its scheme until it ends or repeats a genvar value
// (generate_nonterminating_rejected.va), not by a count.
// genvar_loop_at_unroll_limit.va is the old bound itself, and
// ch05_analog_behavior/sequential_ifs_10000.va runs 10,000 iterations.
//
// BY HAND. x starts at 0.0 and each of the 4097 unrolled bodies adds 1.0, so
// x = 4097.0 exactly (integers below 2^53 are exact in IEEE double).
//
//! lrm 6.6.1
//! checks 1
`include "check.vh"
module genvar_loop_4097_iterations(p);
  inout p; electrical p;
  genvar i;
  real x;
  analog begin
    x = 0.0;
    for (i = 0; i < 4097; i = i + 1) x = x + 1.0;
    `CHECKX("4097 unrolled bodies each add 1", x, 4097.0);
    I(p) <+ 0.0;
  end
endmodule
