// §6.9.3 Elaboration and connectmodules:
//
//   "Automatic insertion of connect modules is a post-elaboration operation, as
//    first the disciplines of the various nets needs to be resolved. ... IT
//    SHOULD ALSO OCCUR AFTER THE PARAMSET SELECTION AS THE CHOICE FOR A
//    PARTICULAR MODULE INSTANTIATION MAY AFFECT THE DISCIPLINES OF THE CONNECTED
//    NETS. This is described in detail in 7.8."
//
// Two instances below name the SAME paramset, `ch6_ci_rx`, and §6.4.2 selects a
// different member for each from the value of `k`:
//
//   u (k = 1)  ->  the paramset over `ch6_ci_din`, whose port is `ddiscrete`
//   w (k = 0)  ->  the paramset over `ch6_ci_ain`, whose port is `electrical`
//
// Both connect to an `electrical` net of the parent, so whether the connection
// is MIXED — and therefore whether §7.8.4 inserts the `ch6_ci_a2d` connect
// module — depends entirely on which module the paramset selected. Deciding
// insertion from the instantiation statement alone (before selection) cannot
// get both right: the name `ch6_ci_rx` is the same on both lines.
//
// The inserted a2d carries §7.8.2's input loading, a 1 kohm resistor to ground.
//
// BY HAND. Each net has a 1 kohm shunt and 1 mA injected by the parent:
//   a (u, digital receiver, a2d inserted): two 1k in parallel = 500 ohm,
//        V(a) = 1e-3 * 500 = 0.5
//   b (w, analog receiver, nothing inserted): one 1k,
//        V(b) = 1e-3 * 1000 = 1.0
// Both exact in binary. An insertion pass that ignored paramset instances gives
// 1.0 for a; one that judged by the paramset's NAME alone could not produce the
// pair.
//
//! lrm 6.9.3
//! lrm 6.9.3:1
//! lrm 6.4.2
//! lrm 7.8.4
//! lrm 6.4.2:1
//! lrm 6.4.2:2
//! lrm 6.4.2:4
//! lrm 7.6
//! lrm 7.6:1
//! lrm 7.8
//! lrm 7.8:1
//! lrm 7.8.4:1
//! solve
`include "check.vh"

connectmodule ch6_ci_a2d(el, cm);
  input el;
  output cm;
  electrical el;
  ddiscrete cm;
  reg cm;
  parameter real rin = 1000.0 from (0.0:inf);
  analog I(el) <+ V(el) / rin;
  initial cm = 1'b0;
endmodule

module ch6_ci_din(din);
  input din;
  ddiscrete din;
  parameter integer k = 0;
endmodule

module ch6_ci_ain(ain);
  input ain;
  electrical ain;
  parameter integer k = 0;
  analog I(ain) <+ 0.0;
endmodule

paramset ch6_ci_rx ch6_ci_din;
  parameter integer k = 1 from [1:inf);
  .k = k;
endparamset

paramset ch6_ci_rx ch6_ci_ain;
  parameter integer k = 0 from (-inf:1);
  .k = k;
endparamset

module ch6_ci_top;
  electrical a, b;
  ch6_ci_rx #(.k(1)) u(a);
  ch6_ci_rx #(.k(0)) w(b);
  analog begin
    I(a) <+ V(a) / 1000.0;
    I(a) <+ -1.0e-3;
    I(b) <+ V(b) / 1000.0;
    I(b) <+ -1.0e-3;
    `CHECK("the paramset selected a discrete receiver, so the a2d was inserted and loads the net", V(a), 0.5, 1e-12);
    `CHECK("the same paramset name selected an analog receiver here, so nothing was inserted", V(b), 1.0, 1e-12);
  end
endmodule

connectrules ch6_ci_rules;
  connect ch6_ci_a2d;
endconnectrules
