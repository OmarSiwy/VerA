// IEEE 1364-2005 4.10.1 and 4.10.2, inherited by AMS 1.1:
// body parameter declarations become local when the header declares parameters,
// but their constant expressions still follow overridden header parameters.
// Override header_value from 2 to 3: body_value = 2*3 = 6, not its default 4.
// This is the legal counterpart of PARAM-HEADER-001; passing it alone does not
// prove that the body parameter itself is protected from direct overrides.
//! lrm 3.4.5
//! lrm 6.2
//! lrm 6.3.3
//! lrm 6.3.3:1
//! lrm 6.3.4
//! lrm 6.3.4:1000
//! checks 2
`include "check.vh"
module header_body_dependency_target #(parameter real header_value = 2.0) ();
  parameter real body_value = 2.0 * header_value;
  analog begin
    `CHECKX("header override reaches the instance", header_value, 3.0);
    `CHECKX("body local dependency follows header", body_value, 6.0);
  end
endmodule
module audit_header_body_parameter_dependency;
  header_body_dependency_target #(.header_value(3.0)) child();
endmodule
