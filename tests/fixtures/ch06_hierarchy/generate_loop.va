// §6.6.1 loop generate: "A loop generate construct permits a generate block to be
// instantiated multiple times using syntax that is similar to a for loop
// statement. The loop index variable shall be declared in a genvar declaration
// prior to its use." Syntax 6-8 gives it as `for ( genvar_initialization ;
// genvar_expression ; genvar_iteration ) generate_block`. Defined construct, so a
// run fixture and not the `//! reject` it used to be.
//
// This file used to declare `electrical [0:2] p` and connect one bit per
// iteration, and it passed for a reason that had nothing to do with generate: the
// reject substring `identifier` was hit at the VECTOR PORT, several tokens before
// the loop. The port is scalar now, so the only thing left to fail is the loop —
// vector nets are a separate gap, held by vector_ports_range_equal.va.
//
// The body accumulates i*i over an ASCENDING loop, which is the sum every
// unrolled copy contributes exactly once:
//
//   i = 0 -> total = 0 +  0 =  0
//   i = 1 -> total = 0 +  1 =  1
//   i = 2 -> total = 1 +  4 =  5
//   i = 3 -> total = 5 +  9 = 14
//
// so total = 14. A loop that ran three times instead of four gives 5; one whose
// condition was `<` misread as `<=` gives 30; one that never unrolled gives 0. The
// square is used rather than i itself so that a wrong ITERATION COUNT and a wrong
// set of values cannot cancel: 0+1+2+3 and 0+1+4+9 have different totals for every
// prefix. Its sibling generate_implicit_localparam.va pins the per-copy localparam
// and generate_loop_descending.va pins the order.
//
//! lrm 6.6.1
//! lrm 6.6
//! bias V(p) = 0.75, V(n) = 0.25
//! xfail VerA's parser reads a generate block body as an analog statement, so the `analog` keyword inside `generate` dies at E0209 "expected an expression: found `analog`"
`include "check.vh"
module ch6_generate_loop(p, n);
  inout p, n; electrical p, n; genvar i;
  integer total;
  analog total = 0;
  generate
    for (i = 0; i < 4; i = i + 1) begin : stage
      analog begin
        total = total + i * i;
        I(p, n) <+ 0.0;
      end
    end
  endgenerate
  analog `CHECKI("four unrolled copies, each contributing its own i*i", total, 14);
endmodule
