// §6.7: an inlined child's identifiers are renamed onto the flattened path, and
// §4.2.14's conditional operator has THREE operands, so all three have to be
// renamed. The first two are covered many times over — every fixture in this
// directory that reads an overridden parameter walks them. The `else` operand
// was not covered by anything: measured by dropping its rename outright, all
// 1152 fixtures stayed green.
//
// The shape that catches it is a name that exists in BOTH scopes. The parent
// declares `gain = 5.0` and the child declares `gain = 1.0` overridden to 2.0 at
// the instance, so `gain` inside the child body is §6.2.1's "priority to the
// local scope" — the child's, 2.0 — and a `gain` that was NOT renamed resolves
// to the parent's 5.0 instead. That is a wrong number and not a compile error,
// which is why the decoy is here: without it the same defect is a diagnostic
// about an undeclared identifier, and a fixture that only pins "it compiled"
// would not notice the day the name happens to exist.
//
// The condition is over V(a,b), not a constant, so nothing folds the conditional
// away before the else arm is reached. With V(a,b) = 0.5 the guard `V(a,b) > 1.0`
// is 0 (§4.2.5 a comparison is an integer), the else arm is selected, and the
// stamped current is 2.0 * 0.5 = 1.0 exactly. Both operands are exact in binary.
//
//! lrm 6.7
//! lrm 6.2.1
//! lrm 4.2.14
//! bias V(p) = 0.75, V(n) = 0.25
`include "check.vh"
module ch6_ternary_else_parent(p, n);
  inout p, n; electrical p, n;
  parameter real gain = 5.0; // the decoy: same name, different scope, never read
  ch6_ternary_else_child #(2.0) u(p, n);
endmodule

module ch6_ternary_else_child(a, b);
  inout a, b; electrical a, b;
  parameter real gain = 1.0;
  analog begin
    `CHECKX("the else operand reads the CHILD's overridden gain", (V(a, b) > 1.0) ? 0.0 : gain, 2.0);
    `CHECKX("and the then operand still reads it too", (V(a, b) > 1.0) ? gain : 0.0, 0.0);
    `CHECKX("so the stamp is gain*V", ((V(a, b) > 1.0) ? 0.0 : gain) * V(a, b), 1.0);
    I(a, b) <+ ((V(a, b) > 1.0) ? 0.0 : gain) * V(a, b);
  end
endmodule
