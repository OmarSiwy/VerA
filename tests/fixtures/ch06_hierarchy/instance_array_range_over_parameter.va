// §6.2.2: "The instantiations of modules can contain a range specification.
// This allows an array of instances to be created." The range is annex A's
// `range ::= [ msb_constant_expression : lsb_constant_expression ]`, and §3.4
// makes a parameter a constant expression ("an expression containing only
// constant numbers and previously defined parameters"). So a range may be
// written over parameters, and it takes the value THIS instance sees — an
// override included (§6.3).
//
// Two arrays, with the element count by hand:
//
//   u[HI:0]    N = 3, HI = N - 1 = 2        -> u[2:0], three elements
//   m.v[W-1:0] W overridden from 7 to 2     -> v[1:0], two elements
//
// THE COUNT IS ASSERTED the way instance_array_constant_expression_range.va
// asserts it: every element's `g` is defparam'd from 9.0 to 5.0, one defparam
// per element. An element the range did not create makes its defparam name
// nothing (E0907); an element beyond the count runs with g = 9.0 and fails the
// check. v folded over W's default 7 would create v[6:0] and fail on v[2].
// Each element stamps 5.0 * 0.5 = 2.5 across the 0.5 V bias.
//
// instance_array_range_variable_rejected.va is the illegal neighbour, a bound
// read from a variable.
//
//! lrm 6.2.2
//! lrm 6.2.2:1004
//! lrm 3.4
//! lrm 6.3
//! bias V(p) = 0.75, V(n) = 0.25
`include "check.vh"
module ch6_iapr_parent(p, n);
  inout p, n; electrical p, n;
  parameter integer N = 3;
  localparam integer HI = N - 1;
  ch6_iapr_kid u[HI:0](p, n);
  ch6_iapr_mid #(.W(2)) m(p, n);
  defparam u[0].g = 5.0, u[1].g = 5.0, u[2].g = 5.0;
  defparam m.v[0].g = 5.0, m.v[1].g = 5.0;
endmodule

module ch6_iapr_mid(a, b);
  inout a, b; electrical a, b;
  parameter integer W = 7;
  ch6_iapr_kid v[W-1:0](a, b);
endmodule

module ch6_iapr_kid(a, b);
  inout a, b; electrical a, b;
  parameter real g = 9.0;
  analog begin
    `CHECKX("every element the parameter range created was reached by its defparam", g, 5.0);
    `CHECKX("so each element stamps the overridden value", g * V(a, b), 2.5);
    I(a, b) <+ g * V(a, b);
  end
endmodule
