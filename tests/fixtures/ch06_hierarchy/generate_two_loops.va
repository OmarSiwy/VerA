// §6.6.1 with TWO loop generate constructs in one generate region, each over its
// own genvar. §6.6 makes the region "a textual span in the module description
// where generate constructs may appear" — plural, and `generate_region ::=
// generate { module_or_generate_item } endgenerate` in Syntax 6-8 puts no limit on
// the count. §6.9.1 then fixes the order: the analog blocks are concatenated in
// the order they are elaborated, so the second loop's copies follow the first
// loop's. Legal, so a run fixture and not the `//! reject` it used to be.
//
// (The old version declared `electrical [0:1] p`; its reject substring
// `identifier` fired on the VECTOR PORT and never reached either loop. Scalar
// ports now — vector nets are a separate gap, held by
// vector_ports_range_equal.va.)
//
// `code` appends one base-10 digit per unrolled copy, so a single integer records
// how many copies each loop produced AND that the two loops did not interleave:
//
//   loop 1, i = 0 -> code =    0*10 + 1 =    1
//   loop 1, i = 1 -> code =    1*10 + 2 =   12
//   loop 2, j = 0 -> code =   12*10 + 5 =  125
//   loop 2, j = 1 -> code =  125*10 + 6 = 1256
//
// 1256 is the answer. Only the first loop elaborating gives 12; only the second,
// 56; the two interleaved, 1526; the second loop reusing `i` instead of its own
// `j` still gives 1256 only if `j` is genuinely a separate genvar with its own
// implicit localparam per copy, which is why the digit alphabets are disjoint
// (1,2 versus 5,6) rather than repeated.
//
//! lrm 6.6.1
//! lrm 6.9.1
//! bias V(p) = 0.75, V(n) = 0.25
//! xfail VerA's parser reads a generate block body as an analog statement, so the `analog` keyword inside `generate` dies at E0209 "expected an expression: found `analog`"
`include "check.vh"
module ch6_two_loops(p, n);
  inout p, n; electrical p, n; genvar i, j;
  integer code;
  analog code = 0;
  generate
    for (i = 0; i < 2; i = i + 1) begin : first
      analog begin
        code = code * 10 + (i + 1);
        I(p, n) <+ 0.0;
      end
    end
    for (j = 0; j < 2; j = j + 1) begin : second
      analog begin
        code = code * 10 + (j + 5);
        I(p, n) <+ 0.0;
      end
    end
  endgenerate
  analog `CHECKI("both loops unroll, in region order, without interleaving", code, 1256);
endmodule
