// §6.2, verbatim: "The keyword macromodule can be used interchangeably with the
// keyword module TO DEFINE A MODULE. An implementation may choose to treat module
// definitions beginning with the macromodule keyword differently." Syntax 6-1 puts
// it in the grammar: `module_keyword ::= module | macromodule | connectmodule`.
//
// The second sentence is a licence to OPTIMIZE, not to refuse: the first sentence
// already makes the keyword a way of defining a module, so a definition spelled
// this way must be accepted. This is therefore a run fixture and not a
// `//! reject`.
//
// What is asserted is chosen to stay inside the first sentence and clear of the
// second. Nothing here is about flattening, hierarchy, or how the instance is
// stored — the two checks are the module's own arithmetic and its own parameter
// state, which "treating the definition differently" cannot move without changing
// what the module MEANS. Held at V(p) = 0.5 with the declared gain of 2.0, the
// contribution is 1.0, binary-exact, hence CHECKX; the parameter is not
// overridden, so $param_given is 0 (§9.19).
//
// Annex B lists `macromodule` as a reserved keyword and annex_b_keywords carries a
// file for it, but that one is `macromodule m(input a, output b); assign b = a;`,
// which is rejected for the digital `assign` and never reaches the
// interchangeability rule. This is the analog form that does.
//
//! lrm 6.2
//! bias V(p) = 0.5
//! xfail VerA rejects the keyword outright: E0201 "construct is not in the supported subset: `macromodule`"
`include "check.vh"
macromodule ch6_macromodule(p);
  inout p; electrical p;
  parameter real gain = 2.0;
  analog begin
    `CHECKX("a macromodule body behaves as a module body", gain * V(p), 1.0);
    `CHECKI("and nothing about the keyword overrides a parameter", $param_given(gain), 0);
    I(p) <+ gain * V(p);
  end
endmodule
