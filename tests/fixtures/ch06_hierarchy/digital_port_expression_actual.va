// §6.2.2: "A connection can be a simple reference to a variable or a net
// identifier, an expression or a blank. An expression can be used for
// supplying a value to a module input port if it is a digital port."
//
// `u.i` is digital (`ddiscrete`), so `a | b` is a legal actual and the port
// receives its value. The flatten synthesizes one net for the port's
// hierarchical path and drives it with `assign u.i = a | b`; the child's
// `V(o) <+ i` then reads that net as a discrete input (§7.3.1, Table 7-1's
// integer row) and contributes the value as a potential. `a = 1, b = 0` makes
// the expression 1, so the only accepted solution is V(out) = 1.
//
// The negative half is `analog_port_expression_actual_rejected.va`: the same
// shape with a continuous `electrical` input is E0906, because the clause
// scopes expressions to digital ports.
//
//! lrm 6.2.2
//! lrm 6.2.2:1002
//! checks 1
//! solve
`include "disciplines.vams"
`include "check.vh"
module ch06_digital_port_expression_actual(out);
  output out; voltage out;
  reg a, b;
  wire w;
  initial begin
    a = 1'b1;
    b = 1'b0;
  end
  ch06_digital_port_expression_child u(.o(w), .i(a | b));
  analog begin
    `CHECKX("§6.2.2 a digital input port takes an expression actual", V(out), 1.0);
    V(out) <+ V(w);
  end
endmodule

module ch06_digital_port_expression_child(o, i);
  output o; voltage o;
  input i; ddiscrete i;
  analog V(o) <+ i;
endmodule
