// LRM 3.4: a parameter's default may be a constant expression over parameters
// declared before it. §6.3 is what makes an instance override REPLACE that
// declared value — by order (§6.3.2), by name (§6.3.3) or by defparam (§6.3.1) —
// and §6.3.4 is what makes the replacement propagate: "an update of gate_width,
// whether by a defparam statement or in an instantiation statement,
// automatically updates gate_cap". The two together mean the chain is
// RE-EVALUATED with the override in place, not frozen at the values the
// declarations happened to produce.
//
// (This file used to cite §6.5.3, which is Real valued ports and contains no
// part of this rule. The cite moved; the wants did not.)
//
// The testbench overrides only a, to 4.0. Therefore
//   b = a + 1 = 5.0        (3.0 if b kept its default-time value)
//   c = a * b = 20.0       (6.0 if nothing propagated, 12.0 if only b did)
// so the three outcomes are distinguishable and 20.0 is the only correct one.
//
//! lrm 6.3
//! lrm 6.3.4
//! lrm 6.3.4:1000
//! param a = 4.0
`include "check.vh"
module ch6_param_chain(p);
  inout p; electrical p;
  parameter real a = 2.0;
  parameter real b = a + 1.0;
  parameter real c = a * b;
  analog begin
    `CHECKX("the override propagates one level", b, 5.0);
    `CHECKX("and through the second dependent parameter", c, 20.0);
    I(p) <+ c;
  end
endmodule
