// §6.6.1 loop generate: the generate block is instantiated once per genvar
// value, and the genvar is "an integer parameter" in each instance, "the
// value of the index variable at the time the instance was elaborated". The
// loop ends after 4097 iterations, so it breaks no rule and every block
// exists. Until 2026-10-15 the instance walk followed at most 4096 iterations
// and lowering refused the loop (E0485, retired); both now follow the scheme
// until it ends or repeats a value (generate_nonterminating_rejected.va).
//
// BY HAND. g[i].u is a gen4097_leaf with k = i, i = 0 .. 4096. Exactly two
// leaves pass their test: g[0].u (k = 0) and g[4096].u (k = 4096), the
// 4097th, which exists only if every iteration was elaborated. Each checks
// its own k exactly: two checks. Each leaf also stamps 1e-6 * V(c); the 4097
// stamps sum into one row, which no check reads.
//
//! lrm 6.6.1
//! bias V(p) = 0.5
//! checks 2
`include "check.vh"
module generate_loop_4097_instances(p);
  inout p; electrical p;
  genvar i;
  generate
    for (i = 0; i < 4097; i = i + 1) begin : g
      gen4097_leaf #(.k(i)) u(p);
    end
  endgenerate
endmodule
module gen4097_leaf(c);
  inout c; electrical c;
  parameter integer k = -1;
  analog begin
    if (k == 0) `CHECKI("the first generated instance has k = 0", k, 0);
    if (k == 4096) `CHECKI("the 4097th generated instance exists, with k = 4096", k, 4096);
    I(c) <+ 1e-6 * V(c);
  end
endmodule
