// §6.5.3 "Ports may be declared as real-valued with a discrete-time discipline
// using the net type wreal (defined in 3.7). There can be a maximum of one
// driver of a real-valued net."
//
// The positive half: a wreal PORT carries a real value across the module
// boundary. The parent drives its wreal net with one continuous assignment
// (the single driver the clause permits); the child declares the port wreal
// and turns it into a potential, which is §3.7's own `drv` example
// (`wreal in; ... V(out) <+ in;`).
//
// DERIVATION. The parent's driver is 0.625 (dyadic). The child contributes
// V(out) <+ in on a potential-only `voltage` output, so V(out) = 0.625 exactly,
// and the child also reads `in` directly.
//
// The three annex_c_analog_subset/*_real_value_*_port_accepted.va fixtures
// (formerly `_rejected`, the Verilog-A SUBSET's C.8 refusal) carry the
// one-declaration `input|output|inout wreal p;` spelling.
//
//! lrm 6.5.3
//! lrm 6.5.3:1
//! lrm 3.7
//! lrm 7.4.2
//! lrm 7.4.2:2
//! solve
`include "check.vh"
module ch6_real_valued_wreal_port(out);
  output out;
  voltage out;
  wreal stim;
  assign stim = 0.625;
  ch6_wreal_drv f1(stim, out);
endmodule

module ch6_wreal_drv(in, out);
  input in;
  output out;
  wreal in;
  voltage out;
  analog begin
    `CHECKX("§6.5.3 the wreal port delivers the parent's real value", in, 0.625);
    V(out) <+ in;
  end
endmodule
