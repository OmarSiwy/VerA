// §6.3 applies defparam before §6.4.2 selects the near link of a §6.4 chain.
// The outer w=7 overrides inline w=2, selecting near->far_high->leaf.
// far_high sets gain=5, so I=5*(1/2)=2.5 A. The near links have no module
// parameter assignment: this asserts no unspecified near/far precedence.
// A.1.9: a paramset needs >= 1 paramset_item_declaration (corrected 2026-10-08)
//! lrm 6.3
//! lrm 6.4
//! lrm 6.4.2
//! lrm 6.4.2:4
//! lrm 6.4:1
//! lrm 6.4:2
//! bias V(p) = 0.5
//! checks 2
`include "check.vh"
module ps_outer_chain(p);
  inout p; electrical p;
  ps_chain_near #(.w(2.0)) u(p);
  defparam u.w=7.0;
  analog begin
    `CHECKX("defparam selected the high chain", u.gain, 5.0);
    `CHECKX("the far link's behavior executes", I(u.br), 2.5);
    I(p) <+ 0.0;
  end
endmodule
paramset ps_chain_near ps_chain_far_low;
  parameter real w=1.0 from [0:4);
  real tag;
  tag=w;
endparamset
paramset ps_chain_near ps_chain_far_high;
  parameter real w=0.0 from [4:10];
  real tag;
  tag=w;
endparamset
paramset ps_chain_far_low ps_chain_leaf;
  parameter real unused_item = 0;
  .gain=2.0;
endparamset
paramset ps_chain_far_high ps_chain_leaf;
  parameter real unused_item = 0;
  .gain=5.0;
endparamset
module ps_chain_leaf(p);
  inout p; electrical p;
  parameter real gain=1.0;
  branch (p) br;
  analog I(br) <+ gain*V(br);
endmodule
