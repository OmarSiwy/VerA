// LRM §6.3.5 / §9.19: "$param_given() ... shall be one (1) if the parameter was
// overridden, either by a defparam statement or by a module instance parameter
// value assignment, and zero (0) otherwise." The testbench overrides gain to
// 2.0, so the answer is 1 — a compiler that compared the supplied value against
// the declared default would answer 0 for an override that happens to match,
// and one that never wired the flag would answer 0 here.
//
// The ternary is the consequence: the first arm is taken, and with V(p) = 0.25
// the contributed current is 2.0 * 0.25 = 0.5 exactly, twice what the
// not-given arm would give.
//
//! lrm 6.3.5
//! lrm 9.19
//! lrm 6.3.5:1000
//! lrm 9.19:4
//! param gain = 2.0
//! bias V(p) = 0.25
`include "check.vh"
module ch6_param_given(p);
  inout p; electrical p;
  parameter real gain = 1.0;
  analog begin
    `CHECKI("$param_given reports the override", $param_given(gain), 1);
    `CHECKX("the given arm scales by gain", ($param_given(gain) ? gain * V(p) : V(p)), 0.5);
    I(p) <+ $param_given(gain) ? gain * V(p) : V(p);
  end
endmodule
