// A digital initial block and an analog block read the same child net and
// named branch. The source fixes both potentials at 2 V; the digital sample
// is after the initial analog solution, away from a changing input.
//! lrm 6.7.1:1005
//! xfail Hierarchical net and branch probes in a digital initial block are refused with E0437.
//! solve
//! time 0, 1n, 2n
`include "check.vh"
`timescale 1ns/1ps
module hierarchy_probe_child;
  electrical p, g;
  ground g;
  branch (p, g) sense;
  analog V(sense) <+ 2.0;
endmodule
module hierarchical_analog_probes_from_digital;
  hierarchy_probe_child u();
  initial begin
    #1;
    `CHECKX("digital hierarchical net", V(u.p), 2.0);
    `CHECKX("digital hierarchical branch", V(u.sense), 2.0);
  end
  analog begin
    `CHECKX("analog hierarchical net", V(u.p), 2.0);
    `CHECKX("analog hierarchical branch", V(u.sense), 2.0);
  end
endmodule
