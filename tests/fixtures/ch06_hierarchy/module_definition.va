// §6.2: "A module definition shall be enclosed between the keywords module and
// endmodule ... The OPTIONAL list of ports or port declarations shall specify an
// ordered list of the ports of the module." Optional is the word this file pins:
// Annex A.1.2's `module_declaration` admits `module identifier ;`, so a module
// with no port list at all is a well-formed definition and must compile. `p` here
// is an internal node, which is the only kind such a module can have.
//
// It now asserts, and the assertion is about exactly that. A portless module's
// only equations are over its private nodes, so the one observable fact is that
// those equations are still SOLVED: KCL at p is V(p)/1 - 1A = 0, whose unique
// solution is V(p) = 1V. A compiler that dropped the internal node, or emitted it
// and left it untied, reads 0 here — which is also Newton's starting guess, so the
// source term is what makes the difference visible.
//
// Do not add a port to make it run. A port-bearing module is every other fixture
// in this directory, and adding one here deletes the only test of the word
// "optional". Its sibling top_level_module.va carries the port and $mfactor.
//
// This file was CANNOT RUN until the device contract stopped requiring
// `num_ports` in 1..|U|. That guard predated the testbench having a Newton solve
// at all: with one, a device with zero terminals and one internal node has a
// residual something can solve, so refusing it was a stale host restriction and
// never a source-language rule. §6.2's "optional" is now checked end to end.
//
//! lrm 6.2
//! lrm 6.2:1
//! lrm 6.2:4
//! solve
`include "check.vh"
module ch6_definition;
  electrical p;
  analog begin
    I(p) <+ V(p) - 1.0;
    `CHECKX("a portless module's internal node is still solved: V(p)/1 = 1A", V(p), 1.0);
  end
endmodule
