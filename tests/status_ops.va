// §9.7.3 `$fatal`/`$error` in a device, which cannot print or stop its
// host: the status channel (`contract.StatusSite`), driven by
// tests/status_host.zig. `mode` picks which sites can run:
//   1  the analog block's `$error`, when V(p,n) > lim, with two arguments
//   2  `analog initial`'s `$fatal(1, ...)`, two arguments
//   3  a `vera_timepoint` statement's `$error`, one argument
//   4  the analog block's `$fatal(2, ...)`, when V(p,n) > lim
//   5  both 1 and 4: the first one reached (site 2) is the status
// Sites in source order: 0 initial $fatal, 1 timepoint $error, 2 $error,
// 3 $fatal.
`include "disciplines.vams"
module status_ops(p, n);
  inout p, n;
  electrical p, n;
  parameter integer mode = 0;
  parameter real lim = 1.0;
  analog initial begin
    if (mode == 2) $fatal(1, "initial: mode %d lim %g", mode, lim);
  end
  analog begin
    (* vera_timepoint *) if (mode == 3) $error("timepoint: lim %g", lim);
    if ((mode == 1 || mode == 5) && V(p, n) > lim)
      $error("V(p,n) = %g exceeds %g", V(p, n), lim);
    if ((mode == 4 || mode == 5) && V(p, n) > lim)
      $fatal(2, "fatal %d", 7);
    I(p, n) <+ V(p, n) / 1k;
    I(p, n) <+ ddt(1p * V(p, n));
  end
endmodule
