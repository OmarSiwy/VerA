module rng_effects(p,n);
  inout p,n; electrical p,n;
  parameter integer mode = 0;
  parameter real mean = 0;
  integer seed, i;
  real unused;
  analog begin
    seed = 7;
    if (mode == 0) unused = $rdist_exponential(seed,V(p,n));
    if (mode == 1 && V(p,n) > 0) unused = $rdist_exponential(seed,mean);
    if (mode == 2) unused = V(p,n) > 0 ? $rdist_exponential(seed,mean) : 0.0;
    if (mode == 3) unused = (V(p,n) > 0) && $rdist_exponential(seed,mean);
    if (mode == 4) unused = (V(p,n) <= 0) || $rdist_exponential(seed,mean);
    if (mode == 5 && V(p,n) > 0) begin
      if (mean <= 0) unused = $rdist_exponential(seed,mean);
    end
    if (mode == 6) begin
      unused = $rdist_chi_square(seed,V(p,n));
      unused = $rdist_uniform(seed,0,mean);
    end
    if (mode == 7) begin
      unused = $rdist_uniform(seed,0,mean);
      unused = $rdist_chi_square(seed,V(p,n));
    end
    if (mode == 8) begin
      for (i=0; i<2; i=i+1)
        if (i==1) unused = $rdist_exponential(seed,V(p,n));
    end
    if (mode == 9) begin
      for (i=0; i<2; i=i+1)
        if (i<0) unused = $rdist_exponential(seed,V(p,n));
    end
    if (mode == 10) begin
      for (i=0; i<3; i=i+1) begin
        if (i==1) break;
        if (i==2) unused = $rdist_exponential(seed,mean);
      end
    end
    if (mode == 11) begin
      for (i=0; i<2; i=i+1) begin
        if (i==0) continue;
        unused = $rdist_exponential(seed,mean);
      end
    end
    if (mode == 12 && V(p,n) > 0) unused = $rdist_exponential(seed,0);
    if (mode == 13) unused = V(p,n) > 0 ? $rdist_exponential(seed,0) : 0.0;
    if (mode == 14) unused = (V(p,n) > 0) && $rdist_exponential(seed,0);
    if (mode == 15) unused = (V(p,n) <= 0) || $rdist_exponential(seed,0);
    if (mode == 16) begin
      unused = 0 && $rdist_exponential(seed,0);
      unused = 1 || $rdist_exponential(seed,0);
      unused = 0 ? $rdist_exponential(seed,0) : 2;
      if (0) unused = $rdist_exponential(seed,0);
      for (i=0; i<0; i=$rdist_exponential(seed,0)) unused=0;
    end
    if (mode == 17) unused = $rdist_exponential(seed,mean);
    if (mode == 18 && V(p,n) > 0) unused = $rdist_chi_square(seed,1.5);
    if (mode == 19 && V(p,n) > 0) unused = $rdist_uniform(seed,5,1);
    I(p,n) <+ V(p,n);
  end
endmodule
