`include "literal_nul.vh"
module literal_nul(p,n);
  inout p,n; electrical p,n;
  string stored = "A\000B";
  string assigned;
  parameter string stored_parameter = "P\000Q";
  analog begin
    assigned = "C\000D";
    $display("literal=[A\000B] direct=[%s] stored=[%s] assigned=[%s] parameter=[%s]",
             "A\000B", stored, assigned, stored_parameter);
    $display("edges=[\0A\00B\000] octal=[\101\102\103]");
    $display("raw=[\000A\000] conversion=[%s] numeric=[%s] padded=[%4s]", "\000A\000", 24'h004100, "\000A\000");
    $display("packed=[%h] decimal=[%d]","A\000B","A\000B");
    $display(`NUL_FORMAT);
    $display("macro-operand=[%s]",`NUL_LITERAL);
    assigned = `NUL_LITERAL;
    $display("macro-stored=[%s]",assigned);
    $sformat(assigned, "stored-format=[A\000B] numeric=[%s] width=[%6s] packed=[%h]", 24'h410042, "A\000B", "A\000B");
    $display("%s", assigned);
    $swrite(assigned, "stored-write=[A\000B%s%c]", "C\000D", 0);
    $display("%s", assigned);
    I(p,n) <+ V(p,n);
  end
endmodule
