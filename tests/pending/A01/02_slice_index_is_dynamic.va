// The same §5.7 slice as 01_partial_slice_assignment.va, but with the slice's
// own subscript computed DURING the solve rather than folded by the compiler.
//
// §5.7 / Annex A.8.5 spell the slice subscript `analog_expression`, not
// `constant_expression`:
//
//   array_analog_variable_rvalue ::=
//         array_variable_identifier
//       | array_variable_identifier [ analog_expression ] { [ analog_expression ] }
//       | assignment_pattern
//
// and §4.5.14 draws the constant/dynamic line only for analog OPERATOR
// arguments, not for subscripts. So a slice index is an ordinary runtime value,
// and this fixture is written so that no amount of constant propagation can
// turn it back into a literal: both indices come from a signal probe.
//
// THE DERIVATION, by hand.
//
//   bias V(p) = 0.5, V(n) = 0 (the `n` terminal is the harness's ground row),
//   so V(p,n) = 0.5 exactly — 0.5 is a power of two and carries no rounding.
//
//   §4.2.1 Operators with real operands, the sentence immediately below
//   Table 4-2: "The result of using logical or relational operators on real
//   numbers is an integer value 0 (false) or 1 (true)." 0.5 > 0.0 is true, so
//   that subexpression is the INTEGER 1.
//
//   (Corrected after review: this sentence was cited as §4.2.5 here and in
//   fixtures 04, 05, 06, 08. §4.2.5 Relational operators is a real clause and
//   it does say "yields the value zero (0) ... or the value one (1)", but it
//   never says INTEGER and it does not contain the quoted text — and it is
//   about relational operators only, whereas this row also leans on `!=` and
//   on the result TYPE. §4.2.1 is the clause that says both. Fixture 05's
//   prose already had it right; the row contradicted itself.)
//
//     src = 2 * 1        = 2
//     dst = 2 - src      = 0
//
//   The table is the same one 01 builds, flag_array[i][j] = 10*i + j:
//
//              j=0   j=1   j=2   j=3
//     i=0        0     1     2     3
//     i=1       10    11    12    13
//     i=2       20    21    22    23
//
//     row              = flag_array[src]  = flag_array[2] = { 20, 21, 22, 23 }
//     flag_array[dst]  = row              -> row 0 becomes { 20, 21, 22, 23 }
//
// The four wants below are each sensitive to a different way of getting this
// wrong:
//
//   row[1]           == 21  — the dynamic slice READ picked row 2. Reading
//                             row 0 gives 1, row 1 gives 11.
//   flag_array[0][1] == 21  — the dynamic slice WRITE landed on row 0.
//   flag_array[2][1] == 21  — and did not disturb its own source row.
//   flag_array[1][1] == 11  — nor the row between them. A flattening bug that
//                             treated `flag_array[dst]` as a scalar offset
//                             would write element 0 of the flat array and leave
//                             this at 11 too, which is why the first two wants
//                             carry the weight and this one is the guard.
//
// WHY IT FAILS TODAY. Same refusal as 01: `checkSubscriptCount`
// (`src/ir/lower.zig`) demands one subscript per declared dimension, so
// `flag_array[src]` on a 2-D array is E0356 before the dynamic question is ever
// reached. Once slices exist, this is the fixture that says they are not
// required to be compile-time constants.
//
//! lrm 5.7
//! lrm 4.2.1
//! lrm A.8.5
//! bias V(p) = 0.5
//! print none
`include "check.vh"
module a01_slice_index_is_dynamic(p, n);
  inout p, n;
  electrical p, n;
  integer flag_array[0:2][0:3];
  integer row[0:3];
  integer i, j, src, dst;

  analog begin
    for (i = 0; i <= 2; i = i + 1)
      for (j = 0; j <= 3; j = j + 1)
        flag_array[i][j] = 10 * i + j;

    // Both subscripts are functions of the operating point, so neither can be
    // folded: §4.2.1 makes the comparison the integer 1 at this bias.
    src = 2 * (V(p, n) > 0.0);
    dst = 2 - src;

    row = flag_array[src];
    `CHECKI("a runtime slice index selects row 2", row[1], 21);

    flag_array[dst] = row;
    `CHECKI("and a runtime slice index on the left writes row 0", flag_array[0][1], 21);
    `CHECKI("the source row is unchanged", flag_array[2][1], 21);
    `CHECKI("the row between them is unchanged", flag_array[1][1], 11);

    I(p, n) <+ V(p, n);
  end
endmodule
