// Reading an array element whose runtime subscript is outside the declared
// dimension. This is the weakest-grounded fixture in the row and the header
// says so up front: the Verilog-AMS text does not name a value directly, so the
// number below is reached in two steps and each one is written out.
//
// STEP 1 — THE PART THE LRM DOES SAY. §5.7 Analog procedural assignments:
//
//   "The requirements of unpacked array variable assignments are A SUBSET OF
//    THE REQUIREMENTS OF IEEE Std 1800 SystemVerilog."
//
// and §3.2 fixes the initial contents of the storage that does exist:
//
//   "Integer variables whose values are assigned in an analog context default
//    to an initial value of zero (0). ... Real variables are initialized to
//    zero (0) at the start of a simulation."
//
// An unpacked-array read at an address the array does not have yields the
// element type's default under the delegated IEEE 1800 rules, and §3.2 says
// what a `real` default is here: 0.0. That is where the `0.0` want comes from.
// It is an INHERITED rule, not a Verilog-AMS sentence, and a reviewer who
// disagrees should change that want — not the two claims above it, which stand
// on their own.
//
// STEP 2 — THE PART THAT NEEDS NO DELEGATION AT ALL. §5.7 says a procedural
// assignment's left side is "an ELEMENT of an integer, real or string array",
// and Annex A.8.5 makes the subscript an `analog_expression`. A subscript
// outside the declared range designates no element. Two consequences follow
// from that alone, and they are the assertions that carry this fixture:
//
//   (a) the read must not ALIAS a different element — an implementation that
//       clamps, wraps or takes a modulus hands back a neighbour's value, which
//       is a silently wrong model rather than a missing feature; and
//   (b) the read must not abort the simulation — §4.3.2 reserves "shall report
//       an error" for a named case and a subscript is not one of them; a device
//       that crashes cannot report anything at all.
//
// THE DERIVATION, by hand.
//
//   real a[0:2];  a[0] = 1.0, a[1] = 2.0, a[2] = 3.0.
//
//   bias V(p) = 0.5 against the grounded `n` row, so V(p,n) = 0.5 and §4.2.1
//   makes `V(p,n) > 0.0` the integer 1. Hence
//
//     hi =  5 * 1 = 5      (four past the top index)
//     lo =  0 - 1 = -1     (one under the bottom index)
//
//   and neither folds, because both depend on the probe.
//
//   past_top = a[hi] and past_bot = a[lo] are each 0.0.
//
//   The spoiler values are named explicitly rather than left implicit:
//     * a CLAMP gives past_top = a[2] = 3.0 and past_bot = a[0] = 1.0;
//     * a MODULUS gives past_bot = a[(-1) mod 3] = a[2] = 3.0;
//   so the two inequality assertions fail for both of those, independently of
//   whether 0.0 is the right default.
//
//   The `!=` comparisons are §4.2.7 logical equality on reals, which §4.2.1
//   says yields "an integer value 0 (false) or 1 (true)", so each conjunction
//   is an integer and `CHECKI` is the right macro for it.
//
//   (`above` and `below` are Verilog-AMS keywords, hence `past_top`/`past_bot`.)
//
// WHY IT FAILS TODAY. `src/backend/codegen.zig` `emitIdx` lowers a runtime read
// to a `switch` over the scalarized cells and closes it with
//
//   else => @panic("VerA: out-of-range array read is not implemented")
//
// — the gap is deliberate and documented in that function's own header ("Exact
// invalid-index values are not implemented ... Fail explicitly instead of
// substituting another cell"), which is the right call for a half-built feature
// and is still a conformance hole. Observed today: the built device aborts
// before the first `$strobe` flushes, so NOTHING in this fixture prints.
//
//! lrm 5.7
//! lrm 3.2
//! lrm 4.2.1
//! bias V(p) = 0.5
//! print none
`include "check.vh"
module a01_invalid_index_read_value(p, n);
  inout p, n;
  electrical p, n;
  real a[0:2];
  integer hi, lo;
  real past_top, past_bot;

  analog begin
    a[0] = 1.0; a[1] = 2.0; a[2] = 3.0;

    hi = 5 * (V(p, n) > 0.0);
    lo = 0 - (V(p, n) > 0.0);

    past_top = a[hi];
    past_bot = a[lo];

    // (a) — no aliasing, in either direction. Independent of the default value.
    `CHECKI("a read past the top does not clamp or wrap onto an element",
            (past_top != 3.0) && (past_top != 2.0) && (past_top != 1.0), 1);
    `CHECKI("a read under the bottom does not clamp or wrap onto an element",
            (past_bot != 3.0) && (past_bot != 2.0) && (past_bot != 1.0), 1);

    // (b) + step 1 — the inherited default. See the header: this is the want a
    // reviewer would revisit, not the two assertions above.
    `CHECKX("an out-of-range read yields the real default", past_top, 0.0);
    `CHECKX("in both directions", past_bot, 0.0);

    I(p, n) <+ V(p, n);
  end
endmodule
