// §5.7 Analog procedural assignments, the unpacked-array rules:
//
//   "The array on the LHS of the assignment shall be an array variable, A SLICE
//    OF AN ARRAY VARIABLE or an array parameter (when the default value of the
//    parameter is assigned)."
//   "Array assignments shall only be done with arrays that are compatible. An
//    array, OR A SLICE OF SUCH AN ARRAY, shall be assignment compatible with any
//    other such array or slice if all the following conditions are satisfied:
//    — The element types of source and target shall be equivalent.
//    — Every dimension of the source array shall have the same number of
//      elements as the target array."
//
// WHAT A SLICE IS SPELLED AS. Annex A.8.5 gives the right-hand side production
//
//   array_analog_variable_rvalue ::=
//         array_variable_identifier
//       | array_variable_identifier [ analog_expression ] { [ analog_expression ] }
//       | assignment_pattern
//
// — a subscript list that is SHORTER than the declared dimension list. So for
// §3.2's own declared example `integer flag_array[0:8][0:3]`, `flag_array[3]` is
// one subscript on a two-dimensional array: a slice, the 4-element row, not a
// scalar. `{ }` is zero-or-more in the annex's metasyntax, which is exactly what
// makes the short form legal. (The annex prints `array_analog_variable_lvalue`
// on the left of `array_analog_variable_assignment` without defining it; the
// matching left-side production is the same shape, which is also what the §5.7
// sentence quoted above says in prose.)
//
// THE ARRAY AND THE NUMBERS, all hand-computed, no bias involved:
//
//   integer flag_array[0:2][0:3];      // §3.2's shape, one row shorter
//   flag_array[i][j] = 10*i + j;       // so every cell names its own address
//
//              j=0   j=1   j=2   j=3
//     i=0        0     1     2     3
//     i=1       10    11    12    13
//     i=2       20    21    22    23
//
//   row = flag_array[1];       // SLICE READ  -> row = { 10, 11, 12, 13 }
//   row[0] = 99;               // mutate the copy
//   flag_array[2] = row;       // SLICE WRITE -> row 2 becomes { 99, 11, 12, 13 }
//
// Four independent claims come out of that, and each one fails differently:
//
//   flag_array[2][0] == 99  — the slice write landed, and landed at column 0.
//   flag_array[2][3] == 13  — it copied the WHOLE row, not just the element
//                             that was changed; 13 is row 1's value, so a
//                             no-op write leaves 23 here and fails.
//   flag_array[1][0] == 10  — §5.7 assignment is a COPY. If `row` aliased the
//                             slice, `row[0] = 99` would have written through
//                             and this reads 99.
//   row[3]           == 13  — the slice read took row 1 and not row 0 (which
//                             would give 3) and not a flattened prefix of the
//                             whole array (which would also give 3).
//
// WHY IT FAILS TODAY. VerA scalarizes every array and requires the subscript
// count to equal the dimension count — `src/ir/lower.zig` `checkSubscriptCount`,
// diagnostic E0356. Its own header comment names this exact case as the reason
// the check exists ("a caller that checked only the range would read
// `flag_array[3]`, a whole ROW, as if it were a scalar"), so the short form is
// refused rather than implemented. Observed today:
//
//   error[E0356]: wrong number of array subscripts: `flag_array` is declared
//                 with 2 dimension(s) and is indexed with 1
//
// on BOTH the read and the write, plus a cascading E0314 on `row`.
//
//! lrm 5.7
//! lrm 3.2
//! lrm A.8.5
//! bias V(p) = 0.5
//! print none
`include "check.vh"
module a01_partial_slice_assignment(p, n);
  inout p, n;
  electrical p, n;
  integer flag_array[0:2][0:3];
  integer row[0:3];
  integer i, j;

  analog begin
    for (i = 0; i <= 2; i = i + 1)
      for (j = 0; j <= 3; j = j + 1)
        flag_array[i][j] = 10 * i + j;

    row = flag_array[1];          // §5.7 slice on the RHS
    `CHECKI("a one-subscript read of a two-dimensional array is row 1", row[3], 13);

    row[0] = 99;
    flag_array[2] = row;          // §5.7 slice on the LHS

    `CHECKI("the slice write landed at column 0 of row 2", flag_array[2][0], 99);
    `CHECKI("and carried the rest of the row with it", flag_array[2][3], 13);
    `CHECKI("§5.7 assignment is a copy: row 1 is untouched", flag_array[1][0], 10);

    I(p, n) <+ V(p, n);
  end
endmodule
