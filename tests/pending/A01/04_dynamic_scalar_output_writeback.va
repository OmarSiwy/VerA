// §4.7.2.3 Output arguments:
//
//   "The argument passed to an output argument must be an ANALOG VARIABLE
//    REFERENCE. ... At the end of the execution of the analog user-defined
//    function, the last value assigned to the output argument is then assigned
//    to the corresponding analog variable reference that was passed into the
//    function."
//
// §4.7.2.4 Inout arguments:
//
//   "inout arguments allow the user to pass in a value to the function and
//    return a different value from it using the same argument. The argument
//    passed to an inout argument must be an analog variable reference. ... the
//    last value assigned to the inout argument is then assigned to the
//    corresponding analog variable reference that was passed into the function."
//
// "An analog variable reference" — §5.7 says what that can be: "either an
// integer, real, or string identifier OR AN ELEMENT OF AN INTEGER, REAL OR
// STRING ARRAY". Nothing in either clause restricts the element's subscript to
// a constant; Annex A.8.5 spells `analog_variable_lvalue` as
// `variable_identifier [ analog_expression ] { [ analog_expression ] }`, and an
// `analog_expression` is an ordinary runtime expression. So `f(..., slot[i])`
// with `i` computed during the solve is a legal output actual, and this fixture
// is the one that says so.
//
// THE FUNCTIONS are §4.7.1's own Example 2 (`geomcalc`, two `output` formals)
// with a return value added, plus a one-line `inout` helper, because the two
// directions differ in exactly one way that a DYNAMIC actual can expose:
// §4.7.2.3 resets the output actual to zero on entry, §4.7.2.4 copies the inout
// actual IN. A writeback that resolved the subscript but not the copy-in passes
// the output half and fails the inout half.
//
// THE DERIVATION, by hand.
//
//   bias V(p) = 0.5 against the grounded `n` row, so V(p,n) = 0.5 exactly.
//   §4.2.1 makes `V(p,n) > 0.0` the integer 1, so
//
//     i = 1        j = i + 1 = 2        k = 3 * i = 3
//
//   and none of the three can be constant-folded: each depends on the probe.
//
//   slot[0..3] all start at 1.0.
//
//   d = geomcalc(3.0, 4.0, slot[i], slot[j]):
//     area  = l * w       = 3 * 4       = 12
//     perim = 2 * (l + w) = 2 * (3 + 4) = 14
//     return  area + perim              = 26
//   so slot[1] = 12.0 and slot[2] = 14.0, and slot[0], slot[3] keep 1.0.
//   3, 4, 12, 14 and 26 are small integers, exact in IEEE 754.
//
//   t = bump(slot[k]) with slot[3] = 1.0:
//     v = v + 5.0 = 6.0
//   so slot[3] = 6.0 and t = 6.0. Because `bump`'s formal is `inout`, the 1.0
//   had to be READ out of the dynamically indexed cell first; an implementation
//   that zeroed it on entry (the `output` rule) gets 5.0 here and fails.
//
//   `d` and `t` are bound to variables before being checked: check.vh expands
//   its GOT twice, and a call with an output formal is not a pure expression.
//
// WHY IT FAILS TODAY. The writeback in `inlineUserFuncPre`
// (`src/ir/lower.zig`) ends in `const slot = try self.resolveLvalue(actual)`,
// and `resolveLvalue`'s `.index` arm requires `constEval` to succeed on every
// subscript. VerA otherwise HAS a runtime-index write path
// (`assignRuntimeIndex`, one masked write per cell) — it is simply not reached
// from here. Observed today:
//
//   error[E0311]: array index is not a constant expression: indexing `slot`
//     --> ...: d = geomcalc(3.0, 4.0, slot[i], slot[j]);
//
// (E0311 cites "LRM 3.2.2", a clause number that does not exist in this
// standard; the array declaration clause is §3.2.)
//
//! lrm 4.7.2.3
//! lrm 4.7.2.4
//! lrm 5.7
//! bias V(p) = 0.5
//! print none
`include "check.vh"
module a01_dynamic_scalar_output_writeback(p, n);
  inout p, n;
  electrical p, n;

  // §4.7.1 Example 2, verbatim apart from the added return value.
  analog function real geomcalc;
    input l, w;
    output area, perim;
    real l, w, area, perim;
    begin
      area = l * w;
      perim = 2 * ( l + w );
      geomcalc = area + perim;
    end
  endfunction

  analog function real bump;
    inout v;
    real v;
    begin
      v = v + 5.0;
      bump = v;
    end
  endfunction

  real slot[0:3];
  integer i, j, k;
  real d, t;

  analog begin
    slot[0] = 1.0; slot[1] = 1.0; slot[2] = 1.0; slot[3] = 1.0;

    // Functions of the operating point: nothing here folds to a literal.
    i = (V(p, n) > 0.0);
    j = i + 1;
    k = 3 * i;

    d = geomcalc(3.0, 4.0, slot[i], slot[j]);
    `CHECKX("an output argument writes back through a runtime subscript", slot[1], 12.0);
    `CHECKX("the second output argument lands in its own cell", slot[2], 14.0);
    `CHECKX("cells the call did not name are untouched", slot[0], 1.0);
    `CHECKX("§4.7.2.1: the identifier variable still carries the return", d, 26.0);

    t = bump(slot[k]);
    `CHECKX("an inout argument copies the runtime-indexed cell IN, then out", slot[3], 6.0);
    `CHECKX("and the same value is what the function returned", t, 6.0);

    I(p, n) <+ V(p, n);
  end
endmodule
