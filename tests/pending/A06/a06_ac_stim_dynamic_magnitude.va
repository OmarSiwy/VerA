// §4.6.3 the magnitude and phase of `ac_stim` are ANALOG EXPRESSIONS, not
// constants. A.8.2 spells it out:
//
//     analog_small_signal_function_call ::=
//           ac_stim ( [ " analysis_identifier " [ , analog_expression
//                                               [ , analog_expression ] ] ] )
//
// Only the analysis name is a quoted identifier; both numeric arguments are
// `analog_expression`, the same production a contribution's right-hand side
// uses. And §4.6.3 puts no constancy rule on them: "the source becomes active
// and models a source with magnitude mag and phase phase."
//
// This is NOT §4.5's constant-argument rule. Table 4-20 ("Analog operator
// arguments") lists every operator that has a constant-expression argument —
// absdelay, ddt, ddx, idt, idtmod, the laplace and zi families, last_crossing,
// limexp, slew, transition — and `ac_stim` is not in it, because it is not an
// analog operator: §4.6 classes it as an analysis-dependent function and it
// keeps no state, so §4.5.15's restrictions do not reach it.
//
// A swept-amplitude source is the reason the clause is written that way: an AC
// magnitude that tracks a bias (a mixer's LO amplitude, a variable-gain stage's
// control voltage) is exactly `ac_stim("ac", k*V(ctrl))`.
//
// THE NUMBERS. `ctrl` is held at 2.0 V and the reference at 0 V, so:
//
//   ac_stim("ac", V(ctrl))          mag = 2.0,  phase = 0 → +2.0
//   ac_stim("ac", 0.5*V(ctrl))      mag = 1.0,  phase = 0 → +1.0
//   ac_stim("ac", V(ctrl), `M_PI)   mag = 2.0,  phase = π → −2.0
//
// Each is an exact f64: 2.0, 0.5 and 1.0 are dyadic, and cos(`M_PI) is −1 to
// the last bit. The third line is the one that pins that the DYNAMIC magnitude
// and the phase compose rather than one of them silently winning.
//
// The `ctrl` node is held by a 1 kΩ resistor to the reference so the harness
// has a residual row to stamp; the stimulus itself is contributed on (p,n).
//
//! lrm 4.6.3
//! lrm A.8.2
//! analysis ac
//! bias V(ctrl) = 2.0
//! bias V(p) = 0.0
//! bias V(n) = 0.0
`include "check.vh"
module a06_ac_stim_dynamic_magnitude(p, n, ctrl);
    inout p, n, ctrl;
    electrical p, n, ctrl;
    parameter real R = 1000.0 from (0:inf);

    analog begin
        `CHECKX("a probe is a legal ac_stim magnitude", ac_stim("ac", V(ctrl)), 2.0);
        `CHECKX("and so is an expression over it", ac_stim("ac", 0.5 * V(ctrl)), 1.0);
        `CHECKX("dynamic magnitude and phase compose",
            ac_stim("ac", V(ctrl), `M_PI), -2.0);

        I(ctrl, n) <+ V(ctrl, n) / R;
        I(p, n) <+ ac_stim("ac", V(ctrl), 0.0);
    end
endmodule
