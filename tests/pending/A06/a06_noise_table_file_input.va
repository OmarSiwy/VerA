// §4.6.4.3 the FILE form of noise_table, with the clause's own example file.
//
// "The argument input can either be a vector or a string indicating a filename.
// … When the input is a file name, the indicated file will contain the
// frequency / power pairs. The file name argument shall be constant and will be
// either a string literal or a string parameter. Each frequency / power pair
// shall be separated by a newline and the numbers in the pair shall be
// separated by one or more spaces or tabs. To increase the readability of the
// data file, comments may be inserted before or after any frequency / power
// pair. Comments begin with '#' and end with a newline. The input file shall be
// in text format only and the numbers shall be real or integer."
//
// `a06_noise_table_input.tbl` beside this file is §4.6.4.3's printed example
// verbatim, plus ONE comment inserted BETWEEN two pairs — the clause permits a
// comment "before or after any frequency / power pair" and its own sample only
// shows leading and trailing ones, so the interior case needs a fixture or the
// rule is untested.
//
// WHAT THE EXPORT MUST BE. Seven knots, in the file's order (already ascending,
// so §4.6.4.3's sort is the identity here and this fixture does not test it —
// `ch04_expressions/181_noise_table_topology.va` does), with the powers
// transcribed exactly:
//
//     1e0  1.65758e-23      1e1  3.31516e-23      1e2  6.63632e-23
//     1e3  1.326064e-22     1e4  2.652128e-22     1e5  5.304256e-22
//     1e6  1.060851e-21
//
// THE "SELF-CHECKING" CLAIM AN EARLIER DRAFT MADE IS FALSE; this note replaces
// it. That draft said each power "is twice the one a decade below it, so a
// transcription slip of one digit is visible by eye". Recomputed, the six
// consecutive ratios are
//
//   3.315160 / 1.657580 = 2.0
//   6.636320 / 3.315160 = 2.0018098673970486        <-- not 2
//   13.26064 / 6.636320 = 1.9981917689321793        <-- not 2
//   2.652128 / 1.326064 = 2.0
//   5.304256 / 2.652128 = 2.0
//   10.60851 / 5.304256 = 1.9999996229442922        <-- not 2
//
// Two of the LRM's own printed numbers do not double. Row 3 is the interesting
// one: 2 × 3.315160e-23 is 6.630320e-23, while row 4 divided by four is
// 3.315160e-23 EXACTLY — so rows 2 and 4 bracket row 3 at precisely 4×, and the
// printed 6.636320e-23 reads like a digit slipped inside the STANDARD (a '3'
// set as a '6'), 9.05e-4 relative. Row 7 is 2 × 5.304256e-22 = 1.0608512e-21
// rounded to the seven significant digits the clause prints, 1.89e-7 relative.
//
// The .tbl transcribes the clause verbatim, slips included, because §4.6.4.3's
// requirement is on what a reader does with the printed file, not on whether
// the file is physical. A reviewer must NOT "correct" 6.636320e-23 to
// 6.630320e-23: it would then stop matching docs/ch4-expressions.html, which is
// the only thing this fixture is faithful to. The doubling is therefore NOT a
// transcription check, and no `CHECK` asserts it; check the seven pairs against
// the clause by eye instead.
//
// THE COMMENT COUNT, also corrected. There are SEVEN '#' lines: four at the
// head (two title lines, a bare '#', and the "freq pwr" ruler), TWO in the
// middle — the inserted comment wraps, and §4.6.4.3 makes a comment "begin with
// '#' and end with a newline", so a wrapped comment is two of them — and one at
// the tail. Seven comments plus seven pairs is fourteen lines, so a reader that
// took '#' as data would report 14 points, not 7. The earlier draft said six
// comment lines and 13 points; both were wrong.
//
// WHY THIS IS NOT COVERED BY THE EXISTING SUITE. `ch04_expressions/
// lrm_4_6_4_3.va` is green today and asserts nothing about it: it binds the
// call to a variable, checks the §4.6 zero, and carries no `//! noise` line, so
// nothing ever reads the export — and the export is EMPTY. Compiling that
// fixture with `--emit-zig` produces a device with no `noise_gens` at all: the
// generator vanished silently, which is worse than the E0519 the inline spelling
// gets, because a host cannot tell a model with no noise from a model whose
// noise was dropped. This fixture is the one that fails on that.
//
// WHERE THIS FIXTURE'S CLAIM LIVES. On the `//! noise table(…) points=` line.
// A file table is read by the COMPILER and handed to the host; §4.6.4.3 gives
// the model's own text no way to index it, and §4.6.4 gives an active generator
// no deterministic scalar value, so no `CHECK` can see a knot. Today the file
// spelling does not even reach the export: E0519, "a file name is not
// supported".
//
// The two `CHECK`s an earlier draft carried are gone, because neither could go
// red on any compiler: `3.31516e-23/1.65758e-23` against 2.0 is arithmetic over
// two literals (and, per the ratio table above, was also advertising a property
// the file does not have), and `V(p,n)/R` against 1e-3 looks like a dc check
// and is not one — `//! bias` PINS x[p] = 1.0 and x[n] = 0.0, so that probe
// reads 1.0/1000.0 whatever the table lowering does.
//
// What replaces them is §4.5.6 against a non-zero want, the same shape the rest
// of the row uses: the tabulated generator's power depends on frequency and on
// nothing in the state vector, so the branch's conductance is the resistor's
// alone, ddx(V(p,n)/R + nt, V(p)) = 1/R = 1e-3 S. A lowering that let a table
// entry reach an unknown moves it. That is a smaller claim than the `points=`
// line and is stated as one.
//
//! lrm 4.6.4.3
//! lrm 4.5.6
//! noise table(p,n)#0 name=file-input interp=linear points=1.0:1.65758e-23,10.0:3.31516e-23,100.0:6.63632e-23,1000.0:1.326064e-22,10000.0:2.652128e-22,100000.0:5.304256e-22,1000000.0:1.060851e-21
//! analysis noise
//! bias V(p) = 1.0
//! bias V(n) = 0.0
`include "check.vh"
module a06_noise_table_file_input(p, n);
    inout p, n;
    electrical p, n;
    parameter real R = 1000.0 from (0:inf);
    real nt;

    analog begin
        // Bound first: `CHECKEQ` expands its operands twice, and a noise call
        // is a generator-creating site rather than a pure expression.
        nt = noise_table("a06_noise_table_input.tbl", "file-input");

        `CHECKEQ("the tabulated generator is outside the branch linearization",
            ddx(V(p, n) / R + nt, V(p)), 1.0 / R, 1e-18);

        I(p, n) <+ V(p, n) / R + nt;
    end
endmodule
