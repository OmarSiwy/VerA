// §4.6.3 AC stimulus, in the analysis it is FOR. Every other fixture in the
// suite reads `ac_stim` in a dc point, where §4.6 hands over the literal zero;
// this one runs the small-signal analysis and pins the active values.
//
// §4.6.3, verbatim: "When the name of the small-signal analysis matches
// analysis_name, the source becomes active and models a source with magnitude
// mag and phase phase. The default magnitude is one (1) and the default phase
// is zero (0). phase is given in radians." And: "the expected name (of the
// equivalent of a SPICE AC analysis) is 'ac', which is the default value of
// analysis_name."
//
// WHY EACH NUMBER IS WHAT IT IS. A source of magnitude m and phase p is the
// phasor m·e^(jp). At p = 0 that is the real number +m, and at p = π it is the
// real number −m (e^(jπ) = −1), so those two phases — and only those two — have
// an exact real spelling that a `CHECK` can hold. So:
//
//   ac_stim()                    → mag 1, phase 0     → +1.0
//   ac_stim("ac")                → same, name spelled → +1.0
//   ac_stim("ac", 2.5)           → mag 2.5, phase 0   → +2.5
//   ac_stim("ac", 2.5, `M_PI)    → 2.5·e^(jπ)         → −2.5
//   ac_stim("xf", 2.5)           → name does not match the analysis, and the
//                                  clause makes that zero "on all small-signal
//                                  analyses using names which do not match
//                                  analysis_name"                     → 0.0
//
// `M_PI is annex D.1 (3.14159265358979323846), so the −2.5 is not a rounding
// question: cos(`M_PI) is −1 to the last bit in f64.
//
// THE OTHER HALF OF "ANALYSIS ENABLEMENT" is the noise family, and it is the
// mirror image here. §4.6.4: "The noise functions are only active in
// small-signal NOISE analyses and return zero (0) otherwise." An ac analysis is
// a small-signal analysis and is not a noise analysis, so all four read exactly
// 0.0 — the same zero they read in dc, for a different clause. A compiler that
// gated the noise family on "any small-signal analysis" passes
// `ch04_expressions/27_noise_sources.va` and fails here.
//
// Table 4-22's AC column is asserted alongside, because it is what the two
// rules above are stated in terms of: during the ac sweep "ac" is true and
// "static" is FALSE — "static" is true only in the operating point that
// PRECEDES the sweep, which is a separate pass with its own analysis kind.
//
//! lrm 4.6.3
//! lrm 4.6.4
//! lrm 4.6.1
//! analysis ac
//! bias V(p) = 0.5
//! bias V(n) = 0.0
`include "check.vh"
module a06_ac_stim_ac_analysis(p, n);
    inout p, n;
    electrical p, n;
    parameter real R = 1000.0 from (0:inf);

    analog begin
        `CHECKX("ac_stim() defaults to magnitude 1 at phase 0", ac_stim(), 1.0);
        `CHECKX("the default analysis_name is \"ac\"", ac_stim("ac"), 1.0);
        `CHECKX("an explicit magnitude is the source's magnitude", ac_stim("ac", 2.5), 2.5);
        `CHECKX("phase pi negates the phasor", ac_stim("ac", 2.5, `M_PI), -2.5);
        `CHECKX("phase 0 is the identity", ac_stim("ac", 2.5, 0.0), 2.5);
        `CHECKX("a non-matching analysis_name is inactive", ac_stim("xf", 2.5), 0.0);

        `CHECKX("white_noise is inactive in an ac analysis", white_noise(1e-18), 0.0);
        `CHECKX("flicker_noise is inactive in an ac analysis", flicker_noise(1e-20, 1.0), 0.0);
        `CHECKX("noise_table is inactive in an ac analysis",
            noise_table('{1.0, 1e-18, 1e6, 1e-24}), 0.0);
        `CHECKX("noise_table_log is inactive in an ac analysis",
            noise_table_log('{1.0, 1e-18, 1e6, 1e-24}), 0.0);

        `CHECKI("Table 4-22: \"ac\" matches an ac analysis", analysis("ac"), 1);
        `CHECKI("Table 4-22: \"static\" is false during the ac sweep", analysis("static"), 0);
        `CHECKI("Table 4-22: \"dc\" is false in an ac analysis", analysis("dc"), 0);
        `CHECKI("Table 4-22: \"noise\" is false in an ac analysis", analysis("noise"), 0);
        `CHECKI("Table 4-22: \"tran\" is false in an ac analysis", analysis("tran"), 0);

        I(p, n) <+ V(p, n) / R + ac_stim("ac", 2.5, 0.0);
    end
endmodule
