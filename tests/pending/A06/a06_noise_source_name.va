// §4.6.4.1 the optional `name` argument — the one argument of the noise family
// that VerA parses and then discards.
//
// The clause says what it is for, and says it identically in §4.6.4.1, .2, .3
// and .4: "The optional name argument acts as a label for the noise source used
// when the simulator outputs the individual contribution of each noise source
// to the total output noise. The contributions of noise sources with the same
// name FROM THE SAME INSTANCE of a module are COMBINED in the noise
// contribution summary."
//
// Two obligations, and the second is not decoration:
//   1. the label reaches the simulator per generator, and
//   2. two generators of the same instance sharing a label are reported as ONE
//      line, with their contributions combined.
//
// Naming is independent of §4.6.4.6's correlation and must not be confused with
// it. "Each noise function generates noise which is uncorrelated with the noise
// generated by other functions" — so the two `white_noise` calls below are
// INDEPENDENT generators (distinct source ids #0 and #1) that happen to carry
// the same label. Independent densities add, so the summary line "thermal"
// reports
//
//   1.0e-18 + 3.0e-18 = 4.0e-18 A²/Hz
//
// and NOT (sqrt(1e-18) + sqrt(3e-18))², which is 7.46e-18 and is what combining
// them as if they were correlated would give. The distinction is the reason
// this fixture keeps two same-named sources rather than one.
//
// The third generator carries a different label and stays its own line at
// 5.0e-18 A²/Hz. Total output density on the branch, all three being
// independent, is 9.0e-18 A²/Hz — the sum the two summary lines must reproduce.
//
// All three sit on the same branch, so nothing here depends on topology: the
// rows are distinguishable ONLY by their labels and source ids, which is
// exactly the property the clause is about.
//
// Today `contract.NoiseGen` has no name field at all — `Lower.NoiseSrc` records
// kind/id/pwr/exp/table and never the string — so a simulator cannot print a
// contribution summary for a VerA device at all, and a model's own names are
// dropped between the parser and the export.
//
// WHERE THIS FIXTURE'S CLAIM LIVES. On the three `//! noise … name=` lines, and
// nowhere else. A label is a property of the EXPORT; §4.6.4.1 gives it no
// reading inside the analog block, and §4.6.4 gives an ACTIVE noise function no
// deterministic scalar value either — so no `CHECK` can observe a name, a
// density, or their combination. This fixture fails today at `//!` directive:
// BadSyntax (`validNoiseEntry`, src/backend/tb.zig:341, requires everything
// after `#` to be digits), which is the gap it exists to hold open.
//
// An earlier draft padded that out with four `CHECK`s, none of which could go
// red on any compiler:
//
//   `1e-18 + 3e-18`           against 4e-18   — arithmetic over literals
//   `1e-18 + 3e-18 + 5e-18`   against 9e-18   — arithmetic over literals
//   `5e-18`                   against 5e-18   — a literal against ITSELF
//   `V(p,n)/R`                against 1e-3    — looks like a dc check and is
//         not one: `//! bias` PINS x[p] = 1.0 and x[n] = 0.0, so this probe
//         reads 1.0/1000.0 whatever the noise lowering does. It cannot move.
//
// All four are gone. The §4.6.4.6 arithmetic they were standing in for — that
// independent same-named sources combine as 4.0e-18 and not as
// (√1e-18+√3e-18)² = 7.46e-18 — stays in the prose above, where a reviewer can
// check it without a binary, and becomes a real assertion only when a host
// prints a contribution summary; that is ARPice's side, and SPEC.md's
// "Deliberately NOT covered" says so.
//
// WHAT REPLACES THEM is the one thing a noise generator IS observable through
// inside the analog block: the linearization. §4.6.4 keeps the generators out
// of the large-signal system, and §4.5.6 — "If the expression does not depend
// explicitly on the unknown, then ddx() returns zero (0)" — makes that testable
// against a NON-ZERO want, which is what gives it teeth:
//
//   ddx(V(p,n)/R + n0 + n1 + n2, V(p)) = 1/R = 1e-3 S exactly
//
// A lowering that let `white_noise(pwr)` reach an unknown — the shape of the
// mistake that would also make its density bias-dependent when the model did
// not ask for it — perturbs that number. The three powers here are constants,
// so the derivative has no legitimate contribution from them at all, and the
// band is 1e-18 absolute against a want of 1e-3: fifteen orders of headroom.
// `CHECKEQ` and not `CHECKR` because the want is an identity the LRM states
// (the resistor's conductance) rather than digits derived by hand.
//
//! lrm 4.6.4.1
//! lrm 4.6.4.2
//! lrm 4.5.6
//! noise thermal(p,n)#0 name=thermal white=1e-18
//! noise thermal(p,n)#1 name=thermal white=3e-18
//! noise thermal(p,n)#2 name=excess white=5e-18
//! analysis noise
//! bias V(p) = 1.0
//! bias V(n) = 0.0
`include "check.vh"
module a06_noise_source_name(p, n);
    inout p, n;
    electrical p, n;
    parameter real R = 1000.0 from (0:inf);
    real n0, n1, n2;

    analog begin
        // Bound to variables first: `CHECKEQ` expands its operands twice
        // (check.vh's own warning), and a noise call is a generator-creating
        // site, not a pure expression.
        n0 = white_noise(1e-18, "thermal");
        n1 = white_noise(3e-18, "thermal");
        n2 = white_noise(5e-18, "excess");

        // §4.5.6 against a non-zero want: the branch conductance is the
        // resistor's alone, 1/R. Band 1e-18 S against 1e-3 S.
        `CHECKEQ("the three generators are outside the branch linearization",
            ddx(V(p, n) / R + n0 + n1 + n2, V(p)), 1.0 / R, 1e-18);
        `CHECKEQ("and the same seen from the other terminal",
            ddx(V(p, n) / R + n0 + n1 + n2, V(n)), -1.0 / R, 1e-18);

        I(p, n) <+ V(p, n) / R + n0 + n1 + n2;
    end
endmodule
