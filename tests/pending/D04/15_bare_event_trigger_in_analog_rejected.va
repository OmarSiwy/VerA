// A.6.4 lists `event_trigger` under `analog_event_statement`:
//
//     analog_event_statement ::=
//           { attribute_instance } analog_loop_statement
//         | { attribute_instance } analog_case_statement
//         | { attribute_instance } analog_conditional_statement
//         | { attribute_instance } analog_procedural_assignment
//         | { attribute_instance } analog_event_seq_block
//         | { attribute_instance } analog_system_task_enable
//         | { attribute_instance } disable_statement
//         | { attribute_instance } event_trigger
//         | { attribute_instance } ;
//
// and NOT under `analog_statement`, whose full alternative list is
// analog_loop_generate_statement, analog_loop_statement, analog_case_statement,
// analog_conditional_statement, analog_procedural_assignment, analog_seq_block,
// analog_system_task_enable, contribution_statement,
// indirect_contribution_statement, analog_event_control_statement and
// jump_statement. So `-> ev;` written directly on the analog spine — outside any
// `@(...)` — has no derivation. The only legal analog spelling is the one
// §5.10.4's own example uses:
//
//     @(timer(1n)) -> ana_event;
//
// This is the same argument, alternative for alternative, that
// annex_a_syntax/18_disable_statement.va makes for `disable` (E0401):
// disable_statement and event_trigger are neighbours in the very list above, and
// both are absent from the one below it.
//
// WHY THIS FIXTURE EXISTS. VerA accepts the form today, and its own source says
// so: lower.zig's `lowerEventTrigger` carries the comment "That is NOT gated
// here: unlike `disable` (E0401), no fixture pins it ... Add the `!in_event_stmt`
// gate beside `lowerDisable`'s when a fixture asks." This is the fixture asking.
// `vera --lint` on this file exits 0 at the time of writing.
//
// The permissive reading — "an unconditional trigger means the event is active
// at every timepoint" — is not harmless once §5.10.4's cross-domain use is
// implemented: `always @(ev)` in the digital domain would then see a trigger at
// every analog timepoint, i.e. a rate set by the solver's step control rather
// than by the model.
//
// EXPECTED CODE. The natural home is a new class-4 diagnostic beside E0401
// ("`disable` is not an analog statement", lrm A.6.4) with the same shape —
// title "`->` is not an analog statement", help "only `@(<event>) -> ev;` is
// legal". Until that code is allocated the phase label is the expectation, the
// same choice ch01_intro/19_potential_contribution_to_flow_only.va makes.
//
// The module is otherwise a well-formed one-ohm resistor, so the trigger on the
// spine is the sole defect.
//
//! lrm A.6.4
//! lrm A.6.5
//! lrm 5.10.4
//! reject DiagnosticsReported
module d04_bare_event_trigger_in_analog(p, n);
    inout p, n;
    electrical p, n;
    event ev;

    analog begin
        -> ev;
        I(p, n) <+ V(p, n);
    end
endmodule
