// §5.10: "The procedural statements following the event expression is executed
// whenever the event described by the expression changes. The analog event
// detection is non-blocking, meaning the execution of the procedural statement
// is skipped unless the analog event has occurred."
//
// and §5.3: "The statements within the block shall be executed in sequence, one
// after another in the given order."
//
// Both sentences together fix what a read of a held variable sees depending on
// WHERE it is written relative to the `@`. The analog block is a sequence; the
// event statement is one member of it; a read before that member sees the value
// the variable came into this evaluation with — its retained value — and a read
// after it sees the result of this evaluation's event, if one occurred.
//
// This is the "events before and after lexical trigger positions" claim of the
// row, and it is the one that makes retention a STORAGE property rather than a
// per-statement rewrite: the retained value has to exist at the top of the
// evaluation, before any event has been examined.
//
// THE EVENT SOURCE. Two one-shot timers (§5.10.3.3), firing at exactly 1n and
// 3n.
//
// THE DERIVATION. `n` starts at the §3.2 default 0; `pre` is read before the
// two event statements, `post` after them. Neither pre nor post is itself
// event-assigned, so each is recomputed every evaluation.
//
//     timepoint   n on entry   event?        pre   post   n on exit
//     t = 0            0       none            0     0        0
//     t = 1n           0       timer(1n)       0     1        1
//     t = 2n           1       none            1     1        1
//     t = 3n           1       timer(3n)       1     2        2
//     t = 4n           2       none            2     2        2
//
//   asserted:  pre  = 0, 0, 1, 1, 2
//              post = 0, 1, 1, 2, 2
//
// The two columns are offset by exactly one event, and that offset is the whole
// assertion. pre = post at t = 0, 2n and 4n (no event: nothing happened between
// the two reads) and pre = post - 1 at t = 1n and 3n (the event happened
// between them). An implementation that seeded the retained value only at the
// point of the event-assignment would read pre = 0 at t = 2n and t = 4n; one
// that made the event write visible to the earlier read would read pre = 1 at
// t = 1n; one without retention at all reads both columns as 0, 1, 0, 1, 0.
//
// `d` asserts the offset directly, so one transcript line carries it.
//
// OBSERVED TODAY: this fixture PASSES. `holdSlot` deliberately replaces the
// declared initializer AT THE DECLARATION for exactly this reason, and its doc
// comment says so ("a read of the variable that lexically precedes the `@(...)`
// must also see the retained value"). Nothing pinned it; this file does. It is
// also the constraint that fixtures 04 and 05 must preserve when retention is
// re-keyed on scope — a block-local's seed has to be emitted at the block's
// declaration, which is a different dominating point than the entry block.
//
//! lrm 5.3
//! lrm 5.10
//! lrm 5.10.3.3
//! analysis tran
//! time 0, 1n, 2n, 3n, 4n
`include "check.vh"
module a03_held_before_event(p);
  inout p; electrical p;
  integer n, pre, post;
  analog begin
    pre = n;
    @(timer(1n, 0.0)) n = n + 1;
    @(timer(3n, 0.0)) n = n + 1;
    post = n;
    `CHECKEQ("a read before the event statement sees the value retained from the last point",
             pre, ($abstime <= 1n) ? 0 : (($abstime <= 3n) ? 1 : 2), 0.0);
    `CHECKEQ("a read after it sees this point's event",
             post, ($abstime < 1n) ? 0 : (($abstime < 3n) ? 1 : 2), 0.0);
    `CHECKEQ("and the two differ by exactly one, only at the two firing instants",
             post - pre, (($abstime == 1n) || ($abstime == 3n)) ? 1 : 0, 0.0);
    I(p) <+ 0.0;
  end
endmodule
