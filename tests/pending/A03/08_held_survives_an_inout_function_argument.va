// §4.7.2.4 inout arguments, quoted in full because every claim below is one of
// its sentences:
//
//   "inout arguments allow the user to pass in a value to the function and
//    return a different value from it using the same argument. ... The inout
//    arguments of an analog user-defined function do not get initialized like
//    those defined as output. ... At the end of the execution of the analog
//    user-defined function, the last value assigned to the inout argument is
//    then assigned to the corresponding analog variable reference that was
//    passed into the function. If a value was not assigned to the inout
//    argument during the execution of the analog user-defined function, then
//    the corresponding analog variable reference is left untouched."
//
//   "Note: inout arguments are not 'pass by reference', but more closely
//    related to 'copy in' and 'copy out'."
//
// This is the FUNCTION-LOCAL LIFETIME half of the row. §4.7.1 forbids an
// analog function from containing an event control statement, so nothing inside
// a function can ever be a §5.10 held variable; the formal `y` is a copy with
// no lifetime beyond the call. All of the state lives in the CALLER's variable,
// and the function's only effect on it is the copy-out.
//
// WHY THE FUNCTION IS IDEMPOTENT, AND WHY THIS FILE USED TO BE WRONG.
// The call site `d = f(h);` sits on the unconditional analog spine, not under
// an `@`. An earlier version of this fixture had `f` ADD ONE to its inout there
// and asserted h = 1, 11, 12, 11, 12. Those digits are not derivable from the
// LRM. Two clauses say so:
//
//   §8.3.3 Convergence: "In the analog kernel, the behavioral description is
//   evaluated iteratively until the NR method converges." How many evaluations
//   a timepoint costs is the solver's business, and nothing bounds it.
//
//   §5.6.1.3 Value retention: "Unlike variables, the contributed value for a
//   branch is only valid for the current iteration." Read the other way round,
//   a VARIABLE's value is NOT discarded between iterations — so an accumulator
//   on the spine counts evaluations, and `+1 per evaluation` asserted at
//   tolerance 0.0 is an assertion about the solver's iteration count. A tool
//   that legitimately evaluates the spine twice per timepoint reads 2, 12, 14
//   and gets told it broke held state. VerA's own commit/revert staging is
//   planted only when `fsmStateCtl()` is true (a cross/above operator is
//   present); this file has only timers, so it was being graded against one
//   particular scheduler rather than against the clause.
//
// Note the contrast with fixtures 04, 05, 07, 10 and 12, which all do keep a
// read-modify-write: theirs is inside an `@(...)` body, where what is counted is
// EVENT OCCURRENCES, and §5.10.2's own bitErrorRate example writes exactly that
// (`@(timer(0, period)) begin ... bits = bits + 1; end`, counting bits and not
// iterations). On the spine there is no occurrence to count.
//
// So `snap` is written to be IDEMPOTENT: snap applied twice leaves the same
// value as snap applied once, for every value this file can reach. Every number
// below is therefore the same after one evaluation of the spine as after ten,
// and the file asserts §4.7.2.4 instead of asserting a scheduler.
//
//     function real snap(inout y):
//         snap = y;                     // returns the value copied IN
//         if (y >= 10.0) y = y / 10.0;  // copied OUT only on this branch
//
//   f(0) = 0 (untouched), f(10) = 1, f(1) = 1, f(50) = 5, f(5) = 5.
//   10.0/10.0 and 50.0/10.0 are exact in IEEE-754 binary64, so the tolerances
//   are 0.0 and mean it.
//
// THE DERIVATION. `h` starts at the §3.2 default 0 ("Real variables are
// initialized to zero (0) at the start of a simulation"). Two one-shot timers
// (§5.10.3.3: "If the period expression evaluates to a value less than or equal
// to 0.0, the timer shall trigger only once at the specified start_time") write
// 10.0 at t = 1n and 50.0 at t = 3n. `snap` is called once on the spine, after
// the event statements. `w2` and `w4` are two more held variables, each written
// by a one-shot timer that fires at a point with NO h event, and each reads `h`
// BEFORE the call — so each is a witness to what the previous timepoint's
// copy-out left behind:
//
//     t        h on entry   event        h at the call   after snap   witness
//     0            0        none              0              0        --
//     1n           0        h = 10.0         10              1        --
//     2n           1        none              1              1        w2 = 1
//     3n           1        h = 50.0         50              5        --
//     4n           5        none              5              5        w4 = 5
//
//   asserted: h  = 0, 1, 1, 5, 5
//             w2 = 0, 0, 1, 1, 1
//             w4 = 0, 0, 0, 0, 5
//
// Every wrong implementation lands somewhere else:
//
//   * copy-out dropped ("pass by value")        -> h = 0, 10, 10, 50, 50
//   * copy-IN dropped (formal starts at 0)      -> snap never assigns y, and
//                                                  §4.7.2.4's "left untouched"
//                                                  gives h = 0, 10, 10, 50, 50
//   * the inout initialized like a §4.7.2.3
//     output (the sentence forbidding it)       -> h = 0 at every point
//   * no retention at all                       -> w2 = 0, w4 = 0
//   * retention snapshotted AT the event rather
//     than at the end of the evaluation         -> w2 = 10, w4 = 50
//
// w2 = 1 is the headline: 1 appears nowhere in the source text of this file. It
// can only be produced by copying 10.0 in at t = 1n, dividing inside the
// function, copying the result back out into the held slot, and carrying that
// slot across a timepoint at which no event occurred.
//
// t = 2n and t = 4n also exercise the clause's last sentence directly: `h` is
// 1 and 5 there, both below the threshold, so `snap` assigns its inout nothing
// and "the corresponding analog variable reference is left untouched" — the
// retained value has to come back out unchanged rather than being zeroed the
// way §4.7.2.3 zeroes an output.
//
// `d` catches the return value so the call has an expression context. Its value
// (the copy-IN) is deliberately NOT asserted: at t = 1n and t = 3n it depends on
// whether the event body has already run in the evaluation being observed, which
// is the same unfixed quantity the rest of this header refuses to pin. w2 and w4
// carry that information from the points where it is fixed.
//
// OBSERVED TODAY: passes. It is a guard rail, not a gap — held slots are read at
// the end of the evaluation (`lower.zig`: `for (self.held_vars.items) |*h|
// h.final = try self.builder.readVariable(...)`), which is what makes the
// copy-out survive. Fixtures 04 and 05 change where slots are allocated; this
// pins what must not change about WHEN they are read.
//
//! lrm 4.7.2.4
//! lrm 5.10
//! lrm 5.10.3.3
//! analysis tran
//! time 0, 1n, 2n, 3n, 4n
`include "check.vh"
module a03_held_through_inout(p);
  inout p; electrical p;
  real h, d, w2, w4;

  // §4.7.1: at least one formal, each with a direction and a type declaration.
  // Idempotent by construction: on the values this module reaches, a second
  // application changes nothing, so the assertions do not count evaluations.
  analog function real snap;
    inout y;
    real y;
    begin
      snap = y;
      if (y >= 10.0) y = y / 10.0;
    end
  endfunction

  analog begin
    @(timer(1n, 0.0)) h = 10.0;
    @(timer(3n, 0.0)) h = 50.0;
    @(timer(2n, 0.0)) w2 = h;
    @(timer(4n, 0.0)) w4 = h;
    d = snap(h);
    `CHECKEQ("the copy-out lands in the held variable, and an unassigned inout leaves it untouched",
             h, ($abstime < 1n) ? 0.0 : (($abstime < 3n) ? 1.0 : 5.0), 0.0);
    `CHECKEQ("at 2n, with no event of its own, h still holds what the 1n copy-out left",
             w2, ($abstime < 2n) ? 0.0 : 1.0, 0.0);
    `CHECKEQ("and at 4n it holds what the 3n copy-out left",
             w4, ($abstime < 4n) ? 0.0 : 5.0, 0.0);
    I(p) <+ 0.0;
  end
endmodule
