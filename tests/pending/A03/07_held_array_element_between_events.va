// §5.10 event control over an ARRAY element with a runtime subscript.
//
//   "The analog event detection is non-blocking, meaning the execution of the
//    procedural statement is skipped unless the analog event has occurred."
//
// §3.2 makes an array of reals a set of locations, one per element: Syntax 3-1
// admits `real_identifier { dimension }`, "a range which defines the upper and
// lower indices of the array", and the clause's own example reads `real
// gain_factor[1:30]; // array of 30 gain multipliers`. Thirty multipliers, not
// one. So the §5.10 retention rule applies element by element: an event that
// writes s[0] leaves s[1] alone, and BOTH keep their values at every timepoint
// where no event occurred. No existing fixture pins retention for an array at
// all.
//
// (Earlier revisions of this file, and of SPEC.md, cited "§3.2.2" here. There
// is no §3.2.2: ch3-datatypes.html runs 3.1 -> 3.2 -> 3.2.1 -> 3.3, and the
// only "3.2.2" in the document is a cross-reference to Annex E.3.2.2. The
// clause that carries the text is §3.2.)
//
// The subscript here is a variable, not a constant — `s[k]` with k itself
// event-assigned — so the write target is only known at run time. That is the
// case that forces retention to be storage rather than a compile-time rename:
// each event must land on the element the CURRENT k selects, and k's own value
// has to have survived from the previous event for the selection to be right.
//
// THE EVENT SOURCE. Three one-shot timers (§5.10.3.3, "the timer shall trigger
// only once at the specified start_time"), so the firing times are exactly 1n,
// 3n and 5n independent of the timestep.
//
// THE DERIVATION. s[0..2] and k all start at the §3.2 default 0 ("Real
// variables are initialized to zero (0) at the start of a simulation";
// "Integer variables whose values are assigned in an analog context default to
// an initial value of zero (0)"):
//
//                  event            body                s[0] s[1] s[2]   k
//     t = 0        none             --                     0    0    0   0
//     t = 1n       timer(1n)        s[0] = 10; k = 1      10    0    0   1
//     t = 2n       none             --                    10    0    0   1
//     t = 3n       timer(3n)        s[1] = 20; k = 2      10   20    0   2
//     t = 4n       none             --                    10   20    0   2
//     t = 5n       timer(5n)        s[2] = 30; k = 3      10   20   30   3
//
// The body is `s[k] = 10 * (k + 1); k = k + 1;` — one statement pair, three
// firings, three different elements. The multiplier makes the value name its
// own slot, so an implementation that wrote every firing to s[0] reads
// s[0] = 30 at t = 5n and fails; one that lost k between events writes s[0]
// three times and leaves s[1] and s[2] at 0; one that lost the ELEMENTS but
// kept k reads s[0] = 0 at t = 3n.
//
// The sum is asserted as well as the elements: 0, 10, 10, 30, 30, 60. It is
// redundant with the three element assertions by construction and is there so a
// single transcript line carries the whole state, which is what a reviewer
// reads first.
//
// OBSERVED TODAY: this fixture PASSES. Module-level held arrays are
// implemented — `declareVarDecl` scalarizes the array and gives every element
// its own persistent slot, and `scanHeld` maps `s[k] = ...` onto the base name.
// It is kept as the guard rail for fixtures 04 and 05: the fix for those is to
// key retention on scope rather than on the bare name, and this is the
// behaviour that fix must not break.
//
//! lrm 3.2
//! lrm 5.10
//! lrm 5.10.3.3
//! analysis tran
//! time 0, 1n, 2n, 3n, 4n, 5n
`include "check.vh"
module a03_held_array(p);
  inout p; electrical p;
  real s[0:2];
  integer k;
  analog begin
    @(timer(1n, 0.0)) begin s[k] = 10.0 * (k + 1); k = k + 1; end
    @(timer(3n, 0.0)) begin s[k] = 10.0 * (k + 1); k = k + 1; end
    @(timer(5n, 0.0)) begin s[k] = 10.0 * (k + 1); k = k + 1; end
    `CHECKEQ("s[0] is written at 1n and retained after it",
             s[0], ($abstime < 1n) ? 0.0 : 10.0, 0.0);
    `CHECKEQ("s[1] is untouched until 3n, then retained",
             s[1], ($abstime < 3n) ? 0.0 : 20.0, 0.0);
    `CHECKEQ("s[2] is untouched until 5n",
             s[2], ($abstime < 5n) ? 0.0 : 30.0, 0.0);
    `CHECKEQ("and the subscript itself survives between events",
             k, ($abstime < 1n) ? 0 : (($abstime < 3n) ? 1 : (($abstime < 5n) ? 2 : 3)), 0.0);
    `CHECKEQ("whole-array sum, the same state on one line",
             s[0] + s[1] + s[2],
             ($abstime < 1n) ? 0.0 : (($abstime < 3n) ? 10.0 : (($abstime < 5n) ? 30.0 : 60.0)), 0.0);
    I(p) <+ 0.0;
  end
endmodule
