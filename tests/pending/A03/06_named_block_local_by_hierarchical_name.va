// §5.3.2 Block names:
//
//   "All identifiers declared within a named sequential block can be accessed
//    outside the scope in which they are declared. Named block variables cannot
//    be assigned outside the scope of the block in which they are declared.
//
//    Parameters declared within a named block have local scope and cannot be
//    assigned outside the scope."
//
// and the clause's own worked example, which this fixture is:
//
//     module example;
//        parameter integer p1 = 1;
//        real moduleVar;
//
//        analog begin
//           begin: myscope
//              parameter real p2 = p1;
//              real localVar = 1.5 * p2;
//           end
//           moduleVar = myscope.localVar;
//        end
//     endmodule
//
// This is the READ direction. The refusal direction — `myscope.localVar = ...`
// from the spine — is already pinned by VerA's E0316 (§5.7, "Hierarchical
// assignment of a variable from another scope/module is not allowed"), so no
// reject fixture is written for it here.
//
// Why it belongs to this row: "accessed outside the scope" is the only spelling
// the LRM gives for observing a named-block local from anywhere else, and the
// held-state fixtures 04 and 05 have to copy their locals into a module
// variable precisely because VerA does not have it. Scoped identity is the same
// feature seen from the two ends — a local is a distinct location (04, 05) and
// it is a NAMEABLE one (here).
//
// THE DERIVATION. p1 = 1 by declaration; p2 = p1 = 1 by §5.3.2's local
// parameter, whose initializer is a module-level parameter reference (§3.4);
// localVar = 1.5 * 1 = 1.5, exact in binary — 1.5 is 3/2, and 1 converts to
// real exactly. The conversion clause is §4.2.1.2 Integer to real conversion
// ("Implicit conversion shall take place when an expression is assigned to a
// real"), which is what `parameter real p2 = p1;` does with the integer p1;
// §4.2.1.1, cited here in an earlier revision, is Real to integer conversion
// and is the wrong direction. So the product is not rounded, moduleVar reads
// exactly 1.5, and the tolerance is 0.
//
// The second assertion reads the block's local PARAMETER by the same route.
// §5.3.2 says "All identifiers declared within a named sequential block", and a
// parameter declared there is one of them; it also fixes p2's value at 1 by
// inheritance from p1, so 1.0 is derived and not merely observed.
//
// This is a DC fixture: nothing here is time-dependent, and the clause is about
// naming, not about events.
//
// OBSERVED TODAY:
//   error[E0901]: hierarchical name names nothing in the elaborated design:
//   `myscope.localVar` names nothing in the elaborated design
//
//! lrm 5.3.2
//! bias V(p) = 0.0
`include "check.vh"
module a03_block_local_hier_read(p);
  inout p; electrical p;
  parameter integer p1 = 1;
  real moduleVar, moduleParam;
  analog begin
    begin : myscope
      parameter real p2 = p1;
      real localVar = 1.5 * p2;
    end
    moduleVar = myscope.localVar;
    moduleParam = myscope.p2;
    `CHECKX("a named block's local is accessible outside its scope", moduleVar, 1.5);
    `CHECKX("and so is its local parameter, which inherits p1 = 1", moduleParam, 1.0);
    I(p) <+ 0.0;
  end
endmodule
