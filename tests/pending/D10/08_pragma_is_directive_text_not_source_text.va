// §10.1 Table 10-1 lists `pragma among the supported compiler directives and
// defers its content to IEEE Std 1364. What §10.1 itself fixes, and what this
// file pins, is the part that does not depend on knowing any particular
// pragma's meaning:
//
//   1. `pragma IS A COMPILER DIRECTIVE. Everything on its line is therefore
//      directive text, not Verilog-AMS source text — so a macro name written
//      among a pragma's arguments is not a use of that macro, and no part of
//      the line reaches the parser as source.
//   2. "The scope of compiler directives extends FROM THE POINT WHERE IT IS
//      PROCESSED ... to the point where another compiler directive supersedes
//      it." A directive has no reach backwards, so the `define ABOVE the pragma
//      keeps its value; and the directive that supersedes this one is the
//      `define BELOW it, which therefore has to take effect.
//
// ch10_directives/19 is the only existing pragma coverage and it writes
// ``pragma f harmless`` — two bare words, no punctuation, nothing after it that
// could be swallowed. It is green under a preprocessor that discards a pragma
// by scanning for the next whitespace, or by scanning to the next accent grave,
// or by expanding the line first. This file is green under none of those.
//
// THE TWO WAYS IT CATCHES A WRONG PRAGMA, each read off the line as actually
// written — `` `pragma vera_row_d10 protect, key = `D10_GAIN, "literal text" ``:
//   - a pragma that stops at the first accent grave puts the remainder,
//     `` `D10_GAIN, "literal text" ``, back into the SOURCE stream at file
//     scope, between two module-level items. `D10_GAIN expands to 2.0 there and
//     the parser meets `` 2.0 , "literal text" `` where a module item is
//     required, so the file does not compile and no assertion prints at all.
//     (There is no 5.0 anywhere in this file; an earlier draft of this header
//     claimed the first assertion would read 5 instead of 2, which described a
//     file that was never shipped. Corrected.)
//   - a pragma that runs past its own line eats the `` `define D10_SCALE 3.0 ``
//     below it, and the second and third assertions die at E0115 (undefined
//     macro) rather than printing a number.
//
// AND ONE THAT IT DOES NOT CATCH, stated rather than implied: a pragma whose
// arguments are macro-expanded before being discarded turns `` `D10_GAIN `` into
// `` 2.0 `` inside the directive and nothing observable changes, because the
// name used there is defined. Catching it needs an UNDEFINED name among the
// arguments, and whether a conforming preprocessor may diagnose that is an IEEE
// 1364 §19.11 question the offline docs cannot answer — so the line carries a
// macro use in the `keyword = value` shape as documentation of the shape, and
// the discrimination is not claimed. SPEC.md records it as out of reach.
//
// THE ORACLE is arithmetic on two literals a human wrote three lines apart:
// `D10_GAIN is 2.0 because line 1 says so and nothing supersedes it, `D10_SCALE
// is 3.0 because line 3 says so, and their product is 6.0. All three are
// binary-exact, so CHECKX with no tolerance. The contribution then stamps
// 6.0 * V(p,n) = 6.0 * 0.5 = 3.0 A, which makes the same claim through the
// solver rather than through the transcript.
//
//! lrm 10.1
//! bias V(p) = 0.75, V(n) = 0.25
`include "check.vh"
`define D10_GAIN 2.0
`pragma vera_row_d10 protect, key = `D10_GAIN, "literal text"
`define D10_SCALE 3.0
module d10_pragma_is_directive_text_not_source_text(p, n);
  inout p, n;
  electrical p, n;
  analog begin
    `CHECKX("the `define above the pragma is untouched", `D10_GAIN, 2.0);
    `CHECKX("the `define below the pragma took effect", `D10_SCALE, 3.0);
    `CHECKX("so the pragma line contributed nothing but itself", `D10_GAIN * `D10_SCALE, 6.0);
    I(p, n) <+ `D10_GAIN * `D10_SCALE * V(p, n);
  end
endmodule
