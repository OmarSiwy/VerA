// IEEE Std 1364 §19.10 pulls an UNCONNECTED input port; §6.2.2 is what decides
// which ports those are. It gives two spellings and ch10_directives/58, 59 and
// 60 only exercise the first:
//
//     "A blank port connection shall represent the situation where the port is
//      not to be connected."
//
// In the ordered list that blank is written as a missing element — `u( , p)`,
// which is what 58 writes. In the NAMED list the same situation has two
// spellings: an explicit `.a()` with an empty expression, and a port simply
// left out of the list altogether. §6.2.2's sentence is about the CONNECTION,
// not about the punctuation, so all three must reach §19.10 identically.
//
// This file instantiates the same child three ways under one `pull0 region and
// asserts one number for all three. A front end that collects unconnected
// inputs only from the ordered form — the shape 58 tests — leaves u1 and u2
// floating and prints 0.5 for them, half a volt away, while u3 stays green.
//
// THE ORACLE. `pull0 holds the unconnected input at 0 of the potential nature's
// units (58's header argues the number; §19.10 fixes the LEVEL and the fact of
// being driven). So V(u1.a) = V(u2.a) = V(u3.a) = 0 exactly.
//
// The current is the corroborating half and it is a derivation, not a repeat:
// the child is one 1 kΩ resistor from `a` to `b`, `b` is tied to `p` at 0.5 V,
// and `a` is clamped at 0, so by Ohm's law the branch current flowing a->b is
// 0.001 * (0 - 0.5) = -5e-4 A. An unpulled `a` would carry 0 A instead, which
// is fixture 60's answer. Both 0.0 and -5e-4 are checked exactly: 5e-4 is not a
// binary-exact decimal, but it is the exact product the same double arithmetic
// produces on both sides of the comparison, and 60 already pins the 0 A case
// with CHECKX on the same circuit.
//
//! lrm 10.1
//! lrm 6.2.2
//! bias V(p) = 0.5
//! solve
`include "check.vh"
`unconnected_drive pull0
module d10_named_conn_child(a, b);
    input a;
    inout b;
    electrical a, b;
    analog I(a, b) <+ 0.001 * V(a, b);
endmodule
`nounconnected_drive

module d10_unconnected_drive_reaches_a_named_port_connection(p);
    inout p;
    electrical p;

    d10_named_conn_child u1(.a(), .b(p));  // named, explicit blank
    d10_named_conn_child u2(.b(p));        // named, port omitted entirely
    d10_named_conn_child u3( , p);         // ordered blank — 58's spelling

    analog begin
        `CHECKX("an explicit `.a()` is a blank port connection", V(u1.a), 0.0);
        `CHECKX("so is a port left out of the named list", V(u2.a), 0.0);
        `CHECKX("and the ordered blank agrees, as it must", V(u3.a), 0.0);
        `CHECKX("the named blank is DRIVEN: 0.001*(0 - 0.5) A flows a->b", I(u1.a, u1.b), -0.0005);
        I(p) <+ 0.0;
    end
endmodule
