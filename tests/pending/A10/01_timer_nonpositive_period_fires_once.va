// §5.10.3.3 timer(), the sentence that fixes what a non-repeating timer is:
//
//   "If the period is specified as greater than zero (0), the timer function
//    schedules subsequent events at multiples of period. If the period
//    expression evaluates to a value less than or equal to 0.0, the timer shall
//    trigger only once at the specified start_time (if the start_time is in the
//    future with respect to the current simulation time)."
//
// So ZERO and NEGATIVE are the same case, and both are the SINGLE-SHOT case —
// not "fire every step", which is what an implementation that adds the period
// blindly does (next = next + 0.0 leaves next where it was, and the event then
// evaluates True at every subsequent time point).
//
// THE SCHEDULE, read off the clause. Both timers start at 2 ns:
//
//   t = 0     start_time is in the future          -> no event, count 0
//   t = 1n    still in the future                  -> no event, count 0
//   t = 2n    the start_time, and "at that time point, the event evaluates to
//             True" (§5.10.3.3)                    -> count 1
//   t = 3n    period <= 0, so there is no second fire  -> count STAYS 1
//   t = 5n    likewise                                  -> count STAYS 1
//
// Two counters, because `0` and `-1n` reach the rule by different arithmetic: a
// `+ period` implementation leaves `zero` firing forever and walks `neg`
// BACKWARDS, so it fires forever too. Both wants are the same digit, and that
// is the point — the clause draws no distinction between them.
//
// The threshold in the oracle sits at 1.5 ns, between the last row before the
// start_time and the start_time itself, so a fire one declared row early or one
// row late fails instead of being absorbed by a loose bound.
//
// THE THIRD COUNTER is the sentence's parenthetical, which is a CONDITION on
// the single fire and not an aside: "the timer shall trigger only once at the
// specified start_time (IF THE START_TIME IS IN THE FUTURE WITH RESPECT TO THE
// CURRENT SIMULATION TIME)". `timer(-1n, 0)` names an instant this run never
// visits — the transient begins at t = 0, and -1 ns is behind the current
// simulation time at every one of the five rows — so the condition is false
// from the first evaluation onward and the clause licenses no fire at all.
// Both wrong readings are firings: a tool that clamps a past start_time to
// "now" fires once at t = 0, and a tool that tests only `$abstime >=
// start_time` fires at every row. Neither is written in the clause, which
// conditions the trigger on future-ness and says nothing else about a past
// start_time. Expected: 0 at all five rows, exactly.
//
// The direction of that claim is worth stating, because it is the direction
// that makes it safe: it demands STRICTLY FEWER events than VerA raises today,
// so no loosening of an event test can be mistaken for a fix. It fails at HEAD,
// where `@(timer(-1n, 0))` fires once at t = 0 and every row reads 1.
//
//! lrm 5.10.3.3
//! analysis tran
//! time 0, 1n, 2n, 3n, 5n
//! bias V(p) = 0
//! print none
`include "check.vh"
module a10_timer_nonpositive_period(p);
  inout p;
  electrical p;
  integer zero_fired, neg_fired, past_fired;
  analog begin
    @(timer(2n, 0)) zero_fired = zero_fired + 1;
    @(timer(2n, -1n)) neg_fired = neg_fired + 1;
    @(timer(-1n, 0)) past_fired = past_fired + 1;
    `CHECKEQ("period 0 fires once, at start_time, and never again", zero_fired,
             ($abstime < 1.5n) ? 0 : 1, 0.0);
    `CHECKEQ("a negative period is the same single-shot rule", neg_fired,
             ($abstime < 1.5n) ? 0 : 1, 0.0);
    `CHECKI("a start_time that is not in the future does not get the single fire",
            past_fired, 0);
    I(p) <+ 0.0;
  end
endmodule
