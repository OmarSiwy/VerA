// §9.16 Dynamic Simulation Probe Function, the sentence that says WHAT is
// probed:
//
//   "$simprobe() queries the simulator for AN OUTPUT VARIABLE named param_name
//    in a sibling instance called inst_name. The arguments inst_name and
//    param_name are string values... To resolve the value, the simulator will
//    look for an instance called inst_name in the parent of the current
//    instance i.e. a sibling of the instance containing the $simprobe()
//    expression. Once the instance is resolved, it will then query that instance
//    for an output variable called param_name."
//
// and the clause's own example, which probes `id` of a mosfet instance `mn` —
// an operating-point quantity, not a parameter:
//
//   monitor #(.inst("mn"),.quant("id"),.threshold(4.0e-3)) amonitor();
//
// "The intended use of this function is to allow DYNAMIC MONITORING of instance
// quantities", so the probed value is one that MOVES with the solution. A probe
// that can only answer parameters answers only numbers that were already in the
// netlist, which is the one thing a monitor does not need a probe for.
//
// THE DERIVATION. `//! bias` pins V(p) = 0.75 and V(n) = 0.25, so the device
// instance sees V(a,b) = 0.75 - 0.25 = 0.5 exactly (both are exact in binary,
// and so is their difference). Its output variable is
//
//   id = gain * V(a,b) = 2.0 * 0.5 = 1.0 A
//
// with `gain` overridden to 2.0 at the instantiation, so
//
//   $simprobe("u_dev", "id")   -> 1.0     the output variable, claim 1
//   $simprobe("u_dev", "gain") -> 2.0     the parameter, claim 2
//
// Claim 2 is a strict subset of what §9.16 requires and is the control: it is
// what VerA resolves today, so it pins the sibling lookup that already works
// and fails if the fix for claim 1 breaks it.
//
// The fallbacks (-1.0) are there so this file RUNS rather than being refused:
// §9.16 makes the no-third-argument form on an unresolvable probe an error, and
// a compile error produces no `ok=` line and therefore no evidence about which
// of the two probes resolved. -1.0 is a value neither correct answer can take,
// so an unresolved probe is visible as `got=-1` rather than as silence.
//
// WHY CLAIM 1 FAILS TODAY. `Lower.lowerSimprobe` (src/ir/lower.zig) resolves
// the pair by building the flat path `inst_name . param_name` and looking it up
// in `param_index` — the PARAMETER table. An output variable ((* desc *) real)
// is not in that table, so the probe falls through to the fallback and returns
// -1.0.
//
//! lrm 9.16
//! analysis dc
//! bias V(p) = 0.75, V(n) = 0.25
`include "check.vh"
module a10_simprobe_top(p, n);
  inout p, n;
  electrical p, n;
  a10_simprobe_dev #(.gain(2.0)) u_dev(p, n);
  a10_simprobe_mon u_mon(p, n);
endmodule

module a10_simprobe_dev(a, b);
  inout a, b;
  electrical a, b;
  parameter real gain = 1.0;
  (* desc="branch current", units="A" *) real id;
  analog begin
    id = gain * V(a, b);
    I(a, b) <+ id;
  end
endmodule

module a10_simprobe_mon(a, b);
  inout a, b;
  electrical a, b;
  real probe_var, probe_param;
  analog begin
    probe_var = $simprobe("u_dev", "id", -1.0);
    probe_param = $simprobe("u_dev", "gain", -1.0);
    `CHECKX("§9.16 probes an OUTPUT VARIABLE of a sibling instance", probe_var, 1.0);
    `CHECKX("and a sibling's parameter resolves through the same lookup", probe_param, 2.0);
    I(a, b) <+ 0.0 * V(a, b);
  end
endmodule
