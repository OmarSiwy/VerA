// §9.15 Table 9-28, the two hierarchy queries with a value that is decided by
// the DESIGN and not by the host's filesystem:
//
//   "module"    The name of the module from which $simparam$str is called
//   "instance"  The hierarchical name of the instance from which $simparam$str
//               is called
//
// and the clause's own worked example, which fixes the spelling of both:
//
//   module testbench;
//     dut dut1;
//   endmodule
//
//   module dut;
//     task mytask;
//       $display( "%s\n%s\n%s\n", $simparam$str("module"),
//                                 $simparam$str("instance"),
//                                 $simparam$str("path"));
//     endtask
//   endmodule
//
//   // produces:
//   // dut
//   // testbench.dut1
//   // testbench.dut1.mytask
//
// Read off that example, with the names of this file: the call sites below sit
// in module `a10_simstr_child`, instantiated once as `u1` inside the top module
// `a10_simstr_top`. So
//
//   "module"   -> "a10_simstr_child"   the module the call is written in, which
//                                      is NOT the top module and NOT the
//                                      instance name;
//   "instance" -> "a10_simstr_top.u1"  the root instance (a top-level module's
//                                      instance name is its module name — the
//                                      example's "testbench") joined to the
//                                      instance path by §6.7's period.
//
// The claim in the TOP module is the control: there, "module" is the top
// module's own name, which is the one answer a flattened elaboration gets right
// for free. Without it a reader cannot tell "queries the calling module" from
// "always answers the compilation unit's name", because in the top module those
// two are the same string.
//
// "path" (Table 9-28's third hierarchy row) is deliberately not asserted: the
// example only shows it inside a named task, and this clause does not say what
// it appends for a call sitting directly in an analog block.
//
// WHY IT FAILS TODAY. `Gen.emitSysCall` (src/backend/codegen.zig) answers
// "module" with `self.mir.name` — the name of the FLATTENED module, i.e. the
// top one, for every call site at every depth — and answers "instance" (and
// "path", "cwd", "analysis_name") with the empty string, on the argument that a
// flattened device has no instance hierarchy. Elaboration does keep the path:
// §6.7's hierarchical name is what `Elaborate.sep` builds and what
// `lowerSimprobe` looks names up by, so the string exists; it is just not
// published through this function.
//
//! lrm 9.15
//! analysis dc
//! bias V(p) = 0.75, V(n) = 0.25
`include "check.vh"
module a10_simstr_top(p, n);
  inout p, n;
  electrical p, n;
  a10_simstr_child u1(p, n);
  analog begin
    `CHECKI("in the top module, `module` is the top module's own name",
            $simparam$str("module") == "a10_simstr_top", 1);
  end
endmodule

module a10_simstr_child(a, b);
  inout a, b;
  electrical a, b;
  analog begin
    `CHECKI("`module` is the module the call is written in, not the top one",
            $simparam$str("module") == "a10_simstr_child", 1);
    `CHECKI("`instance` is the hierarchical name of the calling instance",
            $simparam$str("instance") == "a10_simstr_top.u1", 1);
    I(a, b) <+ 0.0 * V(a, b);
  end
endmodule
