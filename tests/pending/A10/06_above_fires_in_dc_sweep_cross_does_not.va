// §5.10.3.2 above(), the clause that separates it from cross() — and the only
// analog event the LRM requires OUTSIDE a transient:
//
//   "The above() function is almost identical to the cross() function, except
//    that it also triggers during initialization or dc analysis."
//
//   "In contrast, the cross() function can only generate an event after the
//    simulation time has advanced from zero. The cross() function will not
//    generate events for non-transient analyses, such as ac, dc, or noise
//    analyses of SPICE (see 4.6.1), but the above() function can. DURING A DC
//    SWEEP, THE above() FUNCTION SHALL ALSO GENERATE AN EVENT WHEN THE
//    EXPRESSION CROSSES ZERO FROM BELOW; however, the step size of the dc sweep
//    is not controlled to accurately resolve the crossing."
//
// Both halves are asserted here, on ONE sweep, so neither can be satisfied by a
// tool that simply never raises an event: `n_above` has to move and `n_cross`
// has to stay put, in the same run.
//
// THE SWEEP. V(p) takes 0, 0.4, 0.6, 1.0 and the threshold is 0.5, so
// `V(p) - 0.5` is -0.5, -0.1, +0.1, +0.5:
//
//   point 1   V(p)=0.0   expr -0.5   below       above: no event   count 0
//   point 2   V(p)=0.4   expr -0.1   below       above: no event   count 0
//   point 3   V(p)=0.6   expr +0.1   CROSSED     above: EVENT      count 1
//   point 4   V(p)=1.0   expr +0.5   still above above: no event   count 1
//
// "Crosses zero from below" is edge-triggered, so point 4 is not a second event:
// the expression was already positive at point 3. That is the difference between
// above() and a bare `expr > 0` test, and the reason `n_above` is pinned at 1
// and not at 2 on the last point.
//
// `n_cross` is 0 at all four points, because this is a dc analysis.
//
// The oracles are relational only in WHICH point of the sweep they name: both
// branches are the digits derived above, and the partition (`V(p) > 0.5`) is the
// sweep's own coordinate, computed without consulting the event machinery.
//
// `held` is the third claim: the event captured the value at the point where it
// fired, which is 0.6 — not 1.0 (fired late, or re-fired at every positive
// point) and not 0.0 (never fired).
//
//! lrm 5.10.3.2
//! analysis dc
//! sweep V(p) = 0, 0.4, 0.6, 1.0
//! print none
`include "check.vh"
module a10_above_dc_sweep(p);
  inout p;
  electrical p;
  integer n_above, n_cross;
  real held;
  analog begin
    @(above(V(p) - 0.5)) begin
      n_above = n_above + 1;
      held = V(p);
    end
    @(cross(V(p) - 0.5, +1)) n_cross = n_cross + 1;
    `CHECKEQ("above() fires once, on the sweep point where the expression turns positive",
             n_above, (V(p) > 0.5) ? 1 : 0, 0.0);
    `CHECKI("cross() generates no events in a dc analysis", n_cross, 0);
    `CHECKEQ("and above() sampled the point it fired on", held,
             (V(p) > 0.5) ? 0.6 : 0.0, 1e-12);
    I(p) <+ 0.0;
  end
endmodule
