// §4.5.4 the RELEASE edge of idt()'s assert argument — the half of the reset
// rule that nothing in tests/fixtures exercises. ch04_expressions/16 holds
// assert nonzero for the whole run, which pins only the first sentence.
//
//   "When specified with both initial conditions and assert, idt() returns the
//    initial conditions during DC and IC analyses, and whenever assert is
//    nonzero. ONCE assert BECOMES ZERO, idt() RETURNS THE INTEGRAL OF THE
//    ARGUMENT STARTING FROM THE LAST INSTANT WHERE assert WAS NONZERO."
//
//   Table 4-18: "idt(expr,ic,assert) — Returns ∫ta..t x(τ)dτ + c, where c is
//   the value of ic at ta, which is the time when assert was last nonzero or
//   t0 if assert was never nonzero."
//
//   Table 4-20 lists, for idt, `abstol` as the constant expression argument and
//   `expr, ic, assert` as the DYNAMIC ones — so an assert that changes during
//   the run is the intended use, not an abuse.
//
// THE HAND DERIVATION. The integrand is the constant 1e9, so the integral
// gains exactly 1.0 per nanosecond. ic = 7.0. assert is driven from node a and
// falls to zero after t = 1ns, so ta = 1ns and c = 7.0:
//
//   t/ns     0     1     2     3     4
//   assert   1     1     0     0     0
//   idt      7     7     8     9     10       = 7 + max(t/1ns - 1, 0)
//
// t = 0 and t = 1ns pin "returns the initial conditions ... whenever assert is
// nonzero" — note that the second of those is a TRANSIENT point with a nonzero
// integrand, so an implementation that merely parsed the third argument and
// discarded it reads 8 there.
//
// t = 2ns is the release edge and the whole point: the integral restarts from
// ta = 1ns, not from t0 = 0. An implementation that restarts from t0 reads 9
// there and 12 at t = 4ns; one that keeps integrating through the assert reads
// 9 and 11. The three post-release points separate all three readings.
//
// WHY THIS FAILS TODAY. `Gen.argF64` renders the assert through `f64Const`,
// which folds literals and `model.<p>` parameter arithmetic only. A node probe
// is neither, so the call is refused with E0515 — a legal program per Table
// 4-20, and the only spelling in which the release edge is observable at all.
//
//! lrm 4.5.4
//! bias V(n) = 0
//! wave V(a) = 1, 1, 0
//! time 0, 1n, 2n, 3n, 4n
//! analysis tran
//! print none
`include "check.vh"
module a04_idt_assert_release(a, n);
    inout a, n;
    electrical a, n;

    analog begin
        `CHECK("integration resumes from the last instant assert was nonzero",
               idt(1e9, 7.0, V(a, n)) - (7.0 + max($abstime * 1e9 - 1.0, 0.0)), 0.0, 1e-12);
        // Literal and row-invariant: while assert is nonzero the output is
        // pinned at the initial condition, at a transient point where the
        // integrand is not zero.
        `CHECKI("assert pins the output at ic even in transient",
                idt(1e9, 7.0, V(a, n)) == 7.0 || $abstime > 1n, 1);

        I(a, n) <+ 0.0;
    end
endmodule
