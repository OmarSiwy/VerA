// §4.5.8 an INTERRUPTED transition — the case VerA's kernel says the clause is
// silent about. It is not silent; it spends four numbered paragraphs and six
// figures (4-7 .. 4-12) on it. This fixture pins the first of the four:
//
//   "An active transition shall be interrupted if the input to the
//    transition() changes value while in this active transitioning region. An
//    interrupted transition is not considered a new transition, but rather a
//    readjustment of the original transition. ...
//
//    If the original transition was rising and the new destination value is
//    below the value at the interruption, then the ORIGINAL TRANSITION'S
//    DESTINATION shall be used to compute the new origin. ... consider an
//    original transition that rises from (t1,v1) to (t2,v2) with a rise time
//    of tr1=t2-t1, which is interrupted at the point (ti,vi) with a new
//    destination value (v3), where v3 < vi. Then the original transition's
//    destination (v2) shall be used along with the rescheduled transition's
//    actual fall time (tf3), when calculating the slope: (v3-v2)/tf3. This
//    slope will be applied from the point of interruption (ti,vi), and the
//    readjusted transition's expected end time (t3) is then calculated using
//    this slope ... t3 = ti + (v3-vi)/slope."
//
// THE HAND DERIVATION. rise_time = 4ns, fall_time = 2ns, td = 0.
//
//   The input is piecewise constant: 0, then 4 from t = 1ns, then 0 again from
//   t = 4ns.
//
//   The rising transition is created at the change, so (t1,v1) = (1ns, 0) and
//   (t2,v2) = (5ns, 4) — slope +1 V/ns. It is still active at t = 4ns, where
//   the output has reached vi = 3.
//
//   At t = 4ns the input changes to v3 = 0, and 0 < 3 = vi, so this is the
//   quoted case. The clause forbids using vi as the origin value; the slope is
//   built from the ORIGINAL DESTINATION v2 = 4 and the actual fall time
//   tf3 = 2ns:
//
//       slope = (v3 - v2)/tf3 = (0 - 4)/2ns = -2 V/ns
//
//   applied from (ti,vi) = (4ns, 3), so the output reaches 0 at
//
//       t3 = ti + (v3 - vi)/slope = 4ns + (0 - 3)/(-2 V/ns) = 5.5ns.
//
//   t/ns    0   1   2   3   4   5   6   7   8
//   in      0   4   4   4   0   0   0   0   0
//   out     0   0   1   2   3   1   0   0   0
//
// The whole point of the clause is the 1 at t = 5ns, AND THAT IS THE ONLY
// POINT ON THIS GRID THAT SEPARATES THE TWO READINGS. The obvious wrong reading
// — restart a fresh fall from the interruption value over the full fall time,
// i.e. slope (v3-vi)/tf3 = (0-3)/2ns = -1.5 V/ns from (4ns, 3) — puts 1.5 at
// t = 5ns and reaches zero at 4 + 3/1.5 = exactly 6ns. So at t = 6, 7 and 8ns
// both readings are exactly 0: a check of the form "the output is 0 once the
// readjusted fall has arrived" is satisfied by BOTH and settles nothing. The
// checks below are written accordingly.
// That wrong reading is exactly what `zTransStep` implements: its comment
// reads "§4.5.8 says nothing about an input that REVERSES mid-ramp ... the new
// excursion starts where the output actually is (`y`), and is traversed in the
// full rise/fall time of its own direction". The two readings differ at
// t = 5ns and nowhere else on this grid, which is why the grid runs to 8ns:
// every other point is shared, so a failure here is unambiguous.
//
//! lrm 4.5.8
//! bias V(n) = 0
//! wave V(p) = 0, 4, 4, 4, 0
//! time 0, 1n, 2n, 3n, 4n, 5n, 6n, 7n, 8n
//! analysis tran
//! print none
`include "check.vh"
module a04_transition_interrupted_rising(p, n);
    inout p, n;
    electrical p, n;
    real tns, y;

    analog begin
        tns = $abstime * 1e9;
        // ONE operator site, bound once. `CHECK*` expands its GOT twice and the
        // checks below put it in the operand of a `||`; §4.5.15 restricts where
        // an analog operator may sit, so the operator is evaluated here,
        // unconditionally, and every use reads the variable. (The requirement
        // that two sibling sites agree is its own fixture,
        // 12_analog_operator_in_short_circuit_operand.va.)
        y = transition(V(p, n), 0, 4n, 2n);
        // The want is the three-segment piecewise-linear function derived
        // above, written in $abstime alone: flat at 0 until the input changes,
        // the +1 V/ns rise, then the -2 V/ns readjusted fall floored at the
        // new destination.
        `CHECKEQ("an interrupted rising transition falls at (v3-v2)/tf3 from the interruption point",
                 y,
                 (tns <= 1.0) ? 0.0 : ((tns <= 4.0) ? (tns - 1.0) : max(3.0 - 2.0 * (tns - 4.0), 0.0)),
                 1e-12);
        // THE DISCRIMINATOR, at the one grid point where the two readings of
        // §4.5.8 differ. Clause slope (v3-v2)/tf3 = -2 V/ns from (4ns, 3) puts
        // the output at 1.0 at t = 5ns; the naive "restart a fresh fall from
        // the interruption value over the full fall time" slope
        // (v3-vi)/tf3 = -1.5 V/ns puts it at 1.5. 0.25 is the midpoint band, so
        // each reading is rejected by the same margin it is wrong by, and the
        // window 4.5 < tns < 5.5 selects that one point without comparing a
        // float for equality.
        `CHECKI("at t = 5ns the readjusted fall is at 1.0, not the 1.5 of a restart from (ti,vi)",
                abs(y - 1.0) <= 0.25 || tns < 4.5 || tns > 5.5, 1);
        // Second, independent literal: the readjusted transition ARRIVES, at
        // t3 = 5.5ns, so every grid point after it reads exactly zero. This one
        // does NOT separate the two readings above — the naive -1.5 V/ns fall
        // from vi = 3 also reaches exactly 0 at t = 6ns, so both are at 0 on
        // every point of this grid at or past 5.5ns. What it does reject is a
        // kernel that re-arms the ramp from the current output every step,
        // which decays geometrically towards zero and never arrives.
        `CHECKI("the readjusted fall arrives at exactly 0; a re-arming decay never does",
                y == 0.0 || tns < 5.5, 1);

        I(p, n) <+ 1e-3 * y;
    end
endmodule
