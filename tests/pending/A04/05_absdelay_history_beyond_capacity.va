// §4.5.7 a lookback DEEPER THAN THE IMPLEMENTATION'S HISTORY RING. The clause
// states the transport delay as a formula over all of past time,
//
//     Output(t) = Input(max(t - td, 0))
//
// and nowhere bounds how many accepted timepoints a simulator may have taken
// in between. §4.5.15's only statement about the start of history is that "all
// analog operators are considered to have no state history prior to time
// t == 0", which is exactly the max(t - td, 0) floor and says nothing about a
// cap on samples.
//
// THE HAND DERIVATION. The input is the 1 V/ns ramp $abstime*1e9 and
// td = 515ns, over a uniform 1ns grid from 0 to 520ns — 521 accepted
// timepoints. The formula is then max(t/1ns - 515, 0) at every point:
//
//   t/ns     0 .. 515   516   517   518   519   520
//   out      0 ..   0     1     2     3     4     5
//
// WHY THIS FAILS TODAY, AND WHERE. `codegen.hist_len` is a fixed 512-sample
// ring per absdelay site, and `zHistAt`'s last line clamps a query older than
// the ring to the OLDEST retained sample:
//
//     // Query older than the whole ring: clamp to the OLDEST sample.
//     return vs[head];
//
// The operator is evaluated BEFORE the current point is pushed, so at t ns the
// oldest sample still in the ring is t - 512 ns, which for every t > 512 is
// NEWER than the queried t - 515. From t = 513ns on the operator therefore
// answers max(t/1ns - 512, 0) instead of max(t/1ns - 515, 0): it reports a
// delay of 512ns, three nanoseconds short, and it does so silently — no
// diagnostic, no $error, no host-visible flag. Measured, the deviation is 1 at
// t = 513ns and a flat 3 from t = 515ns to the end of the run; at t = 520ns
// the operator answers 8 where the clause requires 5.
//
// This is the row's "record resource failures explicitly" item stated as a
// value: a capacity an implementation cannot meet may be reported, but it may
// not be quietly rewritten into a shorter delay. The first 513 points of this
// fixture pass under both readings, so a failure here localises precisely to
// the sample at which the ring underruns.
//
//! lrm 4.5.7
//! bias V(n) = 0
//! time 0, 1n, 2n, 3n, 4n, 5n, 6n, 7n, 8n, 9n, 10n, 11n, 12n, 13n, 14n, 15n, 16n, 17n, 18n, 19n, 20n, 21n, 22n, 23n, 24n, 25n, 26n, 27n, 28n, 29n, 30n, 31n, 32n, 33n, 34n, 35n, 36n, 37n, 38n, 39n, 40n, 41n, 42n, 43n, 44n, 45n, 46n, 47n, 48n, 49n, 50n, 51n, 52n, 53n, 54n, 55n, 56n, 57n, 58n, 59n, 60n, 61n, 62n, 63n, 64n, 65n, 66n, 67n, 68n, 69n, 70n, 71n, 72n, 73n, 74n, 75n, 76n, 77n, 78n, 79n, 80n, 81n, 82n, 83n, 84n, 85n, 86n, 87n, 88n, 89n, 90n, 91n, 92n, 93n, 94n, 95n, 96n, 97n, 98n, 99n, 100n, 101n, 102n, 103n, 104n, 105n, 106n, 107n, 108n, 109n, 110n, 111n, 112n, 113n, 114n, 115n, 116n, 117n, 118n, 119n, 120n, 121n, 122n, 123n, 124n, 125n, 126n, 127n, 128n, 129n, 130n, 131n, 132n, 133n, 134n, 135n, 136n, 137n, 138n, 139n, 140n, 141n, 142n, 143n, 144n, 145n, 146n, 147n, 148n, 149n, 150n, 151n, 152n, 153n, 154n, 155n, 156n, 157n, 158n, 159n, 160n, 161n, 162n, 163n, 164n, 165n, 166n, 167n, 168n, 169n, 170n, 171n, 172n, 173n, 174n, 175n, 176n, 177n, 178n, 179n, 180n, 181n, 182n, 183n, 184n, 185n, 186n, 187n, 188n, 189n, 190n, 191n, 192n, 193n, 194n, 195n, 196n, 197n, 198n, 199n, 200n, 201n, 202n, 203n, 204n, 205n, 206n, 207n, 208n, 209n, 210n, 211n, 212n, 213n, 214n, 215n, 216n, 217n, 218n, 219n, 220n, 221n, 222n, 223n, 224n, 225n, 226n, 227n, 228n, 229n, 230n, 231n, 232n, 233n, 234n, 235n, 236n, 237n, 238n, 239n, 240n, 241n, 242n, 243n, 244n, 245n, 246n, 247n, 248n, 249n, 250n, 251n, 252n, 253n, 254n, 255n, 256n, 257n, 258n, 259n, 260n, 261n, 262n, 263n, 264n, 265n, 266n, 267n, 268n, 269n, 270n, 271n, 272n, 273n, 274n, 275n, 276n, 277n, 278n, 279n, 280n, 281n, 282n, 283n, 284n, 285n, 286n, 287n, 288n, 289n, 290n, 291n, 292n, 293n, 294n, 295n, 296n, 297n, 298n, 299n, 300n, 301n, 302n, 303n, 304n, 305n, 306n, 307n, 308n, 309n, 310n, 311n, 312n, 313n, 314n, 315n, 316n, 317n, 318n, 319n, 320n, 321n, 322n, 323n, 324n, 325n, 326n, 327n, 328n, 329n, 330n, 331n, 332n, 333n, 334n, 335n, 336n, 337n, 338n, 339n, 340n, 341n, 342n, 343n, 344n, 345n, 346n, 347n, 348n, 349n, 350n, 351n, 352n, 353n, 354n, 355n, 356n, 357n, 358n, 359n, 360n, 361n, 362n, 363n, 364n, 365n, 366n, 367n, 368n, 369n, 370n, 371n, 372n, 373n, 374n, 375n, 376n, 377n, 378n, 379n, 380n, 381n, 382n, 383n, 384n, 385n, 386n, 387n, 388n, 389n, 390n, 391n, 392n, 393n, 394n, 395n, 396n, 397n, 398n, 399n, 400n, 401n, 402n, 403n, 404n, 405n, 406n, 407n, 408n, 409n, 410n, 411n, 412n, 413n, 414n, 415n, 416n, 417n, 418n, 419n, 420n, 421n, 422n, 423n, 424n, 425n, 426n, 427n, 428n, 429n, 430n, 431n, 432n, 433n, 434n, 435n, 436n, 437n, 438n, 439n, 440n, 441n, 442n, 443n, 444n, 445n, 446n, 447n, 448n, 449n, 450n, 451n, 452n, 453n, 454n, 455n, 456n, 457n, 458n, 459n, 460n, 461n, 462n, 463n, 464n, 465n, 466n, 467n, 468n, 469n, 470n, 471n, 472n, 473n, 474n, 475n, 476n, 477n, 478n, 479n, 480n, 481n, 482n, 483n, 484n, 485n, 486n, 487n, 488n, 489n, 490n, 491n, 492n, 493n, 494n, 495n, 496n, 497n, 498n, 499n, 500n, 501n, 502n, 503n, 504n, 505n, 506n, 507n, 508n, 509n, 510n, 511n, 512n, 513n, 514n, 515n, 516n, 517n, 518n, 519n, 520n
//! analysis tran
//! print none
`include "check.vh"
module a04_absdelay_history_capacity(p, n);
    inout p, n;
    electrical p, n;

    analog begin
        `CHECK("a delay spanning more accepted steps than the history ring is still the delay",
               absdelay($abstime * 1e9, 515n)
                 - max($abstime * 1e9 - 515.0, 0.0), 0.0, 1e-9);
        // Literal and row-invariant: the output is still exactly zero at
        // t = 515ns, because Input(max(515-515,0)) = Input(0) = 0.
        //
        // The wrong answer, derived rather than guessed: the operator is
        // evaluated BEFORE the current point is pushed, so at t = 515ns the
        // oldest sample a 512-deep ring still holds is t = 515 - 512 = 3ns.
        // The query for t - td = 0ns is older than that, so `zHistAt`'s
        // "clamp to the OLDEST sample" returns Input(3ns) = 3. A ring that has
        // forgotten everything older than t - 512ns therefore answers 3 here,
        // not 0. Measured at HEAD: the residual asserted by the CHECK above
        // reads got=3 at t = 515ns and at every point to the end of the run.
        `CHECKI("the output is still zero at t = td",
                absdelay($abstime * 1e9, 515n) == 0.0 || $abstime > 515n, 1);

        I(p, n) <+ 0.0;
    end
endmodule
