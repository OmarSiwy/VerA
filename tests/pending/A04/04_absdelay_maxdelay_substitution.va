// §4.5.7 the three-argument form, which is the ONLY way the clause lets td
// vary, and the substitution rule that bounds it.
//
//   "If the optional maxdelay is specified, then td can vary. IF td BECOMES
//    GREATER THAN maxdelay, maxdelay WILL BE USED AS A SUBSTITUTE FOR td."
//   "In time-domain analyses, absdelay() introduces a transport delay equal to
//    the instantaneous value of td based on the following formula.
//        Output(t) = Input(max(t - td, 0))"
//
// WHAT FIGURE 4-4 DOES AND DOES NOT SUPPLY. The td SCHEDULE below is Figure
// 4-4's, rescaled ns-for-s: the figure's ramp input, td = 2 stepping to 4 at
// t = 3 and dropping to 1 at t = 5, and the prose that goes with it —
//
//   "From time 0 until 2s, the output remains at input(0). With a delay of 2s,
//    the output then starts tracking input(t - 2). At 3s, the transport delay
//    changes from 2s to 4s, switching the output back to input(0), since
//    input(max(t-td,0)) returns 0. ..."
//
// Figure 4-4's maxdelay is 5, and its td never exceeds 5, SO THE FIGURE
// ILLUSTRATES NOTHING ABOUT THE SUBSTITUTION RULE THIS FIXTURE IS NAMED FOR.
// The substitution comes only from the normative sentence quoted above. This
// fixture sets maxdelay = 3 instead, which is what makes t = 4ns a point where
// it DEPARTS from the figure: the figure (maxdelay 5, td honoured at 4) reads
// input(0) = 0 there, this fixture (maxdelay 3, td clamped to 3) reads
// input(1ns) = 1. The figure is cited for the varying-td shape and for the
// forward jump at the downward step, and for nothing else.
//
// THE HAND DERIVATION. Input is the 1 V/ns ramp $abstime*1e9, maxdelay = 3ns,
// and td is driven from node d as V(d)*1ns with the piecewise-constant
// schedule 2, 2, 2, 4, 4, 1, 1, 1 (ns). The effective delay is min(td, 3ns):
//
//   t/ns       0    1    2    3    4    5    6    7
//   td/ns      2    2    2    4    4    1    1    1
//   eff/ns     2    2    2    3    3    1    1    1    <- maxdelay substitutes
//   t-eff     -2   -1    0    0    1    4    5    6
//   out        0    0    0    0    1    4    5    6    <- Input(max(t-eff,0))
//
// Two independent facts are pinned by that table:
//
//   · t = 3ns and t = 4ns are where the substitution bites. The raw td is 4ns
//     there; an implementation that honoured it would answer Input(max(3-4,0))
//     = 0 and Input(max(4-4,0)) = 0, so t = 4ns separates "clamped to maxdelay"
//     (1) from "used td as given" (0).
//   · t = 5ns is the downward jump the figure's prose does describe: the delay
//     shortens, so the output JUMPS FORWARD, from 1 to 4. A first-order lag
//     substituted for a transport delay cannot produce that jump, and an
//     implementation that froze td at its first value stays on max(t-2,0) = 3.
//
// The want is written as max(t/1ns - min(V(d), 3), 0) — the clause's own
// formula with the substitution rule inlined — over the driven V(d), which is
// an INPUT of the fixture and not an output of the operator under test.
//
// WHY THIS FAILS TODAY. Two separate defects, both visible in
// `Gen.emitOperator`'s `.absdelay` arm: it passes `argF64(args, 1)` as the
// delay and never looks at argument 2, so maxdelay is dropped entirely; and
// `argF64` cannot render a node probe, so the call is refused with E0515
// before the missing clamp can even be observed. Table 4-20 lists td as a
// dynamic argument and maxdelay as the constant one, which is the opposite of
// what is implemented.
//
//! lrm 4.5.7
//! bias V(n) = 0
//! wave V(d) = 2, 2, 2, 4, 4, 1, 1, 1
//! time 0, 1n, 2n, 3n, 4n, 5n, 6n, 7n
//! analysis tran
//! print none
`include "check.vh"
module a04_absdelay_maxdelay(d, n);
    inout d, n;
    electrical d, n;

    analog begin
        `CHECK("maxdelay substitutes for td once td exceeds it, and td varies otherwise",
               absdelay($abstime * 1e9, V(d, n) * 1n, 3n)
                 - max($abstime * 1e9 - min(V(d, n), 3.0), 0.0), 0.0, 1e-12);
        // Literal and row-invariant: at t = 4ns the clamped delay is 3ns, so
        // the output is Input(1ns) = 1. Honouring the unclamped td = 4ns gives
        // 0 here; freezing td at 2ns gives 2.
        `CHECKI("at t = 4ns the clamp makes the output Input(1ns) = 1",
                absdelay($abstime * 1e9, V(d, n) * 1n, 3n) == 1.0 || $abstime != 4n, 1);

        I(d, n) <+ 0.0;
    end
endmodule
