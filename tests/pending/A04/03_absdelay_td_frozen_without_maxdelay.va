// §4.5.7 the FREEZE rule for a varying td, and Table 4-20's statement that td
// is a dynamic argument of absdelay() in the first place.
//
//   §4.5.7: "absdelay ( input , td [ , maxdelay ] ) ... If the optional
//   maxdelay is specified, then td can vary. ... IF MAXDELAY IS NOT SPECIFIED,
//   THE VALUE OF td WHEN THE absdelay() IS FIRST EVALUATED SHALL BE USED AND
//   ANY FUTURE CHANGES TO td SHALL BE IGNORED."
//
//   Table 4-20 "Analog operator arguments" lists, for absdelay,
//     constant expression arguments: maxdelay
//     dynamic expression arguments:  expr, td
//   so a signal-valued td is a legal program; what the sentence above fixes is
//   that WITHOUT maxdelay its later values are ignored, not that it must be a
//   constant.
//
// THE HAND DERIVATION. td is driven from node d as V(d)*1ns and the input is
// the 1 V/ns ramp $abstime*1e9, so the LRM's time-domain formula
//
//     Output(t) = Input(max(t - td, 0))
//
// with td FROZEN at its first-evaluation value — V(d) = 2 at t = 0, hence
// td = 2ns forever — reads max(t/1ns - 2, 0) at every point, including the
// three points where V(d) has already moved to 5:
//
//   t/ns    0    1    2    3    4    5
//   V(d)    2    2    2    5    5    5
//   out     0    0    0    1    2    3
//
// An implementation that re-reads td every evaluation answers Input(max(t-5,0))
// = 0 at t = 3, 4, 5 — it misses three of the six points, and it misses them in
// the direction that makes a transmission line shrink when its own delay
// parameter is swept during a run.
//
// WHY THIS FAILS TODAY. `Gen.argF64` renders an operator control argument
// through `f64Const`, which folds literals and `model.<p>` parameter
// arithmetic and nothing else. A node probe is neither, so the call is refused
// with E0515 ("a control argument that is a solve result") and the module does
// not compile at all. That is a refusal of a legal program: the frozen value
// this clause asks for is a single number sampled once, which is strictly
// LESS than what the operator already computes every step.
//
//! lrm 4.5.7
//! bias V(n) = 0
//! wave V(d) = 2, 2, 2, 5, 5, 5
//! time 0, 1n, 2n, 3n, 4n, 5n
//! analysis tran
//! print none
`include "check.vh"
module a04_absdelay_td_frozen(d, n);
    inout d, n;
    electrical d, n;

    analog begin
        `CHECK("td is frozen at its first-evaluation value when maxdelay is absent",
               absdelay($abstime * 1e9, V(d, n) * 1n)
                 - max($abstime * 1e9 - 2.0, 0.0), 0.0, 1e-12);
        // Row-invariant and literal: with the delay frozen at 2ns the output
        // is strictly increasing from t = 2ns on. A td that tracks V(d) drops
        // the output back to 0 at t = 3ns, which this cannot be read as.
        `CHECKI("the frozen delay never sends the output back to its start",
                absdelay($abstime * 1e9, V(d, n) * 1n) > 0.0 || $abstime <= 2n, 1);

        I(d, n) <+ 0.0;
    end
endmodule
