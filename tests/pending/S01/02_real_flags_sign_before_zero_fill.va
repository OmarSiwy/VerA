// §9.4.3: the real conversions of Table 9-23 "have the full formatting
// capabilities available in the C language", and the clause's own example
// ("%10.3g sets a minimum field width of 10") makes the C flag/width/precision
// prefix part of the specification and not an extension.
//
// Three C rules (C11 7.21.6.1p6, the flag characters) are pinned here, and each
// one is a place where a naive `std.fmt`-style port loses a character:
//
//   '+'  "the result of a signed conversion always begins with a plus or minus
//        sign".  A POSITIVE real must therefore print a '+'.
//   ' '  "if the first character of a signed conversion is not a sign ... a
//        space is prefixed to the result".  '+' overrides ' '.
//   '0'  "leading zeros ... are used to pad to the field width; no space
//        padding is performed".  The padding goes AFTER the sign, never before
//        it — a field of zeros with the sign buried inside is not a number.
//
// HAND DERIVATION:
//
//   %+08.1f of 2.5    "2.5" is exact in binary, precision 1 leaves it alone.
//                     '+' prepends the sign -> "+2.5", four characters.
//                     Width 8, '0' flag -> four zeros AFTER the sign:
//                     -> "+00002.5"
//   % .2f  of 1.0     no sign character, so the space flag supplies one:
//                     -> " 1.00"
//   %09.2f of -3.5    "-3.50" is five characters; width 9 with '0' puts the
//                     four pad zeros after the '-':
//                     -> "-00003.50"
//   %-9.2f of -3.5    '-' left-justifies and (C: "the 0 flag is ignored") wins
//                     over any zero fill; the pad is spaces on the RIGHT:
//                     -> "-3.50    "  (five characters plus four spaces)
//
// The last one is the CONTROL: it already holds in VerA, so a failure of the
// other three cannot be explained away as "the width machinery is missing".
// The '|' after it is part of the format, not of the number, so a trailing-space
// loss is visible in the comparison instead of being trimmed by an eye.
//
//! lrm 9.4.3
//! lrm 9.5.3
//! print none
`include "check.vh"
module s01_real_flags(p, n);
  inout p, n; electrical p, n;
  string plus_zero, space_flag, neg_zero, left;
  analog begin
    $sformat(plus_zero,  "%+08.1f", 2.5);
    $sformat(space_flag, "% .2f",   1.0);
    $sformat(neg_zero,   "%09.2f",  -3.5);
    $sformat(left,       "%-9.2f|", -3.5);

    `CHECKI("§9.4.3 '+' spells the sign of a positive real and '0' pads behind it", (plus_zero == "+00002.5"), 1);
    `CHECKI("§9.4.3 ' ' puts a space where the sign would be", (space_flag == " 1.00"), 1);
    `CHECKI("§9.4.3 zero fill goes after the minus sign, not in front of it", (neg_zero == "-00003.50"), 1);
    `CHECKI("§9.4.3 '-' left-justifies and pads with spaces (control: holds today)", (left == "-3.50    |"), 1);

    I(p,n) <+ V(p,n);
  end
endmodule
