// §9.4.3, the two sentences this file rests on, quoted in full from
// docs/ch9-system.html:
//
//   "The format specifications in Table 9-23 are used for real numbers and have
//    the full formatting capabilities available in the C language. For example,
//    the format specification %10.3g sets a minimum field width of 10 with
//    three (3) fractional digits."
//
// and Table 9-23's own row:
//
//   "%g or %G   Display 'real' in exponential or decimal format, whichever
//               format results in the shorter printed output"
//
// THE CLAUSE CONTRADICTS ITSELF, AND THIS FILE DOES NOT PRETEND OTHERWISE.
// The first half of that sentence makes C normative, and in C (C11 7.21.6.1p8)
// the precision of `%g` counts SIGNIFICANT digits, so `%10.3g` of 1234.5678 is
// `  1.23e+03`. The second half — the clause's own worked example — says the
// `3` is a count of FRACTIONAL digits, which gives `  1234.568`. Both cannot
// hold. An implementation that follows the printed example is following the
// LRM, so a fixture asserting the C reading of an EXPLICIT precision field
// would fail a conforming tool. Those two rows are therefore withdrawn; see
// the WITHDRAWN note at the bottom and SPEC.md.
//
// WHAT SURVIVES: `%g` WITH NO PRECISION FIELD. There the contradiction does not
// arise — there is no digit for the example to reinterpret — and the answer is
// fixed twice over, once by C and once by Table 9-23's own "whichever format
// results in the shorter printed output". Every row below is derived both ways
// and the two derivations agree, which is why these four are assertable and the
// explicit-precision pair is not.
//
// C's rule, written out (P = precision, default 6; X = the decimal exponent the
// value would get in %e style):
//     if P > X >= -4   -> format as %f with precision P - 1 - X
//     otherwise        -> format as %e with precision P - 1
//   then remove trailing zeros from the fractional part (and the point, if the
//   fraction becomes empty).
//
// HAND DERIVATION, one line per claim, with the Table 9-23 cross-check written
// out as the character counts of the two candidate renderings:
//
//   %g 1234.5678      X=3, P=6.  6 > 3 >= -4  -> %f prec 2 -> "1234.57"
//                     shorter-output check: "1234.57" (7) vs "1.234568e+03"
//                     (12) -> decimal.  Agrees.
//   %g 1e-5           X=-5, P=6. -5 < -4      -> %e prec 5 -> "1.00000e-05"
//                     -> strip zeros -> "1e-05"
//                     shorter-output check: "0.00001" (7) vs "1e-05" (5)
//                     -> exponential.  Agrees.
//   %g 1e8            X=8, P=6.  6 > 8 false  -> %e prec 5 -> "1.00000e+08"
//                     -> strip zeros -> "1e+08"
//                     shorter-output check: "100000000" (9) vs "1e+08" (5)
//                     -> exponential.  Agrees.
//   %g 0.000123456789 X=-4, P=6. 6 > -4 >= -4 -> %f prec 9 -> "0.000123457"
//                     shorter-output check: "0.000123457" (11) vs
//                     "1.234568e-04" (12) -> decimal.  Agrees, and by one
//                     character, which is why this value sits at the boundary.
//
// The exponent is written with a sign and AT LEAST TWO DIGITS ("e-05", "e+08"),
// which is C's %e and which VerA already reproduces for an explicit `%e` — see
// tests/fixtures/ch09_system_tasks/171_display_c_format_flags.va.
//
// WHY THE FOUR THAT REMAIN STILL HAVE TEETH. `src/backend/cg_display.zig`
// renders a real through Zig's shortest-round-trip formatting, so `%g` of 1e8
// prints `100000000` — nine characters where Table 9-23 demands the shorter of
// the two renderings, five. All four rows fail today and each names a distinct
// branch of the rule: below the -4 floor, above the precision ceiling, and the
// two sides of the decimal window.
//
// WHY THE ASSERTION IS A STRING COMPARISON. The value of a conversion is text,
// and the only way to hold text in a Verilog-AMS fixture is §9.5.3's
// `$sformat(string_variable, format_string, …)`, which "supports all the format
// specifiers supported by $display". §3.3 gives `string` an equality operator,
// so the comparison is an integer (§4.2.5) and stays out of a conditional — the
// shape `check.vh` documents.
//
// WITHDRAWN, AND WHERE IT WENT. The two explicit-precision rows —
//   $sformat(e, "%.3g", 1234.5678)  previously asserted "1.23e+03"
//   $sformat(f, "%.2g", 0.012345)   previously asserted "0.012"
// — are removed from this file and from row S01. NO ROW OWNS THEM NOW, and none
// is given them: no clause in the offline LRM set settles the question, because
// the only sentence that speaks to a `%g` precision field is the one quoted at
// the top and it decides against C. What would let them come back, in order of
// preference: (a) an Accellera erratum or a later LRM revision correcting the
// "three (3) fractional digits" example; (b) the IEEE 1364-2005 §17.1.1.2 text
// landing in docs/, if it states the C `%g` precision rule without the gloss —
// it is not in the offline set today, the same reason SPEC.md gives for not
// writing the `%v` strength spellings from memory. Until one of those happens,
// VerA's `1234.568` for `%.3g` is the reading the LRM prints and this row does
// not object to it.
//
//! lrm 9.4.3
//! lrm 9.5.3
//! print none
`include "check.vh"
module s01_real_g_conversion(p, n);
  inout p, n; electrical p, n;
  string a, b, c, d;
  analog begin
    $sformat(a, "%g", 1234.5678);
    $sformat(b, "%g", 1.0e-5);
    $sformat(c, "%g", 1.0e8);
    $sformat(d, "%g", 0.000123456789);

    `CHECKI("§9.4.3 %g of 1234.5678 is %f with precision 6-1-3, and %f is the shorter", (a == "1234.57"), 1);
    `CHECKI("§9.4.3 %g of 1e-5 has exponent -5 < -4, so it is %e, 5 chars against 7", (b == "1e-05"), 1);
    `CHECKI("§9.4.3 %g of 1e8 has exponent 8 >= precision 6, so it is %e, 5 chars against 9", (c == "1e+08"), 1);
    `CHECKI("§9.4.3 %g of 1.23456789e-4 sits at the -4 boundary, so it is %f, 11 chars against 12", (d == "0.000123457"), 1);

    I(p,n) <+ V(p,n);
  end
endmodule
