// §9.5.4.2's conversion-code table has six rows, and VerA's E0813 diagnostic
// enumerates a set that is missing two of them ("§9.5.4.2's codes are %d %o %h
// %x %b %c %f %e %g %s"). The two it drops are both in the LRM table:
//
//   "r   Matches a 'real' number in engineering notation, using the scale
//        factors defined in 2.6.2"
//   "m   Returns the current hierarchical path as a string. Does not read data
//        from the input file or str argument"
//
// §2.6.2 Table 2-1 is the alphabet %r must accept — T 1e12, G 1e9, M 1e6,
// "K, k" 1e3, m 1e-3, u 1e-6, n 1e-9, p 1e-12, f 1e-15, a 1e-18 — and §2.6.2
// also fixes the syntax it appears in: "No space is permitted between the number
// and the symbol."
//
// HAND DERIVATION, %r:
//
//   "1.5m"  1.5 x 1e-3  = 0.0015      (not exact in binary; tolerance 1e-18,
//                                      which is 1e-15 relative — far tighter
//                                      than any mis-scaling)
//   "2.5K"  2.5 x 1e3   = 2500.0      (exact: 2.5 is dyadic and 1e3 is an
//                                      integer, so CHECKX applies)
//   "-3n"   -3  x 1e-9  = -3e-9       (the sign is part of the number, and the
//                                      lower-case n is the only Table 2-1 row
//                                      for 1e-9)
//   "4"     no symbol at all          = 4.0 exactly. A plain real is still a
//                                      real in engineering notation with an
//                                      implied factor of 1, so %r must not
//                                      REQUIRE a scale character.
//
// Each returns 1 — "the number of successfully matched and assigned input items"
// — and "2.5K" is chosen over "2.5k" deliberately: Table 2-1 spells that row
// "K, k", so an INPUT scanner has to take both, even though no fixture may pin
// which one an output prints.
//
// HAND DERIVATION, %m: the claim is the clause's own second sentence, and it is
// asserted by consequence rather than by spelling. "Does not read data from the
// input file or str argument" means the %d after it still sees the whole input,
// so scanning "42" with "%m%d" leaves 42 in the integer destination. A %m that
// consumed the field — or that was silently treated as an unknown code and
// terminated the scan — leaves the destination untouched instead.
//
// The hierarchical path string itself is NOT compared against a literal: §9.5.4.2
// says only "the current hierarchical path", and what that spells for the top
// level of a single-module testbench is not fixed by any clause. Only the
// non-consumption is pinned, which is the half the LRM does state.
//
//! lrm 9.5.4.2
//! lrm 2.6.2
//! print none
`include "check.vh"
module s01_scan_engineering(p, n);
  inout p, n; electrical p, n;
  integer n1, n2, n3, n4, n5, v;
  real milli, kilo, nano, plain;
  string path;
  analog begin
    n1 = $sscanf("1.5m", "%r", milli);
    n2 = $sscanf("2.5K", "%r", kilo);
    n3 = $sscanf("-3n",  "%r", nano);
    n4 = $sscanf("4",    "%r", plain);
    n5 = $sscanf("42",   "%m%d", path, v);

    `CHECKI("§9.5.4.2 %r matches one item", n1, 1);
    `CHECK("§2.6.2 the symbol m scales by 1e-3", milli, 0.0015, 1e-18);
    `CHECKI("§9.5.4.2 %r matches one item", n2, 1);
    `CHECKX("§2.6.2 Table 2-1 spells 1e3 'K, k', so the upper case must scan", kilo, 2500.0);
    `CHECKI("§9.5.4.2 %r matches one item", n3, 1);
    `CHECK("§2.6.2 the sign belongs to the number and n scales by 1e-9", nano, -3e-9, 1e-24);
    `CHECKI("§9.5.4.2 %r matches one item", n4, 1);
    `CHECKX("§2.6.2 a scale symbol is optional: an unscaled real is still a real", plain, 4.0);

    `CHECKI("§9.5.4.2 %m does not read data, so the %d after it still sees 42", v, 42);
    `CHECKI("§9.5.4.2 and the %d was matched and assigned", (n5 >= 1), 1);

    I(p,n) <+ V(p,n) + milli + kilo + nano + plain + v;
  end
endmodule
