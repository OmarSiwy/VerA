// §9.5.4.2 lists the destinations a scan may write and names `real` among them:
//
//   "Both expect as arguments a control string, format, and a SET OF ARGUMENTS
//    SPECIFYING WHERE TO PLACE THE RESULTS. ... If an argument is too small to
//    hold the converted input, then, in general, the least significant bits are
//    transferred. Arguments of any length that is supported by Verilog AMS HDL
//    in the analog context can be used. However, IF THE DESTINATION IS A REAL,
//    then the value inf (or -inf) is transferred."
//
// and the conversion itself:
//
//   "f, e, or g   Matches a floating point number. The format of a floating point
//    number is an optional sign (either + or -), followed by a string of digits
//    ... optionally containing a decimal point character (.), followed by an
//    optional exponent part including e or E ..."
//
// The clause's `real` sentence is about overflow; the reason it can be written at
// all is that a real destination is legal in the first place. This file asserts
// the legal, non-overflowing case, which is the one every table-reading model
// uses.
//
// HAND DERIVATION. The file is written by the fixture itself and holds
// "5.5 -2.25e2 7\n":
//
//   %f on "5.5"      sign absent, digits "5", point, digits "5", no exponent
//                    -> 5.5, exact in binary (11/2)
//   %f on "-2.25e2"  sign '-', digits "2", point, digits "25", exponent "e2"
//                    -> -2.25 * 100 = -225.0, exact (2.25 = 9/4, 225 = 9*25)
//   %d on "7"        -> 7, into an INTEGER destination, which is the control:
//                    it shows the call shape works and isolates the real
//                    destination as the thing under test
//
//   "The number of successfully matched and assigned input items is returned in
//    code" -> 3 for the single call that does all three.
//
// Both reals are dyadic rationals, so CHECKX is exact equality and no tolerance
// is involved; a scanner that loses the exponent answers -2.25 and fails by 100x
// rather than by a last bit.
//
// WHAT THIS ACTUALLY CATCHES TODAY. Not a wrong number — a device that does not
// compile. VerA emits `@floatFromInt(zScanR(...))` for a real destination, and
// `zScanR` already returns an f64, so `zig build-exe` rejects the generated
// source with "expected integer type, found 'f64'" before anything runs. The
// $sscanf form of the same conversion is fine (see
// tests/fixtures/ch09_system_tasks/162_sscanf_conversion_rules.va, which reads
// 5.5 into a real from a string literal), so the defect is in the $fscanf
// lowering alone and this fixture is the smallest thing that exhibits it.
//
//! lrm 9.5.4.2
//! print none
`include "check.vh"
module s01_fscanf_real_destination(p, n);
  inout p, n; electrical p, n;
  integer fd, code, count;
  real first, second;
  analog begin
    fd = $fopen("s01_11_reals.dat", "w");
    $fwrite(fd, "5.5 -2.25e2 7\n");
    $fclose(fd);

    fd = $fopen("s01_11_reals.dat", "r");
    code = $fscanf(fd, "%f %f %d", first, second, count);
    $fclose(fd);

    `CHECKI("§9.5.4.2 three items matched and assigned", code, 3);
    `CHECKX("§9.5.4.2 a real destination receives the converted value", first, 5.5);
    `CHECKX("§9.5.4.2 including the sign and the exponent part", second, -225.0);
    `CHECKI("§9.5.4.2 an integer destination in the same call still works", count, 7);

    I(p,n) <+ V(p,n) + first + second;
  end
endmodule
