// H04 — model-card binding is not a resistor special case: a `.MODEL ... C`
// card has to reach BOTH of Table E.1's capacitor parameters, including the one
// that is an initial condition rather than a coefficient.
//
// THE CLAUSE. Table E.1, `capacitor` row, ports p, n, parameters c, ic:
//
//     V = (1/c) * integral(0..t) I dtau  +  ic
//
// and E.2.2.3 prints this primitive by name — `capacitor #(.c(1p), .ic(1)) C1
// (vcc, out);` — as its translation of E.2.2.2's `C1 VCC OUT 1P IC=1` card. That
// pairing is the annex saying, in its own worked example, that the netlist's
// `IC=1` and the Verilog-AMS `.ic(1)` are the same quantity. A model card
// spelling `IC=2.5` therefore has to land on Table E.1's `ic`.
//
// `ic` is the interesting half. §4.5.4 (Time integral operator), Table 4-18,
// makes the second argument of `idt` the initial condition — "idt(expr,ic)
// Returns ∫ x(τ)dτ + c, where in this case c is the value of ic at t0" — which
// is exactly what this column's `+ ic` is. (§4.5.5 is the *circular* integrator
// `idtmod`, a different operator; an earlier revision of this file cited it by
// mistake.) A tool that
// binds `c` but drops `ic` is off by a constant offset at every time point and
// its capacitor starts discharged when the netlist said 2.5 V.
//
// THE DIGITS, BY HAND. The parent drives a constant 1 mA into p (`I(p) <+ -1m`)
// and `//! bias V(n) = 0.0` sinks it, so KCL leaves the capacitor branch
// carrying exactly 1e-3 A and nothing else does. The card gives c = 1e-3 F, so
// the integrand is
//
//     I / c = 1e-3 / 1e-3 = 1.0   exactly — the same decimal over itself, which
//                                 no rounding can perturb
//
// A constant integrand makes the integral exact at every accepted step, so
//
//     V(x1.p, x1.n) = 1.0 * t + 2.5   volts
//
// and subtracting the t term leaves the constant: the asserted want is `ic`
// itself, 2.5, at t = 0, 0.5 and 1.0. A tool that dropped the card's C answers
// with c = 1 F, integrand 1e-3, and V - 1.0*t = 2.5 - 0.9995 at t = 0.5 — caught
// at the second and third time points. A tool that dropped the card's IC answers
// 0.0 at every point — caught at all three. A tool that dropped both answers 0.0
// at t = 0 and -0.4995 at t = 0.5.
//
// A CAPACITOR IS A POTENTIAL RELATION, which `//! solve` is here to respect: the
// row makes V a function of the integral of I, so the branch FLOW is the unknown
// and the harness has to solve for it. A tool that read the row backwards, as a
// current contribution, cannot produce these numbers at all.
//
//! lrm E.2.2.1
//! lrm E.2.2.3
//! lrm E.3
//! lrm 4.5.4
//! lrm 6.7.1
//! analysis tran
//! time 0, 0.5, 1.0
//! bias V(n) = 0.0
//! solve
//! spice .MODEL CM C C=1E-3 IC=2.5
`include "check.vh"
module h04_model_card_capacitor(p, n);
  inout p, n; electrical p, n;
  cm x1(p, n);
  analog begin
    // 1 mA in at p; the `//! bias` on n is where it leaves.
    I(p) <+ -1m;
    `CHECKX("the card's C reaches Table E.1's c", x1.c, 1.0e-3);
    `CHECKX("the card's IC reaches Table E.1's ic", x1.ic, 2.5);
    `CHECK("Table E.1: V = (1/c)*integral(I) + ic, so V - 1.0*t is ic",
           V(x1.p, x1.n) - 1.0*$abstime, 2.5, 1e-15);
  end
endmodule
