// H04 — Table E.1's `dc` parameter, at the primitive, with no netlist anywhere
// near it. Fixture 07 asserts the same number through a `.SUBCKT`; this one
// isolates the primitive so the two failures are separable.
//
// THE CLAUSE. Table E.1 lists `dc, mag, phase` as the first three parameters of
// every independent-source row — iexp, ipulse, ipwl, isine, vexp, vpulse, vpwl,
// vsine — and none of the three appears in any of those rows' Behavior columns.
// E.3 makes those names REQUIRED ("Table E.1 shows the required names for
// primitives, parameters, and ports which are otherwise unnamed in SPICE"), so
// they are not decoration: a required parameter that no equation reads is a
// parameter that does nothing, which is not what "required name" means.
//
// §4.6.1 Table 4-21 supplies the missing equation by naming the analyses: "dc"
// is "the .OP or .DC analysis (single point or dc sweep analysis)", "ac" the AC
// analysis. So the three lead parameters are the §4.6 analysis-dependent values
// — dc the operating-point value, mag and phase the AC stimulus (§4.6.3's
// `ac_stim(analysis_name, mag, phase)` takes exactly those two) — and the
// Behavior column's sine is the TRANSIENT waveform.
//
// E.2.2.3 is the annex using it: `VA VCC GND 5`, a plain 5 V DC supply, is
// translated `vsine #(.dc(5)) Vcc (vcc, gnd);` with every waveform parameter
// left at its default. If `dc` contributed nothing, that line would be a 0 V
// supply (or, with the defaults a tool happened to pick, some arbitrary sinusoid)
// and E.2.2.3's `ecpOsc` would not be the circuit E.2.2.2 defines.
//
// THE DIGITS, BY HAND. `//! analysis dc` selects the operating point, so the
// source holds its `dc`:
//
//     V(v1.p, v1.n) = dc = 2.5 V   exactly
//
// and the 1 kohm load, Table E.1's resistor row with tc1 = tc2 = 0 so the
// temperature factor is 1:
//
//     I(load.p, load.n) = 2.5 / 1000 = 2.5e-3 A
//
// WHAT VerA DOES TODAY. `Preprocessor.spice_primitives` declares dc/mag/phase on
// every source row and says at the site that they are "declared, in Table E.1's
// order, and unused — selecting on `$analysis`/`analysis()` is the ceiling". So
// `dc` enters no equation and the analysis is never consulted. A run of this
// file today prints the parameter check green — `v1.dc got=2.5 ok=1`, it IS
// declared — beside `V(v1.p,v1.n) got=0 want=2.5 ok=0` and
// `I(load.p,load.n) got=-0 want=0.0025 ok=0`. A required name that does nothing,
// stated as digits.
//
//! lrm E.3
//! lrm E.2.2.3
//! lrm 4.6.1
//! lrm 4.6.2
//! lrm 4.6.3
//! lrm 6.7.1
//! analysis dc
//! bias V(n) = 0.0
//! solve
`include "check.vh"
module h04_vsine_dc(n);
  inout n; electrical n;
  vsine #(.dc(2.5)) v1(p, n);
  resistor #(.r(1k), .tc1(0.0), .tc2(0.0)) load(p, n);
  analog begin
    `CHECKX("the dc override reaches Table E.1's dc", v1.dc, 2.5);
    `CHECK("4.6.1: at the operating point an independent source holds its dc",
           V(v1.p, v1.n), 2.5, 1e-12);
    `CHECKR("so the 1 kohm load draws 2.5/1000", I(load.p, load.n), 2.5e-3, 1e-12);
  end
endmodule
