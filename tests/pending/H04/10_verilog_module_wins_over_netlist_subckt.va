// H04 — E.3.3's name-scoping rule, asserted as a CIRCUIT rather than as an
// acceptance. A Verilog-AMS module whose name exactly matches a SPICE
// subcircuit is the one that gets instantiated, and the way you know is that the
// node voltage is the Verilog-AMS module's.
//
// THE CLAUSE. E.3.3 "Name scoping of SPICE primitives":
//
//     "In the resolution hierarchy of names during elaboration a module or
//      paramset defined in the Verilog-AMS will always be selected in favor of a
//      SPICE primitive, model, or subcircuit using exactly the same name."
//
// and, for the same case:
//
//     "In case of a Verilog-AMS module or paramset whose name exactly matches
//      that of a SPICE model or subcircuit, the Verilog-AMS simulator shall issue
//      an warning message stating that the Verilog-AMS module or paramset is used
//      instead of the SPICE model or subcircuit."
//
// (The "an warning" is the wording printed in the published LRM.)
//
// HOW THIS IS DIFFERENT FROM THE EXISTING SHADOW FIXTURE.
// tests/fixtures/annex_e_spice/spice_name_shadow.va shadows a TABLE E.1
// PRIMITIVE (`resistor`) — the third paragraph of E.3.3 — and there is no
// netlist in that file at all. This one shadows a netlist `.SUBCKT`, which is
// the first and last paragraphs, and it supplies the netlist so that the losing
// candidate genuinely exists. Without both objects present the rule is untested:
// picking the only module there is proves nothing.
//
// THE TWO CANDIDATES ARE DELIBERATELY DIFFERENT CIRCUITS, so the answer names
// the winner. The netlist `.SUBCKT RDIV` is a 1k/3k divider; the Verilog-AMS
// `module rdiv` below is a 1k/1k divider. Same name, same three ports, same
// port order — nothing distinguishes them but E.3.3.
//
// THE DIGITS, BY HAND. `//! bias` holds in at 1.0 V and gnd at 0.0 V, `//!
// solve` frees the divider's midpoint.
//
//   Verilog-AMS rdiv wins (required):  1.0 * 1000/(1000+1000) = 0.5   V
//   netlist RDIV wins    (violation):  1.0 * 3000/(1000+3000) = 0.75  V
//   neither body contributes:                                  0.0    V
//
// Three distinct numbers, one assertion — but 0.5 is ALSO the answer a tool
// gives if it never reads the netlist at all, so that assertion on its own is
// satisfied by a tool with no Annex E netlist reader whatsoever. Measured: with
// `//! spice` unreachable from the CLI today, `vera --emit-exe` on this file
// prints `got=0.5 want=0.5 ok=1`. An assertion true of a tool that has none of
// the feature is not a claim about the feature.
//
// SO THE CONTROL IS IN THIS FILE, not in fixture 06. `.SUBCKT RNET` has a name
// nothing in this file shadows, so E.3.3's rule does not apply to it and the
// only way to answer its check is to have read the netlist and contributed its
// one card. The two checks then bracket the rule from both sides:
//
//     x2 (no Verilog-AMS rival)  must be the NETLIST's:  I = 1.0/4000 = 2.5e-4 A
//     x1 (a Verilog-AMS rival)   must be the MODULE's:   V(out,gnd) = 0.5 V
//
// A tool that ignores netlists fails the first (open circuit, I = 0). A tool
// that lets the netlist win the name race fails the second (0.75). A tool that
// reads netlists and honours E.3.3 passes both, and no tool missing either half
// passes both. That is the claim; the file did not make it before.
//
// THE CONTROL IS NOT A COPY OF 06. 06 asserts an INTERNAL node of a two-card
// divider under `//! solve` — that the body's node ordering and both values
// carry across. This one asserts a port-branch CURRENT through a single card,
// with both of its nodes held by `//! bias`. If 06 is red and this one's first
// check is red, the cause is the shared one (the body is unread); if only 06 is
// red, it is the internal node.
//
// THE DIGITS. `//! bias` holds in at 1.0 V and gnd at 0.0 V. The Table E.1
// resistor row with no tc1/tc2 has factor (1 + tc1*T + tc2*T^2) = 1 exactly, so
// `4K` = 4000 ohm gives I = 1.0/4000 = 2.5e-4 A. 1e-14 relative is ~45 ulp.
//
// WHAT VerA DOES TODAY. `Flatten.findModule` (`src/ir/elaborate.zig`) walks
// `userModules()` first, then the shipped primitives, then the netlist range, so
// the ordering half of E.3.3 is implemented and the 0.5 check reads green. The
// control does not: `src/frontend/spice_cards.zig` gives `.SUBCKT` an empty
// body, so `rNet` is an open circuit and `I(x2.a, x2.b)` is 0. The file is red
// today for a stated reason, which is what it was missing. The mandated WARNING
// is still NOT asserted here — `//! reject` is for diagnostics that stop a
// compile, and this one must not.
//
//! lrm E.3.3
//! lrm E.2
//! lrm 6.7.1
//! bias V(in) = 1.0, V(gnd) = 0.0
//! solve
//! spice .SUBCKT RDIV IN OUT GND
//! spice R1 IN OUT 1K
//! spice R2 OUT GND 3K
//! spice .ENDS RDIV
//! spice .SUBCKT RNET A B
//! spice R1 A B 4K
//! spice .ENDS RNET
`include "check.vh"
// Exactly the netlist subcircuit's name and port order, and a different circuit.
module rdiv(in, out, gnd);
  inout in, out, gnd; electrical in, out, gnd;
  resistor #(.r(1k), .tc1(0.0), .tc2(0.0)) ra(in, out);
  resistor #(.r(1k), .tc1(0.0), .tc2(0.0)) rb(out, gnd);
endmodule

module h04_module_wins(in, gnd);
  inout in, gnd; electrical in, gnd;
  rdiv x1(in, mid, gnd);
  // No Verilog-AMS module is named `rnet`, so E.3.3 leaves this one to the
  // netlist. It is the control that makes the check below attributable.
  rNet x2(in, gnd);
  analog begin
    // The netlist subcircuit IS read and does contribute: 1.0/4000.
    `CHECKR("a .SUBCKT with no Verilog-AMS rival is the one instantiated",
            I(x2.a, x2.b), 2.5e-4, 1e-14);
    // The Verilog-AMS module is 1k/1k -> 0.5. The netlist RDIV is 1k/3k -> 0.75.
    `CHECK("E.3.3: the Verilog-AMS module is selected over the .SUBCKT of the same name",
           V(x1.out, x1.gnd), 0.5, 1e-12);
  end
endmodule
