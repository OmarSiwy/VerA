// §7.3.6.5, in full: "In this case, a digital primary (reg, wire, integer,
// etc.) whose value is calculated in the discrete domain appears in an
// expression which is in the analog context; thus the analog primary is
// evaluated in the continuous domain. The expression shall be evaluated using
// the digital value calculated for the greatest digital time tick which is less
// than or equal to the analog time when the expression is evaluated."
//
// That sentence is the ONLY normative content of the clause, and no fixture in
// the tree checks it: chapter 7's own COVERAGE.md records `s7-3-6-5` as "no
// fixture", having withdrawn the credit `analog_reads_integer.va` used to get
// (its `integer` is written inside the analog block, so §7.2.2 makes it
// continuous and no digital tick is involved).
//
// The rule has two halves and both need a number:
//
//   (a) LAST, not next. At an analog time strictly between two ticks the value
//       is the earlier one; the analog kernel must not see the future.
//   (b) LESS THAN OR EQUAL. At an analog time that IS a tick, the value is the
//       one that tick computed, not the one before it.
//
// DERIVATION, `timescale 1ns/1ns` so ticks are whole nanoseconds. `code` is a
// discrete 4-bit reg with three values, chosen so no two are equal and none is
// the §3.2 default:
//
//   tick 0    code = 4'd1
//   tick 10   code = 4'd5
//   tick 20   code = 4'd9
//
// Table 7-1's bit-grouping row reads them into the continuous context as the
// integers 1, 5 and 9 (bit 0 of the bus to bit 0 of the integer, high bits
// zero, sign bit zero). The observation times mix the two halves:
//
//   t = 5n    between ticks 0 and 10   -> half (a): 1
//   t = 10n   exactly tick 10          -> half (b): 5, not 1
//   t = 15n   between ticks 10 and 20  -> half (a): 5
//   t = 20n   exactly tick 20          -> half (b): 9, not 5
//   t = 25n   after the last change                9
//
// oracle ($abstime >= 20n) ? 9 : ($abstime >= 10n) ? 5 : 1.
//
// A tool that interpolated the discrete value the way it interpolates an analog
// one reads 3 at t = 5n. A tool that took the NEXT tick reads 5 at t = 5n and 9
// at t = 15n. A tool that used `<` instead of `<=` reads 1 at t = 10n and 5 at
// t = 20n — the two points that exist only to catch it. All four failures are
// whole integers apart.
//
// WHAT FAILS TODAY. `error[E0209]: expected an expression: found `#``: the
// `.va` dialect has no `#` delay (`src/frontend/parser.zig:2324` gates it on
// `self.digital`, which is set by file extension), so a discrete variable
// cannot change value at a time at all. VerA does already read a `reg [3:0]`
// written by a CONSTANT `initial` assignment into the analog block as an
// integer — that much is green — so what is missing is precisely the timeline,
// which is the whole of this clause.
//
//! lrm 7.3.6.5
//! lrm 7.3.1
//! analysis tran
//! time 5n, 10n, 15n, 20n, 25n
`timescale 1ns/1ns
`include "check.vh"
module m01_last_tick(p);
  inout p;
  electrical p;
  reg [3:0] code;

  initial begin
    code = 4'd1;
    #10 code = 4'd5;
    #10 code = 4'd9;
  end

  analog begin
    `CHECKEQ("a digital primary reads the greatest tick <= the analog time", code, ($abstime >= 20n) ? 9 : ($abstime >= 10n) ? 5 : 1, 0.0);
    I(p) <+ 1m * code;
  end
endmodule
