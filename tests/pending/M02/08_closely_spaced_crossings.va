// §8.4.7 "Assumptions about the analog and digital algorithms", the digital half,
// verbatim: "The digital engine has some minimum time granularity and all digital
// events occur at a time which is some integer multiple of that granularity. The
// digital engine can always accept events for a given simulation time provided it
// has not yet executed events for a later time. Once it executes events for a
// given time, it can not accept events for an earlier time."
//
// Two A2D crossings 0.2 ns apart, with a 1 ns granularity, are the case that rule
// exists for: they quantize to the SAME tick, and the digital engine must accept
// both, in the order the analog kernel produced them, without coalescing them into
// one and without losing the second because the first already "executed" tick 5.
//
// This is 07's stimulus seen from the digital side. 07 asserts what does NOT reach
// the analog domain; this file asserts what DOES reach the digital domain.
//
// DERIVATION (identical triangle, restated so this file stands alone):
//
//   5.0 ns -> 5.2 ns : 0.50 V -> 0.54 V, slope +0.2 V/ns
//                      rising crossing of 0.52 V at 5.0 + 0.02/0.2 = 5.1 ns
//   5.2 ns -> 5.4 ns : 0.54 V -> 0.50 V, slope -0.2 V/ns
//                      falling crossing of 0.52 V at 5.2 + 0.02/0.2 = 5.3 ns
//
//   round(5.1) = 5 and round(5.3) = 5, so BOTH digital timestamps are the
//   integer 5, and $time is in `timescale` units (nanoseconds here).
//
// ASSERTED, all from 5.4 ns onward:
//
//     n_a        == 2      each crossing is delivered EXACTLY ONCE
//     tick_r     == 5      the rising edge, quantized
//     tick_f     == 5      the falling edge, quantized to the same tick
//     rise_first == 1      the falling handler saw n_a already at 1, so the
//                          rising edge had been executed first
//     a_dig      == 1'b0   the final level is the one the LAST edge set
//
// WHAT EACH ONE CATCHES. A tool that merges same-tick events reads n_a = 1 and
// a_dig = 1. A tool that drops an event arriving at a tick it has already
// processed reads n_a = 1 and a_dig = 1 too, but fails rise_first differently if
// it drops the FIRST instead. A tool that delivers them out of order reads
// rise_first = 0. A tool that never quantizes reads tick_f = 5.3 truncated to 5 —
// which is why tick_r matters as well: 5.1 truncates to 5 and 5.3 truncates to 5,
// so the pair is deliberately NOT a rounding test (04 is), it is a
// delivery-and-ordering test.
//
// The counts are bounded everywhere and pinned only from 5.4 ns, for the
// inserted-timepoint reason spelled out in 07.
//
//! lrm 8.4.7
//! lrm 8.4.3.3
//! lrm 8.5.1
//! analysis tran
//! time 0, 5n, 5.2n, 5.4n, 6n, 8n
//! wave V(vi) = 0, 0.50, 0.54, 0.50, 0.30, 0.0
`timescale 1ns/1ns
`include "check.vh"
module m02_closely_spaced_crossings(vi, vo);
  inout vi, vo; electrical vi, vo;
  reg     a_dig;
  integer n_a, tick_r, tick_f, rise_first;
  // §3.2: an integer assigned in a DIGITAL context defaults to x, not 0 — only
  // analog-context assignment defaults to zero. Every name seeded here is
  // written from an `always`, so without the seed `n = n + 1` evaluates x + 1 = x
  // forever and the guarded arms below compare x against 0.
  initial begin a_dig = 1'b0; n_a = 0; tick_r = 0; tick_f = 0; rise_first = 0; end
  always @(cross(V(vi) - 0.52, +1, 1p, 1u)) begin
    n_a = n_a + 1; tick_r = $time; a_dig = 1'b1;
  end
  always @(cross(V(vi) - 0.52, -1, 1p, 1u)) begin
    rise_first = (n_a == 1); n_a = n_a + 1; tick_f = $time; a_dig = 1'b0;
  end
  analog begin
    `CHECKI("each of the two crossings 0.2 ns apart is delivered exactly once",
            (n_a >= 0 && n_a <= 2) && (($abstime >= 5.4n) ? (n_a == 2) : 1), 1);
    `CHECKI("and both are timestamped at the same digital tick, 5",
            ($abstime >= 5.4n) ? (tick_r == 5 && tick_f == 5) : 1, 1);
    `CHECKI("the rising edge is executed before the falling one",
            ($abstime >= 5.4n) ? (rise_first == 1) : 1, 1);
    `CHECKI("so the surviving digital level is the one the last edge set",
            ($abstime >= 5.4n) ? (a_dig == 1'b0) : 1, 1);
    V(vo) <+ n_a * 0.5;
  end
endmodule
