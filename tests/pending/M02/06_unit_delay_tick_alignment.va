// §8.4.3.3 Figure 8-5 and the §8.4.4 synchronization-loop table, which walk the
// SAME 5.2 ns crossing as 05 through a one-unit-delay inverter instead of a
// zero-delay one: "If the inverter equation is changed to use a one unit delay
// (always @(A) B<= #1 !A), then the timing is as in Figure 8-5."
//
// §8.4.4's event table spells out both ends of that path, verbatim:
//
//   "5.2ns  Evaluate crossing event.  The A2D logic sets the digital signal A,
//    which triggers the evaluation of the non-blocking assign to B, which
//    schedules the actual assignment for 6ns (rounded 1ns delay)."
//   "6.0ns  Non blocking assign performed (digital event)."
//
// DERIVATION. V(vi) is the 0.1 V/ns ramp of 04 and 05, so the crossing of
// V(vi) - 0.52 is at 5.2 ns and the digital kernel rounds it to tick 5. The
// nonblocking assignment carries a #1 delay in `timescale` units, so it is
// scheduled at tick 5 + 1 = 6, and the analog kernel sees B change at
//
//     6 ticks * 1 ns = 6.0e-9 s   EXACTLY,
//
// not at 5.2e-9 + 1e-9 = 6.2e-9. That is the entire claim, and it is the mirror
// image of 05: a zero-delay D2A comes back at the raw analog time, while a
// DELAYED one comes back on the digital grid, because the delay was applied to
// the already-quantized digital time. A tool that adds the delay to the
// unquantized analog time reads 6.2e-9 and fails; one that never quantized at all
// reads 6.2e-9 too and fails the tick check as well.
//
// $abstime is therefore the right partition here, and safely so: §8.4.7 says
// "Digital to analog events shall cause an analog solution of the time where they
// occur", so 6.0 ns IS a solution point, and §8.5.1 orders the nonblocking assign
// update (region 3) before the analog macro-process event (region 3b), so at that
// solution B already carries its new value.
//
// WHY THE TOLERANCE IS NOT 0.0, AND WHY THE ARM SELECTOR MOVED OFF 6 ns. An
// earlier draft wrote `0.0` here and partitioned on `$abstime < 6n`, reasoning
// that a digital tick is an exact multiple of a scale factor. It is not exact in
// IEEE double: the literal 6e-9 is 0x1.9c511dc3a41dfp-28 while the product
// 6 * 1e-9 is 0x1.9c511dc3a41e0p-28 — ONE ULP apart, 8.3e-25 s. A conforming tool
// that forms the D2A time as `tick * time_unit` — which is precisely what "the
// delay was applied to the already-quantized digital time" means — lands on the
// second of those and failed the file. That was a fixture defect, not an
// implementation defect.
//
// The tolerance is therefore 1e-18 s, chosen as a WIDTH and not as a fudge:
//
//     1e-18 / 8.3e-25 = 1.2e6 ULP   -> every defensible way of accumulating six
//                                      1 ns ticks fits inside the band
//     2e-10 / 1e-18   = 2e8         -> the error this file exists to catch,
//                                      6.2e-9 instead of 6.0e-9, is 200 million
//                                      times wider than the band
//
// Nothing between "right" and "wrong in kind" lives in that gap: the next
// plausible wrong answer after 6.0 ns is 6.2 ns, and the one below it is 5.2 ns.
//
// The same 1-ULP hazard sat in the arm selector `($abstime < 6n)` itself: at the
// reported 6 ns point the runner's $abstime and the model's literal can straddle
// the comparison and select the pre-event arm. No timepoint is reported between
// 5 ns and 6 ns, so the selector moves to 5.5 ns — 0.5 ns clear of the nearest
// observation on both sides, and therefore not decidable by rounding.
//
// The pre-crossing value of B is 1 from both the time-zero `initial` and the
// inverter's own evaluation of a_dig = 0, as in 05, so no time-zero start order
// can change it.
//
//! lrm 8.4.3.3
//! lrm 8.4.4
//! lrm 8.4.7
//! analysis tran
//! time 0, 5n, 6n, 7n, 10n
//! wave V(vi) = 0, 0.5, 0.6, 0.7, 1.0
`timescale 1ns/1ns
`include "check.vh"
module m02_unit_delay_tick_alignment(vi, vo);
  inout vi, vo; electrical vi, vo;
  reg     a_dig, b_dig;
  integer tick_a, tick_b;
  real    ana_b;
  // §3.2: an integer assigned in a DIGITAL context defaults to x, not 0 — only
  // analog-context assignment defaults to zero. Every name seeded here is
  // written from an `always`, so without the seed `n = n + 1` evaluates x + 1 = x
  // forever and the guarded arms below compare x against 0.
  initial begin a_dig = 1'b0; b_dig = 1'b1; tick_a = 0; tick_b = 0; end
  always @(cross(V(vi) - 0.52, +1, 1p, 1u)) begin a_dig = 1'b1; tick_a = $time; end
  always @(a_dig) b_dig <= #1 ~a_dig;              // the one unit delay inverter
  always @(b_dig) tick_b = $time;
  analog begin
    @(b_dig) ana_b = $abstime;
    `CHECKI("the A2D edge is quantized to tick 5 before the delay is applied",
            tick_a, (V(vi) > 0.52) ? 5 : 0);
    `CHECKI("the #1 nonblocking assign therefore lands on tick 6",
            tick_b, ($abstime < 5.5n) ? 0 : 6);
    `CHECK("and the analog kernel sees B at exactly 6.0 ns, not 5.2 ns + 1 ns",
           ana_b, ($abstime < 5.5n) ? 0.0 : 6n, 1e-18);
    `CHECKX("B still holds its old value across the whole 5.2 ns to 6.0 ns window",
            b_dig ? 1.0 : 0.0, ($abstime < 5.5n) ? 1.0 : 0.0);
    V(vo) <+ b_dig ? 1.0 : 0.0;
  end
endmodule
