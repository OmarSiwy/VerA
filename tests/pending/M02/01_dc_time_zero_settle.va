// §8.4.2 mixed-signal DC analysis, verbatim: "The steady state of the digital
// circuit is defined as the final state at time 0 when all analog and digital
// events are executed. For mixed-signal DC analysis, the processes of the analog
// DC analysis and the digital simulation at time 0 are executed iteratively,
// starting with the initialization phase (including analog and digital) defined
// in circuit initialization (8.4.1), until all signals at the A/D boundaries
// reach steady state."
//
// This is the first M02 bullet — "iterate DC and time-zero digital activity to
// the required initial state" — reduced to the smallest circuit that can tell
// a settled state from an unsettled one.
//
// THE CIRCUIT. One digital reg `a` set by §8.4.1's time-zero `initial`, then two
// §8.5.3.1 continuous assignments in series. A continuous assignment "corresponds
// to a process, sensitive to the source elements in the expression", so the chain
// re-evaluates through delta cycles inside time 0 with no advance of time:
//
//     initial  a = 1'b1
//     delta 1  b = ~a = 1'b0
//     delta 2  c = ~b = 1'b1
//
// The D2A the analog block performs is `c ? 1.0 : 0.0`, so the DC operating point
// must be V(vo) = 1.0 V.
//
// WHY CONTINUOUS ASSIGNMENTS AND NOT `always @(a)`. An `always` block that waits
// on `a` races the `initial` that writes it at time 0 — IEEE 1364 §11 leaves the
// order of time-zero process starts unspecified, so `always @(a) b = ~a;` may
// legally miss the edge. A continuous assignment is live from elaboration and has
// no such race, which keeps this fixture about ITERATION and not about a
// scheduling coin flip.
//
// WHAT FALSIFIES IT. 1.0 is reachable only by running the whole chain. A tool
// that solves the analog DC before the digital time-zero activity has settled
// reads `c` at its §3.7 initial `x` (or at 0) and contributes 0.0; a tool that
// runs exactly one delta cycle reads c = x and also misses 1.0. Two inverters,
// not one, is the point: one inverter settles after a single delta, so it cannot
// distinguish "iterated to steady state" from "evaluated once".
//
// 1.0 and 0.0 are exact in binary and the D2A selects an operand rather than
// computing one, so the tolerance is CHECKX's.
//
//! lrm 8.4.2
//! lrm 8.4.1
//! lrm 8.5.3.1
//! analysis dc
`timescale 1ns/1ns
`include "check.vh"
module m02_dc_time_zero_settle(vo);
  inout vo; electrical vo;
  reg  a;
  wire b, c;
  initial a = 1'b1;
  assign b = ~a;
  assign c = ~b;
  analog begin
    `CHECKX("the time-zero digital chain is iterated to steady state before the dc solve", c ? 1.0 : 0.0, 1.0);
    `CHECKX("and the intermediate node settled too", b ? 1.0 : 0.0, 0.0);
    V(vo) <+ c ? 1.0 : 0.0;
  end
endmodule
