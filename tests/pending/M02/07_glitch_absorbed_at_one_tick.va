// §8.4.4 the synchronization loop, second event table (Figure 8-6), verbatim:
// "Any events queued ahead of the current global event time may be canceled. For
// instance, if the sequence above is interrupted by a change on the primary input
// before digital assignment takes place". The table's own last two rows are what
// this file asserts:
//
//   "5.4ns  ... The A2D logic sets the digital signal A, which triggers the
//    evaluation of the non-blocking assign to B, which schedules the actual
//    assignment for 6ns (rounded 1ns delay), CANCELING PREVIOUS EVENT.  D2A
//    detects the driver change and qd_val toggles back to 1 before the 0
//    propagates through the transition filter, SO NO ANALOG CHANGE OCCURS AT B."
//   "6.00ns  Non blocking assign performed (digital event).  Value of B doesn't
//    change."
//
// STIMULUS AND DERIVATION. V(vi) is a narrow triangle straddling the 0.52 V
// threshold, piecewise linear between the declared points:
//
//   5.0 ns -> 5.2 ns : 0.50 V -> 0.54 V, slope +0.2 V/ns.
//                      0.52 is 0.02 above 0.50, 0.02/0.2 = 0.1 ns
//                      => RISING crossing at 5.1 ns, round(5.1) = tick 5.
//   5.2 ns -> 5.4 ns : 0.54 V -> 0.50 V, slope -0.2 V/ns.
//                      0.52 is 0.02 below 0.54, 0.02/0.2 = 0.1 ns
//                      => FALLING crossing at 5.3 ns, round(5.3) = tick 5.
//
// Both crossings therefore land on the SAME digital tick, 5, which is the whole
// construction: the rising edge queues `b_dig <= 1'b0` for tick 6 and the falling
// edge, still at tick 5, queues `b_dig <= 1'b1` for the same tick 6.
//
// WHAT "CANCELING PREVIOUS EVENT" DOES AND DOES NOT MEAN. An earlier draft of
// this fixture read Figure 8-6's phrase as NBA-queue cancellation — the second
// `b_dig <= #1 ~a_dig` deleting the first. It does not, and asserting that would
// have been asserting a defect. IEEE 1364-2005 §9.2.2 performs BOTH updates, in
// scheduling order: inside tick 6's nonblocking-update region b_dig goes 1 -> 0
// -> 1. Nothing in 1364 coalesces same-time nonblocking assignments to one
// target, and a tool taught to do so to satisfy this file would be violating the
// inherited standard. The cancellation Figure 8-6 describes is the D2A
// CONNECTMODULE's: "D2A detects the driver change and qd_val toggles back to 1
// before the 0 propagates through the transition filter, so no analog change
// occurs at B" — a driver-level effect of $driver_update/$driver_next_state plus
// a transition() filter, which is M04's machinery, not M02's.
//
// HOW THE INTERIOR TRANSIT IS MADE OBSERVABLE WITHOUT ASSERTING M04's FILTER.
// A review of the first correction found that the corrected file had no teeth: a
// tool with no D2A and no NBA delivery at all leaves b_dig at its `initial` 1'b1
// forever and passes the value check trivially, and the only remaining content,
// `n_a == 2`, is cross()-to-digital counting that fixture 08 already owns in full.
// A fixture whose assertions hold on a tool that implements none of the clause is
// not a fixture.
//
// The missing observable is the transit ITSELF, and it is observable entirely
// within the digital domain — no connectmodule, no transition filter, nothing M04
// owns. §8.5.3.4, verbatim: "A nonblocking assignment statement (see 9.2.2 of IEEE
// Std 1364 Verilog) always computes the updated value and schedules the update as a
// nonblocking assign update event, either in this time step if the delay is zero or
// as a future event if the delay is nonzero." ALWAYS — once per execution of the
// statement, with no same-target merge anywhere in the clause.
// §8.5.2's reference model then says what each of those update events does when it
// is drained from region 3: "if (E is an update event){ update the modified object;
// ADD EVALUATION EVENTS FOR SENSITIVE PROCESSES to event queue; }". Two update
// events to b_dig, values 0 then 1, therefore produce two object updates and two
// rounds of evaluation events, and a process sensitive to the falling edge of
// b_dig runs exactly once. So:
//
// SO THE ASSERTED VALUES ARE:
//
//     n_fall == 1 from 7 ns on                       (the FIRST NBA really landed:
//                                                     b_dig was driven to 0 inside
//                                                     tick 6's region-3 drain and
//                                                     a negedge-sensitive process
//                                                     saw it)
//     b_dig  == 1'b1 at every REPORTED point         (and the SECOND NBA really
//                                                     landed too: the transit is
//                                                     interior to region 3, so the
//                                                     net value every `//! time`
//                                                     point observes is B's old
//                                                     value)
//     n_a    == 2 by 5.4 ns                          (guard, shared with 08: the
//                                                     glitch really happened)
//
// The pair is what has the teeth, because the two checks fail in opposite
// directions:
//
//   - a tool with no D2A/NBA delivery, and a tool that COALESCES the two same-time
//     NBAs into one write of the final value 1 (the IEEE 1364 §9.2.2 violation this
//     file must not reward), both leave b_dig permanently 1: n_fall == 0, FAIL.
//   - a tool that delivers only the rising crossing performs one NBA, so b_dig
//     stays 0 from tick 6: n_fall == 1 passes but the value check FAILS.
//   - only a tool that performs both updates, in order, passes both.
//
// n_fall counts a NEGEDGE and not any change, deliberately. `always @(b_dig)` would
// also be triggered by the time-zero `initial b_dig = 1'b1` if the always block
// happened to be armed first, and IEEE 1364 §11 leaves that start order
// unspecified; x -> 1 is not a negedge, and the only negedge anywhere in this run
// is the first of tick 6's two updates. n_fall is bounded 0..1 everywhere and
// pinned only from 7 ns: the updates are performed at tick 6, and §8.5.1 does put
// region 3 ahead of region 3b so the 6 ns solve should already see them, but the
// reported 6 ns point is a declared observation rather than a D2A-forced one and
// nothing in the clause fixes its position relative to that drain. 7 ns is 1 ns
// clear of the observations on either side, so the pin bites at 8 ns and is not
// decidable by rounding.
//
// WHAT THIS FILE DELIBERATELY NO LONGER ASSERTS. Whether the analog block's
// explicit `@(b_dig)` wake-up fires during that interior transit is precisely
// §8.4.4's transition-filter question, and this row's SPEC.md defers the
// connectmodule driver machinery to M04. The old `ana_b == 0.0` check pinned it
// to zero with tolerance 0.0, which a conforming implementation can fail and
// which an implementer could "fix" by coalescing the NBAs. `ana_b` is still
// captured, and still contributes to V(vo) so it cannot be optimized away, but
// the claim about it belongs in M04 alongside the filter that decides it.
//
// n_a is BOUNDED everywhere and pinned only from 5.4 ns, deliberately: §5.10.3.1
// lets a conforming simulator insert its own timepoint at each crossing, and an
// exact want at 5.1 ns or 5.3 ns would be a knife edge against the 1 ps time_tol
// this file passes. From 5.4 ns onward both crossings are strictly in the past
// under any tolerance and the count is unambiguous. (Same idiom as
// tests/fixtures/ch05_analog_behavior/event_cross_fires.va.)
//
//! lrm 8.4.4
//! lrm 8.4.3.3
//! lrm 8.5.1
//! lrm 8.5.2
//! lrm 8.5.3.4
//! lrm 5.10.3.1
//! analysis tran
//! time 0, 5n, 5.2n, 5.4n, 6n, 8n
//! wave V(vi) = 0, 0.50, 0.54, 0.50, 0.30, 0.0
`timescale 1ns/1ns
`include "check.vh"
module m02_glitch_absorbed_at_one_tick(vi, vo);
  inout vi, vo; electrical vi, vo;
  reg     a_dig, b_dig;
  integer n_a, n_fall;
  real    ana_b;
  // §3.2: an integer assigned in a DIGITAL context defaults to x, not 0 — only
  // analog-context assignment defaults to zero. Every name seeded here is
  // written from an `always`, so without the seed `n = n + 1` evaluates x + 1 = x
  // forever and the guarded arms below compare x against 0.
  initial begin a_dig = 1'b0; b_dig = 1'b1; n_a = 0; n_fall = 0; end
  always @(cross(V(vi) - 0.52, +1, 1p, 1u)) begin a_dig = 1'b1; n_a = n_a + 1; end
  always @(cross(V(vi) - 0.52, -1, 1p, 1u)) begin a_dig = 1'b0; n_a = n_a + 1; end
  always @(a_dig) b_dig <= #1 ~a_dig;
  always @(negedge b_dig) n_fall = n_fall + 1;   // the interior transit, §8.5.2
  analog begin
    @(b_dig) ana_b = $abstime;
    `CHECKI("both A2D edges land on tick 5, and both are delivered",
            (n_a >= 0 && n_a <= 2) && (($abstime >= 5.4n) ? (n_a == 2) : 1), 1);
    `CHECKI("the first of tick 6's two NBA updates drove B to 0 and was seen",
            (n_fall >= 0 && n_fall <= 1) && (($abstime >= 7n) ? (n_fall == 1) : 1), 1);
    `CHECKX("and the second put it back, so B's net value at every reported point is unchanged",
            b_dig ? 1.0 : 0.0, 1.0);
    // Whether `@(b_dig)` fires during tick 6's interior 1 -> 0 -> 1 transit is
    // the transition-filter question M04 owns; ana_b is captured and kept live
    // below, but deliberately not pinned here. See the header.
    // 1e-6 * ana_b, not 0.0 * ana_b: a zero coefficient folds away and takes the
    // wake-up with it. ana_b is a time in seconds, so this perturbs V(vo) by
    // ~5e-15 V and nothing here asserts V(vo).
    V(vo) <+ (b_dig ? 1.0 : 0.0) + 1e-6 * ana_b;
  end
endmodule
