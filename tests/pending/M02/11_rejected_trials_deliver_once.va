// §8.4.7, the analog half and the A2D half, verbatim:
//
//   "The analog engine advances time by calculating a sequence of solutions ...
//    Having calculated the solution for a given time, the analog engine can either
//    ACCEPT OR REJECT that solution; it cannot calculate a solution for a future
//    time until it has accepted the solution for the current time."
//   "Certain analog events (above, cross, initial_step, and final_step) cause an
//    analog solution of the time where they occur. SUCH EVENTS ARE ASSOCIATED WITH
//    THE SOLUTION THAT PRODUCED THEM UNTIL THEY ARE CONSUMED BY THE DIGITAL
//    ENGINE. Until then, they can be rejected along with the solution, if it is
//    rejected."
//
// The consequence a source-level test can see: a speculative analog trial must not
// irreversibly advance digital state. One real crossing produces ONE digital
// event, however many trial solutions the solver computed and threw away on its
// way there, and however many times the macro-process is re-solved afterwards.
//
// §8.4.3.2 is why "afterwards" matters: "Macro processes can be evaluated
// separately but may be evaluated together, in which case, the wake up event for
// one process will cause the re-evaluation of all or some of the processes. Users
// should bear this in mind when writing mixed-signal code, as it will mean that
// the code should be able to handle RE-EVALUATION AT ANY TIME (not just at its own
// event times)."
//
// THE CONSTRUCTION. V(vi) is a strictly monotone 0.1 V/ns ramp, so
// `cross(V(vi) - 0.52, +1)` has exactly ONE rising crossing in the whole run, at
//
//     5 ns + (0.52 - 0.50)/0.1 = 5.2 ns,  round(5.2) = digital tick 5.
//
// `kick` then toggles at ticks 6, 7 and 8. Each toggle is an implicit D2A on a
// variable the analog block reads unguarded, so each one forces a fresh
// macro-process solve (§8.5's "they effectively force a digital-analog
// synchronization when they occur") at a time when the crossing is already in the
// past. Those three forced re-solves are the trap: a tool that re-fires a
// consumed cross() event on every re-evaluation reads n_cross = 4 by 9 ns, and a
// tool that hands A2D events to the digital engine from trial solutions it later
// rejects reads anything above 1.
//
// ASSERTED:
//
//     n_cross    is in [0,1] at EVERY point of the run, and exactly 1 from 6 ns
//     tick_first == tick_last == 5 from 6 ns   (one delivery, not two at the
//                                               same tick overwriting each other)
//     sampled    is inside §5.10.3.1's box: at or above the 0.52 V threshold and
//                no higher than 0.6 V, the value one full declared step later
//
// The upper bound on n_cross is what makes the "exactly once" claim carry weight
// before 6 ns as well - it is an assertion at every timepoint, not just the tail -
// while the exact pin is deferred past the crossing for the inserted-timepoint
// reason spelled out in 07.
//
//! lrm 8.4.7
//! lrm 8.4.3.2
//! lrm 8.5
//! lrm 5.10.3.1
//! analysis tran
//! time 0, 1n, 3n, 5n, 6n, 7n, 8n, 9n, 10n
//! wave V(vi) = 0, 0.1, 0.3, 0.5, 0.6, 0.7, 0.8, 0.9, 1.0
`timescale 1ns/1ns
`include "check.vh"
module m02_rejected_trials_deliver_once(vi, vo);
  inout vi, vo; electrical vi, vo;
  reg     kick;
  integer n_cross, tick_first, tick_last;
  real    sampled;
  // §3.2: an integer assigned in a DIGITAL context defaults to x, not 0 — only
  // analog-context assignment defaults to zero. Every name seeded here is
  // written from an `always`, so without the seed `n = n + 1` evaluates x + 1 = x
  // forever and the guarded arms below compare x against 0.
  initial begin
    kick = 1'b0; n_cross = 0; tick_first = 0; tick_last = 0; sampled = 0.0;
    #6 kick = 1'b1;
    #1 kick = 1'b0;
    #1 kick = 1'b1;
  end
  always @(cross(V(vi) - 0.52, +1, 1p, 1u)) begin
    if (n_cross == 0) tick_first = $time;
    tick_last = $time;
    sampled   = V(vi);
    n_cross   = n_cross + 1;
  end
  analog begin
    `CHECKI("one rising crossing is delivered at most once, no matter how many trials",
            (n_cross >= 0 && n_cross <= 1) && (($abstime >= 6n) ? (n_cross == 1) : 1), 1);
    `CHECKI("and the single delivery carries one digital timestamp, tick 5",
            ($abstime >= 6n) ? (tick_first == 5 && tick_last == 5) : 1, 1);
    `CHECKI("the sampled value is inside the crossing box, not a rejected trial's",
            ($abstime >= 6n) ? (sampled >= 0.52 && sampled <= 0.6) : 1, 1);
    // read unguarded: every `kick` toggle forces another macro-process solve
    V(vo) <+ (kick ? 0.1 : 0.0) + n_cross * 0.25;
  end
endmodule
