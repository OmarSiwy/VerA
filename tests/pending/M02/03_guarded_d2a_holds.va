// §8.4.3.2, the NEGATIVE half of the sentence 02 pins. After giving the plain
// `d2a`, the clause gives the clocked one, `d2aC`, reproduced below verbatim, and
// says of it: "Since val is now guarded by the @(posedge clock) expression the
// analog block is not sensitive to changes in val and only reevaluates when clk
// changes." The governing rule is the same sentence 02 quotes — "Analog processes
// are sensitive to changes in all variables and digital signals read by the
// process UNLESS that access is only in statements 'guarded' by event
// expressions."
//
// This is the falsifiable direction. 02 passes for a tool that resynchronizes on
// every digital write; this file fails for exactly that tool.
//
// STIMULUS AND DERIVATION, `timescale 1ns/1ns`:
//
//     t = 0     val = 16'h4000, clk = 0.  No posedge has occurred, so `v_clkd`
//               still holds the 0.0 §3.2 gives a real variable -> V(vo) = 0 V.
//     t = 4ns   posedge clk. The guarded statement runs and latches
//               16384 * 2^-16 = 0.25 -> V(vo) = 0.25 V.
//     t = 6ns   val = 16'hC000. NO clk edge. The analog block is not sensitive
//               to `val`, so nothing is re-latched: V(vo) STAYS 0.25 V.
//     t = 8ns   negedge clk. `posedge` does not match -> still 0.25 V.
//     t = 12ns  posedge clk. Now the new code is latched,
//               49152 * 2^-16 = 0.75 -> V(vo) = 0.75 V.
//
// Every product is exact: Vgain is 2^-16 and both codes are powers of two, so
// CHECKX is the right tolerance.
//
// THE THREE TIMEPOINTS THAT CARRY THE CLAIM are 6ns, 8ns and 10ns, where `val`
// already reads 16'hC000 and the output must nevertheless be 0.25. A tool that
// ignores the guard reads 0.75 at all three. A tool that implements the guard as
// "never re-evaluate" holds 0.0 for the whole run and fails at 4ns. A tool that
// matches `posedge` against any change re-latches at 8ns and fails 12ns's
// partition only if it also mis-latches — so 8ns is kept as its own sample.
//
//! lrm 8.4.3.2
//! analysis tran
//! time 0, 2n, 4n, 6n, 8n, 10n, 12n, 14n
`timescale 1ns/1ns
`include "check.vh"
module m02_guarded_d2a_holds(vo);
  inout vo; electrical vo;
  parameter real Vgain = 1.0/65536;
  reg        clk;
  reg [15:0] val;
  real       v_clkd;
  initial begin
    clk = 1'b0;
    val = 16'h4000;
    #4  clk = 1'b1;       // posedge: latch 0x4000
    #2  val = 16'hC000;   // 6ns, no edge: must not be seen
    #2  clk = 1'b0;       // 8ns, negedge: must not latch
    #4  clk = 1'b1;       // 12ns, posedge: latch 0xC000
  end
  analog begin
    @(posedge clk) v_clkd = Vgain * val;
    `CHECKX("a guarded read makes the analog block insensitive to the bus",
            v_clkd,
            ($abstime < 4n) ? 0.0 : (($abstime < 12n) ? 0.25 : 0.75));
    V(vo) <+ v_clkd;
  end
endmodule
