// §8.4.3.2 analog macro process scheduling semantics, and its own worked
// example: "Analog processes are sensitive to changes in all variables and
// digital signals read by the process unless that access is only in statements
// 'guarded' by event expressions. For example the following code implements a
// simple digital to analog convertor" — the `d2a` module reproduced below, whose
// body is `V(vo) <+ Vgain * val` with `parameter Vgain = 1.0/65536` and
// `wire [15:0] val`. The clause then says of it: "The output voltage V(vo) is
// reevaluated when any bit in val changes".
//
// §8.5 names the mechanism: "there is also the concept of the implicit D2A event
// that is created when a digital variable to which an analog block is implicitly
// sensitive changes value ... implicit D2A events are not added to the stratified
// event queue, but as they directly cause an analog macro-process event, they
// effectively force a digital-analog synchronization when they occur."
//
// DERIVATION. Vgain is 1.0/65536 = 2^-16, exact in binary, and every code below
// is a power of two, so every product is exact:
//
//     16'h4000 = 16384 -> 16384 * 2^-16 = 0.25 V
//     16'h8000 = 32768 -> 32768 * 2^-16 = 0.50 V
//     16'hC000 = 49152 -> 49152 * 2^-16 = 0.75 V
//
// With `timescale 1ns/1ns` the stimulus places those codes on [0,4ns), [4ns,12ns)
// and [12ns,inf), so the D2A output is the three-step staircase asserted below.
//
// WHY THE STIMULUS IS ONE `initial` WITH DELAYS. It has a single reading, needs
// no clock and cannot race a second process at time zero, so the only thing left
// for the fixture to be about is whether the ANALOG side re-solved when `val`
// changed. A tool that samples `val` once and never resynchronizes holds 0.25 for
// the whole run and fails at 4ns; one that forces a solve but reads the bus as a
// scalar or as x reads 0 or 1 and fails everywhere.
//
// WHAT IS NOT CLAIMED HERE. Nothing about WHEN inside 4ns the solve happens —
// that is 05/06's subject. This fixture only claims the value is right at each
// declared analog timepoint.
//
//! lrm 8.4.3.2
//! lrm 8.5
//! analysis tran
//! time 0, 2n, 4n, 8n, 12n, 16n
`timescale 1ns/1ns
`include "check.vh"
module m02_implicit_d2a_bus(vo);
  inout vo; electrical vo;
  parameter real Vgain = 1.0/65536;
  reg [15:0] val;
  initial begin
    val = 16'h4000;
    #4  val = 16'h8000;
    #8  val = 16'hC000;
  end
  analog begin
    `CHECKX("the analog block is implicitly sensitive to every bit of the bus",
            Vgain * val,
            ($abstime < 4n) ? 0.25 : (($abstime < 12n) ? 0.5 : 0.75));
    V(vo) <+ Vgain * val;
  end
endmodule
