// §8.4.6 "absdelta interpolated A2D events", verbatim: "The absdelta() monitored
// event function allows the analog solver to generate A2D events by INTERPOLATING
// THE TIMES BETWEEN THE LAST TIME STEP AND NEXT TIME STEP at which the absdelta
// expression changed by delta and schedules them in the digital event queue."
//
// §5.10.3.4 gives the trigger list this fixture counts against, verbatim:
// "The absdelta() function generates events for the following times and
// conditions. - During initialization or dc sweep analysis. - When the enable
// argument changes from zero to non-zero. - When the expr value changes in
// absolute value by more than delta, relative to the previous absdelta() event
// (but not when the current time is within time_tol of the previous absdelta()
// event) ... - When expr changes direction (but not when the amount of the change
// is less than expr_tol)." And the placement rule this fixture depends on: "The
// absdelta() function DOES NOT FORCE TIMESTEPS IN THE ANALOG SOLVER - it just
// observes the expr argument and generates events at the appropriate times to meet
// the requirements above. To avoid forcing analog timesteps just to determine an
// event time, absdelta() may interpolate the time at which an event occurred if
// necessary." Finally, §5.10.3.4's placement restriction: "This function is only
// allowed in an initial or always block of a Verilog-AMS module" - hence the
// `always` below and not an analog event control.
//
// DERIVATION. V(vi) is a monotone 0.1 V/ns ramp from 0 V to 1.2 V, and every
// declared analog timepoint (0, 4 ns, 8 ns, 11 ns, 12 ns) sits on that line. With
// delta = 0.25 V the events are:
//
//     t = 0      initialization event                  sampled = 0.00 V
//     t = 2.5 ns V has risen 0.25 from the last event  sampled = 0.25 V
//     t = 5.0 ns                                       sampled = 0.50 V
//     t = 7.5 ns                                       sampled = 0.75 V
//     t = 10  ns                                       sampled = 1.00 V
//
// and there is no sixth: it would need 1.25 V, which the ramp reaches at 12.5 ns,
// past the end of the run.
//
// All four non-initialization events - 2.5, 5, 7.5 and 10 ns - fall strictly
// BETWEEN declared analog solutions, and the clause forbids absdelta from forcing a
// timestep to reach them, so a conforming tool must interpolate them and post them
// into the digital queue. That is the whole point of the declared grid being
// 0/4/8/11/12 and not a multiple of 2.5: a tool that only samples at its own analog
// timepoints reads n = 3 and sampled = 0.8 at 8 ns, and a tool that implements
// absdelta as "fire every timestep" reads n far above 5.
//
// WHY THE RAMP RUNS TO 1.2 V AND NOT TO 1.0 V. An earlier draft ended the run at
// 10 ns / 1.00 V, which put the FIFTH event exactly on the last declared timepoint
// and left it unforced in two independent ways. First, the trigger is "changes in
// absolute value by MORE THAN delta": from the 7.5 ns event at 0.75 V the ramp
// reaches 1.00 V at exactly 10 ns, a change of exactly delta, so a literal reading
// of the clause never fires it. Second, even granting the fire, §5.10.3.4 lets the
// simulator place the event anywhere inside the expr_tol window; with expr_tol = 1u
// on a 0.1 V/ns ramp that is 1e-6 / 0.1 = 1e-5 ns either side, i.e.
// [9.99999, 10.00001] ns - and half of that lay past the end of the run. So
// `n = 4, sampled = 0.75` was exactly as conforming as `n = 5`, and the fixture
// would have failed a correct implementation. Running to 12 ns puts the fifth
// event, and the whole of its tolerance window, 2 ns inside the run, and leaves the
// sixth 0.5 ns outside it: the presence of the fifth and the absence of the sixth
// are both unambiguous. The 11 ns and 12 ns observations both sit after the fifth
// event and before the absent sixth, so neither is a knife edge either.
//
// The monotone ramp also removes the "changes direction" trigger from the
// accounting entirely, so the count below is exactly the delta trigger plus the
// one initialization event.
//
// TOLERANCES, AND WHY THEY ACCUMULATE. expr_tol is 1u, and §5.10.3.4 verbatim:
// "The simulator is allowed to schedule this event at any time between the time
// corresponding to the interpolated absolute change of (delta - expr_tol) and the
// time corresponding to the interpolated absolute change of (delta + expr_tol) for
// performance or other reasons." So ONE event's sampled voltage is right to
// within 1e-6 V.
//
// But the same clause says the change is measured "relative to the PREVIOUS
// absdelta() event", not relative to the ramp's origin, so that 1e-6 V of slack is
// spent afresh on every event and the errors ADD. A conforming tool that lands
// every event at the (delta + expr_tol) end of its window reads:
//
//     event 1 (~2.5 ns)   0.25 + 1e-6      band +-1 * expr_tol
//     event 2 (~5.0 ns)   0.50 + 2e-6      band +-2 * expr_tol
//     event 3 (~7.5 ns)   0.75 + 3e-6      band +-3 * expr_tol
//     event 4 (~10  ns)   1.00 + 4e-6      band +-4 * expr_tol
//
// An earlier draft wrote 1u on all four arms and justified it as "expr_tol, not a
// fudge factor". That justification was wrong for events 2, 3 and 4: the drift is
// up to 4 * expr_tol = 4e-6 V and a conforming implementation failed the check.
// The tolerance is therefore 4u - still DERIVED from expr_tol, not widened to
// taste, and still 12500 times narrower than the 0.05 V gap to the nearest wrong
// arm and 200000 times narrower than the 0.8 V a non-interpolating tool reads at
// 8 ns. The count arms are unaffected: the same slack is 1e-6 V / 0.1 V/ns =
// 1e-5 ns per event, so even four of them move an event time by 4e-5 ns against
// selectors that are >= 0.5 ns clear of every observation.
//
// time_tol is 1p against a 2.5 ns event spacing, so the "within time_tol of the
// previous event" suppression never applies. The count is an integer and is
// checked exactly.
//
//! lrm 8.4.6
//! lrm 5.10.3.4
//! analysis tran
//! time 0, 4n, 8n, 11n, 12n
//! wave V(vi) = 0, 0.4, 0.8, 1.1, 1.2
`timescale 1ns/1ns
`include "check.vh"
module m02_absdelta_interpolated_a2d(vi, vo);
  inout vi, vo; electrical vi, vo;
  integer n;
  real    sampled;
  // §3.2: an integer assigned in a DIGITAL context defaults to x, not 0 — only
  // analog-context assignment defaults to zero. Every name seeded here is
  // written from an `always`, so without the seed `n = n + 1` evaluates x + 1 = x
  // forever and the guarded arms below compare x against 0.
  // The seed runs in the time-zero active region; absdelta's own
  // initialization event is what takes n from 0 to the 1 asserted below.
  initial begin n = 0; sampled = 0.0; end
  always @(absdelta(V(vi), 0.25, 1p, 1u)) begin
    n       = n + 1;
    sampled = V(vi);
  end
  analog begin
    `CHECKI("absdelta posts one A2D event per 0.25 V, plus the initialization one",
            n,
            ($abstime < 2.5n) ? 1 :
            (($abstime < 5n)  ? 2 :
            (($abstime < 7.5n) ? 3 :
            (($abstime < 10n) ? 4 : 5))));
    `CHECK("and all four interior events were interpolated, not snapped to a timestep",
           sampled,
           ($abstime < 2.5n) ? 0.0 :
           (($abstime < 5n)  ? 0.25 :
           (($abstime < 7.5n) ? 0.5 :
           (($abstime < 10n) ? 0.75 : 1.0))),
           4u);   // 4 * expr_tol: the window is spent per event, see header
    V(vo) <+ sampled;
  end
endmodule
