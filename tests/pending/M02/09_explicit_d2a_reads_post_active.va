// §8.5.3.6 "Processing explicit D2A events (region 1b)", verbatim and in full:
// "An explicit D2A event is processed by evaluating the analog block that is
// sensitive to this event. This is so that the values used for the digital
// variables referenced inside the explicitly sensitive event control statement in
// the analog block are the values of those variables AFTER REGION 1 HAS BEEN
// PROCESSED, NOT the values of those variables just before region 3b is
// processed."
//
// §8.5.1's table is the ordering that sentence depends on: region 1 (active),
// then 1b (explicit D2A), then 2 (inactive), then 3 (nonblocking assign update),
// then 3b (analog macro-process). §8.5 defines what makes an event "explicit":
// "An analog block is explicitly sensitive to event expressions mentioned in an
// event control statement in that analog block" - the `@(posedge clk)` below.
//
// THE CONSTRUCTION. One digital process, woken at tick 4, writes `da` and `db`
// blockingly (region 1) and ALSO queues a nonblocking overwrite of `da` (region
// 3). That makes three readings of `da + db` distinguishable by value alone:
//
//     0 + 0 =  0   read before region 1 ran            (wrong: too early)
//     3 + 4 =  7   read in region 1b                   (CORRECT)
//     9 + 4 = 13   read just before region 3b          (wrong: the reading the
//                                                       quoted sentence rules out)
//
// 7 is the only value a conforming tool can produce, and the two wrong answers
// are the two failure modes the clause names. The mixed blocking/nonblocking
// write to `da` is not style, it is the discriminator: with only blocking writes
// the 1b and 3b readings coincide and the fixture would assert nothing about
// region ordering.
//
// TIMING. `timescale 1ns/1ns`, so the `#4` puts the posedge at tick 4. §8.4.7
// makes that a synchronization point on the analog side too - "Digital to analog
// events shall cause an analog solution of the time where they occur" - so 4.0 ns
// is an analog solution and the partition below is exact at it. `s` holds §3.2's
// 0.0 before then, because no posedge has occurred.
//
// 7.0 and 0.0 are exact in binary and every operand is a small integer, so the
// tolerance is CHECKX's. `da` and `db` are read ONLY inside the guarded statement,
// so by §8.4.3.2 the analog block is not implicitly sensitive to them and this
// file is not accidentally testing 02's rule instead.
//
//! lrm 8.5.3.6
//! lrm 8.5.1
//! lrm 8.5
//! lrm 8.4.7
//! analysis tran
//! time 0, 2n, 4n, 6n, 8n
`timescale 1ns/1ns
`include "check.vh"
module m02_explicit_d2a_reads_post_active(vo);
  inout vo; electrical vo;
  reg     clk;
  integer da, db;
  real    s;
  initial begin clk = 1'b0; da = 0; db = 0; #4 clk = 1'b1; end
  always @(posedge clk) begin
    da  = 3;      // region 1
    db  = 4;      // region 1
    da <= 9;      // region 3, after 1b has already read da
  end
  analog begin
    @(posedge clk) s = da + db;                       // region 1b
    `CHECKX("region 1b reads the post-active values, not the pre-region-3b ones",
            s, ($abstime < 4n) ? 0.0 : 7.0);
    V(vo) <+ s * 0.1;
  end
endmodule
