// §8.5.1's stratified event queue, rows 3 and 3b, verbatim:
//
//   "3.   Events that have been evaluated during some previous simulation time,
//    but that shall be assigned at this simulation time after all the active,
//    explicit D2A and inactive events are processed. These are the non blocking
//    assign update events."
//   "3b.  ANALOG MACRO-PROCESS EVENTS SHALL BE PROCESSED AFTER all active,
//    explicit D2A events, inactive events and NON BLOCKING ASSIGN UPDATE EVENTS
//    are processed."
//
// §8.5.3.7 gives the reason and the mechanism: "An analog macro-process event is
// evaluated by calling the analog engine to solve the associated analog
// macro-process ... The reason for processing analog macro-processes after regions
// 1-3 have been processed is to minimize the number of times analog
// macro-processes are evaluated." And §8.5 says what creates the event here:
// "the implicit D2A event ... is created when a digital variable to which an
// analog block is implicitly sensitive changes value ... as they directly cause an
// analog macro-process event, they effectively force a digital-analog
// synchronization when they occur."
//
// THE CONSTRUCTION. `q` is written by a NONBLOCKING assignment, so its update is a
// region-3 event. The analog block reads `q` UNGUARDED, so it is implicitly
// sensitive to it and the change posts a region-3b macro-process event at the same
// digital time. The ordering rule then fixes the value the solve sees:
//
//     tick 4, region 1   the always block evaluates `d` and queues q <= 1
//     tick 4, region 3   the nonblocking update lands:  q becomes 1'b1
//     tick 4, region 3b  the analog macro-process solves and reads q = 1'b1
//
// so the accepted operating point at 4.0 ns already carries V(vo) = 1.0 V. A tool
// that solves the analog macro-process before flushing the NBA queue - i.e. that
// puts 3b anywhere ahead of 3 - reads q = 1'b0 at 4 ns and produces 0.0 V there,
// catching up only at the next timepoint. A tool with no macro-process region at
// all never resynchronizes and reads 0.0 for the whole run.
//
// Note the DIFFERENCE from 09: there the digital variables are read inside a
// guarded statement and the answer is the region-1 value; here the read is
// unguarded and the answer is the region-3 value. Same tick, two different
// rules, two different numbers - which is why both files exist.
//
// `timescale 1ns/1ns` puts the posedge at tick 4, and §8.4.7's "Digital to analog
// events shall cause an analog solution of the time where they occur" makes 4.0 ns
// an analog solution point, so the $abstime partition is exact at it. 1.0 and 0.0
// are exact in binary and the D2A selects an operand, so the tolerance is CHECKX's.
//
//! lrm 8.5.1
//! lrm 8.5.3.7
//! lrm 8.5
//! lrm 8.4.7
//! analysis tran
//! time 0, 2n, 4n, 6n, 8n
`timescale 1ns/1ns
`include "check.vh"
module m02_macro_process_runs_after_nba(vo);
  inout vo; electrical vo;
  reg     clk, q;
  integer d;
  initial begin clk = 1'b0; q = 1'b0; d = 1; #4 clk = 1'b1; end
  always @(posedge clk) q <= d;                     // region 3
  analog begin
    `CHECKX("the macro-process solve sees the nonblocking update of the SAME tick",
            q ? 1.0 : 0.0, ($abstime < 4n) ? 0.0 : 1.0);
    V(vo) <+ q ? 1.0 : 0.0;                         // unguarded read => region 3b
  end
endmodule
