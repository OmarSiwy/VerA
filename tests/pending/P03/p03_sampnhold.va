`include "disciplines.vams"
// VAMS-2023 12.32.3's OWN sample-and-hold module, verbatim except for the port
// direction declarations the clause's listing omits (VAMS-2023 3.6.2 requires
// every port to be declared; the LRM's fragment is not a complete compilation
// unit and this has to be):
//
//     module sampnhold(out, in);
//       electrical out, in;
//       parameter real period = 1e-3;
//       analog begin
//         V(out) <+ $sampler(V(in), period);
//       end
//     endmodule
//
// $sampler is NOT a language function. It exists only because 06_sampler.c
// registered it with vpi_register_analog_systf() (VAMS-2023 12.32), and the
// hold behaviour lives entirely in that C file's acbAbsTime chain.
//
// THE HAND DERIVATION fixture 06 asserts. V(in) is p03_ramp at 1000 V/s, so
// V(in) = 1000*t. The sampler captures at t = k*period, period = 1e-3, and
// holds until the next capture, so on the half-open interval
// [k*1e-3, (k+1)*1e-3):
//
//     V(out) = 1000 * (k * 1e-3) = k volts, exactly.
//
//     t = 2.5e-3 lies in [2e-3, 3e-3) -> V(out) = 2
//     t = 4.25e-3 lies in [4e-3, 5e-3) -> V(out) = 4
//
// and over a 0..5e-3 run the capture instants are t = 0, 1e-3, 2e-3, 3e-3,
// 4e-3, 5e-3 — SIX of them, because 12.31.3 says acbAbsTime "shall force a
// solution at that time" and 5e-3 is the last accepted solution, not past it.
//
// Used by: 06.

module p03_ramp_in(p, n);
    inout p, n;
    electrical p, n;
    parameter real slope = 1000.0 from (0:inf);
    analog
        V(p, n) <+ slope * $abstime;
endmodule

module p03_load1k(p, n);
    inout p, n;
    electrical p, n;
    parameter real r = 1000.0 from (0:inf);
    analog
        I(p, n) <+ V(p, n) / r;
endmodule

module sampnhold(out, in);
    inout out, in;
    electrical out, in;
    parameter real period = 1e-3 from (0:inf);
    analog begin
        V(out) <+ $sampler(V(in), period);
    end
endmodule

module p03_sampnhold_tb;
    electrical in, out, gnd;
    ground gnd;
    p03_ramp_in #(.slope(1000.0)) src (.p(in), .n(gnd));
    sampnhold   #(.period(1.0e-3)) sh  (.out(out), .in(in));
    p03_load1k  #(.r(1000.0))      load(.p(out), .n(gnd));
endmodule
