`include "disciplines.vams"
// The two devices whose Jacobian entries come from a C plugin's derivtf, not
// from this compiler.
//
// p03_resistor_systf is VAMS-2023 12.22.2's OWN $resistor() example module:
//
//     module resistor(p, n);
//       electrical p, n;
//       parameter real r = 1k;
//       real curr;
//       analog begin
//         $resistor(curr, V(p, n), r);
//         I(p, n) <+ curr;
//       end
//     endmodule
//
// with the port directions the clause's fragment omits. 12.22.2's own
// resistor_calltf() computes g = 1/r, writes it to the derivative object
// obtained from vpi_handle_multi(vpiDerivative, i_handle, v_handle), and writes
// curr = V*g to the output argument. Driven by a 1 V source with r = 1 kohm:
//
//     V(a, gnd) = 1        exactly (ideal source)
//     curr      = 1/1000   = 1e-3 A exactly
//     d(curr)/dV = 1e-3    exactly
//
// p03_cube_systf is NOT from the LRM, and it is here for one reason: the
// $resistor above CANNOT distinguish a host that propagated the declared
// partial derivative from one that dropped it. A linear element's residual is
// solved by any Newton step of the right sign, and a zero Jacobian entry on a
// branch that is also driven by an ideal source still lands on the right answer.
// So $cube supplies a strictly nonlinear law with an exact root:
//
//     icube = (V + 1)^3 - 1,     d(icube)/dV = 3*(V + 1)^2
//
// driven by a 7 A injection, so KCL at q is (V+1)^3 - 1 = 7, i.e. (V+1)^3 = 8:
//
//     V(q, gnd)        = 1.0   exactly
//     d(icube)/dV at the solution = 3 * (1+1)^2 = 12.0 exactly
//
// (V+1)^3 rather than V^3 because d(V^3)/dV is 0 at the V = 0 cold start, which
// makes the first Newton step singular for reasons that have nothing to do with
// VPI. At V = 0 this law's derivative is 3, and Newton on u^3 = 8 from u = 1
// runs 1 -> 3.333 -> 2.462 -> 2.081 -> 2.0031 -> 2.0000073 -> 2, monotone. A
// host that ignores the plugin's partial gets a zero column and cannot converge
// at all, which is exactly the failure fixture 07 exists to catch.
//
// Used by: 07, 90.

module p03_vsrc1(p, n);
    inout p, n;
    electrical p, n;
    parameter real dc = 1.0;
    analog
        V(p, n) <+ dc;
endmodule

module p03_isrc7(p, n);
    inout p, n;
    electrical p, n;
    parameter real dc = 7.0;
    // I(p,n) is positive out of p through the branch, so wiring this (gnd, q)
    // injects +7 A into q.
    analog
        I(p, n) <+ dc;
endmodule

module p03_resistor_systf(p, n);
    inout p, n;
    electrical p, n;
    parameter real r = 1000.0 from (0:inf);
    real curr;
    analog begin
        $resistor(curr, V(p, n), r);
        I(p, n) <+ curr;
    end
endmodule

module p03_cube_systf(p, n);
    inout p, n;
    electrical p, n;
    real icube;
    analog begin
        $cube(icube, V(p, n));
        I(p, n) <+ icube;
    end
endmodule

module p03_systf_devices;
    electrical a, q, gnd;
    ground gnd;
    p03_vsrc1          #(.dc(1.0))    v1(.p(a), .n(gnd));
    p03_resistor_systf #(.r(1000.0))  r1(.p(a), .n(gnd));
    p03_isrc7          #(.dc(7.0))    i1(.p(gnd), .n(q));
    p03_cube_systf                    c1(.p(q), .n(gnd));
endmodule
