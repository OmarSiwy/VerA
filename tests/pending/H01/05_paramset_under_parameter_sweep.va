// The elaborated identity of a paramset instance has to be recomputed at every
// sub-task of a parameter sweep, because every input to it can move.
//
// §8.2: "It is important to note that for parametric sweep type analyses like dc
// sweep, the tool SHALL RE-EVALUATE the Elaboration and Pre-simulation steps as
// outlined in Figure 8-1 FOR EACH SWEEP POINT to ensure that all parameter value
// changes are captured." §6.9.2 puts paramset selection inside that elaboration:
// "the paramset for each instance is selected after generate statements have
// been evaluated". §6.4.1 makes the module's value a function of the paramset's
// parameter, and §6.3.4 makes the instance's override a function of the
// enclosing module's parameter.
//
// So the chain under test is three links long and a host sweep moves the first:
//
//     host `//! psweep k`  ->  instance override .w(2.0*k)  ->  paramset .g = 3.0*w
//
// THE NUMBERS. g = 3.0 * w = 3.0 * (2.0 * k) = 6k, so
//
//     k = 1.0  ->  w = 2.0  ->  g =  6.0
//     k = 3.0  ->  w = 6.0  ->  g = 18.0
//
// and both are exact in binary. The asserted quantity is the sweep-INVARIANT
// ratio g/(6k) = 1.0, which holds at every sub-task; an elaboration frozen at the
// first sub-task answers 6.0/18.0 = 0.333… at the second point. The second line
// is the backstop for the opposite failure, a paramset re-elaborated but with a
// stale override: once k is past 2.0 the value cannot still be the first point's
// 6.0.
//
// GROUND TRUTH TODAY: green. VerA re-derives the flattened parameter card per
// sweep point (`D.derive` is called after each card write), and the flattened
// paramset value follows. The row has no fixture that puts a paramset inside a
// sweep, which is what this file adds — the existing ch08 sweep fixtures use a
// plain module.
//
//! lrm 8.2
//! lrm 6.9.2
//! lrm 6.4.1
//! psweep k = 1.0, 3.0
//! analysis dc
//! print none
//! bias V(p) = 0.5
`include "check.vh"
module h01_sweep(p, n);
  inout p, n; electrical p, n;
  parameter real k = 1.0 from (0:inf);
  h01_sweep_ps #(.w(2.0 * k), .kref(k)) u(p, n);
endmodule

paramset h01_sweep_ps h01_sweep_base;
  parameter real w = 1.0 from (0:inf);
  // Carried down untouched so the module can state the invariant in terms of the
  // swept value itself; nothing derives from it.
  parameter real kref = 1.0 from (0:inf);
  .g = 3.0 * w;
  .kk = kref;
endparamset

module h01_sweep_base(a, b);
  inout a, b; electrical a, b;
  parameter real kk = 1.0 from (0:inf);
  parameter real g = 0.0;
  analog begin
    `CHECKX("the paramset value is 6k at every sweep sub-task", g / (6.0 * kk), 1.0);
    `CHECKI("and is not frozen at the first sub-task", (kk > 2.0) ? (g > 17.0) : 1, 1);
    I(a, b) <+ g * V(a, b);
  end
endmodule
