// The one real-to-integer conversion §4.2.1.1 cannot perform.
//
// §4.2.1.1 defines the conversion exhaustively and by ROUNDING: "Real numbers are
// converted to integers by rounding the real number to the nearest integer ...
// If the fractional part of the real number is exactly 0.5, it shall be rounded
// away from zero." An infinity has no nearest integer, so the clause supplies no
// value for this assignment.
//
// §3.2 closes the other door: integer "variables can hold values ranging from
// -2^31 to 2^31-1". There is therefore no in-range answer an implementation could
// substitute and no §3.2 "2's complement result" to wrap to — 1.0/0.0 is not a
// finite integer-valued real that reduction modulo 2^32 is defined on. §3.4.1
// makes this an assignment of exactly that kind: "If the type of the parameter is
// specified as integer or real, and the value assigned to the parameter conflicts
// with the type of the parameter, the value is converted to the type of the
// parameter (see 4.2.1.1)."
//
// So the only conforming outcome is a diagnostic, and this is the row's single
// rejection fixture. The expectation is written as the CLAUSE the diagnostic must
// cite rather than as a code, because no code for it exists yet and inventing one
// here would pin an implementation choice instead of the rule; every VerA
// diagnostic renders `= note: LRM <section>`, so `LRM 4.2.1.1` is the substring
// that says "refused, and refused for this reason".
//
// GROUND TRUTH TODAY: accepted silently, and the parameter comes out
// 9223372036854775807 — the saturation value of VerA's i64 carrier, which is not
// merely wrong but outside §3.2's declared range for the type, so no host reading
// the model card can tell it from a legitimate value.
//
// WHAT THIS DOES NOT CLAIM. Nothing here is about `1.0/0.0` as an expression:
// §4.2.4 leaves real division by zero to IEEE 754, whose answer is +inf, and that
// is fine right up to the point where it is stored in an integer. A real
// parameter initialised the same way is outside this fixture.
//
//! lrm 4.2.1.1
//! lrm 3.2
//! reject LRM 4.2.1.1
`include "check.vh"
module h01_nonfinite(p, n);
  inout p, n; electrical p, n;
  parameter integer overflowed = 1.0 / 0.0;
  analog I(p, n) <+ overflowed * V(p, n);
endmodule
