// A dependent parameter may be derived from a STRING parameter, and the override
// that changes the string has to move the derived value with it.
//
// §6.3.4: "A parameter (for example, gate_cap) can be defined with an expression
// containing another parameter ... Since gate_cap depends on the value of
// gate_width and gate_length, a modification of gate_width or gate_length changes
// the value of gate_cap." §3.4.6 makes a string parameter an ordinary parameter
// for that purpose — "Strings are useful for parameters that act as flags, where
// the correspondence between numerical values and the flag values may not be
// obvious" — and prints the `ebersmoll` example doing exactly this comparison:
// `sign = (transistortype == "NPN") ? 1.0 : -1.0;`. §4.2.7 gives `==` on the
// strings its value, and §4.2.12 the conditional operator.
//
// The only difference from the clause's example is WHERE the conditional lives:
// in a parameter declaration rather than in the analog block, which is what makes
// it a §6.3.4 dependent value that must be re-derived after the override instead
// of an expression evaluated per solve.
//
// THE NUMBER. The instance overrides `mode` with "slow", which is in the declared
// `from '{ "fast", "slow" }` set (§3.4.2), so
//
//     mk = (mode == "fast") ? 2.0 : 3.0 = 3.0
//
// and the contribution is mk*V = 3.0 * 0.5 = 1.5 A. The un-overridden answer is
// 2.0 and 1.0 A, so a derivation frozen at the declared default is a wrong number
// in both lines. Both values are exact in binary.
//
// GROUND TRUTH TODAY: refused with E1004, "host derivation of `u.mk` uses an
// unsupported expression; its declared value cannot be frozen after parameter
// overrides". The renderer that emits the host's `derive` callback handles
// conditionals, short-circuit logic, `%`, `**`, shifts and the math builtins over
// reals — every one of those was checked while writing this file and every one
// works — but not a string comparison, so this is a single missing operand type
// and not a missing control-flow shape.
//
//! lrm 6.3.4
//! lrm 3.4.6
//! bias V(p) = 0.5
`include "check.vh"
module h01_string_derive(p, n);
  inout p, n; electrical p, n;
  h01_string_child #(.mode("slow")) u(p, n);
endmodule

module h01_string_child(a, b);
  inout a, b; electrical a, b;
  parameter string mode = "fast" from '{ "fast", "slow" };
  parameter real mk = (mode == "fast") ? 2.0 : 3.0;
  analog begin
    `CHECKX("the derived value follows the overridden string", mk, 3.0);
    `CHECKX("so the current is 3.0 * 0.5 V", mk * V(a, b), 1.5);
    I(a, b) <+ mk * V(a, b);
  end
endmodule
