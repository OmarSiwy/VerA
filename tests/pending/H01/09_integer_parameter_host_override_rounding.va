// A host writes a parameter card in reals. §4.2.1.1 says what an integer
// parameter is worth when the number it is handed is not one.
//
// §4.2.1.1: "Real numbers are converted to integers by ROUNDING the real number
// to the nearest integer, rather than by truncating it. Implicit conversion takes
// place when a real number is assigned to an integer. If the fractional part of
// the real number is exactly 0.5, it shall be ROUNDED AWAY FROM ZERO." With the
// clause's own examples: "The real numbers 35.7 and 35.5 both become 36 when
// converted to an integer and 35.2 becomes 35. Converting -1.5 to integer yields
// -2".
//
// §3.4.1 is what makes this the override path and not a declaration question: "If
// the type of the parameter is specified as integer or real, and THE VALUE
// ASSIGNED TO THE PARAMETER conflicts with the type of the parameter, the value is
// converted to the type of the parameter (see 4.2.1.1)". The value assigned here
// is the host's, applied after compilation — §6.3's override, arriving through the
// model card rather than through an instance line.
//
// THE THREE NUMBERS, straight from the clause:
//
//     host writes -1.5  ->  n_half_neg = -2   (0.5 exactly, away from zero)
//     host writes 35.5  ->  n_half_pos = 36   (0.5 exactly, away from zero)
//     host writes 35.2  ->  n_down     = 35   (nearest, not truncated-then-up)
//
// 35.2 is the one that separates rounding from truncation only for the negative
// twin, so the -1.5 row carries that weight: truncation gives -1, rounding to
// nearest with ties to EVEN gives -2 as well, and only "away from zero" gets both
// -2 and 36 at once. All three inputs are exactly representable as f64 except
// 35.2, whose nearest double is 35.2000000000000028…, still well inside the
// rounding interval of 35.
//
// GROUND TRUTH TODAY: the fixture does not even get to run. VerA writes host
// overrides into the generated model card verbatim, so the testbench contains
// `model.n_half_neg = -1.5;` against an i64 field and `zig build-exe` fails with
// "fractional component prevents float value '-1.5' from coercion to type 'i64'".
// The conversion §4.2.1.1 mandates happens nowhere on the host-override path.
//
//! lrm 4.2.1.1
//! lrm 3.4.1
//! param n_half_neg = -1.5, n_half_pos = 35.5, n_down = 35.2
//! bias V(p) = 0.5
`include "check.vh"
module h01_int_rounding(p, n);
  inout p, n; electrical p, n;
  parameter integer n_half_neg = 0;
  parameter integer n_half_pos = 0;
  parameter integer n_down = 0;
  analog begin
    `CHECKI("-1.5 rounds away from zero", n_half_neg, -2);
    `CHECKI("35.5 rounds away from zero", n_half_pos, 36);
    `CHECKI("35.2 rounds to nearest", n_down, 35);
    `CHECKI("and the three combine as integers, not as the reals written", n_half_pos + n_down + n_half_neg, 69);
    I(p, n) <+ V(p, n);
  end
endmodule
