// §6.4.2's own worked example, with the clause's own answers.
//
// "Paramset identifiers need not be unique: multiple paramsets can be declared
// using the same paramset_identifier ... During elaboration, the simulator shall
// choose an appropriate paramset from the set sharing a given name for every
// instance that references that name." Selection rules (all must be satisfied),
// then tie-breaking rules applied in order until unique. The clause prints four
// paramsets named `nch` and the table of what each instance selects; this file
// is the two rows of that table that a single .va can carry (m1/m2 need the
// $rdist_ draws of §9.13 and are left to that row).
//
//   m3: nch #(.l(1u), .w(10u))                     -> DEFAULT paramset
//       "Mismatch paramset excluded (default mm out of range); discriminates
//        against long-channel (fewer un-overridden params)"
//   m4: nch #(.l(3u), .w(5u), .ad(1.2p), .as(1.3p)) -> LONG-CHANNEL paramset
//       "Short-channel also has ad/as but l=3u is out of range for short-channel"
//
// WORKING THE TWO ROWS BY HAND.
//
// m3 overrides l and w only. The mismatch paramset is out: its `mm` defaults to
// 0 and its range is `(0:1]`, which excludes 0, so selection rule 2 fails. The
// short-channel paramset is out: l = 1u and its range is `[0.25u:1u)`, open at
// the top. Default and long-channel both survive, so tie-breaking rule 1 decides
// — "the paramset with the fewest number of un-overridden parameters": default
// has two parameters and both are overridden (0 left), long-channel has four and
// two are overridden (2 left). Default wins. Its values are u0 = 650,
// nfs = 0.8e12, and `.ad = w*0.5u` = 10e-6 * 0.5e-6 = 5.0e-12.
//
// m4 overrides l, w, ad and as. Default and mismatch are out on selection rule 1
// — "all parameters overridden on the instance shall be parameters of the
// paramset" — and neither declares ad or as. Short-channel is out on rule 2:
// l = 3u is outside `[0.25u:1u)`. Long-channel alone survives, with u0 = 640,
// nfs = 0.7e12 and ad = 1.2e-12 taken from the instance.
//
// HOW ONE ANALOG BLOCK ASSERTS TWO DIFFERENT ANSWERS. Both instances elaborate
// the same module, so the assertion is written as one predicate keyed on the one
// value that differs and is exact: l is 1e-6 for m3 and 3e-6 for m4. The verdict
// is the literal 1 either way, which is what keeps a single `want` honest.
//
// `ad` is compared with a tolerance and the other two exactly: 10e-6 * 0.5e-6
// rounds to 5.0000000000000005e-12 in binary, so an `==` against 5.0e-12 would
// fail for a reason that has nothing to do with paramset selection. 1e-24 is
// four orders below the 1e-20 gap between the two candidate `ad` values
// (5.0e-12 vs 4.0e-12 = 0.4*w), so the check still discriminates.
//
// GROUND TRUTH TODAY: VerA already selects both rows correctly
// (`Flatten.selectParamset` + `paramsetAdmits` + `paramsetTieBreak`). This
// fixture exists because the clause's printed table had no fixture of its own —
// ch06_hierarchy/paramset_overload_unsupported.va pins a two-bin geometry split
// and paramset_tie_break_fewest_unoverridden.va pins rule 1 in isolation, but
// neither runs the four-paramset set the clause actually prints.
//
//! lrm 6.4.2
//! analysis dc
//! print none
`include "check.vh"
module h01_bins(d1, g, s, b);
  inout d1, g, s, b; electrical d1, g, s, b;
  nch #(.l(1.0e-6), .w(10.0e-6)) m3(g, g, s, b);
  nch #(.l(3.0e-6), .w(5.0e-6), .ad(1.2e-12), .as(1.3e-12)) m4(d1, g, s, b);
endmodule

paramset nch h01_nmos3;   // default paramset
  parameter real l = 1.0e-6 from [0.25e-6:inf);
  parameter real w = 1.0e-6 from [0.2e-6:inf);
  .l = l; .w = w; .ad = w * 0.5e-6; .as = w * 0.5e-6;
  .u0 = 650.0; .nfs = 0.8e12;
endparamset

paramset nch h01_nmos3;   // mismatch paramset
  parameter real l = 1.0e-6 from [0.25e-6:inf);
  parameter real w = 1.0e-6 from [0.2e-6:inf);
  parameter integer mm = 0 from (0:1];
  .l = l; .w = w; .ad = w * 0.5e-6; .as = w * 0.5e-6;
  .u0 = 650.0; .nfs = 0.8e12;
endparamset

paramset nch h01_nmos3;   // short-channel paramset
  parameter real l = 0.25e-6 from [0.25e-6:1.0e-6);
  parameter real w = 1.0e-6 from [0.2e-6:inf);
  parameter real ad = 0.5 * w from (0:inf);
  parameter real as = 0.5 * w from (0:inf);
  .l = l; .w = w; .ad = ad; .as = as;
  .u0 = 650.0; .nfs = 0.8e12;
endparamset

paramset nch h01_nmos3;   // long-channel paramset
  parameter real l = 1.0e-6 from [1.0e-6:inf);
  parameter real w = 1.0e-6 from [0.2e-6:inf);
  parameter real ad = 0.4 * w from (0:inf);
  parameter real as = 0.4 * w from (0:inf);
  .l = l; .w = w; .ad = ad; .as = as;
  .u0 = 640.0; .nfs = 0.7e12;
endparamset

module h01_nmos3(d, g, s, b);
  inout d, g, s, b; electrical d, g, s, b;
  parameter real l = 0.0, w = 0.0, ad = 0.0, as = 0.0, u0 = 0.0, nfs = 0.0;
  analog begin
    `CHECKI("6.4.2's table: l=1u takes the default bin, l=3u the long-channel one",
            (l < 2.0e-6)
              ? ((u0 == 650.0) && (abs(ad - 5.0e-12) < 1.0e-24) && (nfs == 0.8e12))
              : ((u0 == 640.0) && (abs(ad - 1.2e-12) < 1.0e-24) && (nfs == 0.7e12)), 1);
    `CHECKI("nfs pairs with u0 in every bin the clause prints",
            (u0 == 650.0) ? (nfs == 0.8e12) : (nfs == 0.7e12), 1);
    I(d, s) <+ 1.0e-6 * V(d, s);
    I(g) <+ 0.0;
    I(b) <+ 0.0;
  end
endmodule
