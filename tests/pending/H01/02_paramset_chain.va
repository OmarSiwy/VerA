// §6.4: "The first identifier following `paramset` is the name of the paramset.
// The second identifier is usually the name of a module with which the paramset
// is associated. The second identifier may instead be the name of a second
// paramset. A CHAIN OF PARAMSETS MAY BE DEFINED, but the last paramset in the
// chain shall reference a module."
//
// That is the whole of what the clause says about chains, and it is all this
// fixture asserts: `h01_fast -> h01_slow -> h01_chain_base` is a legal two-link
// chain, an instance naming the near link elaborates to the module at the end of
// it, and the assignments of the link whose own second identifier IS a module
// arrive there.
//
// THE NUMBER. The far link (`h01_slow`, associated directly with the module) has
// `.j = 2.0`; the module's own default is `j = 0.0`. §6.4.1: the
// `.module_parameter_identifier = ...` syntax "is used to assign values to the
// parameters of the associated module". So j = 2.0, and at the biased 0.5 V the
// contribution j*V is 2.0 * 0.5 = 1.0 A. Both are asserted: an implementation
// that reached the module but dropped the statement reads j = 0.0 and 0.0 A.
//
// This cannot be satisfied without walking the chain. The instance names
// `h01_fast`, which is not a module and never becomes one except by following a
// second identifier twice, so there is no fallback path that produces 2.0.
//
// WITHDRAWN, AND WHERE IT WENT. An earlier version of this fixture also put
// `.k = 5.0` on the NEAR link and asserted the module's `k` came out 5.0 (and a
// 7.0 sum, 3.5 A). §6.4 does not license that. It says a chain may exist and
// where it must end; it says nothing about what a near link's `.k` targets when
// the thing that link is associated with is a paramset that has no parameter
// `k`. Two readings survive the text. Syntax 6-4 spells the left-hand side
// `module_parameter_identifier` and offers no production at all for assigning a
// nested paramset's parameter, which argues a near link's `.k` is the end
// module's `k`; but §6.4.1 scopes that syntax to "the parameters of the
// ASSOCIATED module", and a near link's associated thing is a paramset, which
// argues a near link may only refine the far link and that `.k` is an error here.
// Under the first reading the old assertion holds; under the second the file is
// ill-formed before it runs. Nothing in §6.4/§6.4.1 picks one, and neither does
// the precedence question a chain raises next (which link wins when both assign
// the same module parameter). A fixture a conforming implementation of the
// second reading must fail is not a conformance fixture, so the claim is gone
// from this row and is asserted NOWHERE ELSE in the suite — no row owns it, and
// SPEC.md records it as withdrawn rather than covered. It comes back the day
// §6.4/§6.4.1 (or an erratum) says which of the two things a near-link statement
// names; at that point this file grows a third check and the module grows back
// its `k`.
//
// Deliberately, therefore, the near link carries NO `.module_parameter` statement
// at all: a paramset variable declaration plus an assignment to it (§6.4.1,
// "Paramset statements may assign values to variables declared in the paramset";
// Syntax 6-4's `analog_function_statement` alternative). That is the smallest
// body Syntax 6-4 admits — one item declaration and one statement — and it is
// legal under both readings, so the file's only claim is the chain itself.
//
// GROUND TRUTH TODAY: refused. `Flatten` resolves `ps.target` with `findModule`
// only (E0904, "`h01_slow`, the module this paramset specializes"), so the second
// identifier is required to be a module and the chain is unreachable. The
// rewrite above changes nothing about that: verified by running --check, the
// file still stops at E0904 on line 68 — the same diagnostic the old one gave.
//
//! lrm 6.4
//! lrm 6.4.1
//! bias V(p) = 0.5
`include "check.vh"
module h01_chain(p, n);
  inout p, n; electrical p, n;
  h01_fast u(p, n);
endmodule

paramset h01_fast h01_slow;
  real link_tag;
  link_tag = 1.0;
endparamset

paramset h01_slow h01_chain_base;
  .j = 2.0;
endparamset

module h01_chain_base(a, b);
  inout a, b; electrical a, b;
  parameter real j = 0.0;
  analog begin
    `CHECKX("the chain reached the module and the far link's statement arrived", j, 2.0);
    `CHECKX("so the conductance is 2.0 and the current 1.0 A at 0.5 V", j * V(a, b), 1.0);
    I(a, b) <+ j * V(a, b);
  end
endmodule
