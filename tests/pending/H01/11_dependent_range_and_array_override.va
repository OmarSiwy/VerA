// Two §3.4 rules that only mean anything at the INSTANCE, after overrides: a
// range whose bound is itself a parameter, and an array whose size is.
//
// §3.4.2: "Range checking applies to the value of the parameter for the instance
// and not against the default values specified in the device. It shall be an
// error only if the value of the parameter is out of range during simulation." So
// `x = 1.0 from [0:hi]` with hi overridden to 40.0 admits x = 20.0, even though
// the DECLARED default of hi is 10.0 and would not have.
//
// §3.4.4: "Since array range in the parameter array declaration may depend on
// previously-declared parameters, the array size may be changed by overriding the
// appropriate parameters. If the array size is changed, the parameter array shall
// be assigned an array of the new size FROM THE SAME MODULE AS THE PARAMETER
// ASSIGNMENT that changed the parameter array size." The instance line below does
// both in one `#(...)`: nn goes 2 -> 3 and c is given three elements in the same
// override list, which is what the sentence requires.
//
// THE NUMBERS.
//
//   hi -> 40.0, x -> 20.0        x is in [0:40] and keeps 20.0; the check is
//                                x/hi = 0.5, a ratio that is wrong for a
//                                declared-default ceiling (20/10 = 2.0) and
//                                wrong again if the override is dropped
//                                (1/40 = 0.025)
//   nn -> 3, c -> '{2,4,8}       c[nn-1] = c[2] = 8.0 — the element that does
//                                not exist in the two-element default, so an
//                                implementation that keeps the declared size
//                                either reads out of bounds or answers 1.0
//   c[0]+3*c[1]+5*c[2]           = 2 + 12 + 40 = 54.0, a weighting no
//                                permutation of {2,4,8} repeats, so an array
//                                that is resized but filled in the wrong order
//                                is caught too
//
// All exact in binary (powers of two, and 20/40).
//
// GROUND TRUTH TODAY: green, both halves. Recorded because the row claimed
// dependent ranges and arrays without a fixture that overrides the BOUND or the
// SIZE — ch06's dependent-parameter fixtures move values, not shapes. The
// residual defect this file does NOT reach is noted in SPEC.md: the same two
// rules applied to a HOST override (`//! param`) instead of an instance line are
// not checked at all, and W0651 misreads `[0:hi]` as a range admitting infinity.
//
//! lrm 3.4.2
//! lrm 3.4.4
//! bias V(p) = 0.5
`include "check.vh"
module h01_dep(p, n);
  inout p, n; electrical p, n;
  h01_dep_child #(.hi(40.0), .x(20.0), .nn(3), .c('{ 2.0, 4.0, 8.0 })) u(p, n);
endmodule

module h01_dep_child(a, b);
  inout a, b; electrical a, b;
  parameter real hi = 10.0 from (0:inf);
  parameter real x = 1.0 from [0:hi];
  parameter integer nn = 2;
  parameter real c[0:nn-1] = '{ 1.0, 1.0 };
  analog begin
    `CHECKX("the range ceiling is the OVERRIDDEN hi, so 20.0 is admitted", x / hi, 0.5);
    `CHECKX("the array was resized with its size parameter", c[nn-1], 8.0);
    `CHECKX("and holds all three given elements in order", c[0] + 3.0 * c[1] + 5.0 * c[2], 54.0);
    I(a, b) <+ x * V(a, b);
  end
endmodule
