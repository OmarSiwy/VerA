// §5.4.2.1's OTHER sentence, and the anti-symmetric partner to
// 02_flow_probe_is_a_zero_volt_source.va:
//
//   "The branch flow of a potential probe is zero (0)."
//
// Figure 5-1 draws it as a voltmeter — an open circuit. This fixture exists to
// stop 02 from being "fixed" by the cheapest wrong rule, "a probe branch shorts
// its terminals". Under that rule this circuit moves, and it must not.
//
// THE CIRCUIT:
//
//     s --[ 1k ]-- a --[ 2k ]-- g          the divider under observation
//                  |
//              (V probe)                   reads V(a,c), contributes nothing
//                  |
//                  c --[ 10k ]-- g         c has no other source
//
// BY HAND. The probe carries no flow, so it loads nothing and connects nothing:
//
//   V(a) = 3.0 * 2000/(1000 + 2000) = 2.0 V exactly
//   V(c) = 0.0 V  — the 10k is c's only path, and with zero probe flow it
//                   carries zero current, so c sits at the reference
//   V(a,c) = 2.0 V
//
// IF THE PROBE WERE A SHORT the answer is different in every digit: a and c
// merge, the 2k and the 10k are then in parallel (1.6667 k), and
// V(a) = 3.0*1666.67/2666.67 = 1.875 V with V(a,c) = 0. So 2.0 versus 1.875 and
// 2.0 versus 0.0 are the two guard rails.
//
// WHAT EACH ASSERTION IS WORTH (added after review — this row must not claim
// three independent facts where it has two). `V(a)` and `V(c)` are the two
// independent ones and they are the guard rail: the short reading misses both.
// The third, `v_meas == 2.0`, is algebraically implied by them, since
// V(a,c) = V(a) - V(c). It is kept because the READ is what makes (a,c) a
// potential probe at all — delete it and §5.4.2.1 no longer applies to this
// circuit, so the other two assertions pin nothing. It is a precondition, not a
// third claim, and SPEC.md counts it as one.
//
// THIS FIXTURE PASSES TODAY — deliberately. VerA leaves every probe branch
// unconnected, which is right for a potential probe and wrong for a flow probe;
// the pair 02/03 is what makes those two independently checkable, so wire them
// in together or the fix has no way to know it overshot.
//
//! lrm 5.4.2.1
//! bias V(s) = 3.0
//! bias V(g) = 0.0
//! solve
`include "check.vh"
module a02_potential_probe_open(s, g);
  inout s, g;
  electrical s, g, a, c;
  real v_meas;
  analog begin
    I(s, a) <+ V(s, a)/1000.0;
    I(a, g) <+ V(a, g)/2000.0;
    I(c, g) <+ V(c, g)/10000.0;

    // Nothing is contributed to (a,c) and only its potential is read, so
    // §5.4.2.1 makes it a potential probe and its flow zero.
    v_meas = V(a, c);

    `CHECK("the probe loads nothing, so the 1k/2k divider is untouched", V(a), 2.0, 1e-12);
    `CHECK("and it connects nothing, so c is left at the reference", V(c), 0.0, 1e-12);
    `CHECK("the voltmeter reads the full divider output", v_meas, 2.0, 1e-12);
  end
endmodule
