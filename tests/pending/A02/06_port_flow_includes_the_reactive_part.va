// §5.4.3's port access function, on the case its own Example 1 is built around.
// The LRM's junction diode monitors the TOTAL terminal current:
//
//     I(i_diode)  <+ is*(limexp(V(i_diode)/$vt) - 1);
//     I(junc_cap) <+ ddt(tf*I(i_diode) - 2*cjo*sqrt(phi*(phi*V(junc_cap))));
//     if (I(<a>) > imax)
//         $strobe( "Warning: diode is melting!" );
//
// `I(<a>)` there is the sum of a conduction branch and a CHARGE branch. A port
// probe that reported only the conduction half would never see the capacitive
// spike, which is precisely the event the example's `imax` guard is looking for.
//
// THE MEASUREMENT, a capacitor and a resistor in parallel between the two ports,
// driven by the same 1 V/ns ramp as 04:
//
//     I(p,n) <+ c*ddt(V(p,n)) + V(p,n)/r        c = 1 nF, r = 1 kohm
//
//   t      0     1n    2n    3n
//   V(p)   0     1     2     3        (the `//! wave` line, V(n) held at 0)
//
// BY HAND, term by term:
//
//   capacitive  c*dV/dt = 1e-9 * (1 V / 1e-9 s) = 1.0 A at every t > 0, and
//               0 at t = 0 because §4.5.3 makes ddt zero at the DC point;
//   resistive   V(p,n)/r = (t/1ns) / 1000, i.e. 1.0e-3, 2.0e-3, 3.0e-3 A.
//
//   I(<p>) = 0, 1.001, 1.002, 1.003 A
//
// The `want` is written from $abstime and not from V(p,n), so an error common to
// the probe and to the expectation cannot cancel: `$abstime*1.0e6` is the
// resistive term (1e-9 s * 1e6 = 1e-3 A at the first step) and
// `($abstime > 0)*1.0` is the capacitive one. The resistive term is deliberately
// three decades below the reactive one, so the transcript column shows at a
// glance WHICH half survived: 0.001 is "reactive dropped", 1.0 would be
// "resistive dropped", 1.001 is the answer.
//
// OBSERVED TODAY: `got=0.001`, `got=0.002`, `got=0.003` — exactly the resistive
// half. Two separate things are missing and both are named in tests/torture's
// own source: the generated device does emit a charge row for the port unknown
// (`q[flowZ28Z3cpZ3eZ29] = -1e-9` with the correct derivative), but
// src/backend/tb.zig's `solve` carries a `ponytail:` note reading "the RESISTIVE
// residual only ... Fold q in when a fixture needs a transient solve" — this is
// that fixture. Whether the remaining gap after that is in the harness or in
// codegen is for the implementer to find; the number above is what the clause
// requires either way.
//
//! lrm 5.4.3
//! lrm 4.5.3
//! bias V(n) = 0
//! wave V(p) = 0, 1, 2, 3
//! time 0, 1n, 2n, 3n
//! analysis tran
//! solve
//! print none
`include "check.vh"
module a02_reactive_port_flow(p, n);
  inout p, n;
  electrical p, n;
  parameter real c = 1n from (0:inf);
  parameter real r = 1k from (0:inf);
  analog begin
    I(p, n) <+ c*ddt(V(p, n)) + V(p, n)/r;
    `CHECK("the port probe measures the charge current as well as the conduction current",
           I(<p>), ($abstime > 0) * 1.0 + $abstime * 1.0e6, 1e-9);
  end
endmodule
