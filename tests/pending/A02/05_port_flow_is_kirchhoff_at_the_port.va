// §5.4.3 Accessing flow through a port:
//
//   "The port access function accesses the flow into a port of a module."
//
// and §5.4.1 Example 4: "I(<p1>) is used to access the current flow into the
// module through the electrical port p1."
//
// That is a DEFINITION, not a declaration: `I(<p>)` introduces an unknown, and
// its defining equation is Kirchhoff's current law taken over every branch of
// the module that touches p. tests/fixtures/ch05_analog_behavior/port_flow_probe.va
// pins the probe's spelling but FORCES the unknown with
// `//! sweep flowZ28Z3cpZ3eZ29 = 0.0625`, so it never asks what defines it.
// This file leaves it free and states the number KCL requires.
//
// THE NETWORK — a delta, so that two different branches reach p and their sum,
// not either one, is the answer:
//
//        p --[ 1k ]-- m --[ 1k ]-- n
//        |                          |
//        +---------[ 4k ]-----------+
//
//      V(p) = 2.0 V, V(n) = 0.0 V, m free.
//
// BY HAND. The 1k-1k arm is a symmetric divider, so V(m) = 1.0 V and it carries
// 1.0/1000 = 1.0 mA; the 4k arm carries 2.0/4000 = 0.5 mA. Both leave p:
//
//   I(<p>) = 1.0e-3 + 0.5e-3 = 1.5e-3 A
//   I(<n>) = -1.5e-3 A
//   I(<p>) + I(<n>) = 0        — the module as a whole conserves flow
//
// Every value is exact in binary.
//
// WHAT EACH ASSERTION IS WORTH (corrected after review — the original text here
// overstated the third line). The third assertion catches a per-branch
// bookkeeping error that gets one port right and the other wrong — a compiler
// that counted the 4k arm once at p and twice at n satisfies one of the first
// two lines but not this one. It does NOT stand alone: an implementation with
// no port-flow equation at all answers 0 for both ports and satisfies it
// trivially. Lines 1 and 2 are what exclude that case, so all three are only
// meaningful together; do not keep the conservation line without them.
//
// THIS FIXTURE PASSES TODAY. It is written because the behaviour it pins has no
// evidence anywhere in tests/fixtures/ — the plan's A02 line lists port-current
// probes as unfinished, and the audit brief says an implemented-without-evidence
// row still needs its test. It is also the static baseline that
// 06_port_flow_includes_the_reactive_part.va extends; keep the two together, so
// that a fix for 06 that rewrites the port equation has something to regress
// against.
//
//! lrm 5.4.3
//! lrm 5.4.1
//! bias V(p) = 2.0
//! bias V(n) = 0.0
//! solve
`include "check.vh"
module a02_port_flow_kcl(p, n);
  inout p, n;
  electrical p, n, m;
  analog begin
    I(p, m) <+ V(p, m)/1000.0;
    I(m, n) <+ V(m, n)/1000.0;
    I(p, n) <+ V(p, n)/4000.0;
    `CHECK("the divider arm and the shunt arm both leave p", I(<p>), 1.5e-3, 1e-12);
    `CHECK("and the same current arrives at n", I(<n>), -1.5e-3, 1e-12);
    `CHECK("so the module conserves flow", I(<p>) + I(<n>), 0.0, 1e-15);
    `CHECK("the symmetric divider fixes the interior node", V(m, n), 1.0, 1e-12);
  end
endmodule
