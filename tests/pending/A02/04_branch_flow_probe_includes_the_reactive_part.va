// §5.4.2.2 Sources:
//
//   "Both the potential and the flow of a source branch are accessible in
//    expressions anywhere in the module."
//
// and §5.6.1.2, which says what that flow IS: the simulator evaluates the
// right-hand side, adds it to the retained value, and "at the end of the
// simulation cycle ... assigns the retained value to the source branch". The
// retained value of this branch is `c*ddt(V(cap))` — the whole of it. There is
// no clause anywhere that lets a reactive term be retained for the purpose of
// the node equation and dropped for the purpose of a probe.
//
// This is the plan's "reactive branch-current probes", and it is the measured
// capacitor current of §5.4.3's own diode example, where `I(i_diode)` — a
// branch flow — is read back inside `ddt` to build the transit-time charge.
//
// THE MEASUREMENT. A 1 nF capacitor driven by a 1 V/ns ramp:
//
//   t      0     1n    2n    3n
//   V(p)   0     1     2     3        (the `//! wave` line, V(n) held at 0)
//
// BY HAND. §4.5.3 makes `ddt` zero at the DC point that opens a transient, and
// on every step after it the harness's backward-Euler difference over a uniform
// 1 ns step is exactly the ramp slope:
//
//   dV/dt = (V_k - V_{k-1})/dt = 1 V / 1e-9 s = 1e9 V/s
//   I(cap) = c * dV/dt = 1e-9 F * 1e9 V/s = 1.0 A   for every t > 0
//   I(cap) = 0.0 A                                   at t = 0
//
// 1.0 A is a deliberately absurd current for a 1 nF part; it is chosen so the
// asserted number is 1 and not a decade-scaled almost-zero that a dropped term
// could hide inside a tolerance. Both the value and the step are powers of two
// times powers of ten, so the only rounding is the one ulp `1/1e-9` costs.
//
// The verdict is folded onto ONE literal with a §4.2.5 relational, the way
// ch05_analog_behavior/switch_branch_solved.va folds its two states:
// `($abstime > 0)` is the integer 1 or 0, so `want` is 1.0 after t = 0 and 0.0
// at t = 0, and the same source line asserts all four points.
//
// OBSERVED TODAY: `got=0` at every transient point. The emitted device puts the
// capacitor on the charge tape (`q[p] = 1e-9` with the right derivative, so the
// NODE equation is correct) but the probe read of `I(cap)` is compiled from the
// resistive half of the contribution only, and there is no resistive half here.
// A model that computes its own dissipation, its own charge-conservation check,
// or §5.4.3's transit-time term reads zero.
//
//! lrm 5.4.2.2
//! lrm 5.6.1.2
//! lrm 4.5.3
//! bias V(n) = 0
//! wave V(p) = 0, 1, 2, 3
//! time 0, 1n, 2n, 3n
//! analysis tran
//! print none
`include "check.vh"
module a02_reactive_branch_flow(p, n);
  inout p, n;
  electrical p, n;
  branch (p, n) cap;
  parameter real c = 1n from (0:inf);
  analog begin
    I(cap) <+ c*ddt(V(cap));
    `CHECK("the flow of a source branch is its whole retained value, reactive term included",
           I(cap), ($abstime > 0) * 1.0, 1e-9);
  end
endmodule
