// §5.6.8.2 Hierarchical direct contributions to branches:
//
//   "Hierarchical direct contributions to named and unnamed branches is allowed
//    provided that the branch is suitable for such contributions."
//
// with the clause's own first example, `V(top.drv.br_v) <+ 1.8;` — "contributes
// 1.8 volts to the named branch br_v in top.drv".
//
// This is the OPPOSITE of §5.6.8.1, which is fixture 07: there, naming the
// child's NETS creates a new branch in the parent; here, naming the child's
// BRANCH reaches the branch the child already owns. So §5.6.1.2's accumulation
// rule applies across the module boundary — "the simulator adds the value of the
// right-hand side to any previously retained value of the branch" — and the two
// contributions sum on one source.
//
// THE CIRCUIT:
//
//     gnd ---[ br: child 0.5 V + parent 1.8 V ]--- x ---[ 1k ]--- gnd
//
// BY HAND. Same kind of contribution twice, so §5.6.1.3's "multiple
// contributions to the same potential branch or same flow branch will be
// additive" gives
//
//   V(br)  = 0.5 + 1.8 = 2.3 V
//   V(x)   = 2.3 V          (the branch's far end is held at the reference)
//   I(br)  = -2.3 mA
//
// The SIGN is §5.6.1.1: "the branch is directed from the first net of the access
// function to the second net", and `br` is declared `branch (x, b)`. The 1 kohm
// load carries 2.3/1000 = 2.3 mA out of x and into the reference; that current
// is returned to x through the source, i.e. it traverses `br` from b to x, which
// is -2.3 mA in the branch's declared direction. Flipping the declaration to
// `branch (b, x)` would flip both this number and the sense of the 0.5 V the
// child contributes, so the sign is part of what is being pinned, not an
// accident of how the file happens to be written.
//
// TOLERANCE — CORRECTED AFTER REVIEW, and the old justification was simply
// false. This file used to say "`0.5 + 1.8` and the literal `2.3` differ in the
// last ulp" and set 1e-15 on the potentials, 1e-18 on the current. They do not
// differ: in IEEE-754 double `0.5 + 1.8 == 2.3` bit-for-bit, and
// `2.3/1000.0 == 2.3e-3` bit-for-bit as well. So those tolerances were not a
// rounding allowance, they were the ULP floor:
//
//   ulp(2.3)    = 2^-51 = 4.440892098500626e-16   ->  1e-15 = 2.25 ulp
//   ulp(2.3e-3) = 2^-61 = 4.336808689942018e-19   ->  1e-18 = 2.31 ulp
//
// This file is the regression floor for the matrix-assembly rewrite that 01, 02
// and 07 all require, so a tolerance that only holds while the assembly happens
// to land bit-exact is exactly the wrong thing to leave behind: summing the two
// contributions in the other order, or scaling through the 1 kohm as
// `2.3 * 1e-3` rather than `2.3 / 1000.0`, is conforming and would red it.
//
// All three are now 1e-12, which is 4.3e-13 relative on a potential and still
// has full teeth: every wrong answer this fixture exists to reject — 0.5, 1.8
// or 0 volts, and -0.5e-3, -1.8e-3 or 0 amps — is at least 0.5 V / 5e-4 A away,
// i.e. more than 5e8 tolerances.
//
// WHY 2.3 IS THE DISCRIMINATING NUMBER. Under §5.6.8.1's rule — a NEW branch in
// the parent — this design is not merely different, it is illegal: two ideal
// potential sources, 0.5 V and 1.8 V, in parallel across the same node pair, the
// voltage-source loop the clause tells the simulator to check for. So a compiler
// that applies 07's rule here either refuses this file or picks one of 0.5 and
// 1.8 arbitrarily. Neither is 2.3.
//
// THIS FIXTURE PASSES TODAY, and nothing in tests/fixtures/ covers it: the tree
// has no hierarchical contribution to a named branch at all. It is also the file
// that stops a fix for 07 from being implemented as "hierarchy always
// creates a new branch", which would break exactly this clause. Keep 07 and 08
// wired in together — they are the two halves of §5.6.8 and each one is the
// other's guard rail.
//
//! lrm 5.6.8.2
//! lrm 5.6.1.2
//! lrm 5.6.1.3
//! lrm 5.6.1.1
//! bias V(g) = 0.0
//! solve
`include "check.vh"
module a02_hier_named_branch(g);
  inout g;
  electrical g;
  a02_hier_named_branch_child drv(g);
  analog begin
    // §5.6.8.2's own example, path made resolvable by instantiating the child.
    V(drv.br) <+ 1.8;
    I(g) <+ 0.0;
  end
endmodule

module a02_hier_named_branch_child(b);
  inout b;
  electrical b, x;
  branch (x, b) br;
  analog begin
    V(br) <+ 0.5;
    I(x) <+ V(x)/1000.0;
    I(b) <+ 0.0;
    `CHECK("the parent reaches the child's own branch, so the two add", V(br), 2.3, 1e-12);
    `CHECK("and the node it drives follows", V(x), 2.3, 1e-12);
    `CHECK("the load current returns through the branch, against its declared direction", I(br), -2.3e-3, 1e-12);
  end
endmodule
