// §5.6.8.2's second example, and the grammar production behind it — A.8.9 /
// Syntax 5-3:
//
//   hierarchical_unnamed_branch_reference ::=
//       hierarchical_inst_identifier.branch ( branch_terminal [ , branch_terminal ] )
//     | hierarchical_inst_identifier.branch ( < port_identifier > )
//     | hierarchical_inst_identifier.branch ( < hierarchical_port_identifier > )
//
//   // contributes 1.2 volts to the unnamed branch between
//   // nets x and y in top.drv
//   V(top.drv.branch(x,y)) <+ 1.2;
//
// This is the only spelling in the language that reaches a CHILD's existing
// unnamed branch. `V(drv.x, drv.y)` does not — §5.6.8.1 makes that a NEW branch
// in the parent (fixture 07). The two forms are written differently because they
// mean different circuits, and a compiler that has only the first has no way to
// express the second.
//
// THE CIRCUIT. The child owns a 1 kohm conductance between x and y, pins x at
// 3 V, and loads y with 1 kohm to ground. The parent pushes 1 mA into the
// child's OWN (x,y) branch:
//
//     x --[ child: I(x,y) <+ V(x,y)/1k  +  parent: I(drv.branch(x,y)) <+ 1m ]-- y
//    3 V                                                                        |
//                                                                            [ 1k ]
//                                                                              gnd
//
// BY HAND. Same kind of contribution to the same branch, so §5.6.1.2 adds them:
// the branch flow is V(x,y)/1000 + 1e-3. Kirchhoff at y, writing v for V(y):
//
//   (3 - v)/1000 + 1e-3 = v/1000
//        3 - v  + 1     = v
//                   v   = 2.0 V   exactly
//
//   I(x,y) = (3 - 2)/1000 + 1e-3 = 1.0e-3 + 1.0e-3 = 2.0e-3 A
//
// THE PAIR IS THE DISCRIMINATOR. If this statement were (wrongly) treated as
// §5.6.8.1 and made a SEPARATE 1 mA source in the parent, Kirchhoff at y is the
// identical equation — 1 mA arrives at y either way — so V(y) is still 2.0. But
// then the child's own branch carries only (3-2)/1000 = 1.0 mA, half the
// asserted value. So V(y) = 2.0 pins the circuit and I(x,y) = 2.0 mA pins WHICH
// branch the contribution landed on.
//
// OBSERVED TODAY: the file does not parse.
//
//     error[E0208]: expected an identifier: found `branch`
//      --> 09_hierarchical_unnamed_branch_reference.va:...:22
//
// The production is simply absent from the parser; nothing in tests/fixtures/
// references it, so no existing file records the gap.
//
//! lrm 5.6.8.2
//! lrm 5.6.1.2
//! lrm A.8.9
//! bias V(g) = 0.0
//! solve
`include "check.vh"
module a02_hier_unnamed_branch(g);
  inout g;
  electrical g;
  a02_hier_unnamed_branch_child drv(g);
  analog begin
    I(drv.branch(x, y)) <+ 1m;
    I(g) <+ 0.0;
  end
endmodule

module a02_hier_unnamed_branch_child(b);
  inout b;
  electrical b, x, y;
  analog begin
    V(x) <+ 3.0;
    I(x, y) <+ V(x, y)/1000.0;
    I(y) <+ V(y)/1000.0;
    I(b) <+ 0.0;
    `CHECK("the parent's milliamp landed on the child's own branch", I(x, y), 2.0e-3, 1e-12);
    `CHECK("and Kirchhoff at the loaded node gives 2 V", V(y), 2.0, 1e-12);
  end
endmodule
