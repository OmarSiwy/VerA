// §5.4.2.1 Probes:
//
//   "If no value is specified for either the potential or the flow, the branch
//    is a probe. If the flow of the branch appears in an expression anywhere in
//    the module, the branch is a flow probe, otherwise the branch is a potential
//    probe. ... The branch potential of a flow probe is zero (0)."
//
// Figure 5-1 draws that as an ammeter: a flow probe is a SHORT with a current
// meter in it. So reading `I(a,b)` and nothing else is not a passive
// observation — it is a topology statement. It connects a to b.
//
// Nothing in tests/fixtures/ pins this. Every flow-probe fixture there either
// contributes to the branch as well (current_controlled_current.va writes
// `V(sense) <+ 0.0` BY HAND, which is the short the clause says is already
// implied) or forces the flow unknown with `//! sweep`. Both hide the topology.
//
// THE CIRCUIT. A resistive divider cut in half by the probe:
//
//     s --[ 1k ]-- a ---(I probe)--- b --[ 2k ]-- g
//    3.0 V                                       0.0 V
//
// The probe is the ONLY thing joining a to b. Nothing is contributed to the
// branch (a,b); its flow is read into a variable, which by §5.4.2.1 is what
// makes it a flow probe.
//
// BY HAND. With the probe a zero-volt source the network is 1k in series with
// 2k across 3.0 V:
//
//   I   = 3.0 / (1000 + 2000) = 1.0e-3 A exactly
//   V(a) = V(b) = 3.0 - 1.0e-3 * 1000 = 2.0 V exactly
//
// 1 mA and 2.0 V are the asserted values. The branch potential itself is NOT
// asserted, because §5.4.2.1 makes reading both quantities of a probe illegal
// and VerA enforces that (E0423); `V(a) - V(b)` is the same claim written with
// two other branches, each a potential probe of its own, and it is 0.
//
// WHAT AN OPEN CIRCUIT ANSWERS. If the flow probe is left as no connection at
// all — today's behaviour — a floats up to the source at 3.0 V, b sits at the
// reference 0.0 V, their difference is 3.0 instead of 0.0, and the measured
// current is 0 instead of 1 mA. Each of the three assertions separates the two
// topologies on its own.
//
// OBSERVED TODAY: `x[a] = 3.0`, `x[b] = 0.0`, and the testbench prints
// `res[flowZ28aZ2cbZ29] = 0` with NO Jacobian entries — the unknown the probe
// introduces has no defining equation and is stamped into neither node's KCL.
// Same structural defect as 01, in its topological form.
//
//! lrm 5.4.2.1
//! bias V(s) = 3.0
//! bias V(g) = 0.0
//! solve
`include "check.vh"
module a02_flow_probe_short(s, g);
  inout s, g;
  electrical s, g, a, b;
  real i_meas;
  analog begin
    I(s, a) <+ V(s, a)/1000.0;
    I(b, g) <+ V(b, g)/2000.0;

    // The whole of the probe: its flow appears in an expression, nothing is
    // contributed to it. §5.4.2.1 then fixes its potential at zero.
    i_meas = I(a, b);

    `CHECK("a flow probe is a zero-volt source, so it shorts a to b", V(a) - V(b), 0.0, 1e-12);
    `CHECK("and the series divider then sits at 2.0 V", V(a), 2.0, 1e-12);
    `CHECK("the ammeter reads the 1 mA the 3 kohm series string carries", i_meas, 1.0e-3, 1e-12);
  end
endmodule
