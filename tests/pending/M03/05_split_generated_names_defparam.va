// §7.8.5, split case: "In the split case, one or more ports have a given
// discipline at their bottom connection and a common signal of another
// discipline, call it TopDiscipline, at their top connection. One module
// instance is instantiated for each such port. In this case, the instance name
// of the connect module is
//
//     SigName__InstName__PortName
//
// where InstName and PortName are the local instance name of the port and its
// instance respectively."
//
// THAT SENTENCE SWAPS ITS OWN TWO NOUNS — read literally it makes InstName "the
// local instance name of the port" and PortName "[the local instance name of]
// its instance", which is backwards. §7.8.5.1's opening two sentences are what
// settle it, and they are normative rather than illustrative:
//
//     "In the cases of instances of modules and instances of UDPs, port names
//      are well defined. In these cases the port name is the name of the signal
//      at the lower connection of the port."
//
// The lower (formal) connection of a module-instance port is the net declared
// inside the instantiated module, so PortName is the FORMAL PORT NAME. §7.8.4
// supplies the other two: it is the clause that defines "the segment in the
// instantiating module is the upper or actual connection", so SigName is the
// upper-connection signal at that port, and InstName is then the only field
// left — the local instance name.
//
// WITHDRAWN: earlier revisions of this file claimed §7.8.5.1 prints a worked
// example naming the connect module on `and gate_instance(y, a, b)`'s port
// `in1` as `a__gate_instance__in1`. NO SUCH EXAMPLE EXISTS. §7.8.5.1 is the two
// sentences quoted above plus a paragraph and six bullets that assign port
// NAMES (out, in1, in2, source, drain, gate, …) to built-in digital primitives
// and print no instance name at all. `grep -rn gate_instance docs/` matches only
// Annex A grammar nonterminals. The conclusion below is unchanged because it
// never depended on the invented example — §7.8.5.1's real first two sentences
// carry it — but the evidence had to be replaced, not merely re-worded.
//
// The generated-name convention for built-in primitives that §7.8.5.1 actually
// states is NOT claimed by this row at all; it lives with the digital-primitive
// work (see tests/fixtures/ch07_mixed_signal/primitive_generated_ports_unsupported.va),
// and could come back here only once a gate primitive can be instantiated.
//
// HERE both ports carry signal `a`, the instances are `u1` and `u2`, and the
// formal port on `m03_din` is `din`. With `split` the two generated names are
//
//     a__u1__din
//     a__u2__din
//
// and they must be DISTINCT — that is the reason the split naming scheme exists
// at all, and the reason this file defparams only ONE of them. A compiler that
// generated the merged spelling for both, or one name for both ports, cannot
// produce the number below.
//
// DERIVATION. Two split a2d instances. `a__u1__din.rin` is raised to 3000;
// `a__u2__din` keeps the declared default of 1000. Top module: 1 kohm shunt,
// 1 mA source. KCL at `a`:
//
//     V/1000 - 1e-3 + V/3000 + V/1000 = 0
//     V * (3 + 1 + 3)/3000 = 1e-3
//     V * 7/3000 = 1e-3
//     V(a) = 3/7 = 0.42857142857142855 (nearest double)
//
// Separating answers: defparam ignored (both at 1k) -> 1/3 = 0.333...;
// merged instead of split -> 0.5 or 0.666...; nothing inserted -> the defparam
// target does not exist and the file must not compile.
//
//! lrm 7.8.5
//! lrm 7.8.5.1
//! lrm 7.8.3.2
//! lrm 6.3.1
//! solve
//! xfail VerA performs no §7.8 insertion, so neither split-generated name exists
`include "check.vh"

connectmodule m03_a2d(el, cm);
  input el;
  output cm;
  electrical el;
  ddiscrete cm;
  reg cm;
  parameter real rin = 1000.0 from (0.0:inf);
  analog I(el) <+ V(el) / rin;
  initial cm = 1'b0;
endmodule

module m03_din(din);
  input din;
  ddiscrete din;
  // No digital process here: the port is a receiver by its DISCIPLINE alone
  // (§7.8.4 selects on the two connections' disciplines and the port
  // direction). An unread `reg seen` process only made the file stop at E0205
  // before it could reach its own assertion.
endmodule

module m03_top;
  electrical a;

  m03_din u1(a);
  m03_din u2(a);

  // §7.8.5 split: SigName__InstName__PortName. Only u1's bridge is retuned.
  defparam a__u1__din.rin = 3000.0;

  analog begin
    I(a) <+ V(a) / 1000.0;
    I(a) <+ -1.0e-3;
    `CHECK("split generates a__u1__din and a__u2__din; defparam retunes only the first",
           V(a), 0.42857142857142855, 1e-12);
  end
endmodule

connectrules m03_rules;
  connect m03_a2d split;
endconnectrules
