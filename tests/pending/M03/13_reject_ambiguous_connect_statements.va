// §7.8.4, third selection rule: "A connection shall be selected for a port only
// if one of the connections to the port is digital and the other is analog. In
// this case, THE PORT SHALL MATCH ONE (AND ONLY ONE) CONNECT STATEMENT. The
// module named in the connect statement is the one which shall be selected for
// the port."
//
// §7.8 says the same from the other side: "An instance of the connect module
// shall be inserted across any mixed port that matches the rule specified by a
// connect statement."
//
// THE AMBIGUITY HERE IS EXACT, not a near miss. `m03_a2d_fast` and
// `m03_a2d_slow` declare the same port disciplines (`electrical` continuous
// input, `ddiscrete` discrete output) and the same directions, so both connect
// statements match `u1.din` — an input port of discipline `ddiscrete` whose
// upper connection is the electrical signal `a` — by §7.6 EXAMPLE 2's direction
// pair, the `a2d` that "can bridge ... a mixed input port whose upper connection
// is compatible with electrical and whose lower connection is compatible with
// ddiscrete". (Example 1 is the mirror `d2a`; earlier revisions of this file
// cited it by mistake.) Nothing in §7.7.1 or §7.8 breaks the tie:
//
//   - §7.7.2.1's "first match wins with a warning" rule is stated for
//     `connect ... resolveto` DISCIPLINE RESOLUTION ("when more than one
//     specified rule applies to a given scenario a warning message shall be
//     issued by the simulator and the first match would be used"), and §7.7.2.1's
//     last paragraph keeps the two forms apart: "the connect ... resolveto shall
//     not be used as a mechanism to set the disciplines of simulator primitives
//     but used only for discipline resolution". It does not reach §7.8.4's
//     selection step, which uses the stronger "one (and only one)".
//   - §7.7.1's whole purpose — "the connect module specification statement
//     specifies which is to be used in the auto-insertion process" when "there
//     can be multiple connect module declarations of a given (discrete —
//     continuous) discipline pair" — is to make the choice UNIQUE. Two statements
//     asserting the same pair defeat it.
//
// So the design is in error, and which of the two bridges was inserted is not
// something a fixture could assert: the two differ in `rin` on purpose (1 kohm
// versus 4 kohm), which is precisely why silently picking one is not an
// acceptable outcome — the node voltage would depend on source order.
//
// THE CONTRAST THAT MAKES THIS A RULE AND NOT A STYLE POINT is fixture 03, where
// two connect statements naming two different modules coexist legally because
// each matches a DIFFERENT port (an input port and an output port). Multiple
// connect statements are fine; multiple matches for one port are not.
//
// NOTE ON THE EXPECTATION TEXT: as with fixture 12, VerA has no code for this
// check — the `//! reject` substring states the rule and should be replaced with
// the allocated diagnostic code when §7.8.4's selection step exists.
//
//! lrm 7.8.4
//! lrm 7.8
//! lrm 7.7.1
//! lrm 7.7.2.1
//! reject matches more than one connect statement

connectmodule m03_a2d_fast(el, cm);
  input el;
  output cm;
  electrical el;
  ddiscrete cm;
  reg cm;
  parameter real rin = 1000.0 from (0.0:inf);
  analog I(el) <+ V(el) / rin;
  initial cm = 1'b0;
endmodule

connectmodule m03_a2d_slow(el, cm);
  input el;
  output cm;
  electrical el;
  ddiscrete cm;
  reg cm;
  parameter real rin = 4000.0 from (0.0:inf);
  analog I(el) <+ V(el) / rin;
  initial cm = 1'b0;
endmodule

module m03_din(din);
  input din;
  ddiscrete din;
  // No digital process here: the port is a receiver by its DISCIPLINE alone
  // (§7.8.4 selects on the two connections' disciplines and the port
  // direction). An unread `reg seen` process only made the file stop at E0205
  // before it could reach its own assertion.
endmodule

module m03_top;
  electrical a;
  m03_din u1(a);
  analog begin
    I(a) <+ V(a) / 1000.0;
    I(a) <+ -1.0e-3;
  end
endmodule

connectrules m03_rules;
  // Same discipline pair, same directions, two different modules. `u1.din`
  // matches both.
  connect m03_a2d_fast;
  connect m03_a2d_slow;
endconnectrules
