// §7.8: "Automatic insertion of connect modules is performed when signals and
// ports with continuous time domain and discrete time domain disciplines are
// connected together. THE CONNECT MODULE DEFINES THE CONVERSION between these
// different disciplines."
//
// A connect module is the one kind of module that is required to have both a
// discrete and a continuous half and to have BOTH RUN — §7.5: "Connect modules
// are automatically inserted to connect the continuous and discrete disciplines
// (mixed nets) of the design hierarchy together." Everything about insertion
// counts, names and levels is worthless if the inserted instance does not
// actually convert. This fixture asserts the conversion, in both logic states.
//
// THE BRIDGE HAS A REAL DIGITAL PROCESS. `m03_d2a`'s analog contribution does
// not read the port `cm` directly; it reads `lvl`, a `reg` that only the
// bridge's own `always @(cm)` can set, seeded to 1'b0 by an `initial`. So if the
// digital half of the INSERTED instance never runs, `lvl` stays 0 and the bridge
// drives its LOW level whatever the port says — which the first assertion
// catches.
//
// TWO CHAINS, opposite logic states, so neither answer can be produced by a
// stuck bridge:
//
//   chain 1: sel1 = 1'b0 -> m03_inv u1 -> q = 1'b1 -> d2a drives vhigh = 2.0
//   chain 2: sel2 = 1'b1 -> m03_inv u2 -> q = 1'b0 -> d2a drives vlow  = 0.5
//
// `sel1`/`sel2` are ddiscrete at both ends of u1/u2's `d` port, so §7.8.4's
// "rules ... apply only to mixed signals" excludes them and nothing is inserted
// there. Only `q` is mixed: lower connection ddiscrete, upper connection
// electrical, port direction output — §7.6 EXAMPLE 1's direction pair, since
// Example 1's `d2a` is the one that "can bridge ... a mixed output port whose
// upper connection is compatible with discipline electrical and whose lower
// connection is compatible with ddiscrete". Example 2 is the mirror `a2d` and
// does not cover this port; earlier revisions of this file cited it by mistake.
// So one m03_d2a per net (merged, the §7.8.3 default, one port each).
//
// WHY THE LOW LEVEL IS 0.5 V AND NOT 0 V. Nothing in §7.6 or §7.8 fixes a d2a's
// output levels — the conversion is the connect module's own behavior — so this
// fixture chooses them, and an earlier revision chose badly. With a 0 V low
// level the chain-2 want was V(y2) = 0.0, which is ALSO what an uninserted
// design reads: the top's 1 kohm shunt alone pulls an undriven net to 0. That
// assertion could not fail for the reason it was written for. A nonzero VOL
// fixes it — the low state becomes a value only an actually-inserted,
// actually-converting bridge produces. `vlow` is this fixture's own model
// constant, not an LRM number.
//
// DERIVATION. Each top-level net carries the bridge's Thevenin source
//
//     vdrv = vlow + (vsup - vlow) * lvl
//
// behind rout = 1 kohm, loaded by the top module's 1 kohm to ground, so V is
// half of vdrv:
//
//   chain 1: (V - 2.0)/1000 + V/1000 = 0  ->  2V = 2.0  ->  V(y1) = 1.0
//   chain 2: (V - 0.5)/1000 + V/1000 = 0  ->  2V = 0.5  ->  V(y2) = 0.25
//
// Separating answers, and which check catches each:
//   nothing inserted                                  -> 0.0 , 0.0   (both)
//   bridge's digital half never runs (lvl stuck at 0) -> 0.25, 0.25  (y1)
//   inverter's always never runs (q stuck at 0)       -> 0.25, 0.25  (y1)
//   inversion dropped (q follows d)                   -> 0.25, 1.0   (both)
//   lvl reads x rather than the port value            -> 0.25, 0.25  (y1)
//
// y2 cannot by construction separate "the always ran and wrote 0" from "the
// always never ran and the 1'b0 seed stands" — the two leave the same state.
// That discrimination is y1's job, which is why the pair is the fixture and
// neither check is shipped alone.
//
// DELIBERATELY NOT PINNED HERE: the a2d direction at a DC operating point. §7.8's
// own `elect_to_logic` derives its digital state from `@(cross(...))`, and a
// crossing does not occur during a DC solve — what the digital side holds at
// time zero is mixed-signal initialization (M01/M02), not insertion. The a2d
// direction's ANALOG half is pinned by fixtures 01-08 instead.
//
//! lrm 7.8
//! lrm 7.5
//! lrm 7.6
//! lrm 7.8.4
//! solve
//! xfail VerA has no digital kernel in the emitted device, so neither half of a bridge can run
`include "check.vh"

connectmodule m03_d2a(cm, el);
  input cm;
  output el;
  ddiscrete cm;
  electrical el;
  parameter real rout = 1000.0 from (0.0:inf);
  parameter real vsup = 2.0;
  // A nonzero output-low level, so "drives low" and "was never inserted" are
  // different numbers. Not an LRM constant — see the header.
  parameter real vlow = 0.5;
  reg lvl;
  initial lvl = 1'b0;
  always @(cm) lvl = cm;                      // the discrete half
  analog I(el) <+ (V(el) - (vlow + (vsup - vlow) * ((lvl == 1'b1) ? 1.0 : 0.0))) / rout;  // the continuous half
endmodule

module m03_inv(d, q);
  input d;
  output q;
  ddiscrete d, q;
  reg q;
  initial q = 1'b0;
  always @(d) q = ~d;
endmodule

module m03_top;
  electrical y1;
  electrical y2;
  ddiscrete sel1;
  ddiscrete sel2;

  assign sel1 = 1'b0;
  assign sel2 = 1'b1;

  m03_inv u1(sel1, y1);
  m03_inv u2(sel2, y2);

  analog begin
    I(y1) <+ V(y1) / 1000.0;
    I(y2) <+ V(y2) / 1000.0;
    `CHECK("~0 = 1 crosses the inserted d2a: 2.0 V behind 1k into 1k",
           V(y1), 1.0, 1e-12);
    `CHECK("~1 = 0 crosses the same bridge in the other state: vlow=0.5 V behind 1k into 1k",
           V(y2), 0.25, 1e-12);
  end
endmodule

connectrules m03_rules;
  connect m03_d2a;
endconnectrules
