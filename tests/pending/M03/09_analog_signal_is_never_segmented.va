// §7.8.2 signal segmentation, the rule that is absolute: "This segmentation of
// the signal which connects ports is only performed in the case of digital ports
// (i.e., ports with discrete-time domain or digital discipline). For analog (or
// continuous-time domain) disciplines, it is not desirable to segment the signal
// between the ports; I.E., THERE SHALL NEVER BE MORE THAN ONE ANALOG NODE
// REPRESENTING A SIGNAL."
//
// §7.8.4 states it again as the first insertion rule: "A mixed signal is
// represented in the analog domain by a single node, regardless of how its
// analog contexts are distributed hierarchically."
//
// THE DESIGN. The signal at the top is `ddiscrete d`, driven digitally to 1'b1.
// Two children each present an ELECTRICAL input port on it. §7.6 Example 1 makes
// that the d2a direction pair — "can bridge a mixed input port whose upper
// connection is compatible with discipline ddiscrete and whose lower connection
// is compatible with electrical" — so one m03_d2a is selected, and merged (the
// §7.8.3 default) inserts exactly one instance.
//
// The two children load their ports differently on purpose: u1 with 1 kohm, u2
// with 3 kohm. That asymmetry is what makes the single-node rule measurable —
// on one shared node the two loads are in parallel and both probes read the same
// voltage; on two nodes they would read different voltages.
//
// DERIVATION. The d2a is a Thevenin source of vsup*dval behind rout. dval = 1
// (the digital half below), vsup = 2.0, rout = 1000. ONE node carrying the
// bridge output and both children's ports:
//
//     (V - 2)/1000 + V/1000 + V/3000 = 0
//     3(V - 2) + 3V + V = 0                    (x3000)
//     7V = 6
//     V(u1.p) = V(u2.p) = 6/7 = 0.85714285714285710 (nearest double)
//
// IF THE ANALOG SIGNAL WERE SEGMENTED — one bridge and one node per port, the
// shape §7.8.2 forbids — the two probes would read
//
//     u1: (V - 2)/1000 + V/1000 = 0        -> 1.0
//     u2: (V - 2)/1000 + V/3000 = 0        -> 1.5
//
// so both the common value and the equality are assertions, and a wrong topology
// misses on both probes at once.
//
// THE PROBES ARE HIERARCHICAL, §6.7.1: "potential and flow access for named and
// unnamed branches (including port branches) can be done hierarchically". They
// are the only way to see the far end of an inserted bridge from source.
//
// DELIBERATELY NOT PINNED HERE: how many instances `split` inserts when the
// ports are analog. §7.8.3.2 Example 3 says only that "there is no segmentation
// of the signal between these ports, since the ports have discipline electrical",
// which constrains the NODE COUNT and leaves the INSTANCE COUNT unstated. This
// file therefore uses merged, where §7.8.4 fixes the instance count at one.
//
//! lrm 7.8.2
//! lrm 7.8.4
//! lrm 7.6
//! lrm 6.7.1
//! solve
//! xfail VerA performs no §7.8 insertion and has no digital domain to drive a ddiscrete signal
`include "check.vh"

connectmodule m03_d2a(cm, el);
  input cm;
  output el;
  ddiscrete cm;
  electrical el;
  parameter real rout = 1000.0 from (0.0:inf);
  parameter real vsup = 2.0;
  analog I(el) <+ (V(el) - vsup * ((cm == 1'b1) ? 1.0 : 0.0)) / rout;
endmodule

module m03_aload(p);
  input p;
  electrical p;
  parameter real rl = 1000.0 from (0.0:inf);
  analog I(p) <+ V(p) / rl;
endmodule

module m03_top;
  ddiscrete d;
  assign d = 1'b1;

  m03_aload            u1(d);
  m03_aload #(.rl(3000.0)) u2(d);

  analog begin
    `CHECK("u1's port sits on the single analog node of the signal (1k || 3k against 2V/1k)",
           V(u1.p), 0.85714285714285710, 1e-12);
    `CHECK("u2's port sits on that SAME node, so it reads the identical voltage",
           V(u2.p), 0.85714285714285710, 1e-12);
  end
endmodule

connectrules m03_rules;
  connect m03_d2a;
endconnectrules
