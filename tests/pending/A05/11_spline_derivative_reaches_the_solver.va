// §9.21 lookup ON AN UNKNOWN, differentiated. §9.21's own example contributes
// `$table_model(0.0, V(a,b), "sample.dat")` to a branch, so the lookup is a
// function OF a solution variable and its derivative is what the simulator
// stamps into the Jacobian. §4.5.6's `ddx` is the only construct that makes
// that derivative observable from inside the model, so it is the oracle here:
// "The operator returns the partial derivative of its first argument with
// respect to the unknown indicated by the second argument, holding all other
// unknowns fixed and evaluated at the current operating point."
//
// CITATION CORRECTED AFTER REVIEW. This file used to cite §4.5.14, which is
// *Constant versus dynamic arguments* and says nothing about `ddx`. §4.5.6 is
// the clause, and it is strictly better evidence, because it ends with the
// LRM's own sign-flip example —
//
//     vin      = V(pin,nin);
//     one      = ddx(vin, V(pin));
//     minusone = ddx(vin, V(nin));
//
// "The names of the variables indicate the values of the partial derivatives:
// +1, -1, or 0." That is the precedent the -1.125 want below rests on, and it
// is in §4.5.6, not §4.5.14.
//
// The derivative is a PROPERTY OF THE SELECTED SCHEME, and the schemes below
// were chosen so that two of them agree on the VALUE at the probe point and
// disagree on the slope — a tool that computed the spline value but handed the
// solver a secant or a zero would pass a value-only fixture and fail this one.
//
// DATA:   x = 0, 1, 2      f = 0, 1, 0        bias V(p,n) = 0.5
//
// "3LL" natural cubic (derivation in 01_cubic_spline_natural_ends.va):
//       S(x)  = -0.5x^3 + 1.5x          S(0.5)  = 0.6875
//       S'(x) = -1.5x^2 + 1.5           S'(0.5) = -0.375 + 1.5 = 1.125
//
// "3CC" clamped cubic (derivation in 02_cubic_spline_constant_ends.va):
//       S(x)  = (1-x)^3 - x^3 - (1-x) + 2x      S(0.5)  = 0.5
//       S'(x) = 3 - 3(1-x)^2 - 3x^2             S'(0.5) = 3 - 0.75 - 0.75 = 1.5
//
// "1LL" linear: the segment through (0,0) and (1,1), so the value is 0.5 —
//       the SAME as the clamped cubic at this point — and the slope is 1.0.
//
// "D" closest point: §9.21.4, "the closest point lookup algorithm returns the
//       closest point"; x = 0.5 is equidistant from the samples at 0 and 1 and
//       "when the lookup ordinate is equidistant from two bracketing samples
//       the function snaps away from zero", so the value is f(1) = 1. A lookup
//       is piecewise CONSTANT, so its derivative with respect to the unknown is
//       exactly 0 — the residual contribution is a pure current source here.
//
//! lrm 4.5.6
//! lrm 9.21
//! lrm 9.21.4
//! bias V(p) = 0.5
//! bias V(n) = 0
`include "check.vh"
module a05_spline_derivative_reaches_the_solver(p, n);
  inout p, n; electrical p, n;
  real xs[0:2], fs[0:2];
  analog begin
    xs[0] = 0.0; fs[0] = 0.0;
    xs[1] = 1.0; fs[1] = 1.0;
    xs[2] = 2.0; fs[2] = 0.0;
    `CHECK("the bias the wants below assume", V(p, n), 0.5, 0.0);
    `CHECK("natural cubic value at the probe point",
           $table_model(V(p, n), xs, fs, "3LL"), 0.6875, 1e-12);
    `CHECK("d/dV of the natural cubic lookup is S'(0.5) = 1.125",
           ddx($table_model(V(p, n), xs, fs, "3LL"), V(p)), 1.125, 1e-9);
    `CHECK("clamped cubic has the SAME value here",
           $table_model(V(p, n), xs, fs, "3CC"), 0.5, 1e-12);
    `CHECK("...and a different slope: S'(0.5) = 1.5",
           ddx($table_model(V(p, n), xs, fs, "3CC"), V(p)), 1.5, 1e-9);
    `CHECK("linear lookup has that value too, with slope 1",
           ddx($table_model(V(p, n), xs, fs, "1LL"), V(p)), 1.0, 1e-12);
    `CHECK("the branch is p MINUS n, so the partial wrt n flips sign",
           ddx($table_model(V(p, n), xs, fs, "3LL"), V(n)), -1.125, 1e-9);
    `CHECKX("closest-point lookup at a tie snaps away from zero",
            $table_model(V(p, n), xs, fs, "D"), 1.0);
    `CHECK("a closest-point lookup is piecewise constant: zero slope",
           ddx($table_model(V(p, n), xs, fs, "D"), V(p)), 0.0, 0.0);
    I(p, n) <+ $table_model(V(p, n), xs, fs, "3LL");
  end
endmodule
