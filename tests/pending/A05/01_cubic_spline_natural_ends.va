// §9.21.4 CUBIC SPLINE, both ends natural. Table 9-30 gives `3` as "Cubic
// spline interpolation"; §9.21.4 fixes the end conditions from the
// EXTRAPOLATION characters:
//
//   "When formulating the cubic spline equations the desired derivative of the
//    interpolation function at both end points must be specified in order to
//    provide the complete set of constraints for the cubic spline equations. It
//    is convenient then that the table model function specifies end point
//    extrapolation behavior. If the user selects linear extrapolation this
//    leads to a natural spline."
//
// So "3LL" is the natural cubic spline: S''(x0) = S''(xn) = 0.
//
// DATA (1-D, the whole set is one isoline):
//
//     x  = 0, 1, 2          f = 0, 1, 0
//
// HAND DERIVATION. With M_i = S''(x_i), h = 1, the standard moment equation at
// the single interior knot is
//
//     h*M0 + 2(h+h)*M1 + h*M2 = 6[(f2-f1)/h - (f1-f0)/h]
//
// and the natural end conditions are M0 = M2 = 0, so
//
//     4*M1 = 6[(0-1) - (1-0)] = -12   =>   M1 = -3.
//
// On [0,1] the segment is
//
//     S(x) = M0(1-x)^3/6 + M1 x^3/6 + (f0 - M0/6)(1-x) + (f1 - M1/6)x
//          = -0.5 x^3 + 1.5 x
//
// (check: S(0)=0, S(1)=1, S''(0)=0, S''(1)=-3=M1). The data is symmetric about
// x=1, so on [1,2] the segment is the mirror, S(x) = -0.5(2-x)^3 + 1.5(2-x).
//
//     S(0.25) = -0.5(0.015625) + 0.375   = 0.3671875
//     S(0.5)  = -0.0625        + 0.75    = 0.6875
//     S(1)    =  the knot                = 1
//     S(1.5)  = mirror of S(0.5)         = 0.6875
//
// EXTRAPOLATION. Table 9-31: linear extrapolation "extends linearly to the
// requested point from the endpoint using a slope consistent with the selected
// interpolation method" — the slope is the SPLINE's end slope, not the slope of
// the last pair of samples:
//
//     S'(x) = -1.5x^2 + 1.5        S'(0) = 1.5      S'(2) = -1.5
//     f(-1) = 0 + 1.5*(-1) = -1.5      f(3) = 0 + (-1.5)(1) = -1.5
//
// A tool that extrapolated off the last SAMPLE pair instead would report
// f(-1) = -1 and f(3) = +1, so this pair of wants discriminates.
//
// Every want above is a dyadic rational, but the tridiagonal solve for M is
// real division, so the tolerance is 1e-12 rather than exact equality — still
// twelve orders tighter than the gap to linear interpolation (0.5 at x=0.5).
//
//! lrm 9.21.2
//! lrm 9.21.4
`include "check.vh"
module a05_cubic_spline_natural_ends(p, n);
  inout p, n; electrical p, n;
  real xs[0:2], fs[0:2];
  analog begin
    xs[0] = 0.0; fs[0] = 0.0;
    xs[1] = 1.0; fs[1] = 1.0;
    xs[2] = 2.0; fs[2] = 0.0;
    `CHECK("natural cubic at x=0.25: -0.5(0.25)^3 + 1.5(0.25)",
           $table_model(0.25, xs, fs, "3LL"), 0.3671875, 1e-12);
    `CHECK("natural cubic at x=0.5: -0.5(0.125) + 0.75",
           $table_model(0.5, xs, fs, "3LL"), 0.6875, 1e-12);
    `CHECK("a spline interpolates: the knot value is returned unchanged",
           $table_model(1.0, xs, fs, "3LL"), 1.0, 1e-12);
    `CHECK("the mirrored segment at x=1.5 by symmetry of the sample set",
           $table_model(1.5, xs, fs, "3LL"), 0.6875, 1e-12);
    `CHECK("linear extrapolation below x0 uses the SPLINE end slope S'(0)=1.5",
           $table_model(-1.0, xs, fs, "3LL"), -1.5, 1e-12);
    `CHECK("linear extrapolation above xn uses the SPLINE end slope S'(2)=-1.5",
           $table_model(3.0, xs, fs, "3LL"), -1.5, 1e-12);
    I(p, n) <+ V(p, n);
  end
endmodule
