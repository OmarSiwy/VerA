// §9.21.2 + §9.21.4: the TWO end conditions of a cubic spline are chosen
// INDEPENDENTLY, one per end, by the two extrapolation characters.
//
//   §9.21.2: "When two extrapolation method characters are given, the first
//    character specifies the extrapolation method used for the end with the
//    lower coordinate value, and the second character is used for the end with
//    the higher coordinate value."
//   §9.21.4: linear extrapolation "leads to a natural spline" (S'' = 0 at that
//    end); "If constant extrapolation is specified the end point derivative is
//    set to zero" (S' = 0 at that end).
//
// Two samples is the §9.21 minimum ("at least two points per dimension"), and
// with two samples the spline is ONE cubic fixed by four constraints — two
// interpolation conditions and the two end conditions — so the algebra is a
// four-line hand solve with no linear system at all. That makes this the
// sharpest test of the per-end rule: swapping the two control characters must
// swap the answer.
//
// DATA:   x = 0, 1      f = 0, 1      S(x) = a + bx + cx^2 + dx^3
//
// "3CL"  low end constant  -> S'(0) = 0;  high end linear -> S''(1) = 0.
//     a = 0 (S(0)=0);  b = 0 (S'(0)=0);  S''(1) = 2c + 6d = 0 -> c = -3d;
//     S(1) = c + d = -2d = 1 -> d = -0.5, c = 1.5.
//     S(x) = 1.5x^2 - 0.5x^3
//     S(0.25) = 0.09375 - 0.0078125 = 0.0859375
//     S(0.5)  = 0.375   - 0.0625    = 0.3125
//     S'(1) = 3 - 1.5 = 1.5, so the LINEAR high extrapolation gives
//     f(1.5) = 1 + 1.5*0.5 = 1.75
//     the CONSTANT low extrapolation gives f(-1) = f(0) = 0.
//
// "3LC"  low end linear -> S''(0) = 0;  high end constant -> S'(1) = 0.
//     a = 0;  c = 0 (S''(0)=0);  S'(1) = b + 3d = 0 -> b = -3d;
//     S(1) = b + d = -2d = 1 -> d = -0.5, b = 1.5.
//     S(x) = 1.5x - 0.5x^3
//     S(0.5)  = 0.75 - 0.0625 = 0.6875
//     S'(0) = 1.5, so the LINEAR low extrapolation gives f(-0.5) = -0.75
//     the CONSTANT high extrapolation gives f(2) = f(1) = 1.
//
// 0.3125 vs 0.6875 at the same abscissa on the same samples is the assertion
// that the control string is read per END and not per dimension; linear
// interpolation would return 0.5 for both.
//
//! lrm 9.21.2
//! lrm 9.21.4
`include "check.vh"
module a05_cubic_spline_mixed_ends(p, n);
  inout p, n; electrical p, n;
  real xs[0:1], fs[0:1];
  analog begin
    xs[0] = 0.0; fs[0] = 0.0;
    xs[1] = 1.0; fs[1] = 1.0;
    `CHECK("3CL at x=0.25: S = 1.5x^2 - 0.5x^3",
           $table_model(0.25, xs, fs, "3CL"), 0.0859375, 1e-12);
    `CHECK("3CL at x=0.5: zero slope at the low end pulls the curve down",
           $table_model(0.5, xs, fs, "3CL"), 0.3125, 1e-12);
    `CHECK("3CL high end is linear with the spline slope S'(1)=1.5",
           $table_model(1.5, xs, fs, "3CL"), 1.75, 1e-12);
    `CHECK("3CL low end is constant: the endpoint value",
           $table_model(-1.0, xs, fs, "3CL"), 0.0, 1e-12);
    `CHECK("3LC at x=0.5: the mirrored condition lifts the curve",
           $table_model(0.5, xs, fs, "3LC"), 0.6875, 1e-12);
    `CHECK("3LC low end is linear with the spline slope S'(0)=1.5",
           $table_model(-0.5, xs, fs, "3LC"), -0.75, 1e-12);
    `CHECK("3LC high end is constant: the endpoint value",
           $table_model(2.0, xs, fs, "3LC"), 1.0, 1e-12);
    I(p, n) <+ V(p, n);
  end
endmodule
