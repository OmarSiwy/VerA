// §9.21.4 CUBIC SPLINE with CONSTANT extrapolation at both ends. The clause
// makes the end condition follow the extrapolation character:
//
//   "If constant extrapolation is specified the end point derivative is set to
//    zero thus avoiding a discontinuity in the first order derivative at that
//    end point."
//
// So "3CC" is the CLAMPED cubic spline with S'(x0) = S'(xn) = 0 — a different
// interpolant from 01_cubic_spline_natural_ends.va over the SAME samples, which
// is the whole point: the extrapolation control changes the interior values.
//
// DATA (1-D):   x = 0, 1, 2      f = 0, 1, 0
//
// HAND DERIVATION. h = 1, M_i = S''(x_i). Clamped end equations plus the one
// interior moment equation:
//
//     2M0 +  M1        = 6[(f1-f0)/h - S'(x0)] = 6[1 - 0]     =  6
//      M0 + 4M1 +  M2  = 6[(f2-f1) - (f1-f0)]  = 6[-1 - 1]    = -12
//            M1 + 2M2  = 6[S'(xn) - (f2-f1)/h] = 6[0 - (-1)]  =  6
//
// By the symmetry of the data M0 = M2; then 2M0 + 4M1 = -12 and 2M0 + M1 = 6
// give M1 = -6 and M0 = M2 = 6.
//
// On [0,1]:
//
//     S(x) = 6(1-x)^3/6 - 6x^3/6 + (0 - 6/6)(1-x) + (1 + 6/6)x
//          = (1-x)^3 - x^3 - (1-x) + 2x
//
// check: S(0) = 1 - 0 - 1 + 0 = 0, S(1) = 0 - 1 - 0 + 2 = 1,
//        S'(x) = 3 - 3(1-x)^2 - 3x^2, S'(0) = 0 as the clamp demands.
//
//     S(0.25) = 0.421875 - 0.015625 - 0.75 + 0.5  = 0.15625
//     S(0.5)  = 0.125    - 0.125    - 0.5  + 1.0  = 0.5
//     S(0.75) = 0.015625 - 0.421875 - 0.25 + 1.5  = 0.84375
//
// S(0.5) = 0.5 coincides with the linear answer (the data is symmetric about
// x=1 and 0.5 is the midpoint of the first interval), which is why 0.25 and
// 0.75 are checked too: linear interpolation would give 0.25 and 0.75 there,
// nowhere near 0.15625 and 0.84375.
//
// EXTRAPOLATION. Table 9-31: "The constant extrapolation method returns the
// table endpoint value" — f(-1) and f(3) are the endpoint samples, both 0.
//
//! lrm 9.21.2
//! lrm 9.21.4
`include "check.vh"
module a05_cubic_spline_constant_ends(p, n);
  inout p, n; electrical p, n;
  real xs[0:2], fs[0:2];
  analog begin
    xs[0] = 0.0; fs[0] = 0.0;
    xs[1] = 1.0; fs[1] = 1.0;
    xs[2] = 2.0; fs[2] = 0.0;
    `CHECK("clamped cubic at x=0.25 (S'(0)=0 forced by the `C` low end)",
           $table_model(0.25, xs, fs, "3CC"), 0.15625, 1e-12);
    `CHECK("clamped cubic at the interval midpoint",
           $table_model(0.5, xs, fs, "3CC"), 0.5, 1e-12);
    `CHECK("clamped cubic at x=0.75",
           $table_model(0.75, xs, fs, "3CC"), 0.84375, 1e-12);
    `CHECK("constant extrapolation returns the table endpoint value, low end",
           $table_model(-1.0, xs, fs, "3CC"), 0.0, 1e-12);
    `CHECK("constant extrapolation returns the table endpoint value, high end",
           $table_model(3.0, xs, fs, "3CC"), 0.0, 1e-12);
    I(p, n) <+ V(p, n);
  end
endmodule
