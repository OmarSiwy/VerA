// §9.21.1 FILE data source with more than one dependent column, plus the
// dependent selector that picks between them.
//
//   "A table of M dependent variables of dimension N are laid out in N+M
//    columns in the file, with the independent variables appearing in the first
//    N columns followed by the dependent variables in the remaining M columns."
//   "The file may contain multiple dependent variables, all sharing the same
//    set of isoline samples."
//
// Table 9-32, first row: with the control string omitted, "Dimensionality of
// the data is assumed to be N. Column N+1 is taken as the dependent." Third
// row: a selector of 1 "is the default behavior when there are multiple
// dependent variables in the file and there is no dependent variable selector
// specified in the control string."
//
// DATA — a05_two_dependents.tbl, columns  y  x  f1  f2  with
//
//     f1(y,x) = x + y        f2(y,x) = 2x - y
//
// on the two isolines y = 0 and y = 1, x sampled at 0, 1, 2. Both dependents
// are AFFINE in (y,x), so the specified linear scheme reproduces them exactly
// and every want below is an evaluation of the closed form, not a recorded
// number:
//
//     at (y, x) = (0.5, 1.5):   f1 = 1.5 + 0.5 = 2.0
//                               f2 = 3.0 - 0.5 = 2.5
//
// The two dependents differ at that point (2.0 vs 2.5), which is what makes the
// selector observable; a tool that ignored `;2` and always took column N+1
// would report 2.0 for the second want.
//
// The file also exercises §9.21.1's text rules — leading spaces, comment lines
// beginning with #, and blank lines between the isolines — which must all be
// skipped rather than parsed as samples.
//
// THE `";2"` WANT AND `06_ignored_column_and_selector.va` (corrected after
// review). 06 derives the dependent column from Table 9-32 as "number of
// sub-strings + selector". Applied blind to the `";2"` call below — which has
// NO sub-strings — that arithmetic gives column 0 + 2 = 2, the inner
// independent, and an implementer who took 06's sentence as universal would
// break this file. The two arms are both in Table 9-32 and 06's header now
// spells them out: when the `interp_control` half of Syntax 9-16's
// `"[interp_control[;dependent_selector]]"` is written, one sub-string is spent
// per leading column; when it is empty, Table 9-32's first row applies and the
// dimensionality N is taken from the number of `table_inputs`. Here N = 2 from
// the two inputs, so `";2"` is column 2 + 2 = 4 = f2 = 2.5. Nothing in this
// file's wants changed; the rule 06 states did.
//
// THIS FILE PASSES AT HEAD, 5 of 5 (see SPEC.md). It is kept because its wants
// are not vacuous — a tool that ignored the selector answers 2.0 twice — but it
// applies no pressure on the §9.21 gap and must not be counted as if it did.
//
//! lrm 9.21.1
//! lrm 9.21.2
//! lrm 9.21.3
`include "check.vh"
module a05_file_multiple_dependents(p, n);
  inout p, n; electrical p, n;
  analog begin
    `CHECKX("control string omitted: column N+1 = f1 = x + y",
            $table_model(0.5, 1.5, "a05_two_dependents.tbl"), 2.0);
    `CHECKX("explicit selector 1 names the same column",
            $table_model(0.5, 1.5, "a05_two_dependents.tbl", "1LL,1LL;1"), 2.0);
    `CHECKX("selector 2 names the second dependent, f2 = 2x - y",
            $table_model(0.5, 1.5, "a05_two_dependents.tbl", "1LL,1LL;2"), 2.5);
    `CHECKX("a bare selector with a null interpolation control still defaults to linear",
            $table_model(0.5, 1.5, "a05_two_dependents.tbl", ";2"), 2.5);
    `CHECKX("a sample point is returned exactly",
            $table_model(1.0, 2.0, "a05_two_dependents.tbl", "1LL,1LL;2"), 3.0);
    I(p, n) <+ V(p, n);
  end
endmodule
