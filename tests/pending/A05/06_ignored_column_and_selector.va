// §9.21.2 Table 9-30 character `I` — "Ignore this input column" — and the
// column arithmetic it forces on the dependent selector.
//
// §9.21.1: "A column in the data source may also be marked as ignore. These and
// all interpolation control settings are provided via the interpolation control
// string."
//
// THE COLUMN RULE, read straight off Table 9-32's own two examples:
//
//   "I,1CC,1CC;3"  "Ignore column 1, linear interpolation and constant
//                   extrapolation in all dimensions, interpolation applies to
//                   dependent variable 3. There are at least 6 column[s] in the
//                   data file."
//   "3,D,I,1;3"    "... ignore column 3 ... Interpolate dependent variable 3
//                   (column 7). This file has at least 7 columns."
//
// Both arithmetics agree: a control sub-string is spent on a COLUMN whether or
// not that column is a dimension, so
//
//     leading columns consumed   = number of sub-strings
//     dependent column (1-based) = leading columns consumed + selector
//     number of lookup inputs    = number of NON-`I` sub-strings
//
// 3 sub-strings + selector 3 = column 6, and 4 sub-strings + selector 3 =
// column 7, exactly as the table states. A tool that instead counted only the
// dimensions would land one column early per ignored column — which is the
// failure this fixture is built to catch.
//
// THE RULE IS SCOPED TO A NON-NULL `interp_control` (corrected after review).
// Syntax 9-16 makes the control string `"[interp_control[;dependent_selector]]"`
// — both halves optional — and when the `interp_control` half is EMPTY there
// are no sub-strings to count, so "leading columns consumed" cannot come from
// them. Table 9-32's first row supplies that case instead: with the control
// string a null string or omitted, "Dimensionality of the data is assumed to be
// N. Column N+1 is taken as the dependent", i.e. N is read off the number of
// `table_inputs` in the call. So:
//
//     leading columns consumed = (number of sub-strings)  if any are written
//                              = N, the number of table inputs, if none are
//
// That is why `07_file_multiple_dependents.va` gets 2.5 from `";2"` on a 2-D
// call: no sub-strings, so N = 2 from the two inputs, and the dependent is
// column 2 + 2 = 4. Reading the count-the-sub-strings form above as universal
// would make that call land on column 3 and answer 2.0, which is the exact
// contradiction between these two files that the review caught. There is one
// rule and it has two arms, both of them written in Table 9-32.
//
// PART 1, 4 columns, ignore first.  columns: junk | x | f1 | f2
//
//     junk =  5, -3,  9      deliberately unsorted and non-monotonic, so a tool
//                            that mistook it for an independent variable would
//                            re-sort the rows and answer something else
//     x    =  0,  1,  2
//     f1   =  0, 10, 20      f2 = 0, 100, 200
//
//   "I,1;1" -> 2 sub-strings + 1 = column 3 = f1; linear at x=1.5 is halfway
//              between 10 and 20 -> 15
//   "I,1;2" -> 2 sub-strings + 2 = column 4 = f2 -> 150
//   "I,1"   -> no selector, so Table 9-32's default "dependent variable 1",
//              i.e. column 3 again -> 15
//
// PART 2, the ignored column in the MIDDLE (the shape of "3,D,I,1;3").
// columns: y | junk | x | f, holding f(y,x) = 2y + x on the 2x2 corner set:
//
//     y = 0,0,1,1    junk = 7,-2,4,9    x = 0,1,0,1    f = 0,1,2,3
//
//   "1,I,1;1" -> 3 sub-strings + 1 = column 4 = f, two dimensions (y outer,
//                x inner), and the affine f is reproduced exactly:
//                f(0.5, 0.5) = 1 + 0.5 = 1.5
//
// Every value here is a dyadic rational reached by one linear interpolation, so
// the comparisons are exact.
//
//! lrm 9.21.1
//! lrm 9.21.2
//! lrm 9.21.3
`include "check.vh"
module a05_ignored_column_and_selector(p, n);
  inout p, n; electrical p, n;
  real junk[0:2], xs[0:2], f1[0:2], f2[0:2];
  real yy[0:3], mid[0:3], xx[0:3], ff[0:3];
  analog begin
    junk[0] =  5.0; xs[0] = 0.0; f1[0] =  0.0; f2[0] =   0.0;
    junk[1] = -3.0; xs[1] = 1.0; f1[1] = 10.0; f2[1] = 100.0;
    junk[2] =  9.0; xs[2] = 2.0; f1[2] = 20.0; f2[2] = 200.0;
    `CHECKX("`I` drops column 1; selector 1 is column 3",
            $table_model(1.5, junk, xs, f1, f2, "I,1;1"), 15.0);
    `CHECKX("selector 2 is column 4 — the ignored column still consumed one",
            $table_model(1.5, junk, xs, f1, f2, "I,1;2"), 150.0);
    `CHECKX("no selector defaults to dependent variable 1, i.e. column 3",
            $table_model(1.5, junk, xs, f1, f2, "I,1"), 15.0);
    yy[0]=0.0; mid[0]= 7.0; xx[0]=0.0; ff[0]=0.0;
    yy[1]=0.0; mid[1]=-2.0; xx[1]=1.0; ff[1]=1.0;
    yy[2]=1.0; mid[2]= 4.0; xx[2]=0.0; ff[2]=2.0;
    yy[3]=1.0; mid[3]= 9.0; xx[3]=1.0; ff[3]=3.0;
    `CHECKX("an ignored column between two dimensions: f(0.5,0.5) = 2y + x",
            $table_model(0.5, 0.5, yy, mid, xx, ff, "1,I,1;1"), 1.5);
    I(p, n) <+ V(p, n);
  end
endmodule
