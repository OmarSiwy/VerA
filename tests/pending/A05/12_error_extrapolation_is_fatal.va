// §9.21.2 Table 9-31 `E`, the OTHER half of 10_error_extrapolation_inside_is
// _legal.va: a lookup that really is beyond the interpolation region.
//
//   "With this method, an extrapolation error is reported if the $table_model
//    function is requested to evaluate a point beyond the interpolation
//    region."
//   "Error extrapolation results in a FATAL error being raised."
//
// Fatal, not a returned sentinel and not a compile-time refusal: the point that
// triggers it is a runtime value. So the oracle is the same one
// tests/fixtures/ch09_system_tasks/173_fatal_terminates.va uses — a two-point
// sweep where the first point is legal and asserts a value, and the second
// point must never print its assertion because the run is already over.
//
// DATA:   x = 1, 3     f = 2, 6      control "1EE"
//
//   point 0, V(p,n) = 2.0: inside the region [1,3]. Linear interpolation:
//       2 + (2-1)/(3-1) * (6-2) = 4.0, and `ok=1` prints.
//   point 1, V(p,n) = 5.0: beyond the high end, whose extrapolation character
//       is `E`. The run terminates with a fatal error and a nonzero status,
//       which `//! exit 1` checks (VerA floors a fatal status at 1 so it can
//       never be mistaken for a clean exit).
//
// WITHOUT the termination the second point extrapolates linearly to
// 2 + (5-1)/2 * 4 = 10, printing `got=10 want=4 ok=0` — so this fixture fails
// loudly in both directions rather than only through the exit code.
//
//! lrm 9.21.2
//! exit 1
//! sweep V(p) = 2.0, 5.0
`include "check.vh"
module a05_error_extrapolation_is_fatal(p, n);
  inout p, n; electrical p, n;
  real xs[0:1], fs[0:1], f;
  analog begin
    xs[0] = 1.0; fs[0] = 2.0;
    xs[1] = 3.0; fs[1] = 6.0;
    f = $table_model(V(p, n), xs, fs, "1EE");
    `CHECKX("printed at the first point only: the second is beyond the region and is fatal",
            f, 4.0);
    I(p, n) <+ V(p, n) + f;
  end
endmodule
