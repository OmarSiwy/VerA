// §9.21.1: "The state of the data source is captured on the FIRST CALL to the
// table model function. Any change after this point is ignored."
//
// The rule is about a CALL, not about a compilation. A $table_model site that
// is never executed never makes a first call, so it never captures anything —
// and a data source that is only ever named by such a site is never read. This
// is already the settled reading for the ARRAY form (an unexecuted site must
// not capture a mutable array; see tests/fixtures/ch09_system_tasks/
// 187_table_snapshot_function.va), and nothing in §9.21 gives the FILE form a
// different lifetime: `table_data_source ::= file_name | table_model_array`
// is one production with one capture rule.
//
// WHAT THIS FIXTURE PINS
//
//   1. The guarded call below names "a05_never_read.tbl", which DOES NOT EXIST
//      in this directory. Its guard `V(p,n) > 100` is false at the fixture's
//      operating point, so the site never runs, so the absent file is never a
//      diagnostic. A compiler that reads the data source while lowering reports
//      a missing file here and fails to produce a device at all.
//
//   2. `dead` therefore keeps the value assigned to it before the branch, -1.0,
//      and that literal is the assertion that the branch did not run.
//
//   3. The second site's guard IS true, so it loads a05_two_dependents.tbl at
//      that first executed call and returns its value. The file's columns are
//      y, x, f1 = x + y, f2 = 2x - y (see the file's own header), the bias
//      fixes V(p,n) = 1.5, and the control string is omitted, so Table 9-32's
//      first row applies — linear interpolation, column N+1 taken as the
//      dependent:
//
//          f1(y = 0.5, x = 1.5) = 1.5 + 0.5 = 2.0
//
//      f1 is affine, so the linear scheme is exact and the want is a closed
//      form, not a recorded number.
//
//   4. The same site evaluated again at the same point returns the same value:
//      capture-on-first-call is not capture-per-call.
//
//   5. AND NOT ONLY FOR A MISSING FILE (added after review). The review's
//      objection to the earlier revision of this file was fair as far as it
//      went: points 1-4 are one incident of the rule plus two already-green
//      values, and "no diagnostic was emitted" is what remains once the
//      diagnostic is gone. The claim is still a real one — HEAD refuses this
//      whole model today, so the fixture is red for its own clause's reason —
//      but a rule deserves more than one incident, so there is now a SECOND
//      never-executed site, failing for an unrelated reason:
//
//          xs = 0, 1, 1      fs = 0, 10, 99
//
//      two points sharing an abscissa with different dependents, which §9.21
//      makes "an error" and which 13_duplicate_points.va requires at the call.
//      Here there is no call, so there is no data set to be in error: §9.21's
//      conditions are stated about "the data set", and §9.21.1 says the data
//      set comes into existence when "the state of the data source is captured
//      on the first call". No first call, no capture, no data set, no error.
//      An implementation that validated table contents at elaboration passes
//      point 1 (it only reads files eagerly) and still fails this one.
//
//      What this fixture cannot have is a positive runtime witness, because by
//      construction the sites it is about produce no value. That is disclosed
//      in SPEC.md rather than papered over. The array-snapshot witness that
//      would have been the obvious candidate belongs to a DIFFERENT rule and
//      already has a home: tests/fixtures/ch09_system_tasks/
//      187_table_snapshot_function.va pins "Any change after this point is
//      ignored" per call site, including the case of a site whose first call is
//      skipped — the mirror image of this file, from inside a function.
//
//! lrm 9.21
//! lrm 9.21.1
//! bias V(p) = 1.5
//! bias V(n) = 0
`include "check.vh"
module a05_file_loaded_on_first_executed_call(p, n);
  inout p, n; electrical p, n;
  real dead, live, again;
  real xs[0:2], fs[0:2], rotten;
  analog begin
    dead = -1.0;
    live = -1.0;
    again = -1.0;
    rotten = -1.0;
    // Never taken: V(p,n) is 1.5. The named file does not exist, and must not
    // be looked for until this site actually executes.
    if (V(p, n) > 100.0)
      dead = $table_model(V(p, n), "a05_never_read.tbl");
    `CHECKX("an unexecuted $table_model site reads nothing and returns nothing",
            dead, -1.0);
    // Taken: the load happens here, on the first executed call.
    if (V(p, n) > 1.0) begin
      live = $table_model(0.5, V(p, n), "a05_two_dependents.tbl");
      again = $table_model(0.5, V(p, n), "a05_two_dependents.tbl");
    end
    `CHECKX("the file is loaded at the first executed call: f1(0.5,1.5) = 2.0",
            live, 2.0);
    `CHECKX("a second evaluation of the same site returns the same value",
            again, 2.0);
    // Second never-executed site, failing for a different reason: the array
    // holds two points with the same abscissa and different dependents, which
    // 13_duplicate_points.va requires to be an error AT THE CALL. This site
    // makes no call, so it is not an error here.
    xs[0] = 0.0; fs[0] =  0.0;
    xs[1] = 1.0; fs[1] = 10.0;
    xs[2] = 1.0; fs[2] = 99.0;
    if (V(p, n) > 100.0)
      rotten = $table_model(0.5, xs, fs);
    `CHECKX("an unexecuted site does not validate its data either",
            rotten, -1.0);
    I(p, n) <+ V(p, n);
  end
endmodule
