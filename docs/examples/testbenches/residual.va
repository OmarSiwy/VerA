// Without `//! print none`, each point also prints the residual vector and
// the Jacobian the device returned there.
//! bias V(p) = 1
`include "disciplines.vams"

module residual(p, n);
  inout p, n;
  electrical p, n;
  parameter real r = 1k from (0:inf);
  analog I(p, n) <+ V(p, n) / r;
endmodule
