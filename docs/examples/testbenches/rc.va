// A series RC driven by a step: `in` is a wave the testbench writes at each
// time point, `out` is solved. Backward Euler at a fixed step.
//! time 0, 1e-4, 2e-4, 3e-4, 4e-4, 5e-4
//! wave V(in) = 0, 1
//! bias V(gnd) = 0
//! solve
//! print none
`include "disciplines.vams"

module rc(in, out, gnd);
  inout in, out, gnd;
  electrical in, out, gnd;
  parameter real r = 1k from (0:inf);
  parameter real c = 100n from (0:inf);
  analog begin
    I(in, out) <+ V(in, out) / r;
    I(out, gnd) <+ c * ddt(V(out, gnd));
    $strobe("t = %.1e  V(out) = %.6f", $abstime, V(out, gnd));
  end
endmodule
