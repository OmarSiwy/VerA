// pnjlim, by hand. LRM 9.17.3 names "pnjlim" but leaves its algorithm to the
// simulator; VerA's is ngspice's DEVpnjlim (src/spicelib/devices/devsup.c,
// transcribed in lib/backend/kernels/limit_kernels.zig), not SPICE3f5's
// older vold + vte * ln(1 + (vnew - vold) / vte).
// vte = 25 mV and vcrit = 0.6 V. From an old junction voltage of 0.65 V,
// Newton proposes 1.0 V. That is above vcrit and moves more than 2*vte, and
// the old value is positive, so the step is compressed logarithmically:
//
//   arg  = (1.0 - 0.65) / 0.025             = 14
//   vnew = 0.65 + 0.025 * (2 + ln(14 - 2))  = 0.7621226662447
//
// (python3: 0.65 + 0.025 * (2 + math.log(12)); the testbench compares to a
// relative 1e-12, so the want carries every digit)
// and the iteration is not converged, since the value was changed. The
// junction sits behind a series resistance, so the limited node `ai` is
// internal: a device clamps only its own nodes, never a port.
//! bias V(a) = 1.0, V(ai) = 1.0
//! print none
//! limit V(ai) = 0.65 -> V(ai) = 0.7621226662447, converged = 0
`include "disciplines.vams"

module pnjlim(a, k);
  inout a, k;
  electrical a, k, ai;
  parameter real is = 1e-14 from (0:1];
  parameter real rs = 10 from (0:inf);
  parameter real vte = 0.025 from (0:1];
  parameter real vcrit = 0.6 from (0:1];
  real vd;
  analog begin
    I(a, ai) <+ V(a, ai) / rs;
    vd = $limit(V(ai, k), "pnjlim", vte, vcrit);
    I(ai, k) <+ is * (exp(vd / vte) - 1);
  end
endmodule
