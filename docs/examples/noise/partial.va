// Exercise: partially correlated noise (LRM §4.6.4.6, Example 2). n1 and n2
// are each used once and n12 on both branches, so the table has four rows:
// (a,b) from n1 and n12, (b,c) from n2 and n12. The two n12 rows share a
// source id; n1 and n2 have ids of their own. VerA numbers generators in
// the order the contributions reach them (src/codegen/device/codegen/plan/noise.zig):
// n1 is #0, n12 #1, n2 #2.
//
// By hand, with corr = 0.25 and the coefficient 1e-9 on every generator:
//   n1, n2 rows:  (1e-9)^2 * (1 - 0.25) = 7.5e-19 A^2/Hz
//   n12 rows:     (1e-9)^2 * 0.25       = 2.5e-19 A^2/Hz
// The n12 rows are one generator with coefficients of the same sign, so
// their correlation is +1; n1 and n2 are independent, so theirs is 0.
//! bias V(a) = 1.0, V(b) = 0.5
//! noise thermal(a,b)#0 white=7.5e-19 corr=2:0
//! noise thermal(a,b)#1 white=2.5e-19 corr=3:1
//! noise thermal(b,c)#2 white=7.5e-19
//! noise thermal(b,c)#1 white=2.5e-19
//! print none
`include "disciplines.vams"

module partial(a, b, c);
  inout a, b, c;
  electrical a, b, c;
  parameter real corr = 0.25 from [0:1];
  real n1, n2, n12;
  analog begin
    n1 = white_noise(1 - corr);
    n2 = white_noise(1 - corr);
    n12 = white_noise(corr);
    I(a, b) <+ 1e-9 * (n1 + n12);
    I(b, c) <+ 1e-9 * (n2 + n12);
  end
endmodule
