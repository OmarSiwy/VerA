// A junction diode behind a series resistance: two ports, one internal node.
`include "disciplines.vams"

module diode(a, k);
  inout a, k;
  electrical a, k, ai;
  parameter real is = 1e-14 from (0:1];
  parameter real n = 1.0 from [0.5:4];
  parameter real rs = 10 from (0:inf);
  analog begin
    I(a, ai) <+ V(a, ai) / rs;
    I(ai, k) <+ is * (limexp(V(ai, k) / (n * $vt)) - 1);
  end
endmodule
