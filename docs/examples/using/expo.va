`include "disciplines.vams"

module expo(p, n);
  inout p, n;
  electrical p, n;
  parameter real is = 1e-14 from (0:inf);
  parameter real vt = 0.026;
  analog I(p, n) <+ is * (exp(V(p, n) / vt) - 1);
endmodule
