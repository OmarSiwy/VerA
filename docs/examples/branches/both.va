// Two contributions of different kinds to one branch. LRM 5.6.1.3: a flow
// contributed to a branch that holds a potential discards the potential, so
// after both statements (p, n) is a 1 mA flow source. The residual is 1 mA
// leaving p whatever the bias (5 V here), and nothing depends on V(p, n).
//! bias V(p) = 5
`include "disciplines.vams"

module both(p, n);
  inout p, n;
  electrical p, n;
  analog begin
    V(p, n) <+ 1;
    I(p, n) <+ 1m;
  end
endmodule
