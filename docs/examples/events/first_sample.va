// Exercise 2: also sample at the start. `initial_step or cross(...)` (LRM
// §5.10.1) fires at the first point as well as at the rising crossing. The
// input starts at 0.05 V, so `held` is 0.05 from t = 0 and 1 us, and becomes
// 0.2 at 2 us, the first grid point after the crossing.
//! time 0, 1u, 2u, 3u
//! wave V(clk) = 0, 0, 1, 1
//! wave V(in) = 0.05, 0.1, 0.2, 0.3
//! print none
`include "disciplines.vams"

module first_sample(in, clk, out);
  input in, clk;
  output out;
  electrical in, clk, out;
  real held;
  analog begin
    @(initial_step or cross(V(clk) - 0.5, +1))
      held = V(in);
    V(out) <+ held;
    $strobe("t = %g  held = %g", $abstime, held);
  end
endmodule
