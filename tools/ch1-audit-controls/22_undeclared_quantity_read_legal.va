// Legal control for 22_undeclared_quantity_read.va; compile acceptance only.
module ch01_undeclared_quantity_read(p, n);
    inout p, n;
    electrical p, n;
    voltage vonly;
    real x;

    analog begin
        x = V(vonly);
        V(vonly) <+ 1.0;
        I(p, n) <+ V(p, n) * 1.0e-3 + x;
    end
endmodule
