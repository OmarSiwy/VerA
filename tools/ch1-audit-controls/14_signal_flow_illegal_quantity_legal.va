// Legal control; compile acceptance only.
module ch01_signal_flow_illegal_quantity(p, n);
    inout p, n;
    electrical p, n;
    voltage vonly;

    analog begin
        V(vonly) <+ 1.0;
        I(p, n) <+ V(p, n) * 1.0e-3;
    end
endmodule
