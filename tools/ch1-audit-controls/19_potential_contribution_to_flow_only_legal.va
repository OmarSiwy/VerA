// Legal control; compile acceptance only.
module ch01_potential_contribution_to_flow_only(p, n);
    inout p, n;
    electrical p, n;
    current ionly;

    analog begin
        I(ionly) <+ 1.0e-3;
        I(p, n) <+ V(p, n) * 1.0e-3;
    end
endmodule
