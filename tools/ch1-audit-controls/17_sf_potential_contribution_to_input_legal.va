// Legal control for 17_sf_potential_contribution_to_input.va; compile acceptance only.
module ch01_sf_potential_contribution_to_input(inp, outp);
    input inp;
    output outp;
    voltage inp, outp;

    analog begin
        V(outp) <+ V(inp);
        V(outp) <+ 2.0;
    end
endmodule
