// IEEE 1364-2005 12.8.2: generated scope renamed to avoid target rebinding.
module scope_root;
  scope_child slot();
endmodule
module scope_child;
  parameter integer select = 2;
  defparam scope_root.slot.select = 1;
  generate if (select == 1) begin : different_name
    scope_leaf slot();
  end endgenerate
endmodule
module scope_leaf;
  parameter integer select = 3;
endmodule
